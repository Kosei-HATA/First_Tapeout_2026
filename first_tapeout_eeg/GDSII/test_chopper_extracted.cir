* Extracted by KLayout with SKY130 LVS runset on : 13/09/2026 07:21

.SUBCKT eeg_cmos_chopper_lowq INN INP NPHI NPHIB OUTN OUTP PHI PHIB VDD18 VSS
X$1 VDD18 VSS NPHI PHI OUTP INP eeg_tg_lowq
X$2 VDD18 VSS NPHIB PHIB OUTP INN eeg_tg_lowq
X$3 VDD18 VSS NPHIB PHIB OUTN INP eeg_tg_lowq
X$4 VDD18 VSS NPHI PHI OUTN INN eeg_tg_lowq
.ENDS eeg_cmos_chopper_lowq

.SUBCKT eeg_tg_lowq VDD18 VSS ENB EN B A
M$1 A EN A VDD18 sky130_fd_pr__pfet_01v8 L=0.15 W=0.84 AS=0.5544 AD=0.5544 PS=3
+ PD=3
M$2 A ENB A VSS sky130_fd_pr__nfet_01v8 L=0.15 W=0.42 AS=0.126 AD=0.126 PS=1.44
+ PD=1.44
M$3 B EN B VDD18 sky130_fd_pr__pfet_01v8 L=0.15 W=0.84 AS=0.5544 AD=0.5544 PS=3
+ PD=3
M$4 A ENB B VDD18 sky130_fd_pr__pfet_01v8 L=0.15 W=1.68 AS=1.7136 AD=1.7136
+ PS=5.4 PD=5.4
M$5 B ENB B VSS sky130_fd_pr__nfet_01v8 L=0.15 W=0.42 AS=0.126 AD=0.126 PS=1.44
+ PD=1.44
M$6 A EN B VSS sky130_fd_pr__nfet_01v8 L=0.15 W=0.84 AS=0.5544 AD=0.5544 PS=3
+ PD=3
.ENDS eeg_tg_lowq
