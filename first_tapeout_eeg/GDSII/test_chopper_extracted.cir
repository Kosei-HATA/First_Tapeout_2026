* Extracted by KLayout with SKY130 LVS runset on : 04/09/2026 14:58

.SUBCKT eeg_cmos_chopper_lowq A|INN A|INP B|OUTN B|OUTP EN|PHI EN|PHIB ENB|NPHI
+ ENB|NPHIB VDD18 VSS
M$1 A|INN ENB|NPHI B|OUTN VDD18 sky130_fd_pr__pfet_01v8 L=0.15 W=1.68 AS=1.7136
+ AD=1.7136 PS=5.4 PD=5.4
M$2 B|OUTP EN|PHI B|OUTP VDD18 sky130_fd_pr__pfet_01v8 L=0.15 W=0.84 AS=0.5544
+ AD=0.5544 PS=3 PD=3
M$3 A|INN ENB|NPHIB B|OUTP VDD18 sky130_fd_pr__pfet_01v8 L=0.15 W=1.68
+ AS=1.7136 AD=1.7136 PS=5.4 PD=5.4
M$4 B|OUTP EN|PHIB B|OUTP VDD18 sky130_fd_pr__pfet_01v8 L=0.15 W=0.84 AS=0.5544
+ AD=0.5544 PS=3 PD=3
M$5 A|INP ENB|NPHIB B|OUTN VDD18 sky130_fd_pr__pfet_01v8 L=0.15 W=1.68
+ AS=1.7136 AD=1.7136 PS=5.4 PD=5.4
M$6 B|OUTN EN|PHIB B|OUTN VDD18 sky130_fd_pr__pfet_01v8 L=0.15 W=0.84 AS=0.5544
+ AD=0.5544 PS=3 PD=3
M$7 A|INN EN|PHI A|INN VDD18 sky130_fd_pr__pfet_01v8 L=0.15 W=0.84 AS=0.5544
+ AD=0.5544 PS=3 PD=3
M$8 A|INN EN|PHIB A|INN VDD18 sky130_fd_pr__pfet_01v8 L=0.15 W=0.84 AS=0.5544
+ AD=0.5544 PS=3 PD=3
M$9 B|OUTN EN|PHI B|OUTN VDD18 sky130_fd_pr__pfet_01v8 L=0.15 W=0.84 AS=0.5544
+ AD=0.5544 PS=3 PD=3
M$10 A|INP ENB|NPHI B|OUTP VDD18 sky130_fd_pr__pfet_01v8 L=0.15 W=1.68
+ AS=1.7136 AD=1.7136 PS=5.4 PD=5.4
M$11 A|INP EN|PHIB A|INP VDD18 sky130_fd_pr__pfet_01v8 L=0.15 W=0.84 AS=0.5544
+ AD=0.5544 PS=3 PD=3
M$12 A|INP EN|PHI A|INP VDD18 sky130_fd_pr__pfet_01v8 L=0.15 W=0.84 AS=0.5544
+ AD=0.5544 PS=3 PD=3
M$13 A|INP EN|PHIB B|OUTN VSS sky130_fd_pr__nfet_01v8 L=0.15 W=0.84 AS=0.5544
+ AD=0.5544 PS=3 PD=3
M$14 A|INN EN|PHIB B|OUTP VSS sky130_fd_pr__nfet_01v8 L=0.15 W=0.84 AS=0.5544
+ AD=0.5544 PS=3 PD=3
M$15 A|INN ENB|NPHI A|INN VSS sky130_fd_pr__nfet_01v8 L=0.15 W=0.42 AS=0.126
+ AD=0.126 PS=1.44 PD=1.44
M$16 A|INN ENB|NPHIB A|INN VSS sky130_fd_pr__nfet_01v8 L=0.15 W=0.42 AS=0.126
+ AD=0.126 PS=1.44 PD=1.44
M$17 B|OUTN ENB|NPHIB B|OUTN VSS sky130_fd_pr__nfet_01v8 L=0.15 W=0.42 AS=0.126
+ AD=0.126 PS=1.44 PD=1.44
M$18 A|INN EN|PHI B|OUTN VSS sky130_fd_pr__nfet_01v8 L=0.15 W=0.84 AS=0.5544
+ AD=0.5544 PS=3 PD=3
M$19 B|OUTP ENB|NPHI B|OUTP VSS sky130_fd_pr__nfet_01v8 L=0.15 W=0.42 AS=0.126
+ AD=0.126 PS=1.44 PD=1.44
M$20 B|OUTN ENB|NPHI B|OUTN VSS sky130_fd_pr__nfet_01v8 L=0.15 W=0.42 AS=0.126
+ AD=0.126 PS=1.44 PD=1.44
M$21 A|INP EN|PHI B|OUTP VSS sky130_fd_pr__nfet_01v8 L=0.15 W=0.84 AS=0.5544
+ AD=0.5544 PS=3 PD=3
M$22 B|OUTP ENB|NPHIB B|OUTP VSS sky130_fd_pr__nfet_01v8 L=0.15 W=0.42 AS=0.126
+ AD=0.126 PS=1.44 PD=1.44
M$23 A|INP ENB|NPHIB A|INP VSS sky130_fd_pr__nfet_01v8 L=0.15 W=0.42 AS=0.126
+ AD=0.126 PS=1.44 PD=1.44
M$24 A|INP ENB|NPHI A|INP VSS sky130_fd_pr__nfet_01v8 L=0.15 W=0.42 AS=0.126
+ AD=0.126 PS=1.44 PD=1.44
.ENDS eeg_cmos_chopper_lowq
