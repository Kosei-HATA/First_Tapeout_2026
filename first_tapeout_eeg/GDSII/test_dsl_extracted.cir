* Extracted by KLayout with SKY130 LVS runset on : 04/09/2026 15:39

.SUBCKT eeg_dsl GN GP VCM_REF VDD18 VSS
M$1 VDD18 \$46 \$47 VDD18 sky130_fd_pr__pfet_01v8 L=4 W=8 AS=8.16 AD=8.16
+ PS=18.04 PD=18.04
M$2 \$47 \$41 \$2 \$47 sky130_fd_pr__pfet_01v8 L=2 W=4 AS=4.08 AD=4.08 PS=10.04
+ PD=10.04
M$3 VDD18 \$46 \$46 VDD18 sky130_fd_pr__pfet_01v8 L=4 W=4 AS=4.08 AD=4.08
+ PS=10.04 PD=10.04
M$4 \$47 \$39 \$38 \$47 sky130_fd_pr__pfet_01v8 L=2 W=4 AS=4.08 AD=4.08
+ PS=10.04 PD=10.04
M$5 VSS \$38 \$2 VSS sky130_fd_pr__nfet_01v8 L=4 W=2 AS=2.04 AD=2.04 PS=6.04
+ PD=6.04
M$6 VSS \$2 GN VSS sky130_fd_pr__nfet_01v8 L=4 W=1 AS=1.02 AD=1.02 PS=4.04
+ PD=4.04
M$7 VSS \$38 \$38 VSS sky130_fd_pr__nfet_01v8 L=4 W=2 AS=2.04 AD=2.04 PS=6.04
+ PD=6.04
M$8 \$41 VCM_REF VDD18 VSS sky130_fd_pr__nfet_01v8 L=2 W=2 AS=2.04 AD=2.04
+ PS=6.04 PD=6.04
M$9 VSS \$37 \$37 VSS sky130_fd_pr__nfet_01v8 L=8 W=2 AS=2.04 AD=2.04 PS=6.04
+ PD=6.04
M$10 \$39 GN VDD18 VSS sky130_fd_pr__nfet_01v8 L=2 W=2 AS=2.04 AD=2.04 PS=6.04
+ PD=6.04
M$11 \$39 GP VDD18 VSS sky130_fd_pr__nfet_01v8 L=2 W=2 AS=2.04 AD=2.04 PS=6.04
+ PD=6.04
M$12 VSS \$37 \$39 VSS sky130_fd_pr__nfet_01v8 L=8 W=1 AS=0.3 AD=0.3 PS=3.2
+ PD=3.2
M$13 VSS \$2 GP VSS sky130_fd_pr__nfet_01v8 L=4 W=1 AS=1.02 AD=1.02 PS=4.04
+ PD=4.04
M$14 VSS \$37 \$46 VSS sky130_fd_pr__nfet_01v8 L=8 W=1 AS=1.02 AD=1.02 PS=4.04
+ PD=4.04
M$15 VSS \$37 \$41 VSS sky130_fd_pr__nfet_01v8 L=8 W=1 AS=1.02 AD=1.02 PS=4.04
+ PD=4.04
R$36 VDD18 \$37 VSS sky130_fd_pr__res_xhigh_po_0p69 R=2000000 L=690 W=0.69
+ A=476.1 P=1407.6
C$37 VSS \$2 sky130_fd_pr__model__cap_mim C=5e-11 A=25000 P=8000
.ENDS eeg_dsl
