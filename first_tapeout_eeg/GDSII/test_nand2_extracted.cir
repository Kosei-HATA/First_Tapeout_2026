* Extracted by KLayout with SKY130 LVS runset on : 05/09/2026 13:17

.SUBCKT eeg_nand2 A B VDD18 VSS Y
M$1 Y B VDD18 VDD18 sky130_fd_pr__pfet_01v8 L=0.15 W=2 AS=2.04 AD=2.04 PS=6.04
+ PD=6.04
M$2 Y A VDD18 VDD18 sky130_fd_pr__pfet_01v8 L=0.15 W=2 AS=2.04 AD=2.04 PS=6.04
+ PD=6.04
M$3 \$9 B VSS VSS sky130_fd_pr__nfet_01v8 L=0.15 W=1 AS=1.02 AD=1.02 PS=4.04
+ PD=4.04
M$4 Y A \$9 VSS sky130_fd_pr__nfet_01v8 L=0.15 W=1 AS=1.02 AD=1.02 PS=4.04
+ PD=4.04
.ENDS eeg_nand2
