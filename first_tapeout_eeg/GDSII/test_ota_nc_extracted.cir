* Extracted by KLayout with SKY130 LVS runset on : 11/09/2026 19:08

.SUBCKT eeg_fd_ota_full2_nc INN INP OUTN OUTP VCM_REF VDD18 VSS
X$1 VSS \$2 \$3 VCM_REF VDD18 \$14 eeg_cmfb_amp_dl2_s2
X$2 OUTP OUTN VSS \$6 \$7 \$14 \$3 VCM_REF VDD18 stage2
X$3 VSS \$2 VDD18 eeg_bias_gen
X$4 VSS \$2 \$11 VCM_REF VDD18 \$8 eeg_cmfb_amp_dl2
X$5 VSS \$2 INN INP \$7 \$6 \$8 \$11 VCM_REF VDD18 eeg_fd_ota_core_soft
.ENDS eeg_fd_ota_full2_nc

.SUBCKT eeg_bias_gen VSS VBNF VDD18
X$105 VDD18 VBN eeg_pseudo_res
C$1 VSS VBNF sky130_fd_pr__model__cap_mim C=1e-10 A=50000 P=10000
M$126 VSS VBN VBN VSS sky130_fd_pr__nfet_01v8 L=4 W=10 AS=6.35 AD=6.35 PS=17.54
+ PD=17.54
M$128 \$104 VBN VBP VSS sky130_fd_pr__nfet_01v8 L=4 W=40 AS=13.85 AD=13.85
+ PS=50.54 PD=50.54
R$136 VSS \$104 VSS sky130_fd_pr__res_xhigh_po_0p69 R=24985.5072464 L=8.62
+ W=0.69 A=5.9478 P=18.62
M$137 VDD18 VBP VBP VDD18 sky130_fd_pr__pfet_01v8 L=4 W=10 AS=6.35 AD=6.35
+ PS=17.54 PD=17.54
R$237 VBNF VBN VSS sky130_fd_pr__res_xhigh_po_0p69 R=10000000 L=3450 W=0.69
+ A=2380.5 P=7038
M$239 VDD18 VBP VBN VDD18 sky130_fd_pr__pfet_01v8 L=4 W=10 AS=6.35 AD=6.35
+ PS=17.54 PD=17.54
.ENDS eeg_bias_gen

.SUBCKT stage2 OUTP OUTN VSS N2P N2N VBP2 VCM2 VCM_REF VDD18
C$1 OUTP \$3 sky130_fd_pr__model__cap_mim C=1e-11 A=5000 P=1300
C$21 OUTN \$4 sky130_fd_pr__model__cap_mim C=1e-11 A=5000 P=1300
R$41 \$3 N2P VSS sky130_fd_pr__res_xhigh_po_0p69 R=20000 L=6.9 W=0.69 A=4.761
+ P=15.18
R$42 \$4 N2N VSS sky130_fd_pr__res_xhigh_po_0p69 R=20000 L=6.9 W=0.69 A=4.761
+ P=15.18
M$43 VSS N2P OUTP VSS sky130_fd_pr__nfet_01v8 L=12 W=12 AS=7.62 AD=7.62
+ PS=20.54 PD=20.54
M$45 VSS N2N OUTN VSS sky130_fd_pr__nfet_01v8 L=12 W=12 AS=7.62 AD=7.62
+ PS=20.54 PD=20.54
M$47 VDD18 VBP2 OUTP VDD18 sky130_fd_pr__pfet_01v8 L=12 W=48 AS=16.62 AD=16.62
+ PS=59.54 PD=59.54
R$86 VCM_REF OUTN VSS sky130_fd_pr__res_xhigh_po_0p69 R=2000000 L=690 W=0.69
+ A=476.1 P=1407.6
R$93 VCM_REF OUTP VSS sky130_fd_pr__res_xhigh_po_0p69 R=2000000 L=690 W=0.69
+ A=476.1 P=1407.6
R$123 VCM2 OUTP VSS sky130_fd_pr__res_xhigh_po_0p69 R=5000000 L=1725 W=0.69
+ A=1190.25 P=3519
R$128 VCM2 OUTN VSS sky130_fd_pr__res_xhigh_po_0p69 R=5000000 L=1725 W=0.69
+ A=1190.25 P=3519
M$195 VDD18 VBP2 OUTN VDD18 sky130_fd_pr__pfet_01v8 L=12 W=48 AS=16.62 AD=16.62
+ PS=59.54 PD=59.54
.ENDS stage2

.SUBCKT eeg_cmfb_amp_dl2_s2 VSS VBN VCM_SENSE VCM_REF VDD18 VBP
M$1 VSS VBN \$5 VSS sky130_fd_pr__nfet_01v8 L=4 W=12 AS=7.62 AD=7.62 PS=20.54
+ PD=20.54
M$3 VDD18 VBP VBP VDD18 sky130_fd_pr__pfet_01v8 L=4 W=0.5 AS=0.15 AD=0.15
+ PS=1.6 PD=1.6
M$4 VDD18 \$6 \$6 VDD18 sky130_fd_pr__pfet_01v8 L=2 W=2 AS=2.04 AD=2.04 PS=6.04
+ PD=6.04
M$5 \$5 VCM_REF VBP VSS sky130_fd_pr__nfet_01v8 L=2 W=2 AS=2.04 AD=2.04 PS=6.04
+ PD=6.04
M$6 \$5 VCM_SENSE \$6 VSS sky130_fd_pr__nfet_01v8 L=2 W=2 AS=2.04 AD=2.04
+ PS=6.04 PD=6.04
.ENDS eeg_cmfb_amp_dl2_s2

.SUBCKT eeg_cmfb_amp_dl2 VSS VBN VCM_SENSE VCM_REF VDD18 VBP
M$1 VSS VBN \$5 VSS sky130_fd_pr__nfet_01v8 L=4 W=12 AS=7.62 AD=7.62 PS=20.54
+ PD=20.54
M$3 VDD18 VBP VBP VDD18 sky130_fd_pr__pfet_01v8 L=4 W=4 AS=4.08 AD=4.08
+ PS=10.04 PD=10.04
M$4 VDD18 \$6 \$6 VDD18 sky130_fd_pr__pfet_01v8 L=2 W=2 AS=2.04 AD=2.04 PS=6.04
+ PD=6.04
M$5 \$5 VCM_REF VBP VSS sky130_fd_pr__nfet_01v8 L=2 W=2 AS=2.04 AD=2.04 PS=6.04
+ PD=6.04
M$6 \$5 VCM_SENSE \$6 VSS sky130_fd_pr__nfet_01v8 L=2 W=2 AS=2.04 AD=2.04
+ PS=6.04 PD=6.04
.ENDS eeg_cmfb_amp_dl2

.SUBCKT eeg_fd_ota_core_soft VSS VBN INN INP OUTN OUTP VBP VCM_SENSE VCM_REF
+ VDD18
M$1 VDD18 VBP OUTP VDD18 sky130_fd_pr__pfet_01v8 L=4 W=48 AS=16.62 AD=16.62
+ PS=59.54 PD=59.54
R$25 VCM_REF OUTP VSS sky130_fd_pr__res_xhigh_po_0p69 R=2000000 L=690 W=0.69
+ A=476.1 P=1407.6
R$77 VCM_SENSE OUTP VSS sky130_fd_pr__res_xhigh_po_0p69 R=5000000 L=1725 W=0.69
+ A=1190.25 P=3519
R$97 OUTN VCM_REF VSS sky130_fd_pr__res_xhigh_po_0p69 R=2000000 L=690 W=0.69
+ A=476.1 P=1407.6
R$103 OUTN VCM_SENSE VSS sky130_fd_pr__res_xhigh_po_0p69 R=5000000 L=1725
+ W=0.69 A=1190.25 P=3519
M$149 VDD18 VBP OUTN VDD18 sky130_fd_pr__pfet_01v8 L=4 W=48 AS=16.62 AD=16.62
+ PS=59.54 PD=59.54
M$157 VSS VBN \$73 VSS sky130_fd_pr__nfet_01v8 L=4 W=96 AS=28.62 AD=28.62
+ PS=111.54 PD=111.54
M$173 \$73 VSS OUTP VSS sky130_fd_pr__nfet_01v8 L=4 W=20 AS=19.9 AD=19.9
+ PS=33.98 PD=33.98
M$174 OUTP INP \$73 VSS sky130_fd_pr__nfet_01v8 L=4 W=240 AS=60 AD=60 PS=252
+ PD=252
M$175 \$73 INN OUTN VSS sky130_fd_pr__nfet_01v8 L=4 W=240 AS=60 AD=60 PS=252
+ PD=252
.ENDS eeg_fd_ota_core_soft

.SUBCKT eeg_pseudo_res A B
M$1 \$3 \$3 B B sky130_fd_pr__pfet_01v8 L=4 W=1 AS=1.02 AD=1.02 PS=4.04 PD=4.04
M$2 \$3 \$3 A A sky130_fd_pr__pfet_01v8 L=4 W=1 AS=1.02 AD=1.02 PS=4.04 PD=4.04
.ENDS eeg_pseudo_res
