* Extracted by KLayout with SKY130 LVS runset on : 03/09/2026 17:04

.SUBCKT eeg_tg_lowq A|B|EN VDD18 VSS
M$1 A|B|EN A|B|EN A|B|EN VDD18 sky130_fd_pr__pfet_01v8 L=0.15 W=2.52 AS=2.268
+ AD=2.268 PS=8.4 PD=8.4
M$3 A|B|EN A|B|EN A|B|EN VSS sky130_fd_pr__nfet_01v8 L=0.15 W=1.26 AS=0.6804
+ AD=0.6804 PS=4.44 PD=4.44
.ENDS eeg_tg_lowq
