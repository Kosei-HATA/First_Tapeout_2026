* nonlinear C versus exact integral Q
.include /work/Test-2-4/manufacturing_preflight/analog/models/design.ngspice
.lib /work/Test-2-4/manufacturing_preflight/analog/models/sm141064.ngspice typical
.lib /work/Test-2-4/manufacturing_preflight/analog/models/sm141064.ngspice moscap_typical
.include /work/Test-2-4/manufacturing_preflight/analog/moscap_charge_equivalent/q_models.spice
.include /work/Test-2-4/manufacturing_preflight/analog/moscap_saved_wave_replay/stimulus.inc
Enmos_c nmos_c 0 node 0 1
Xnmos_c nmos_c 0 cap_nmos_03v3 c_length=28.6u c_width=44u m=1
Enmos_q nmos_q 0 node 0 1
Xnmos_q nmos_q 0 audit_q_nmos c_length=28.6u c_width=44u m=1
Epmos_c pmos_c 0 node 0 -1
Xpmos_c pmos_c 0 cap_pmos_03v3 c_length=28.6u c_width=44u m=1
Epmos_q pmos_q 0 node 0 -1
Xpmos_q pmos_q 0 audit_q_pmos c_length=28.6u c_width=44u m=1

.temp 27
.options method=gear reltol=1e-4 abstol=1e-12 vntol=1e-7
.control
set numdgt=15
tran 1n 7.932482490343595u 0 1n
wrdata wave.csv v(node) i(enmos_c) i(enmos_q) i(epmos_c) i(epmos_q)
quit
.endc
.end
