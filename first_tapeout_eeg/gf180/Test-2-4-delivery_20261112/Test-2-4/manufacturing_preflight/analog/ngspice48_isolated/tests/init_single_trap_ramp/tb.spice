* original model isolation
.include /work/Test-2-4/manufacturing_preflight/analog/models/design.ngspice
.lib /work/Test-2-4/manufacturing_preflight/analog/models/sm141064.ngspice typical
.lib /work/Test-2-4/manufacturing_preflight/analog/models/sm141064.ngspice moscap_typical
VDRV drive 0 PWL(0 0 500n .85)
RDRV drive gate 1k
XC gate 0 cap_nmos_03v3 c_length=28.6u c_width=44u

.options method=trap reltol=1e-4 abstol=1e-12 vntol=1e-7
.control
set numdgt=15
tran 1n 1e-06 0 1n
wrdata wave.csv v(gate)
quit
.endc
.end
