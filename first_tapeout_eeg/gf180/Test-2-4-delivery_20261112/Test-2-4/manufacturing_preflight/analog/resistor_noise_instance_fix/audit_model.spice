* Verification-only instance noise flag; not foundry-qualified replacement
.subckt audit_ppolyf_u_1k 1 2 3 r_length=l r_width=w dtemp=0 par=1 s=1
.param r_rsh0='rsh_ppolyf_u_1k*(1+mc_rsh_ppolyf_u_1k/(rsh_ppolyf_u_1k)*res_mc_skew*sw_stat_global)'
.param r_dw='0.0148e-6*(1+mc_dw_ppolyf_u_1k*res_mc_skew*sw_stat_global)'
.param r_dl=3.85e-11
.param r_vc1=0
.param r_vc2=0
.param r_tc1=-9.39e-4
.param r_tc2=2.51e-6
.param r_tnom=25
.param r_l='s*(r_length-2*r_dl)'
.param r_w='r_width-2*r_dw'
.param r_n='r_l/r_w'
.param r_temp='1+r_tc1*(temper+dtemp-r_tnom)+r_tc2*(temper+dtemp-r_tnom)*(temper+dtemp-r_tnom)'
.model ppolyf_u_1k_body r
+ af=1
+ kf=2.62e-26
+ noise=1
.model ppolyf_u_1k_t r
+ af=1
+ kf=2.62e-26
+ rsh='85.45+mc_rt_ppolyf_u_1k*res_mc_skew*sw_stat_global'
+ tc1=-7.92e-3
+ tc2=4.25e-5
+ tnom=25
.model fox_sub c
+ cox=8.85e-05
rt1 1 11 ppolyf_u_1k_t dtemp=dtemp l='s*1u' w=r_w
c1 1 3 fox_sub dtemp=dtemp l='r_l/2' w=r_w
rb 11 21 ppolyf_u_1k_body r='r_temp*r_n*(r_rsh0+r_vc1*abs(v(11,21))/r_n+r_vc2*abs(v(11,21))*abs(v(11,21))/r_n/r_n)' w=r_w l=r_l dtemp=dtemp noisy=1
rt2 21 2 ppolyf_u_1k_t dtemp=dtemp l='s*1u' w=r_w
c2 2 3 fox_sub dtemp=dtemp l='r_l/2' w=r_w
.ends audit_ppolyf_u_1k
