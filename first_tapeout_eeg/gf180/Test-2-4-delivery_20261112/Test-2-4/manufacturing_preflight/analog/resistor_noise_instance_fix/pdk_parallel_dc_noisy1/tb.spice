* independent resistor zero-bias thermal noise sanity
.include /work/Test-2-4/manufacturing_preflight/analog/models/design.ngspice
.lib /work/Test-2-4/manufacturing_preflight/analog/models/sm141064.ngspice res_typical
.include /work/Test-2-4/manufacturing_preflight/analog/resistor_noise_instance_fix/audit_model.spice
.temp 27
ITEST 0 out DC 0 AC 1
XR1 out 0 0 audit_ppolyf_u_1k r_length=291.28u r_width=1u
XR2 out 0 0 audit_ppolyf_u_1k r_length=291.28u r_width=1u
.control
set numdgt=15
dc ITEST -1u 1u 1u
wrdata dc.csv v(out)
quit
.endc
.end
