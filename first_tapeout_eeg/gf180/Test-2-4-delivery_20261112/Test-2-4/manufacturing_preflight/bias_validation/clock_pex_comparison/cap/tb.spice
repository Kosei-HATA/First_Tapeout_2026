* eeg_adc_clk timing with OTA1 as load
.include /work/Test-2-4/functional/models/design.ngspice
.lib /work/Test-2-4/functional/models/sm141064.ngspice typical
.lib /work/Test-2-4/functional/models/sm141064.ngspice mimcap_typical
.lib /work/Test-2-4/functional/models/sm141064.ngspice cap_mim
.include /work/Test-2-4/functional/sim_work/gf180/tapeout/adc/eeg_adc_otas.spice
.include /work/Test-2-4/manufacturing_preflight/extraction/core_pex_probe/clock_probe/flat/cap.spice
.temp 27
.options sparse reltol=1e-4
VDD VDD 0 3.3
VCH CHOP1 0 PULSE(3.3 0 9.975000e-08 0.5n 0.5n 1.995000e-07 1u)
VCLK VCLK 0 3.3
XC CHOP1 CIA NCIA CIB NCIB CDA NCDA CDB NCDB VCLK 0 eeg_adc_clk
XOTA1 VCM VCM O1P O1N VCM VBN1 VNC1 VPC1 VBCM1 CIA NCIA CIB NCIB CDA NCDA CDB NCDB VDD 0 gf180_inside_cascode_ota
C1P O1P 0 684.5p
C1N O1N 0 684.5p
.lib /work/Test-2-4/functional/models/sm141064.ngspice res_typical
.param moscap_corner=1.0
.include /work/Test-2-4/functional/sim_work/gf180/tapeout/sim/moscap_lin.spice
.include /work/Test-2-4/functional/sim_work/gf180/tapeout/bias/eeg_bias.spice
EVIB1 IB1 0 VDD 0 1
VIB0 IB0 0 0.0
VBP1 BP1 0 0
EVBP0 BP0 0 VDD 0 1
VBN1 BN1 0 0
EVBN0 BN0 0 VDD 0 1
VMBLN BLN BLNL 0
XLN BLNL BLNL 0 0 nfet_03v3 W=20u L=8u nf=1 m=4
VMBLP BLPL BLP 0
XLP BLPL BLPL VDD VDD pfet_03v3 W=20u L=8u nf=1 m=4
VRP VREFP 0 1.9
VRN VREFN 0 1.4
VMIDN IDN IDNL 0
XDLN IDNL IDNL 0 0 nfet_03v3 W=1u L=20u nf=1 m=10
VMIDP IDPL IDP 0
XDLP IDPL IDPL VDD VDD pfet_03v3 W=1u L=20u nf=1 m=10
VMIQ IQ IQL 0
VMITST ITST 0 1
XDQ IQL IQL 0 0 nfet_03v3 W=4u L=2u nf=1 m=8
XB VBN VBCM BLP BLN VBN1 VBCM1 VNC1 VPC1 VBPC2 VBNC2 IDP IDN IQ ITST VCM VREFP VREFN IB1 IB0 BP1 BP0 BN1 BN0 VDD 0 eeg_bias

.control
set noaskquit
op
wrdata op.csv v(vcm) v(vbn1) v(vnc1) v(vpc1) v(vbcm1) v(xota1.cip) v(xota1.cin) v(xota1.xota.xcore.d1p) v(xota1.xota.xcore.d1n) v(xota1.xota.xcore.n1p) v(xota1.xota.xcore.n1n) v(xota1.xota.xcore.p1p) v(xota1.xota.xcore.p1n) v(xota1.xota.xcore.p2p) v(xota1.xota.xcore.p2n)
tran 0.01n 500n 0 0.05n
wrdata out.csv v(chop1) v(cia) v(ncia) v(cib) v(ncib) v(cda) v(ncda) v(cdb) v(ncdb) i(vclk)
wrdata load_wave.csv v(vcm) v(vbn1) v(vnc1) v(vpc1) v(vbcm1) v(xota1.cip) v(xota1.cin) v(xota1.xota.xcore.d1p) v(xota1.xota.xcore.d1n) v(xota1.xota.xcore.n1p) v(xota1.xota.xcore.n1n) v(xota1.xota.xcore.p1p) v(xota1.xota.xcore.p1n) v(xota1.xota.xcore.p2p) v(xota1.xota.xcore.p2n)
quit
.endc
.end
