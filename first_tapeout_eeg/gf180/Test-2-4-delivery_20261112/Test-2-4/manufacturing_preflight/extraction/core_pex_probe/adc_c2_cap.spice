* NGSPICE file created from adc_c2.ext - technology: gf180mcuD

.subckt cap_mim$5$3 m4_n120_n120# m4_0_0# VSUBS
X0 m4_0_0# m4_n120_n120# cap_mim_2f0_m4m5_noshield c_width=98.82999u c_length=98.82999u
C0 m4_n120_n120# m4_0_0# 5.85015f
C1 m4_0_0# VSUBS 85.7325f
C2 m4_n120_n120# VSUBS 13.0787f
.ends

.subckt adc_c2
Xcap_mim$5$3_0 m4_200_21366# m4_200_80# VSUBS cap_mim$5$3
C0 m4_200_21366# m4_200_80# 11.67871f
C1 m4_200_80# VSUBS 4.53961f
C2 m4_200_21366# VSUBS 0.529f
.ends
