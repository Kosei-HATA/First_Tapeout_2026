* Qualified for isolated nominal device-model unit/multiplicity check only.
* TOP/BOT map via existing core LVS: C2P ADC.I2P/O2N, C2N ADC.I2N/O2P.
* Include sm141064.ngspice mimcap_typical (loads native cap_mim_new).
.subckt adc_c2_device TOP BOT
X0 TOP BOT cap_mim_2f0_m4m5_noshield c_width=98.82999u c_length=98.82999u
.ends adc_c2_device
