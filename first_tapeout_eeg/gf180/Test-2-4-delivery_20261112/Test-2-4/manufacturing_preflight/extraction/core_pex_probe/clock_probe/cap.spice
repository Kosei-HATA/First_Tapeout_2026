* NGSPICE file created from eeg_adc_clk.ext - technology: gf180mcuD

.subckt eeg_aclk_inv_s24 a_236_340# w_n40_1450# w_n40_0# a_172_2100#
X0 w_n40_1450# a_172_2100# a_236_340# w_n40_1450# pfet_03v3 ad=0.65p pd=3.02u as=0.65p ps=3.02u w=2.5u l=0.28u
X1 w_n40_1450# a_172_2100# a_236_340# w_n40_1450# pfet_03v3 ad=0.65p pd=3.02u as=0.65p ps=3.02u w=2.5u l=0.28u
X2 a_236_340# a_172_2100# w_n40_1450# w_n40_1450# pfet_03v3 ad=0.65p pd=3.02u as=0.65p ps=3.02u w=2.5u l=0.28u
X3 w_n40_0# a_172_2100# a_236_340# w_n40_0# nfet_03v3 ad=0.26p pd=1.52u as=0.26p ps=1.52u w=1u l=0.28u
X4 a_236_340# a_172_2100# w_n40_1450# w_n40_1450# pfet_03v3 ad=0.65p pd=3.02u as=0.65p ps=3.02u w=2.5u l=0.28u
X5 a_236_340# a_172_2100# w_n40_0# w_n40_0# nfet_03v3 ad=0.26p pd=1.52u as=0.26p ps=1.52u w=1u l=0.28u
X6 w_n40_1450# a_172_2100# a_236_340# w_n40_1450# pfet_03v3 ad=0.65p pd=3.02u as=0.65p ps=3.02u w=2.5u l=0.28u
X7 w_n40_1450# a_172_2100# a_236_340# w_n40_1450# pfet_03v3 ad=0.65p pd=3.02u as=0.65p ps=3.02u w=2.5u l=0.28u
X8 w_n40_0# a_172_2100# a_236_340# w_n40_0# nfet_03v3 ad=0.26p pd=1.52u as=0.26p ps=1.52u w=1u l=0.28u
X9 a_236_340# a_172_2100# w_n40_1450# w_n40_1450# pfet_03v3 ad=0.65p pd=3.02u as=1.125p ps=5.9u w=2.5u l=0.28u
X10 a_236_340# a_172_2100# w_n40_0# w_n40_0# nfet_03v3 ad=0.26p pd=1.52u as=0.26p ps=1.52u w=1u l=0.28u
X11 w_n40_0# a_172_2100# a_236_340# w_n40_0# nfet_03v3 ad=0.26p pd=1.52u as=0.26p ps=1.52u w=1u l=0.28u
X12 a_236_340# a_172_2100# w_n40_0# w_n40_0# nfet_03v3 ad=0.26p pd=1.52u as=0.26p ps=1.52u w=1u l=0.28u
X13 w_n40_1450# a_172_2100# a_236_340# w_n40_1450# pfet_03v3 ad=0.65p pd=3.02u as=0.65p ps=3.02u w=2.5u l=0.28u
X14 a_236_340# a_172_2100# w_n40_0# w_n40_0# nfet_03v3 ad=0.26p pd=1.52u as=0.26p ps=1.52u w=1u l=0.28u
X15 a_236_340# a_172_2100# w_n40_1450# w_n40_1450# pfet_03v3 ad=0.65p pd=3.02u as=0.65p ps=3.02u w=2.5u l=0.28u
X16 a_236_340# a_172_2100# w_n40_1450# w_n40_1450# pfet_03v3 ad=0.65p pd=3.02u as=0.65p ps=3.02u w=2.5u l=0.28u
X17 w_n40_1450# a_172_2100# a_236_340# w_n40_1450# pfet_03v3 ad=0.65p pd=3.02u as=0.65p ps=3.02u w=2.5u l=0.28u
X18 a_236_340# a_172_2100# w_n40_1450# w_n40_1450# pfet_03v3 ad=0.65p pd=3.02u as=0.65p ps=3.02u w=2.5u l=0.28u
X19 a_236_340# a_172_2100# w_n40_0# w_n40_0# nfet_03v3 ad=0.26p pd=1.52u as=0.45p ps=2.9u w=1u l=0.28u
X20 w_n40_0# a_172_2100# a_236_340# w_n40_0# nfet_03v3 ad=0.26p pd=1.52u as=0.26p ps=1.52u w=1u l=0.28u
X21 a_236_340# a_172_2100# w_n40_0# w_n40_0# nfet_03v3 ad=0.26p pd=1.52u as=0.26p ps=1.52u w=1u l=0.28u
X22 w_n40_0# a_172_2100# a_236_340# w_n40_0# nfet_03v3 ad=0.45p pd=2.9u as=0.26p ps=1.52u w=1u l=0.28u
X23 a_236_340# a_172_2100# w_n40_1450# w_n40_1450# pfet_03v3 ad=0.65p pd=3.02u as=0.65p ps=3.02u w=2.5u l=0.28u
X24 w_n40_1450# a_172_2100# a_236_340# w_n40_1450# pfet_03v3 ad=1.125p pd=5.9u as=0.65p ps=3.02u w=2.5u l=0.28u
X25 w_n40_0# a_172_2100# a_236_340# w_n40_0# nfet_03v3 ad=0.26p pd=1.52u as=0.26p ps=1.52u w=1u l=0.28u
X26 a_236_340# a_172_2100# w_n40_0# w_n40_0# nfet_03v3 ad=0.26p pd=1.52u as=0.26p ps=1.52u w=1u l=0.28u
X27 a_236_340# a_172_2100# w_n40_0# w_n40_0# nfet_03v3 ad=0.26p pd=1.52u as=0.26p ps=1.52u w=1u l=0.28u
X28 a_236_340# a_172_2100# w_n40_1450# w_n40_1450# pfet_03v3 ad=0.65p pd=3.02u as=0.65p ps=3.02u w=2.5u l=0.28u
X29 w_n40_0# a_172_2100# a_236_340# w_n40_0# nfet_03v3 ad=0.26p pd=1.52u as=0.26p ps=1.52u w=1u l=0.28u
X30 w_n40_1450# a_172_2100# a_236_340# w_n40_1450# pfet_03v3 ad=0.65p pd=3.02u as=0.65p ps=3.02u w=2.5u l=0.28u
X31 a_236_340# a_172_2100# w_n40_1450# w_n40_1450# pfet_03v3 ad=0.65p pd=3.02u as=0.65p ps=3.02u w=2.5u l=0.28u
X32 a_236_340# a_172_2100# w_n40_1450# w_n40_1450# pfet_03v3 ad=0.65p pd=3.02u as=0.65p ps=3.02u w=2.5u l=0.28u
X33 w_n40_1450# a_172_2100# a_236_340# w_n40_1450# pfet_03v3 ad=0.65p pd=3.02u as=0.65p ps=3.02u w=2.5u l=0.28u
X34 w_n40_1450# a_172_2100# a_236_340# w_n40_1450# pfet_03v3 ad=0.65p pd=3.02u as=0.65p ps=3.02u w=2.5u l=0.28u
X35 a_236_340# a_172_2100# w_n40_0# w_n40_0# nfet_03v3 ad=0.26p pd=1.52u as=0.26p ps=1.52u w=1u l=0.28u
X36 a_236_340# a_172_2100# w_n40_1450# w_n40_1450# pfet_03v3 ad=0.65p pd=3.02u as=0.65p ps=3.02u w=2.5u l=0.28u
X37 w_n40_1450# a_172_2100# a_236_340# w_n40_1450# pfet_03v3 ad=0.65p pd=3.02u as=0.65p ps=3.02u w=2.5u l=0.28u
X38 w_n40_0# a_172_2100# a_236_340# w_n40_0# nfet_03v3 ad=0.26p pd=1.52u as=0.26p ps=1.52u w=1u l=0.28u
X39 a_236_340# a_172_2100# w_n40_0# w_n40_0# nfet_03v3 ad=0.26p pd=1.52u as=0.26p ps=1.52u w=1u l=0.28u
X40 a_236_340# a_172_2100# w_n40_0# w_n40_0# nfet_03v3 ad=0.26p pd=1.52u as=0.26p ps=1.52u w=1u l=0.28u
X41 w_n40_0# a_172_2100# a_236_340# w_n40_0# nfet_03v3 ad=0.26p pd=1.52u as=0.26p ps=1.52u w=1u l=0.28u
X42 a_236_340# a_172_2100# w_n40_0# w_n40_0# nfet_03v3 ad=0.26p pd=1.52u as=0.26p ps=1.52u w=1u l=0.28u
X43 w_n40_0# a_172_2100# a_236_340# w_n40_0# nfet_03v3 ad=0.26p pd=1.52u as=0.26p ps=1.52u w=1u l=0.28u
X44 w_n40_1450# a_172_2100# a_236_340# w_n40_1450# pfet_03v3 ad=0.65p pd=3.02u as=0.65p ps=3.02u w=2.5u l=0.28u
X45 w_n40_0# a_172_2100# a_236_340# w_n40_0# nfet_03v3 ad=0.26p pd=1.52u as=0.26p ps=1.52u w=1u l=0.28u
X46 a_236_340# a_172_2100# w_n40_1450# w_n40_1450# pfet_03v3 ad=0.65p pd=3.02u as=0.65p ps=3.02u w=2.5u l=0.28u
X47 w_n40_0# a_172_2100# a_236_340# w_n40_0# nfet_03v3 ad=0.26p pd=1.52u as=0.26p ps=1.52u w=1u l=0.28u
C0 w_n40_1450# a_172_2100# 6.41249f
C1 w_n40_1450# a_236_340# 7.61241f
C2 a_172_2100# a_236_340# 3.70874f
C3 a_236_340# w_n40_0# 4.9901f
C4 a_172_2100# w_n40_0# 11.37f
C5 w_n40_1450# w_n40_0# 23.932f
.ends

.subckt eeg_aclk_slow a_180_208# a_580_1540# w_n40_1450# w_n40_0#
X0 a_580_1540# a_180_208# w_n40_1450# w_n40_1450# pfet_03v3 ad=0.45p pd=2.9u as=0.45p ps=2.9u w=1u l=2u
X1 a_580_1540# a_180_208# w_n40_0# w_n40_0# nfet_03v3 ad=0.45p pd=2.9u as=0.45p ps=2.9u w=1u l=4u
C0 w_n40_1450# a_180_208# 0.84466f
C1 w_n40_1450# a_580_1540# 0.12484f
C2 a_180_208# a_580_1540# 0.37569f
C3 a_580_1540# w_n40_0# 0.66404f
C4 a_180_208# w_n40_0# 2.57374f
C5 w_n40_1450# w_n40_0# 8.99289f
.ends

.subckt eeg_aclk_inv_s1 a_236_340# w_n40_1450# w_n40_0# a_172_2100#
X0 a_236_340# a_172_2100# w_n40_1450# w_n40_1450# pfet_03v3 ad=1.125p pd=5.9u as=1.125p ps=5.9u w=2.5u l=0.28u
X1 a_236_340# a_172_2100# w_n40_0# w_n40_0# nfet_03v3 ad=0.45p pd=2.9u as=0.45p ps=2.9u w=1u l=0.28u
C0 w_n40_1450# a_172_2100# 0.24185f
C1 w_n40_1450# a_236_340# 0.36148f
C2 a_172_2100# a_236_340# 0.11095f
C3 a_236_340# w_n40_0# 0.70861f
C4 a_172_2100# w_n40_0# 0.73761f
C5 w_n40_1450# w_n40_0# 3.64095f
.ends

.subckt eeg_aclk_inv_s8 a_236_340# w_n40_1450# w_n40_0# a_172_2100#
X0 a_236_340# a_172_2100# w_n40_1450# w_n40_1450# pfet_03v3 ad=0.65p pd=3.02u as=1.125p ps=5.9u w=2.5u l=0.28u
X1 a_236_340# a_172_2100# w_n40_0# w_n40_0# nfet_03v3 ad=0.26p pd=1.52u as=0.26p ps=1.52u w=1u l=0.28u
X2 w_n40_1450# a_172_2100# a_236_340# w_n40_1450# pfet_03v3 ad=0.65p pd=3.02u as=0.65p ps=3.02u w=2.5u l=0.28u
X3 a_236_340# a_172_2100# w_n40_1450# w_n40_1450# pfet_03v3 ad=0.65p pd=3.02u as=0.65p ps=3.02u w=2.5u l=0.28u
X4 a_236_340# a_172_2100# w_n40_0# w_n40_0# nfet_03v3 ad=0.26p pd=1.52u as=0.45p ps=2.9u w=1u l=0.28u
X5 w_n40_0# a_172_2100# a_236_340# w_n40_0# nfet_03v3 ad=0.26p pd=1.52u as=0.26p ps=1.52u w=1u l=0.28u
X6 a_236_340# a_172_2100# w_n40_0# w_n40_0# nfet_03v3 ad=0.26p pd=1.52u as=0.26p ps=1.52u w=1u l=0.28u
X7 w_n40_1450# a_172_2100# a_236_340# w_n40_1450# pfet_03v3 ad=0.65p pd=3.02u as=0.65p ps=3.02u w=2.5u l=0.28u
X8 a_236_340# a_172_2100# w_n40_1450# w_n40_1450# pfet_03v3 ad=0.65p pd=3.02u as=0.65p ps=3.02u w=2.5u l=0.28u
X9 w_n40_1450# a_172_2100# a_236_340# w_n40_1450# pfet_03v3 ad=1.125p pd=5.9u as=0.65p ps=3.02u w=2.5u l=0.28u
X10 w_n40_0# a_172_2100# a_236_340# w_n40_0# nfet_03v3 ad=0.26p pd=1.52u as=0.26p ps=1.52u w=1u l=0.28u
X11 a_236_340# a_172_2100# w_n40_0# w_n40_0# nfet_03v3 ad=0.26p pd=1.52u as=0.26p ps=1.52u w=1u l=0.28u
X12 w_n40_1450# a_172_2100# a_236_340# w_n40_1450# pfet_03v3 ad=0.65p pd=3.02u as=0.65p ps=3.02u w=2.5u l=0.28u
X13 w_n40_0# a_172_2100# a_236_340# w_n40_0# nfet_03v3 ad=0.45p pd=2.9u as=0.26p ps=1.52u w=1u l=0.28u
X14 a_236_340# a_172_2100# w_n40_1450# w_n40_1450# pfet_03v3 ad=0.65p pd=3.02u as=0.65p ps=3.02u w=2.5u l=0.28u
X15 w_n40_0# a_172_2100# a_236_340# w_n40_0# nfet_03v3 ad=0.26p pd=1.52u as=0.26p ps=1.52u w=1u l=0.28u
C0 w_n40_1450# a_172_2100# 2.11923f
C1 w_n40_1450# a_236_340# 2.5575f
C2 a_172_2100# a_236_340# 1.20807f
C3 a_236_340# w_n40_0# 1.87845f
C4 a_172_2100# w_n40_0# 3.97439f
C5 w_n40_1450# w_n40_0# 9.79326f
.ends

.subckt eeg_aclk_nand2_s1 a_332_2100# a_236_340# a_236_1540# w_n40_1450# w_n40_0#
+ a_172_2100#
X0 a_236_1540# a_172_2100# w_n40_1450# w_n40_1450# pfet_03v3 ad=0.65p pd=3.02u as=1.125p ps=5.9u w=2.5u l=0.28u
X1 a_236_340# a_172_2100# w_n40_0# w_n40_0# nfet_03v3 ad=0.52p pd=2.52u as=0.9p ps=4.9u w=2u l=0.28u
X2 a_236_1540# a_332_2100# a_236_340# w_n40_0# nfet_03v3 ad=0.9p pd=4.9u as=0.52p ps=2.52u w=2u l=0.28u
X3 w_n40_1450# a_332_2100# a_236_1540# w_n40_1450# pfet_03v3 ad=1.125p pd=5.9u as=0.65p ps=3.02u w=2.5u l=0.28u
C0 w_n40_1450# a_172_2100# 0.24126f
C1 w_n40_1450# a_332_2100# 0.22005f
C2 w_n40_1450# a_236_1540# 0.68401f
C3 a_172_2100# a_332_2100# 0.19479f
C4 a_172_2100# a_236_1540# 0.0676f
C5 a_172_2100# a_236_340# 0.01535f
C6 a_332_2100# a_236_1540# 0.10552f
C7 a_332_2100# a_236_340# 0.01535f
C8 a_236_1540# a_236_340# 0.22251f
C9 a_236_340# w_n40_0# 0.2478f
C10 a_236_1540# w_n40_0# 0.52087f
C11 a_332_2100# w_n40_0# 0.4822f
C12 a_172_2100# w_n40_0# 0.4949f
C13 w_n40_1450# w_n40_0# 4.54974f
.ends

.subckt eeg_aclk_inv_s6 a_236_340# w_n40_1450# w_n40_0# a_172_2100#
X0 a_236_340# a_172_2100# w_n40_1450# w_n40_1450# pfet_03v3 ad=0.65p pd=3.02u as=1.125p ps=5.9u w=2.5u l=0.28u
X1 a_236_340# a_172_2100# w_n40_0# w_n40_0# nfet_03v3 ad=0.26p pd=1.52u as=0.26p ps=1.52u w=1u l=0.28u
X2 w_n40_1450# a_172_2100# a_236_340# w_n40_1450# pfet_03v3 ad=1.125p pd=5.9u as=0.65p ps=3.02u w=2.5u l=0.28u
X3 a_236_340# a_172_2100# w_n40_1450# w_n40_1450# pfet_03v3 ad=0.65p pd=3.02u as=0.65p ps=3.02u w=2.5u l=0.28u
X4 a_236_340# a_172_2100# w_n40_0# w_n40_0# nfet_03v3 ad=0.26p pd=1.52u as=0.45p ps=2.9u w=1u l=0.28u
X5 w_n40_0# a_172_2100# a_236_340# w_n40_0# nfet_03v3 ad=0.26p pd=1.52u as=0.26p ps=1.52u w=1u l=0.28u
X6 w_n40_1450# a_172_2100# a_236_340# w_n40_1450# pfet_03v3 ad=0.65p pd=3.02u as=0.65p ps=3.02u w=2.5u l=0.28u
X7 a_236_340# a_172_2100# w_n40_1450# w_n40_1450# pfet_03v3 ad=0.65p pd=3.02u as=0.65p ps=3.02u w=2.5u l=0.28u
X8 w_n40_0# a_172_2100# a_236_340# w_n40_0# nfet_03v3 ad=0.26p pd=1.52u as=0.26p ps=1.52u w=1u l=0.28u
X9 a_236_340# a_172_2100# w_n40_0# w_n40_0# nfet_03v3 ad=0.26p pd=1.52u as=0.26p ps=1.52u w=1u l=0.28u
X10 w_n40_1450# a_172_2100# a_236_340# w_n40_1450# pfet_03v3 ad=0.65p pd=3.02u as=0.65p ps=3.02u w=2.5u l=0.28u
X11 w_n40_0# a_172_2100# a_236_340# w_n40_0# nfet_03v3 ad=0.45p pd=2.9u as=0.26p ps=1.52u w=1u l=0.28u
C0 w_n40_1450# a_172_2100# 1.58159f
C1 w_n40_1450# a_236_340# 1.92516f
C2 a_172_2100# a_236_340# 0.89548f
C3 a_236_340# w_n40_0# 1.48949f
C4 a_172_2100# w_n40_0# 3.04994f
C5 w_n40_1450# w_n40_0# 8.03956f
.ends

.subckt eeg_aclk_inv_s48 a_492_2060# a_556_400# w_n40_0# w_n40_2270#
X0 a_556_400# a_492_2060# w_n40_2270# w_n40_2270# pfet_03v3 ad=2.6p pd=10.52u as=2.6p ps=10.52u w=10u l=0.28u
X1 a_556_400# a_492_2060# w_n40_0# w_n40_0# nfet_03v3 ad=2.08p pd=8.52u as=3.6p ps=16.9u w=8u l=0.28u
X2 w_n40_2270# a_492_2060# a_556_400# w_n40_2270# pfet_03v3 ad=2.6p pd=10.52u as=2.6p ps=10.52u w=10u l=0.28u
X3 a_556_400# a_492_2060# w_n40_2270# w_n40_2270# pfet_03v3 ad=2.6p pd=10.52u as=2.6p ps=10.52u w=10u l=0.28u
X4 a_556_400# a_492_2060# w_n40_2270# w_n40_2270# pfet_03v3 ad=2.6p pd=10.52u as=2.6p ps=10.52u w=10u l=0.28u
X5 w_n40_2270# a_492_2060# a_556_400# w_n40_2270# pfet_03v3 ad=2.6p pd=10.52u as=2.6p ps=10.52u w=10u l=0.28u
X6 w_n40_0# a_492_2060# a_556_400# w_n40_0# nfet_03v3 ad=2.08p pd=8.52u as=2.08p ps=8.52u w=8u l=0.28u
X7 a_556_400# a_492_2060# w_n40_0# w_n40_0# nfet_03v3 ad=2.08p pd=8.52u as=2.08p ps=8.52u w=8u l=0.28u
X8 w_n40_2270# a_492_2060# a_556_400# w_n40_2270# pfet_03v3 ad=2.6p pd=10.52u as=2.6p ps=10.52u w=10u l=0.28u
X9 a_556_400# a_492_2060# w_n40_2270# w_n40_2270# pfet_03v3 ad=2.6p pd=10.52u as=2.6p ps=10.52u w=10u l=0.28u
X10 a_556_400# a_492_2060# w_n40_2270# w_n40_2270# pfet_03v3 ad=2.6p pd=10.52u as=4.5p ps=20.9u w=10u l=0.28u
X11 w_n40_2270# a_492_2060# a_556_400# w_n40_2270# pfet_03v3 ad=2.6p pd=10.52u as=2.6p ps=10.52u w=10u l=0.28u
X12 a_556_400# a_492_2060# w_n40_0# w_n40_0# nfet_03v3 ad=2.08p pd=8.52u as=2.08p ps=8.52u w=8u l=0.28u
X13 w_n40_0# a_492_2060# a_556_400# w_n40_0# nfet_03v3 ad=3.6p pd=16.9u as=2.08p ps=8.52u w=8u l=0.28u
X14 w_n40_0# a_492_2060# a_556_400# w_n40_0# nfet_03v3 ad=2.08p pd=8.52u as=2.08p ps=8.52u w=8u l=0.28u
X15 a_556_400# a_492_2060# w_n40_2270# w_n40_2270# pfet_03v3 ad=2.6p pd=10.52u as=2.6p ps=10.52u w=10u l=0.28u
X16 w_n40_2270# a_492_2060# a_556_400# w_n40_2270# pfet_03v3 ad=2.6p pd=10.52u as=2.6p ps=10.52u w=10u l=0.28u
X17 w_n40_2270# a_492_2060# a_556_400# w_n40_2270# pfet_03v3 ad=4.5p pd=20.9u as=2.6p ps=10.52u w=10u l=0.28u
C0 w_n40_2270# a_492_2060# 2.78917f
C1 w_n40_2270# a_556_400# 15.4853f
C2 a_492_2060# a_556_400# 3.3463f
C3 a_556_400# w_n40_0# 6.90246f
C4 a_492_2060# w_n40_0# 2.88475f
C5 w_n40_2270# w_n40_0# 20.5942f
.ends

.subckt eeg_aclk_inv_s2 a_236_340# w_n40_1450# w_n40_0# a_172_2100#
X0 a_236_340# a_172_2100# w_n40_1450# w_n40_1450# pfet_03v3 ad=0.65p pd=3.02u as=1.125p ps=5.9u w=2.5u l=0.28u
X1 a_236_340# a_172_2100# w_n40_0# w_n40_0# nfet_03v3 ad=0.26p pd=1.52u as=0.45p ps=2.9u w=1u l=0.28u
X2 w_n40_0# a_172_2100# a_236_340# w_n40_0# nfet_03v3 ad=0.45p pd=2.9u as=0.26p ps=1.52u w=1u l=0.28u
X3 w_n40_1450# a_172_2100# a_236_340# w_n40_1450# pfet_03v3 ad=1.125p pd=5.9u as=0.65p ps=3.02u w=2.5u l=0.28u
C0 w_n40_1450# a_172_2100# 0.5035f
C1 w_n40_1450# a_236_340# 0.65873f
C2 a_172_2100# a_236_340# 0.27031f
C3 a_236_340# w_n40_0# 0.71158f
C4 a_172_2100# w_n40_0# 1.20104f
C5 w_n40_1450# w_n40_0# 4.55854f
.ends

.subckt eeg_aclk_inv_s12 a_236_340# w_n40_1450# w_n40_0# a_172_2100#
X0 w_n40_1450# a_172_2100# a_236_340# w_n40_1450# pfet_03v3 ad=1.125p pd=5.9u as=0.65p ps=3.02u w=2.5u l=0.28u
X1 a_236_340# a_172_2100# w_n40_0# w_n40_0# nfet_03v3 ad=0.26p pd=1.52u as=0.26p ps=1.52u w=1u l=0.28u
X2 w_n40_0# a_172_2100# a_236_340# w_n40_0# nfet_03v3 ad=0.45p pd=2.9u as=0.26p ps=1.52u w=1u l=0.28u
X3 a_236_340# a_172_2100# w_n40_1450# w_n40_1450# pfet_03v3 ad=0.65p pd=3.02u as=1.125p ps=5.9u w=2.5u l=0.28u
X4 a_236_340# a_172_2100# w_n40_0# w_n40_0# nfet_03v3 ad=0.26p pd=1.52u as=0.26p ps=1.52u w=1u l=0.28u
X5 w_n40_1450# a_172_2100# a_236_340# w_n40_1450# pfet_03v3 ad=0.65p pd=3.02u as=0.65p ps=3.02u w=2.5u l=0.28u
X6 a_236_340# a_172_2100# w_n40_1450# w_n40_1450# pfet_03v3 ad=0.65p pd=3.02u as=0.65p ps=3.02u w=2.5u l=0.28u
X7 a_236_340# a_172_2100# w_n40_1450# w_n40_1450# pfet_03v3 ad=0.65p pd=3.02u as=0.65p ps=3.02u w=2.5u l=0.28u
X8 w_n40_1450# a_172_2100# a_236_340# w_n40_1450# pfet_03v3 ad=0.65p pd=3.02u as=0.65p ps=3.02u w=2.5u l=0.28u
X9 a_236_340# a_172_2100# w_n40_0# w_n40_0# nfet_03v3 ad=0.26p pd=1.52u as=0.45p ps=2.9u w=1u l=0.28u
X10 w_n40_0# a_172_2100# a_236_340# w_n40_0# nfet_03v3 ad=0.26p pd=1.52u as=0.26p ps=1.52u w=1u l=0.28u
X11 a_236_340# a_172_2100# w_n40_0# w_n40_0# nfet_03v3 ad=0.26p pd=1.52u as=0.26p ps=1.52u w=1u l=0.28u
X12 w_n40_0# a_172_2100# a_236_340# w_n40_0# nfet_03v3 ad=0.26p pd=1.52u as=0.26p ps=1.52u w=1u l=0.28u
X13 w_n40_1450# a_172_2100# a_236_340# w_n40_1450# pfet_03v3 ad=0.65p pd=3.02u as=0.65p ps=3.02u w=2.5u l=0.28u
X14 a_236_340# a_172_2100# w_n40_1450# w_n40_1450# pfet_03v3 ad=0.65p pd=3.02u as=0.65p ps=3.02u w=2.5u l=0.28u
X15 a_236_340# a_172_2100# w_n40_1450# w_n40_1450# pfet_03v3 ad=0.65p pd=3.02u as=0.65p ps=3.02u w=2.5u l=0.28u
X16 w_n40_1450# a_172_2100# a_236_340# w_n40_1450# pfet_03v3 ad=0.65p pd=3.02u as=0.65p ps=3.02u w=2.5u l=0.28u
X17 a_236_340# a_172_2100# w_n40_0# w_n40_0# nfet_03v3 ad=0.26p pd=1.52u as=0.26p ps=1.52u w=1u l=0.28u
X18 w_n40_0# a_172_2100# a_236_340# w_n40_0# nfet_03v3 ad=0.26p pd=1.52u as=0.26p ps=1.52u w=1u l=0.28u
X19 a_236_340# a_172_2100# w_n40_0# w_n40_0# nfet_03v3 ad=0.26p pd=1.52u as=0.26p ps=1.52u w=1u l=0.28u
X20 w_n40_1450# a_172_2100# a_236_340# w_n40_1450# pfet_03v3 ad=0.65p pd=3.02u as=0.65p ps=3.02u w=2.5u l=0.28u
X21 w_n40_0# a_172_2100# a_236_340# w_n40_0# nfet_03v3 ad=0.26p pd=1.52u as=0.26p ps=1.52u w=1u l=0.28u
X22 a_236_340# a_172_2100# w_n40_1450# w_n40_1450# pfet_03v3 ad=0.65p pd=3.02u as=0.65p ps=3.02u w=2.5u l=0.28u
X23 w_n40_0# a_172_2100# a_236_340# w_n40_0# nfet_03v3 ad=0.26p pd=1.52u as=0.26p ps=1.52u w=1u l=0.28u
C0 w_n40_1450# a_172_2100# 3.19307f
C1 w_n40_1450# a_236_340# 3.82147f
C2 a_172_2100# a_236_340# 1.83323f
C3 a_236_340# w_n40_0# 2.65636f
C4 a_172_2100# w_n40_0# 5.82329f
C5 w_n40_1450# w_n40_0# 13.326f
.ends

.subckt eeg_aclk_nor2_s1 a_172_2600# a_236_340# a_332_2600# a_236_1540# w_n40_1450#
+ w_n40_0#
X0 a_236_1540# a_172_2600# w_n40_1450# w_n40_1450# pfet_03v3 ad=1.3p pd=5.52u as=2.25p ps=10.9u w=5u l=0.28u
X1 a_236_340# a_172_2600# w_n40_0# w_n40_0# nfet_03v3 ad=0.26p pd=1.52u as=0.45p ps=2.9u w=1u l=0.28u
X2 w_n40_0# a_332_2600# a_236_340# w_n40_0# nfet_03v3 ad=0.45p pd=2.9u as=0.26p ps=1.52u w=1u l=0.28u
X3 a_236_340# a_332_2600# a_236_1540# w_n40_1450# pfet_03v3 ad=2.25p pd=10.9u as=1.3p ps=5.52u w=5u l=0.28u
C0 w_n40_1450# a_172_2600# 0.2457f
C1 w_n40_1450# a_332_2600# 0.18148f
C2 w_n40_1450# a_236_1540# 0.58974f
C3 w_n40_1450# a_236_340# 0.1284f
C4 a_172_2600# a_332_2600# 0.22013f
C5 a_172_2600# a_236_1540# 0.04231f
C6 a_172_2600# a_236_340# 0.07713f
C7 a_332_2600# a_236_1540# 0.04231f
C8 a_332_2600# a_236_340# 0.13632f
C9 a_236_1540# a_236_340# 0.56752f
C10 a_236_340# w_n40_0# 0.87132f
C11 a_236_1540# w_n40_0# 0.00424f
C12 a_332_2600# w_n40_0# 0.60335f
C13 a_172_2600# w_n40_0# 0.59801f
C14 w_n40_1450# w_n40_0# 4.47878f
.ends

.subckt eeg_aclk_inv_s10 a_236_340# w_n40_1450# w_n40_0# a_172_2100#
X0 a_236_340# a_172_2100# w_n40_0# w_n40_0# nfet_03v3 ad=0.26p pd=1.52u as=0.26p ps=1.52u w=1u l=0.28u
X1 a_236_340# a_172_2100# w_n40_1450# w_n40_1450# pfet_03v3 ad=0.65p pd=3.02u as=1.125p ps=5.9u w=2.5u l=0.28u
X2 a_236_340# a_172_2100# w_n40_0# w_n40_0# nfet_03v3 ad=0.26p pd=1.52u as=0.26p ps=1.52u w=1u l=0.28u
X3 w_n40_1450# a_172_2100# a_236_340# w_n40_1450# pfet_03v3 ad=0.65p pd=3.02u as=0.65p ps=3.02u w=2.5u l=0.28u
X4 a_236_340# a_172_2100# w_n40_1450# w_n40_1450# pfet_03v3 ad=0.65p pd=3.02u as=0.65p ps=3.02u w=2.5u l=0.28u
X5 w_n40_1450# a_172_2100# a_236_340# w_n40_1450# pfet_03v3 ad=1.125p pd=5.9u as=0.65p ps=3.02u w=2.5u l=0.28u
X6 a_236_340# a_172_2100# w_n40_0# w_n40_0# nfet_03v3 ad=0.26p pd=1.52u as=0.45p ps=2.9u w=1u l=0.28u
X7 w_n40_0# a_172_2100# a_236_340# w_n40_0# nfet_03v3 ad=0.26p pd=1.52u as=0.26p ps=1.52u w=1u l=0.28u
X8 a_236_340# a_172_2100# w_n40_0# w_n40_0# nfet_03v3 ad=0.26p pd=1.52u as=0.26p ps=1.52u w=1u l=0.28u
X9 w_n40_0# a_172_2100# a_236_340# w_n40_0# nfet_03v3 ad=0.45p pd=2.9u as=0.26p ps=1.52u w=1u l=0.28u
X10 w_n40_1450# a_172_2100# a_236_340# w_n40_1450# pfet_03v3 ad=0.65p pd=3.02u as=0.65p ps=3.02u w=2.5u l=0.28u
X11 a_236_340# a_172_2100# w_n40_1450# w_n40_1450# pfet_03v3 ad=0.65p pd=3.02u as=0.65p ps=3.02u w=2.5u l=0.28u
X12 a_236_340# a_172_2100# w_n40_1450# w_n40_1450# pfet_03v3 ad=0.65p pd=3.02u as=0.65p ps=3.02u w=2.5u l=0.28u
X13 w_n40_1450# a_172_2100# a_236_340# w_n40_1450# pfet_03v3 ad=0.65p pd=3.02u as=0.65p ps=3.02u w=2.5u l=0.28u
X14 w_n40_0# a_172_2100# a_236_340# w_n40_0# nfet_03v3 ad=0.26p pd=1.52u as=0.26p ps=1.52u w=1u l=0.28u
X15 a_236_340# a_172_2100# w_n40_0# w_n40_0# nfet_03v3 ad=0.26p pd=1.52u as=0.26p ps=1.52u w=1u l=0.28u
X16 w_n40_1450# a_172_2100# a_236_340# w_n40_1450# pfet_03v3 ad=0.65p pd=3.02u as=0.65p ps=3.02u w=2.5u l=0.28u
X17 w_n40_0# a_172_2100# a_236_340# w_n40_0# nfet_03v3 ad=0.26p pd=1.52u as=0.26p ps=1.52u w=1u l=0.28u
X18 a_236_340# a_172_2100# w_n40_1450# w_n40_1450# pfet_03v3 ad=0.65p pd=3.02u as=0.65p ps=3.02u w=2.5u l=0.28u
X19 w_n40_0# a_172_2100# a_236_340# w_n40_0# nfet_03v3 ad=0.26p pd=1.52u as=0.26p ps=1.52u w=1u l=0.28u
C0 w_n40_1450# a_172_2100# 2.6565f
C1 w_n40_1450# a_236_340# 3.18965f
C2 a_172_2100# a_236_340# 1.52065f
C3 a_236_340# w_n40_0# 2.26741f
C4 a_172_2100# w_n40_0# 4.89884f
C5 w_n40_1450# w_n40_0# 11.5584f
.ends

.subckt eeg_adc_clk CHOP1 CIA NCIA CIB NCIB CDA NCDA CDB NCDB VDD VSS
Xeeg_aclk_inv_s24_0 CDB VDD VSS m2_22100_5122# eeg_aclk_inv_s24
Xeeg_aclk_inv_s24_1 CDA VDD VSS m2_12660_5122# eeg_aclk_inv_s24
Xeeg_aclk_inv_s24_2 NCIB VDD VSS m2_6260_5122# eeg_aclk_inv_s24
Xeeg_aclk_inv_s24_3 NCIA VDD VSS m2_22100_1182# eeg_aclk_inv_s24
Xeeg_aclk_slow_0 m2_11060_1182# m2_11860_1182# VDD VSS eeg_aclk_slow
Xeeg_aclk_slow_1 m2_11860_1182# m2_13780_1182# VDD VSS eeg_aclk_slow
Xeeg_aclk_slow_2 m2_1620_1182# m2_10420_1182# VDD VSS eeg_aclk_slow
Xeeg_aclk_slow_3 m2_5300_1182# m2_7220_1182# VDD VSS eeg_aclk_slow
Xeeg_aclk_inv_s1_0 m2_27220_5122# VDD VSS m2_9140_1182# eeg_aclk_inv_s1
Xeeg_aclk_inv_s1_1 m2_17780_5122# VDD VSS m2_8020_1182# eeg_aclk_inv_s1
Xeeg_aclk_slow_5 m2_2420_1182# m2_3860_1182# VDD VSS eeg_aclk_slow
Xeeg_aclk_slow_4 m2_3860_1182# m2_5300_1182# VDD VSS eeg_aclk_slow
Xeeg_aclk_slow_6 m2_1620_1182# m2_2420_1182# VDD VSS eeg_aclk_slow
Xeeg_aclk_inv_s1_2 m2_4500_5122# VDD VSS m2_4500_4196# eeg_aclk_inv_s1
Xeeg_aclk_inv_s1_3 m2_9140_1182# VDD VSS m2_8660_1182# eeg_aclk_inv_s1
Xeeg_aclk_inv_s1_4 m2_11060_1182# VDD VSS m2_10420_1182# eeg_aclk_inv_s1
Xeeg_aclk_inv_s1_5 m2_4500_4196# VDD VSS m2_15220_1182# eeg_aclk_inv_s1
Xeeg_aclk_inv_s1_6 m2_20340_1182# VDD VSS m2_14420_1182# eeg_aclk_inv_s1
Xeeg_aclk_inv_s8_0 m2_6260_5122# VDD VSS m2_5140_5122# eeg_aclk_inv_s8
Xeeg_aclk_inv_s1_7 m2_980_1182# VDD VSS CHOP1 eeg_aclk_inv_s1
Xeeg_aclk_inv_s8_2 m2_22100_5122# VDD VSS m2_20980_5122# eeg_aclk_inv_s8
Xeeg_aclk_inv_s8_1 m2_12660_5122# VDD VSS m2_11540_5122# eeg_aclk_inv_s8
Xeeg_aclk_nand2_s1_0 m2_1620_1182# eeg_aclk_nand2_s1_0/a_236_340# m2_8660_1182# VDD
+ VSS m2_7220_1182# eeg_aclk_nand2_s1
Xeeg_aclk_inv_s8_3 m2_22100_1182# VDD VSS m2_20980_1182# eeg_aclk_inv_s8
Xeeg_aclk_nand2_s1_1 m2_11060_1182# eeg_aclk_nand2_s1_1/a_236_340# m2_14420_1182#
+ VDD VSS m2_13780_1182# eeg_aclk_nand2_s1
Xeeg_aclk_inv_s6_0 m2_1460_5122# VDD VSS m2_1780_4196# eeg_aclk_inv_s6
Xeeg_aclk_inv_s48_0 m2_1780_7542# NCDB VSS VDD eeg_aclk_inv_s48
Xeeg_aclk_inv_s48_1 m2_3060_12092# NCDA VSS VDD eeg_aclk_inv_s48
Xeeg_aclk_inv_s6_1 m2_17300_1182# VDD VSS m2_16340_1182# eeg_aclk_inv_s6
Xeeg_aclk_inv_s2_0 m2_11540_5122# VDD VSS m2_8020_1182# eeg_aclk_inv_s2
Xeeg_aclk_inv_s2_1 m2_5140_5122# VDD VSS m2_4500_5122# eeg_aclk_inv_s2
Xeeg_aclk_inv_s2_2 m2_18420_5122# VDD VSS m2_17780_5122# eeg_aclk_inv_s2
Xeeg_aclk_inv_s12_0 CIB VDD VSS m2_1460_5122# eeg_aclk_inv_s12
Xeeg_aclk_inv_s12_1 CIA VDD VSS m2_17300_1182# eeg_aclk_inv_s12
Xeeg_aclk_inv_s2_3 m2_20980_5122# VDD VSS m2_9140_1182# eeg_aclk_inv_s2
Xeeg_aclk_nor2_s1_0 m2_1620_1182# m2_8020_1182# m2_7220_1182# eeg_aclk_nor2_s1_0/a_236_1540#
+ VDD VSS eeg_aclk_nor2_s1
Xeeg_aclk_inv_s2_4 m2_2260_8468# VDD VSS m2_27220_5122# eeg_aclk_inv_s2
Xeeg_aclk_nor2_s1_1 m2_11060_1182# m2_15220_1182# m2_13780_1182# eeg_aclk_nor2_s1_1/a_236_1540#
+ VDD VSS eeg_aclk_nor2_s1
Xeeg_aclk_inv_s2_5 m2_1780_4196# VDD VSS m2_4500_4196# eeg_aclk_inv_s2
Xeeg_aclk_inv_s10_0 m2_3060_12092# VDD VSS m2_18420_5122# eeg_aclk_inv_s10
Xeeg_aclk_inv_s2_6 m2_20980_1182# VDD VSS m2_20340_1182# eeg_aclk_inv_s2
Xeeg_aclk_inv_s10_1 m2_1780_7542# VDD VSS m2_2260_8468# eeg_aclk_inv_s10
Xeeg_aclk_inv_s2_7 m2_16340_1182# VDD VSS m2_14420_1182# eeg_aclk_inv_s2
Xeeg_aclk_inv_s2_8 m2_1620_1182# VDD VSS m2_980_1182# eeg_aclk_inv_s2
C0 m2_22100_5122# CDB 0.22813f
C1 m2_22100_5122# NCIA 0.76994f
C2 m2_22100_5122# m2_9140_1182# 0.35065f
C3 m2_22100_5122# m2_20980_5122# 0.32878f
C4 m2_22100_5122# m2_27220_5122# 0.02114f
C5 m2_22100_5122# m2_2260_8468# 0.04662f
C6 m2_22100_5122# VDD 0.23914f
C7 CDB NCIA 0.20635f
C8 CDB m2_9140_1182# 0.09128f
C9 CDB m2_20980_5122# 0.00952f
C10 CDB NCDB 0.07079f
C11 CDB m2_27220_5122# 0.11047f
C12 CDB m2_2260_8468# 0.09782f
C13 CDB VDD 0.63494f
C14 m2_12660_5122# CDA 0.22876f
C15 m2_12660_5122# NCIB 0.62463f
C16 m2_12660_5122# NCIA 0.19844f
C17 m2_12660_5122# m2_13780_1182# 0
C18 m2_12660_5122# m2_9140_1182# 0.05902f
C19 m2_12660_5122# m2_11060_1182# 0
C20 m2_12660_5122# m2_11540_5122# 0.32283f
C21 m2_12660_5122# m2_17780_5122# 0.02094f
C22 m2_12660_5122# CIB 0.01577f
C23 m2_12660_5122# CIA 0.03996f
C24 m2_12660_5122# m2_8020_1182# 0.42091f
C25 m2_12660_5122# m2_2260_8468# 0.03314f
C26 m2_12660_5122# VDD 0.27721f
C27 CDA NCIB 0.15038f
C28 CDA NCIA 0.35787f
C29 CDA m2_13780_1182# 0
C30 CDA m2_9140_1182# 0
C31 CDA m2_11060_1182# 0
C32 CDA m2_11540_5122# 0.00557f
C33 CDA NCDB 0.06655f
C34 CDA NCDA 0.06246f
C35 CDA m2_17780_5122# 0.17898f
C36 CDA CIA 0
C37 CDA m2_8020_1182# 0.1344f
C38 CDA m2_2260_8468# 0.08918f
C39 CDA m2_18420_5122# 0.01888f
C40 CDA m2_3060_12092# 0.06865f
C41 CDA VDD 0.6581f
C42 m2_6260_5122# NCIB 0.20823f
C43 m2_6260_5122# NCIA 0.11353f
C44 m2_6260_5122# m2_7220_1182# 0.00467f
C45 m2_6260_5122# m2_9140_1182# 0.02292f
C46 m2_6260_5122# m2_5140_5122# 0.32354f
C47 m2_6260_5122# m2_11540_5122# 0.0116f
C48 m2_6260_5122# m2_4500_5122# 0.00676f
C49 m2_6260_5122# CIB 0.4861f
C50 m2_6260_5122# CIA 0.2557f
C51 m2_6260_5122# m2_8020_1182# 0.04454f
C52 m2_6260_5122# m2_2260_8468# 0.0362f
C53 m2_6260_5122# VDD 0.29279f
C54 m2_6260_5122# m2_1620_1182# 0
C55 NCIB NCIA 0.94272f
C56 NCIB m2_7220_1182# 0
C57 NCIB m2_9140_1182# 0.04527f
C58 NCIB m2_5140_5122# 0.00557f
C59 NCIB m2_11540_5122# 0.41121f
C60 NCIB NCDB 0.06655f
C61 NCIB NCDA 0.06246f
C62 NCIB CIB 0.55931f
C63 NCIB CIA 0.05632f
C64 NCIB m2_8020_1182# 0.11902f
C65 NCIB m2_2260_8468# 0.09039f
C66 NCIB m2_3060_12092# 0.06655f
C67 NCIB VDD 0.69631f
C68 NCIB m2_1620_1182# 0
C69 NCIA m2_9140_1182# 0.22505f
C70 NCIA m2_4500_4196# 0.21586f
C71 NCIA m2_20980_5122# 0.17412f
C72 NCIA m2_11540_5122# 0.04806f
C73 NCIA m2_22100_1182# 0.64956f
C74 NCIA NCDB 0.06655f
C75 NCIA NCDA 0.06246f
C76 NCIA m2_17780_5122# 0.08421f
C77 NCIA CIB 1.38436f
C78 NCIA m2_8020_1182# 0.16068f
C79 NCIA m2_2260_8468# 0.81316f
C80 NCIA m2_1780_4196# 0.38672f
C81 NCIA m2_18420_5122# 0.1865f
C82 NCIA m2_3060_12092# 0.23933f
C83 NCIA m2_20980_1182# 0.00558f
C84 NCIA VDD 1.52663f
C85 m2_11860_1182# m2_13780_1182# 0.31974f
C86 m2_11860_1182# m2_9140_1182# 0
C87 m2_11860_1182# m2_10420_1182# 0.0021f
C88 m2_11860_1182# m2_11060_1182# 0.32273f
C89 m2_11860_1182# m2_4500_4196# 0.67509f
C90 m2_11860_1182# m2_14420_1182# 0.03661f
C91 m2_11860_1182# eeg_aclk_nand2_s1_1/a_236_340# 0.0042f
C92 m2_11860_1182# m2_8020_1182# 0.09349f
C93 m2_11860_1182# eeg_aclk_nor2_s1_1/a_236_1540# 0
C94 m2_11860_1182# m2_15220_1182# 0.00262f
C95 m2_11860_1182# m2_1780_4196# 0.66962f
C96 m2_11860_1182# VDD 0.14282f
C97 m2_11860_1182# m2_1620_1182# 0
C98 m2_13780_1182# m2_9140_1182# 0
C99 m2_13780_1182# m2_11060_1182# 0.53341f
C100 m2_13780_1182# m2_4500_4196# 0.08034f
C101 m2_13780_1182# m2_14420_1182# 0.2024f
C102 m2_13780_1182# eeg_aclk_nand2_s1_1/a_236_340# 0
C103 m2_13780_1182# CIA 0.08417f
C104 m2_13780_1182# m2_8020_1182# 0
C105 m2_13780_1182# eeg_aclk_nor2_s1_1/a_236_1540# 0.01193f
C106 m2_13780_1182# m2_15220_1182# 0.09832f
C107 m2_13780_1182# m2_1780_4196# 0.05495f
C108 m2_13780_1182# VDD 0.57886f
C109 m2_7220_1182# m2_3860_1182# 0.01362f
C110 m2_7220_1182# m2_5300_1182# 0.31147f
C111 m2_7220_1182# m2_9140_1182# 0
C112 m2_7220_1182# m2_4500_4196# 0.10233f
C113 m2_7220_1182# m2_8660_1182# 0.04023f
C114 m2_7220_1182# eeg_aclk_nand2_s1_0/a_236_340# 0
C115 m2_7220_1182# CIA 0.09294f
C116 m2_7220_1182# eeg_aclk_nor2_s1_0/a_236_1540# 0.01378f
C117 m2_7220_1182# m2_8020_1182# 0.12212f
C118 m2_7220_1182# m2_1780_4196# 0.05371f
C119 m2_7220_1182# VDD 0.61609f
C120 m2_7220_1182# m2_1620_1182# 0.74632f
C121 m2_3860_1182# m2_5300_1182# 0.28093f
C122 m2_3860_1182# m2_2420_1182# 0.24988f
C123 m2_3860_1182# m2_4500_4196# 0.487f
C124 m2_3860_1182# m2_1780_4196# 0.66426f
C125 m2_3860_1182# VDD 0.18051f
C126 m2_3860_1182# m2_1620_1182# 0.08116f
C127 m2_5300_1182# m2_2420_1182# 0.01349f
C128 m2_5300_1182# m2_4500_4196# 0.70878f
C129 m2_5300_1182# m2_8660_1182# 0.00374f
C130 m2_5300_1182# eeg_aclk_nand2_s1_0/a_236_340# 0.00107f
C131 m2_5300_1182# eeg_aclk_nor2_s1_0/a_236_1540# 0.00351f
C132 m2_5300_1182# m2_8020_1182# 0.03025f
C133 m2_5300_1182# m2_1780_4196# 0.66691f
C134 m2_5300_1182# VDD 0.13266f
C135 m2_5300_1182# m2_1620_1182# 0.04634f
C136 m2_2420_1182# m2_4500_4196# 0.18163f
C137 m2_2420_1182# CHOP1 0.00562f
C138 m2_2420_1182# m2_980_1182# 0.00435f
C139 m2_2420_1182# m2_1780_4196# 0.69292f
C140 m2_2420_1182# VDD 0.19125f
C141 m2_2420_1182# m2_1620_1182# 0.31926f
C142 m2_9140_1182# m2_10420_1182# 0.53047f
C143 m2_9140_1182# m2_11060_1182# 0.00687f
C144 m2_9140_1182# m2_4500_4196# 0.50633f
C145 m2_9140_1182# m2_20980_5122# 0.19213f
C146 m2_9140_1182# m2_11540_5122# 0.02656f
C147 m2_9140_1182# m2_8660_1182# 0.27928f
C148 m2_9140_1182# m2_17780_5122# 0.0777f
C149 m2_9140_1182# CIA 1.87194f
C150 m2_9140_1182# eeg_aclk_nor2_s1_0/a_236_1540# 0
C151 m2_9140_1182# m2_8020_1182# 3.0266f
C152 m2_9140_1182# m2_27220_5122# 0.10016f
C153 m2_9140_1182# m2_2260_8468# 0.00801f
C154 m2_9140_1182# m2_1780_4196# 0.01898f
C155 m2_9140_1182# m2_18420_5122# 0.17855f
C156 m2_9140_1182# m2_3060_12092# 0.04405f
C157 m2_9140_1182# VDD 2.8491f
C158 m2_9140_1182# m2_1620_1182# 0.20018f
C159 m2_10420_1182# m2_11060_1182# 0.15827f
C160 m2_10420_1182# m2_4500_4196# 0.08436f
C161 m2_10420_1182# m2_8660_1182# 0.00804f
C162 m2_10420_1182# CIA 0
C163 m2_10420_1182# m2_8020_1182# 0.13504f
C164 m2_10420_1182# m2_1780_4196# 0.03401f
C165 m2_10420_1182# VDD 0.2397f
C166 m2_10420_1182# m2_1620_1182# 0.14603f
C167 m2_11060_1182# m2_4500_4196# 1.61884f
C168 m2_11060_1182# m2_14420_1182# 0.49423f
C169 m2_11060_1182# eeg_aclk_nand2_s1_1/a_236_340# 0
C170 m2_11060_1182# CIA 0
C171 m2_11060_1182# m2_8020_1182# 0.39069f
C172 m2_11060_1182# eeg_aclk_nor2_s1_1/a_236_1540# 0.02051f
C173 m2_11060_1182# m2_15220_1182# 0.14382f
C174 m2_11060_1182# m2_1780_4196# 0.08705f
C175 m2_11060_1182# m2_16340_1182# 0
C176 m2_11060_1182# VDD 0.80311f
C177 m2_11060_1182# m2_1620_1182# 0.04206f
C178 m2_4500_4196# m2_20340_1182# 0.30594f
C179 m2_4500_4196# m2_5140_5122# 0
C180 m2_4500_4196# m2_8660_1182# 0.15021f
C181 m2_4500_4196# m2_22100_1182# 0.41387f
C182 m2_4500_4196# m2_14420_1182# 1.23109f
C183 m2_4500_4196# m2_17300_1182# 0.33645f
C184 m2_4500_4196# m2_4500_5122# 0.0916f
C185 m2_4500_4196# m2_1460_5122# 0.04384f
C186 m2_4500_4196# CIB 0.01292f
C187 m2_4500_4196# CIA 0.15839f
C188 m2_4500_4196# eeg_aclk_nor2_s1_0/a_236_1540# 0.00699f
C189 m2_4500_4196# m2_8020_1182# 1.59797f
C190 m2_4500_4196# m2_2260_8468# 0.0014f
C191 m2_4500_4196# eeg_aclk_nor2_s1_1/a_236_1540# 0.00365f
C192 m2_4500_4196# m2_15220_1182# 0.31409f
C193 m2_4500_4196# m2_1780_4196# 1.94844f
C194 m2_4500_4196# m2_20980_1182# 0.18596f
C195 m2_4500_4196# m2_16340_1182# 0.34064f
C196 m2_4500_4196# VDD 2.49132f
C197 m2_4500_4196# m2_1620_1182# 0.42035f
C198 m2_20340_1182# m2_22100_1182# 0.00676f
C199 m2_20340_1182# m2_14420_1182# 0.08443f
C200 m2_20340_1182# m2_17300_1182# 0.02111f
C201 m2_20340_1182# CIA 0.11051f
C202 m2_20340_1182# m2_1780_4196# 0.11873f
C203 m2_20340_1182# m2_20980_1182# 0.30296f
C204 m2_20340_1182# VDD 0.34628f
C205 m2_5140_5122# m2_4500_5122# 0.21046f
C206 m2_5140_5122# m2_1460_5122# 0
C207 m2_5140_5122# CIB 0.21257f
C208 m2_5140_5122# CIA 0.56947f
C209 m2_5140_5122# m2_2260_8468# 0.01308f
C210 m2_5140_5122# VDD 0.2046f
C211 CHOP1 m2_980_1182# 0.22011f
C212 CHOP1 NCDA 1.52347f
C213 CHOP1 m2_1460_5122# 0.47752f
C214 CHOP1 CIB 0.18226f
C215 CHOP1 m2_2260_8468# 0.72966f
C216 CHOP1 m2_1780_4196# 0.29024f
C217 CHOP1 m2_3060_12092# 0.30507f
C218 CHOP1 m2_1780_7542# 0.34041f
C219 CHOP1 VDD 1.51006f
C220 CHOP1 m2_1620_1182# 0.2776f
C221 m2_980_1182# m2_1780_4196# 0.0728f
C222 m2_980_1182# VDD 0.31854f
C223 m2_980_1182# m2_1620_1182# 0.36391f
C224 m2_20980_5122# m2_2260_8468# 0.01092f
C225 m2_20980_5122# m2_18420_5122# 0.01173f
C226 m2_20980_5122# m2_3060_12092# 0.11048f
C227 m2_20980_5122# VDD 0.26793f
C228 m2_11540_5122# CIB 0.06745f
C229 m2_11540_5122# CIA 0.01331f
C230 m2_11540_5122# m2_8020_1182# 0.23575f
C231 m2_11540_5122# m2_2260_8468# 0.01084f
C232 m2_11540_5122# VDD 0.26269f
C233 m2_8660_1182# eeg_aclk_nand2_s1_0/a_236_340# 0
C234 m2_8660_1182# CIA 0
C235 m2_8660_1182# eeg_aclk_nor2_s1_0/a_236_1540# 0.00373f
C236 m2_8660_1182# m2_8020_1182# 0.15867f
C237 m2_8660_1182# m2_1780_4196# 0.02653f
C238 m2_8660_1182# VDD 0.29428f
C239 m2_8660_1182# m2_1620_1182# 0.21123f
C240 eeg_aclk_nand2_s1_0/a_236_340# m2_8020_1182# 0
C241 eeg_aclk_nand2_s1_0/a_236_340# m2_1780_4196# 0.00375f
C242 m2_22100_1182# m2_1780_4196# 0.67976f
C243 m2_22100_1182# m2_20980_1182# 0.32276f
C244 m2_22100_1182# VDD 0.20747f
C245 m2_14420_1182# eeg_aclk_nand2_s1_1/a_236_340# 0
C246 m2_14420_1182# m2_17300_1182# 0.17801f
C247 m2_14420_1182# CIA 0.16771f
C248 m2_14420_1182# eeg_aclk_nor2_s1_1/a_236_1540# 0.01004f
C249 m2_14420_1182# m2_15220_1182# 0.42538f
C250 m2_14420_1182# m2_1780_4196# 0.05035f
C251 m2_14420_1182# m2_20980_1182# 0.00121f
C252 m2_14420_1182# m2_16340_1182# 0.21139f
C253 m2_14420_1182# VDD 0.90542f
C254 eeg_aclk_nand2_s1_1/a_236_340# m2_1780_4196# 0.00375f
C255 NCDB NCDA 0.13697f
C256 NCDB CIB 0.06655f
C257 NCDB CIA 0.88721f
C258 NCDB m2_3060_12092# 2.89167f
C259 NCDB m2_1780_7542# 0.42091f
C260 NCDB VDD 0.2579f
C261 NCDA CIB 0.06246f
C262 NCDA CIA 0.06246f
C263 NCDA m2_3060_12092# 0.21453f
C264 NCDA m2_1780_7542# 0.00722f
C265 NCDA VDD 0.42342f
C266 m2_17300_1182# CIA 0.53679f
C267 m2_17300_1182# m2_15220_1182# 0
C268 m2_17300_1182# m2_1780_4196# 0.30453f
C269 m2_17300_1182# m2_20980_1182# 0
C270 m2_17300_1182# m2_16340_1182# 0.34806f
C271 m2_17300_1182# VDD 0.21933f
C272 m2_4500_5122# m2_1460_5122# 0.02094f
C273 m2_4500_5122# CIB 0.2225f
C274 m2_4500_5122# CIA 0.13615f
C275 m2_4500_5122# m2_2260_8468# 0.00454f
C276 m2_4500_5122# VDD 0.37795f
C277 m2_17780_5122# CIA 0.01738f
C278 m2_17780_5122# m2_8020_1182# 0.10112f
C279 m2_17780_5122# m2_2260_8468# 0.00378f
C280 m2_17780_5122# m2_18420_5122# 0.3047f
C281 m2_17780_5122# m2_3060_12092# 0.01025f
C282 m2_17780_5122# VDD 0.36558f
C283 m2_1460_5122# CIB 0.15001f
C284 m2_1460_5122# CIA 0.00209f
C285 m2_1460_5122# m2_2260_8468# 0.02006f
C286 m2_1460_5122# m2_1780_4196# 0.11469f
C287 m2_1460_5122# m2_1780_7542# 0
C288 m2_1460_5122# VDD 0.28555f
C289 CIB CIA 0.26954f
C290 CIB m2_8020_1182# 0.022f
C291 CIB m2_2260_8468# 0.28891f
C292 CIB m2_1780_4196# 0.00557f
C293 CIB m2_3060_12092# 0.06655f
C294 CIB VDD 0.79365f
C295 CIA m2_8020_1182# 0.06523f
C296 CIA m2_2260_8468# 0.07076f
C297 CIA eeg_aclk_nor2_s1_1/a_236_1540# 0
C298 CIA m2_15220_1182# 0.02311f
C299 CIA m2_1780_4196# 0.15541f
C300 CIA m2_3060_12092# 0.06595f
C301 CIA m2_20980_1182# 0.00154f
C302 CIA m2_1780_7542# 0.39083f
C303 CIA m2_16340_1182# 0.00807f
C304 CIA VDD 3.53836f
C305 CIA m2_1620_1182# 0.16771f
C306 eeg_aclk_nor2_s1_0/a_236_1540# m2_8020_1182# 0
C307 eeg_aclk_nor2_s1_0/a_236_1540# VDD 0.01369f
C308 eeg_aclk_nor2_s1_0/a_236_1540# m2_1620_1182# 0.01648f
C309 m2_8020_1182# m2_2260_8468# 0.00234f
C310 m2_8020_1182# m2_1780_4196# 1.55518f
C311 m2_8020_1182# m2_18420_5122# 0
C312 m2_8020_1182# VDD 1.32734f
C313 m2_8020_1182# m2_1620_1182# 0.03367f
C314 m2_27220_5122# m2_2260_8468# 0.19105f
C315 m2_27220_5122# VDD 0.42998f
C316 m2_2260_8468# m2_1780_4196# 0.00686f
C317 m2_2260_8468# m2_18420_5122# 0.01209f
C318 m2_2260_8468# m2_3060_12092# 0.07832f
C319 m2_2260_8468# m2_1780_7542# 0.45549f
C320 m2_2260_8468# VDD 1.12537f
C321 eeg_aclk_nor2_s1_1/a_236_1540# m2_15220_1182# 0.02142f
C322 eeg_aclk_nor2_s1_1/a_236_1540# VDD 0.0153f
C323 m2_15220_1182# m2_1780_4196# 0.03816f
C324 m2_15220_1182# m2_16340_1182# 0.00522f
C325 m2_15220_1182# VDD 0.38662f
C326 m2_1780_4196# m2_20980_1182# 0.30936f
C327 m2_1780_4196# m2_1780_7542# 0
C328 m2_1780_4196# m2_16340_1182# 0.30018f
C329 m2_1780_4196# VDD 0.82454f
C330 m2_1780_4196# m2_1620_1182# 0.59831f
C331 m2_18420_5122# m2_3060_12092# 0.25969f
C332 m2_18420_5122# VDD 0.24867f
C333 m2_3060_12092# m2_1780_7542# 0.24555f
C334 m2_3060_12092# VDD 0.5268f
C335 m2_20980_1182# VDD 0.22761f
C336 m2_1780_7542# VDD 0.67931f
C337 m2_16340_1182# VDD 0.22714f
C338 VDD m2_1620_1182# 1.77558f
C339 m2_1620_1182# VSS -0.27135f
C340 VDD VSS -46.39264f
C341 m2_16340_1182# VSS -0.26363f
C342 m2_1780_7542# VSS 0.74121f
C343 m2_20980_1182# VSS -0.26295f
C344 m2_3060_12092# VSS 2.43554f
C345 m2_18420_5122# VSS -0.21004f
C346 m2_1780_4196# VSS 4.86622f
C347 m2_15220_1182# VSS -0.40773f
C348 m2_2260_8468# VSS 1.68919f
C349 m2_27220_5122# VSS -0.1118f
C350 m2_8020_1182# VSS -0.24766f
C351 CIA VSS 0.69813f
C352 CIB VSS 1.96271f
C353 m2_1460_5122# VSS 0.09016f
C354 m2_17780_5122# VSS -0.28451f
C355 m2_4500_5122# VSS -0.24884f
C356 m2_17300_1182# VSS -0.25422f
C357 NCDA VSS 5.43213f
C358 NCDB VSS 4.83721f
C359 eeg_aclk_nand2_s1_1/a_236_340# VSS 0
C360 m2_14420_1182# VSS -0.17853f
C361 m2_22100_1182# VSS -0.17234f
C362 eeg_aclk_nand2_s1_0/a_236_340# VSS 0
C363 m2_8660_1182# VSS -0.18937f
C364 m2_11540_5122# VSS -0.21648f
C365 m2_20980_5122# VSS -0.1981f
C366 m2_980_1182# VSS -0.0045f
C367 CHOP1 VSS 0.71748f
C368 m2_5140_5122# VSS -0.25235f
C369 m2_20340_1182# VSS -0.27364f
C370 m2_4500_4196# VSS 0.11567f
C371 m2_11060_1182# VSS -0.15721f
C372 m2_10420_1182# VSS -0.07617f
C373 m2_9140_1182# VSS 0.34167f
C374 m2_2420_1182# VSS -0.17443f
C375 m2_5300_1182# VSS -0.17738f
C376 m2_3860_1182# VSS -0.20542f
C377 m2_7220_1182# VSS -0.08632f
C378 m2_13780_1182# VSS -0.08309f
C379 m2_11860_1182# VSS -0.17934f
C380 NCIA VSS 1.70914f
C381 NCIB VSS 1.93867f
C382 m2_6260_5122# VSS -0.11876f
C383 CDA VSS 1.92226f
C384 m2_12660_5122# VSS -0.10647f
C385 CDB VSS 2.13334f
C386 m2_22100_5122# VSS -0.14721f
.ends
