* NGSPICE file created from eeg_adc_clk.ext - technology: gf180mcuD

.subckt eeg_adc_clk CHOP1 CIA NCIA CIB NCIB CDA NCDA CDB NCDB VDD VSS
X0 VDD a_7916_340# a_11436_4320# VDD pfet_03v3 ad=1.125p pd=5.9u as=0.65p ps=3.02u w=2.5u l=0.28u
X1 VSS a_16236_340# a_16876_340# VSS nfet_03v3 ad=0.26p pd=1.52u as=0.26p ps=1.52u w=1u l=0.28u
X2 VDD a_20876_4320# a_21516_4320# VDD pfet_03v3 ad=0.65p pd=3.02u as=0.65p ps=3.02u w=2.5u l=0.28u
X3 VDD a_16236_340# a_16876_340# VDD pfet_03v3 ad=0.65p pd=3.02u as=0.65p ps=3.02u w=2.5u l=0.28u
X4 VSS a_5676_4320# NCIB VSS nfet_03v3 ad=0.26p pd=1.52u as=0.26p ps=1.52u w=1u l=0.28u
X5 NCIB a_5676_4320# VDD VDD pfet_03v3 ad=0.65p pd=3.02u as=0.65p ps=3.02u w=2.5u l=0.28u
X6 a_21516_4320# a_20876_4320# VSS VSS nfet_03v3 ad=0.26p pd=1.52u as=0.45p ps=2.9u w=1u l=0.28u
X7 VDD a_20876_4320# a_21516_4320# VDD pfet_03v3 ad=0.65p pd=3.02u as=0.65p ps=3.02u w=2.5u l=0.28u
X8 VSS a_1036_4320# CIB VSS nfet_03v3 ad=0.26p pd=1.52u as=0.26p ps=1.52u w=1u l=0.28u
X9 a_4556_4320# a_4492_4188# VDD VDD pfet_03v3 ad=1.125p pd=5.9u as=1.125p ps=5.9u w=2.5u l=0.28u
X10 VSS a_972_8460# a_1036_6700# VSS nfet_03v3 ad=0.26p pd=1.52u as=0.26p ps=1.52u w=1u l=0.28u
X11 VDD a_1036_6700# NCDB VDD pfet_03v3 ad=2.6p pd=10.52u as=2.6p ps=10.52u w=10u l=0.28u
X12 NCIA a_21516_340# VSS VSS nfet_03v3 ad=0.26p pd=1.52u as=0.26p ps=1.52u w=1u l=0.28u
X13 CDA a_12076_4320# VSS VSS nfet_03v3 ad=0.26p pd=1.52u as=0.26p ps=1.52u w=1u l=0.28u
X14 VDD a_12076_4320# CDA VDD pfet_03v3 ad=0.65p pd=3.02u as=0.65p ps=3.02u w=2.5u l=0.28u
X15 VSS a_1036_4320# CIB VSS nfet_03v3 ad=0.45p pd=2.9u as=0.26p ps=1.52u w=1u l=0.28u
X16 CDB a_21516_4320# VSS VSS nfet_03v3 ad=0.26p pd=1.52u as=0.26p ps=1.52u w=1u l=0.28u
X17 VDD a_21516_4320# CDB VDD pfet_03v3 ad=1.125p pd=5.9u as=0.65p ps=3.02u w=2.5u l=0.28u
X18 a_1036_6700# a_972_8460# VDD VDD pfet_03v3 ad=0.65p pd=3.02u as=1.125p ps=5.9u w=2.5u l=0.28u
X19 VDD a_16876_340# CIA VDD pfet_03v3 ad=0.65p pd=3.02u as=0.65p ps=3.02u w=2.5u l=0.28u
X20 VSS a_21516_340# NCIA VSS nfet_03v3 ad=0.26p pd=1.52u as=0.26p ps=1.52u w=1u l=0.28u
X21 CDB a_21516_4320# VSS VSS nfet_03v3 ad=0.26p pd=1.52u as=0.26p ps=1.52u w=1u l=0.28u
X22 a_5036_4320# a_4556_4320# VSS VSS nfet_03v3 ad=0.26p pd=1.52u as=0.45p ps=2.9u w=1u l=0.28u
X23 VDD a_5036_4320# a_5676_4320# VDD pfet_03v3 ad=0.65p pd=3.02u as=0.65p ps=3.02u w=2.5u l=0.28u
X24 NCIB a_5676_4320# VSS VSS nfet_03v3 ad=0.26p pd=1.52u as=0.26p ps=1.52u w=1u l=0.28u
X25 a_2500_1540# a_1516_340# VDD VDD pfet_03v3 ad=0.45p pd=2.9u as=0.45p ps=2.9u w=1u l=2u
X26 VDD a_5676_4320# NCIB VDD pfet_03v3 ad=0.65p pd=3.02u as=0.65p ps=3.02u w=2.5u l=0.28u
X27 a_21516_4320# a_20876_4320# VDD VDD pfet_03v3 ad=0.65p pd=3.02u as=0.65p ps=3.02u w=2.5u l=0.28u
X28 a_1036_6700# a_972_8460# VSS VSS nfet_03v3 ad=0.26p pd=1.52u as=0.26p ps=1.52u w=1u l=0.28u
X29 NCIA a_21516_340# VDD VDD pfet_03v3 ad=0.65p pd=3.02u as=0.65p ps=3.02u w=2.5u l=0.28u
X30 a_12076_4320# a_11436_4320# VDD VDD pfet_03v3 ad=0.65p pd=3.02u as=0.65p ps=3.02u w=2.5u l=0.28u
X31 NCDA a_1292_12000# VDD VDD pfet_03v3 ad=2.6p pd=10.52u as=2.6p ps=10.52u w=10u l=0.28u
X32 VDD a_972_8460# a_1036_6700# VDD pfet_03v3 ad=0.65p pd=3.02u as=0.65p ps=3.02u w=2.5u l=0.28u
X33 VDD a_972_4188# a_1036_4320# VDD pfet_03v3 ad=0.65p pd=3.02u as=0.65p ps=3.02u w=2.5u l=0.28u
X34 VSS a_11436_4320# a_12076_4320# VSS nfet_03v3 ad=0.26p pd=1.52u as=0.26p ps=1.52u w=1u l=0.28u
X35 CIA a_16876_340# VDD VDD pfet_03v3 ad=0.65p pd=3.02u as=0.65p ps=3.02u w=2.5u l=0.28u
X36 NCIB a_5676_4320# VSS VSS nfet_03v3 ad=0.26p pd=1.52u as=0.26p ps=1.52u w=1u l=0.28u
X37 CDB a_21516_4320# VDD VDD pfet_03v3 ad=0.65p pd=3.02u as=0.65p ps=3.02u w=2.5u l=0.28u
X38 VSS a_20876_4320# a_21516_4320# VSS nfet_03v3 ad=0.45p pd=2.9u as=0.26p ps=1.52u w=1u l=0.28u
X39 VSS a_1036_6700# NCDB VSS nfet_03v3 ad=3.6p pd=16.9u as=2.08p ps=8.52u w=8u l=0.28u
X40 a_1516_340# a_1036_340# VSS VSS nfet_03v3 ad=0.26p pd=1.52u as=0.45p ps=2.9u w=1u l=0.28u
X41 VSS a_21516_4320# CDB VSS nfet_03v3 ad=0.26p pd=1.52u as=0.26p ps=1.52u w=1u l=0.28u
X42 a_14476_1540# a_11116_340# a_14476_340# VSS nfet_03v3 ad=0.9p pd=4.9u as=0.52p ps=2.52u w=2u l=0.28u
X43 a_5676_4320# a_5036_4320# VDD VDD pfet_03v3 ad=0.65p pd=3.02u as=1.125p ps=5.9u w=2.5u l=0.28u
X44 VSS a_1292_12000# NCDA VSS nfet_03v3 ad=2.08p pd=8.52u as=2.08p ps=8.52u w=8u l=0.28u
X45 VSS a_12076_4320# CDA VSS nfet_03v3 ad=0.26p pd=1.52u as=0.26p ps=1.52u w=1u l=0.28u
X46 VSS a_4556_4320# a_5036_4320# VSS nfet_03v3 ad=0.45p pd=2.9u as=0.26p ps=1.52u w=1u l=0.28u
X47 a_7916_1540# a_1516_340# VDD VDD pfet_03v3 ad=1.3p pd=5.52u as=2.25p ps=10.9u w=5u l=0.28u
X48 VDD a_27276_4320# a_972_8460# VDD pfet_03v3 ad=1.125p pd=5.9u as=0.65p ps=3.02u w=2.5u l=0.28u
X49 VDD a_11436_4320# a_12076_4320# VDD pfet_03v3 ad=0.65p pd=3.02u as=0.65p ps=3.02u w=2.5u l=0.28u
X50 a_1036_6700# a_972_8460# VDD VDD pfet_03v3 ad=0.65p pd=3.02u as=0.65p ps=3.02u w=2.5u l=0.28u
X51 a_12076_4320# a_11436_4320# VSS VSS nfet_03v3 ad=0.26p pd=1.52u as=0.45p ps=2.9u w=1u l=0.28u
X52 VSS a_16876_340# CIA VSS nfet_03v3 ad=0.26p pd=1.52u as=0.26p ps=1.52u w=1u l=0.28u
X53 VSS a_5676_4320# NCIB VSS nfet_03v3 ad=0.26p pd=1.52u as=0.26p ps=1.52u w=1u l=0.28u
X54 a_21516_4320# a_20876_4320# VSS VSS nfet_03v3 ad=0.26p pd=1.52u as=0.26p ps=1.52u w=1u l=0.28u
X55 VDD a_21516_4320# CDB VDD pfet_03v3 ad=0.65p pd=3.02u as=0.65p ps=3.02u w=2.5u l=0.28u
X56 NCDA a_1292_12000# VSS VSS nfet_03v3 ad=2.08p pd=8.52u as=2.08p ps=8.52u w=8u l=0.28u
X57 VSS a_972_8460# a_1036_6700# VSS nfet_03v3 ad=0.45p pd=2.9u as=0.26p ps=1.52u w=1u l=0.28u
X58 a_21516_340# a_20876_340# VSS VSS nfet_03v3 ad=0.26p pd=1.52u as=0.26p ps=1.52u w=1u l=0.28u
X59 a_15116_1540# a_11116_340# VDD VDD pfet_03v3 ad=1.3p pd=5.52u as=2.25p ps=10.9u w=5u l=0.28u
X60 VDD a_21516_340# NCIA VDD pfet_03v3 ad=0.65p pd=3.02u as=0.65p ps=3.02u w=2.5u l=0.28u
X61 VDD a_12076_4320# CDA VDD pfet_03v3 ad=0.65p pd=3.02u as=0.65p ps=3.02u w=2.5u l=0.28u
X62 CDA a_12076_4320# VSS VSS nfet_03v3 ad=0.26p pd=1.52u as=0.26p ps=1.52u w=1u l=0.28u
X63 a_12076_4320# a_11436_4320# VSS VSS nfet_03v3 ad=0.26p pd=1.52u as=0.26p ps=1.52u w=1u l=0.28u
X64 VSS a_972_4188# a_1036_4320# VSS nfet_03v3 ad=0.26p pd=1.52u as=0.26p ps=1.52u w=1u l=0.28u
X65 VDD a_12076_4320# CDA VDD pfet_03v3 ad=1.125p pd=5.9u as=0.65p ps=3.02u w=2.5u l=0.28u
X66 CIB a_1036_4320# VDD VDD pfet_03v3 ad=0.65p pd=3.02u as=1.125p ps=5.9u w=2.5u l=0.28u
X67 a_972_8460# a_27276_4320# VDD VDD pfet_03v3 ad=0.65p pd=3.02u as=1.125p ps=5.9u w=2.5u l=0.28u
X68 VDD a_16876_340# CIA VDD pfet_03v3 ad=0.65p pd=3.02u as=0.65p ps=3.02u w=2.5u l=0.28u
X69 a_7916_340# a_6820_1540# a_7916_1540# VDD pfet_03v3 ad=2.25p pd=10.9u as=1.3p ps=5.52u w=5u l=0.28u
X70 a_27276_4320# a_9196_340# VSS VSS nfet_03v3 ad=0.45p pd=2.9u as=0.45p ps=2.9u w=1u l=0.28u
X71 a_5676_4320# a_5036_4320# VSS VSS nfet_03v3 ad=0.26p pd=1.52u as=0.26p ps=1.52u w=1u l=0.28u
X72 VSS a_21516_340# NCIA VSS nfet_03v3 ad=0.26p pd=1.52u as=0.26p ps=1.52u w=1u l=0.28u
X73 VDD a_5036_4320# a_5676_4320# VDD pfet_03v3 ad=1.125p pd=5.9u as=0.65p ps=3.02u w=2.5u l=0.28u
X74 a_17836_4320# a_7916_340# VSS VSS nfet_03v3 ad=0.45p pd=2.9u as=0.45p ps=2.9u w=1u l=0.28u
X75 a_5676_4320# a_5036_4320# VSS VSS nfet_03v3 ad=0.26p pd=1.52u as=0.26p ps=1.52u w=1u l=0.28u
X76 a_16876_340# a_16236_340# VSS VSS nfet_03v3 ad=0.26p pd=1.52u as=0.26p ps=1.52u w=1u l=0.28u
X77 a_21516_340# a_20876_340# VDD VDD pfet_03v3 ad=0.65p pd=3.02u as=0.65p ps=3.02u w=2.5u l=0.28u
X78 NCIA a_21516_340# VDD VDD pfet_03v3 ad=0.65p pd=3.02u as=0.65p ps=3.02u w=2.5u l=0.28u
X79 VSS a_11436_4320# a_12076_4320# VSS nfet_03v3 ad=0.26p pd=1.52u as=0.26p ps=1.52u w=1u l=0.28u
X80 CDA a_12076_4320# VDD VDD pfet_03v3 ad=0.65p pd=3.02u as=1.125p ps=5.9u w=2.5u l=0.28u
X81 a_1036_4320# a_972_4188# VSS VSS nfet_03v3 ad=0.26p pd=1.52u as=0.26p ps=1.52u w=1u l=0.28u
X82 VSS a_11436_4320# a_12076_4320# VSS nfet_03v3 ad=0.45p pd=2.9u as=0.26p ps=1.52u w=1u l=0.28u
X83 NCDB a_1036_6700# VDD VDD pfet_03v3 ad=2.6p pd=10.52u as=2.6p ps=10.52u w=10u l=0.28u
X84 CDB a_21516_4320# VDD VDD pfet_03v3 ad=0.65p pd=3.02u as=0.65p ps=3.02u w=2.5u l=0.28u
X85 VSS a_21516_4320# CDB VSS nfet_03v3 ad=0.26p pd=1.52u as=0.26p ps=1.52u w=1u l=0.28u
X86 VSS a_21516_340# NCIA VSS nfet_03v3 ad=0.26p pd=1.52u as=0.26p ps=1.52u w=1u l=0.28u
X87 a_16236_340# a_14476_1540# VDD VDD pfet_03v3 ad=0.65p pd=3.02u as=1.125p ps=5.9u w=2.5u l=0.28u
X88 NCIA a_21516_340# VDD VDD pfet_03v3 ad=0.65p pd=3.02u as=0.65p ps=3.02u w=2.5u l=0.28u
X89 CIB a_1036_4320# VSS VSS nfet_03v3 ad=0.26p pd=1.52u as=0.26p ps=1.52u w=1u l=0.28u
X90 VDD a_17836_4320# a_18316_4320# VDD pfet_03v3 ad=1.125p pd=5.9u as=0.65p ps=3.02u w=2.5u l=0.28u
X91 VDD a_1036_4320# CIB VDD pfet_03v3 ad=0.65p pd=3.02u as=0.65p ps=3.02u w=2.5u l=0.28u
X92 VSS a_5036_4320# a_5676_4320# VSS nfet_03v3 ad=0.26p pd=1.52u as=0.26p ps=1.52u w=1u l=0.28u
X93 VDD a_20876_340# a_21516_340# VDD pfet_03v3 ad=0.65p pd=3.02u as=0.65p ps=3.02u w=2.5u l=0.28u
X94 NCIA a_21516_340# VSS VSS nfet_03v3 ad=0.26p pd=1.52u as=0.26p ps=1.52u w=1u l=0.28u
X95 VDD a_1036_6700# NCDB VDD pfet_03v3 ad=4.5p pd=20.9u as=2.6p ps=10.52u w=10u l=0.28u
X96 a_9196_340# a_8556_1540# VDD VDD pfet_03v3 ad=1.125p pd=5.9u as=1.125p ps=5.9u w=2.5u l=0.28u
X97 VDD a_5676_4320# NCIB VDD pfet_03v3 ad=0.65p pd=3.02u as=0.65p ps=3.02u w=2.5u l=0.28u
X98 a_4492_4188# a_15116_340# VDD VDD pfet_03v3 ad=1.125p pd=5.9u as=1.125p ps=5.9u w=2.5u l=0.28u
X99 VSS a_14476_1540# a_16236_340# VSS nfet_03v3 ad=0.45p pd=2.9u as=0.26p ps=1.52u w=1u l=0.28u
X100 NCIB a_5676_4320# VDD VDD pfet_03v3 ad=0.65p pd=3.02u as=0.65p ps=3.02u w=2.5u l=0.28u
X101 VDD a_1292_12000# NCDA VDD pfet_03v3 ad=2.6p pd=10.52u as=2.6p ps=10.52u w=10u l=0.28u
X102 CIB a_1036_4320# VDD VDD pfet_03v3 ad=0.65p pd=3.02u as=0.65p ps=3.02u w=2.5u l=0.28u
X103 VSS a_5676_4320# NCIB VSS nfet_03v3 ad=0.26p pd=1.52u as=0.26p ps=1.52u w=1u l=0.28u
X104 NCIB a_5676_4320# VDD VDD pfet_03v3 ad=0.65p pd=3.02u as=0.65p ps=3.02u w=2.5u l=0.28u
X105 a_1292_12000# a_18316_4320# VSS VSS nfet_03v3 ad=0.26p pd=1.52u as=0.26p ps=1.52u w=1u l=0.28u
X106 VDD a_21516_340# NCIA VDD pfet_03v3 ad=0.65p pd=3.02u as=0.65p ps=3.02u w=2.5u l=0.28u
X107 a_16876_340# a_16236_340# VSS VSS nfet_03v3 ad=0.26p pd=1.52u as=0.45p ps=2.9u w=1u l=0.28u
X108 VDD a_12076_4320# CDA VDD pfet_03v3 ad=0.65p pd=3.02u as=0.65p ps=3.02u w=2.5u l=0.28u
X109 CDA a_12076_4320# VSS VSS nfet_03v3 ad=0.26p pd=1.52u as=0.26p ps=1.52u w=1u l=0.28u
X110 VSS a_1036_4320# CIB VSS nfet_03v3 ad=0.26p pd=1.52u as=0.26p ps=1.52u w=1u l=0.28u
X111 CIB a_1036_4320# VDD VDD pfet_03v3 ad=0.65p pd=3.02u as=0.65p ps=3.02u w=2.5u l=0.28u
X112 NCIA a_21516_340# VSS VSS nfet_03v3 ad=0.26p pd=1.52u as=0.45p ps=2.9u w=1u l=0.28u
X113 VDD a_16236_340# a_16876_340# VDD pfet_03v3 ad=0.65p pd=3.02u as=0.65p ps=3.02u w=2.5u l=0.28u
X114 VDD a_12076_4320# CDA VDD pfet_03v3 ad=0.65p pd=3.02u as=0.65p ps=3.02u w=2.5u l=0.28u
X115 CDA a_12076_4320# VSS VSS nfet_03v3 ad=0.26p pd=1.52u as=0.26p ps=1.52u w=1u l=0.28u
X116 VDD a_21516_4320# CDB VDD pfet_03v3 ad=0.65p pd=3.02u as=0.65p ps=3.02u w=2.5u l=0.28u
X117 CDB a_21516_4320# VSS VSS nfet_03v3 ad=0.26p pd=1.52u as=0.26p ps=1.52u w=1u l=0.28u
X118 NCDA a_1292_12000# VDD VDD pfet_03v3 ad=2.6p pd=10.52u as=2.6p ps=10.52u w=10u l=0.28u
X119 NCIB a_5676_4320# VDD VDD pfet_03v3 ad=0.65p pd=3.02u as=0.65p ps=3.02u w=2.5u l=0.28u
X120 a_1036_340# CHOP1 VDD VDD pfet_03v3 ad=1.125p pd=5.9u as=1.125p ps=5.9u w=2.5u l=0.28u
X121 VSS a_21516_340# NCIA VSS nfet_03v3 ad=0.26p pd=1.52u as=0.26p ps=1.52u w=1u l=0.28u
X122 VDD a_5676_4320# NCIB VDD pfet_03v3 ad=0.65p pd=3.02u as=0.65p ps=3.02u w=2.5u l=0.28u
X123 VDD a_1036_6700# NCDB VDD pfet_03v3 ad=2.6p pd=10.52u as=2.6p ps=10.52u w=10u l=0.28u
X124 a_1292_12000# a_18316_4320# VDD VDD pfet_03v3 ad=0.65p pd=3.02u as=0.65p ps=3.02u w=2.5u l=0.28u
X125 NCIB a_5676_4320# VSS VSS nfet_03v3 ad=0.26p pd=1.52u as=0.45p ps=2.9u w=1u l=0.28u
X126 a_2500_1540# a_1516_340# VSS VSS nfet_03v3 ad=0.45p pd=2.9u as=0.45p ps=2.9u w=1u l=4u
X127 VDD a_5676_4320# NCIB VDD pfet_03v3 ad=0.65p pd=3.02u as=0.65p ps=3.02u w=2.5u l=0.28u
X128 VSS a_18316_4320# a_1292_12000# VSS nfet_03v3 ad=0.26p pd=1.52u as=0.26p ps=1.52u w=1u l=0.28u
X129 VDD a_1292_12000# NCDA VDD pfet_03v3 ad=2.6p pd=10.52u as=2.6p ps=10.52u w=10u l=0.28u
X130 VSS a_13380_1540# a_15116_340# VSS nfet_03v3 ad=0.45p pd=2.9u as=0.26p ps=1.52u w=1u l=0.28u
X131 VSS a_18316_4320# a_1292_12000# VSS nfet_03v3 ad=0.26p pd=1.52u as=0.26p ps=1.52u w=1u l=0.28u
X132 NCIA a_21516_340# VDD VDD pfet_03v3 ad=0.65p pd=3.02u as=1.125p ps=5.9u w=2.5u l=0.28u
X133 VSS a_5676_4320# NCIB VSS nfet_03v3 ad=0.26p pd=1.52u as=0.26p ps=1.52u w=1u l=0.28u
X134 a_11436_4320# a_7916_340# VDD VDD pfet_03v3 ad=0.65p pd=3.02u as=1.125p ps=5.9u w=2.5u l=0.28u
X135 VSS a_12076_4320# CDA VSS nfet_03v3 ad=0.26p pd=1.52u as=0.26p ps=1.52u w=1u l=0.28u
X136 a_16876_340# a_16236_340# VDD VDD pfet_03v3 ad=0.65p pd=3.02u as=1.125p ps=5.9u w=2.5u l=0.28u
X137 VDD a_5676_4320# NCIB VDD pfet_03v3 ad=0.65p pd=3.02u as=0.65p ps=3.02u w=2.5u l=0.28u
X138 VSS a_9196_340# a_20876_4320# VSS nfet_03v3 ad=0.45p pd=2.9u as=0.26p ps=1.52u w=1u l=0.28u
X139 a_4492_4188# a_15116_340# VSS VSS nfet_03v3 ad=0.45p pd=2.9u as=0.45p ps=2.9u w=1u l=0.28u
X140 a_21516_4320# a_20876_4320# VDD VDD pfet_03v3 ad=0.65p pd=3.02u as=0.65p ps=3.02u w=2.5u l=0.28u
X141 VSS a_21516_4320# CDB VSS nfet_03v3 ad=0.26p pd=1.52u as=0.26p ps=1.52u w=1u l=0.28u
X142 CDB a_21516_4320# VDD VDD pfet_03v3 ad=0.65p pd=3.02u as=0.65p ps=3.02u w=2.5u l=0.28u
X143 a_16876_340# a_16236_340# VDD VDD pfet_03v3 ad=0.65p pd=3.02u as=0.65p ps=3.02u w=2.5u l=0.28u
X144 VSS a_16876_340# CIA VSS nfet_03v3 ad=0.26p pd=1.52u as=0.26p ps=1.52u w=1u l=0.28u
X145 NCDA a_1292_12000# VDD VDD pfet_03v3 ad=2.6p pd=10.52u as=2.6p ps=10.52u w=10u l=0.28u
X146 CDA a_12076_4320# VDD VDD pfet_03v3 ad=0.65p pd=3.02u as=0.65p ps=3.02u w=2.5u l=0.28u
X147 CIB a_1036_4320# VSS VSS nfet_03v3 ad=0.26p pd=1.52u as=0.26p ps=1.52u w=1u l=0.28u
X148 VDD a_5676_4320# NCIB VDD pfet_03v3 ad=1.125p pd=5.9u as=0.65p ps=3.02u w=2.5u l=0.28u
X149 a_21516_340# a_20876_340# VSS VSS nfet_03v3 ad=0.26p pd=1.52u as=0.26p ps=1.52u w=1u l=0.28u
X150 VSS a_12076_4320# CDA VSS nfet_03v3 ad=0.26p pd=1.52u as=0.26p ps=1.52u w=1u l=0.28u
X151 CDA a_12076_4320# VDD VDD pfet_03v3 ad=0.65p pd=3.02u as=0.65p ps=3.02u w=2.5u l=0.28u
X152 CIA a_16876_340# VSS VSS nfet_03v3 ad=0.26p pd=1.52u as=0.26p ps=1.52u w=1u l=0.28u
X153 VSS a_21516_4320# CDB VSS nfet_03v3 ad=0.26p pd=1.52u as=0.26p ps=1.52u w=1u l=0.28u
X154 CDB a_21516_4320# VDD VDD pfet_03v3 ad=0.65p pd=3.02u as=0.65p ps=3.02u w=2.5u l=0.28u
X155 NCIB a_5676_4320# VSS VSS nfet_03v3 ad=0.26p pd=1.52u as=0.26p ps=1.52u w=1u l=0.28u
X156 VDD a_1036_340# a_1516_340# VDD pfet_03v3 ad=1.125p pd=5.9u as=0.65p ps=3.02u w=2.5u l=0.28u
X157 NCIB a_5676_4320# VDD VDD pfet_03v3 ad=0.65p pd=3.02u as=0.65p ps=3.02u w=2.5u l=0.28u
X158 VDD a_20876_4320# a_21516_4320# VDD pfet_03v3 ad=0.65p pd=3.02u as=0.65p ps=3.02u w=2.5u l=0.28u
X159 a_20876_4320# a_9196_340# VSS VSS nfet_03v3 ad=0.26p pd=1.52u as=0.45p ps=2.9u w=1u l=0.28u
X160 VSS a_1292_12000# NCDA VSS nfet_03v3 ad=2.08p pd=8.52u as=2.08p ps=8.52u w=8u l=0.28u
X161 a_1292_12000# a_18316_4320# VSS VSS nfet_03v3 ad=0.26p pd=1.52u as=0.26p ps=1.52u w=1u l=0.28u
X162 VSS a_5676_4320# NCIB VSS nfet_03v3 ad=0.26p pd=1.52u as=0.26p ps=1.52u w=1u l=0.28u
X163 NCIB a_5676_4320# VDD VDD pfet_03v3 ad=0.65p pd=3.02u as=0.65p ps=3.02u w=2.5u l=0.28u
X164 VDD a_21516_340# NCIA VDD pfet_03v3 ad=0.65p pd=3.02u as=0.65p ps=3.02u w=2.5u l=0.28u
X165 VSS a_21516_340# NCIA VSS nfet_03v3 ad=0.26p pd=1.52u as=0.26p ps=1.52u w=1u l=0.28u
X166 VDD a_12076_4320# CDA VDD pfet_03v3 ad=0.65p pd=3.02u as=0.65p ps=3.02u w=2.5u l=0.28u
X167 CDA a_12076_4320# VSS VSS nfet_03v3 ad=0.26p pd=1.52u as=0.26p ps=1.52u w=1u l=0.28u
X168 a_5380_1540# a_3940_1540# VSS VSS nfet_03v3 ad=0.45p pd=2.9u as=0.45p ps=2.9u w=1u l=4u
X169 VSS a_972_8460# a_1036_6700# VSS nfet_03v3 ad=0.26p pd=1.52u as=0.26p ps=1.52u w=1u l=0.28u
X170 VDD a_21516_340# NCIA VDD pfet_03v3 ad=0.65p pd=3.02u as=0.65p ps=3.02u w=2.5u l=0.28u
X171 VDD a_12076_4320# CDA VDD pfet_03v3 ad=0.65p pd=3.02u as=0.65p ps=3.02u w=2.5u l=0.28u
X172 CDA a_12076_4320# VSS VSS nfet_03v3 ad=0.26p pd=1.52u as=0.26p ps=1.52u w=1u l=0.28u
X173 CIA a_16876_340# VSS VSS nfet_03v3 ad=0.26p pd=1.52u as=0.45p ps=2.9u w=1u l=0.28u
X174 a_6820_1540# a_5380_1540# VDD VDD pfet_03v3 ad=0.45p pd=2.9u as=0.45p ps=2.9u w=1u l=2u
X175 VDD a_21516_4320# CDB VDD pfet_03v3 ad=0.65p pd=3.02u as=0.65p ps=3.02u w=2.5u l=0.28u
X176 CDB a_21516_4320# VSS VSS nfet_03v3 ad=0.26p pd=1.52u as=0.26p ps=1.52u w=1u l=0.28u
X177 VDD a_16876_340# CIA VDD pfet_03v3 ad=0.65p pd=3.02u as=0.65p ps=3.02u w=2.5u l=0.28u
X178 VDD a_12076_4320# CDA VDD pfet_03v3 ad=0.65p pd=3.02u as=0.65p ps=3.02u w=2.5u l=0.28u
X179 VSS a_18316_4320# a_1292_12000# VSS nfet_03v3 ad=0.26p pd=1.52u as=0.26p ps=1.52u w=1u l=0.28u
X180 a_13380_1540# a_11940_1540# VSS VSS nfet_03v3 ad=0.45p pd=2.9u as=0.45p ps=2.9u w=1u l=4u
X181 NCIA a_21516_340# VDD VDD pfet_03v3 ad=0.65p pd=3.02u as=0.65p ps=3.02u w=2.5u l=0.28u
X182 a_1036_4320# a_972_4188# VDD VDD pfet_03v3 ad=0.65p pd=3.02u as=1.125p ps=5.9u w=2.5u l=0.28u
X183 VSS a_7916_340# a_11436_4320# VSS nfet_03v3 ad=0.45p pd=2.9u as=0.26p ps=1.52u w=1u l=0.28u
X184 NCDB a_1036_6700# VSS VSS nfet_03v3 ad=2.08p pd=8.52u as=2.08p ps=8.52u w=8u l=0.28u
X185 NCIA a_21516_340# VDD VDD pfet_03v3 ad=0.65p pd=3.02u as=0.65p ps=3.02u w=2.5u l=0.28u
X186 a_12076_4320# a_11436_4320# VDD VDD pfet_03v3 ad=0.65p pd=3.02u as=0.65p ps=3.02u w=2.5u l=0.28u
X187 VDD a_972_8460# a_1036_6700# VDD pfet_03v3 ad=0.65p pd=3.02u as=0.65p ps=3.02u w=2.5u l=0.28u
X188 VDD a_5676_4320# NCIB VDD pfet_03v3 ad=0.65p pd=3.02u as=0.65p ps=3.02u w=2.5u l=0.28u
X189 VSS a_20876_4320# a_21516_4320# VSS nfet_03v3 ad=0.26p pd=1.52u as=0.26p ps=1.52u w=1u l=0.28u
X190 NCIA a_21516_340# VSS VSS nfet_03v3 ad=0.26p pd=1.52u as=0.26p ps=1.52u w=1u l=0.28u
X191 a_1036_6700# a_972_8460# VSS VSS nfet_03v3 ad=0.26p pd=1.52u as=0.26p ps=1.52u w=1u l=0.28u
X192 VSS a_16236_340# a_16876_340# VSS nfet_03v3 ad=0.26p pd=1.52u as=0.26p ps=1.52u w=1u l=0.28u
X193 VDD a_11116_340# a_14476_1540# VDD pfet_03v3 ad=1.125p pd=5.9u as=0.65p ps=3.02u w=2.5u l=0.28u
X194 NCIB a_5676_4320# VSS VSS nfet_03v3 ad=0.26p pd=1.52u as=0.26p ps=1.52u w=1u l=0.28u
X195 CIA a_16876_340# VDD VDD pfet_03v3 ad=0.65p pd=3.02u as=1.125p ps=5.9u w=2.5u l=0.28u
X196 VSS a_20876_4320# a_21516_4320# VSS nfet_03v3 ad=0.26p pd=1.52u as=0.26p ps=1.52u w=1u l=0.28u
X197 NCIA a_21516_340# VDD VDD pfet_03v3 ad=0.65p pd=3.02u as=0.65p ps=3.02u w=2.5u l=0.28u
X198 CDB a_21516_4320# VDD VDD pfet_03v3 ad=0.65p pd=3.02u as=1.125p ps=5.9u w=2.5u l=0.28u
X199 CDA a_12076_4320# VDD VDD pfet_03v3 ad=0.65p pd=3.02u as=0.65p ps=3.02u w=2.5u l=0.28u
X200 a_4556_4320# a_4492_4188# VSS VSS nfet_03v3 ad=0.45p pd=2.9u as=0.45p ps=2.9u w=1u l=0.28u
X201 VDD a_972_4188# a_1036_4320# VDD pfet_03v3 ad=1.125p pd=5.9u as=0.65p ps=3.02u w=2.5u l=0.28u
X202 a_1036_6700# a_972_8460# VSS VSS nfet_03v3 ad=0.26p pd=1.52u as=0.26p ps=1.52u w=1u l=0.28u
X203 VSS a_12076_4320# CDA VSS nfet_03v3 ad=0.26p pd=1.52u as=0.26p ps=1.52u w=1u l=0.28u
X204 CDA a_12076_4320# VDD VDD pfet_03v3 ad=0.65p pd=3.02u as=0.65p ps=3.02u w=2.5u l=0.28u
X205 NCDB a_1036_6700# VDD VDD pfet_03v3 ad=2.6p pd=10.52u as=2.6p ps=10.52u w=10u l=0.28u
X206 a_20396_340# a_14476_1540# VDD VDD pfet_03v3 ad=1.125p pd=5.9u as=1.125p ps=5.9u w=2.5u l=0.28u
X207 VSS a_21516_4320# CDB VSS nfet_03v3 ad=0.45p pd=2.9u as=0.26p ps=1.52u w=1u l=0.28u
X208 a_7916_340# a_1516_340# VSS VSS nfet_03v3 ad=0.26p pd=1.52u as=0.45p ps=2.9u w=1u l=0.28u
X209 NCDA a_1292_12000# VDD VDD pfet_03v3 ad=2.6p pd=10.52u as=2.6p ps=10.52u w=10u l=0.28u
X210 a_1036_6700# a_972_8460# VDD VDD pfet_03v3 ad=0.65p pd=3.02u as=0.65p ps=3.02u w=2.5u l=0.28u
X211 CIA a_16876_340# VDD VDD pfet_03v3 ad=0.65p pd=3.02u as=0.65p ps=3.02u w=2.5u l=0.28u
X212 a_14476_1540# a_13380_1540# VDD VDD pfet_03v3 ad=0.65p pd=3.02u as=1.125p ps=5.9u w=2.5u l=0.28u
X213 VSS a_5036_4320# a_5676_4320# VSS nfet_03v3 ad=0.26p pd=1.52u as=0.26p ps=1.52u w=1u l=0.28u
X214 VSS a_5676_4320# NCIB VSS nfet_03v3 ad=0.26p pd=1.52u as=0.26p ps=1.52u w=1u l=0.28u
X215 a_5676_4320# a_5036_4320# VDD VDD pfet_03v3 ad=0.65p pd=3.02u as=0.65p ps=3.02u w=2.5u l=0.28u
X216 VDD a_21516_340# NCIA VDD pfet_03v3 ad=0.65p pd=3.02u as=0.65p ps=3.02u w=2.5u l=0.28u
X217 a_21516_4320# a_20876_4320# VSS VSS nfet_03v3 ad=0.26p pd=1.52u as=0.26p ps=1.52u w=1u l=0.28u
X218 a_1036_4320# a_972_4188# VDD VDD pfet_03v3 ad=0.65p pd=3.02u as=0.65p ps=3.02u w=2.5u l=0.28u
X219 VSS a_972_8460# a_1036_6700# VSS nfet_03v3 ad=0.26p pd=1.52u as=0.26p ps=1.52u w=1u l=0.28u
X220 VDD a_21516_340# NCIA VDD pfet_03v3 ad=0.65p pd=3.02u as=0.65p ps=3.02u w=2.5u l=0.28u
X221 a_12076_4320# a_11436_4320# VSS VSS nfet_03v3 ad=0.26p pd=1.52u as=0.26p ps=1.52u w=1u l=0.28u
X222 VDD a_16876_340# CIA VDD pfet_03v3 ad=0.65p pd=3.02u as=0.65p ps=3.02u w=2.5u l=0.28u
X223 VSS a_972_4188# a_1036_4320# VSS nfet_03v3 ad=0.26p pd=1.52u as=0.26p ps=1.52u w=1u l=0.28u
X224 VDD a_1292_12000# NCDA VDD pfet_03v3 ad=2.6p pd=10.52u as=2.6p ps=10.52u w=10u l=0.28u
X225 VDD a_21516_4320# CDB VDD pfet_03v3 ad=0.65p pd=3.02u as=0.65p ps=3.02u w=2.5u l=0.28u
X226 CIA a_16876_340# VSS VSS nfet_03v3 ad=0.26p pd=1.52u as=0.26p ps=1.52u w=1u l=0.28u
X227 VDD a_16876_340# CIA VDD pfet_03v3 ad=0.65p pd=3.02u as=0.65p ps=3.02u w=2.5u l=0.28u
X228 CDB a_21516_4320# VSS VSS nfet_03v3 ad=0.26p pd=1.52u as=0.26p ps=1.52u w=1u l=0.28u
X229 VDD a_21516_4320# CDB VDD pfet_03v3 ad=0.65p pd=3.02u as=0.65p ps=3.02u w=2.5u l=0.28u
X230 a_5676_4320# a_5036_4320# VSS VSS nfet_03v3 ad=0.26p pd=1.52u as=0.45p ps=2.9u w=1u l=0.28u
X231 VSS a_20876_340# a_21516_340# VSS nfet_03v3 ad=0.45p pd=2.9u as=0.26p ps=1.52u w=1u l=0.28u
X232 VDD a_5036_4320# a_5676_4320# VDD pfet_03v3 ad=0.65p pd=3.02u as=0.65p ps=3.02u w=2.5u l=0.28u
X233 VSS a_16876_340# CIA VSS nfet_03v3 ad=0.45p pd=2.9u as=0.26p ps=1.52u w=1u l=0.28u
X234 a_11116_340# a_10020_1540# VDD VDD pfet_03v3 ad=1.125p pd=5.9u as=1.125p ps=5.9u w=2.5u l=0.28u
X235 a_18316_4320# a_17836_4320# VDD VDD pfet_03v3 ad=0.65p pd=3.02u as=1.125p ps=5.9u w=2.5u l=0.28u
X236 VDD a_1516_340# a_8556_1540# VDD pfet_03v3 ad=1.125p pd=5.9u as=0.65p ps=3.02u w=2.5u l=0.28u
X237 a_21516_340# a_20876_340# VDD VDD pfet_03v3 ad=0.65p pd=3.02u as=1.125p ps=5.9u w=2.5u l=0.28u
X238 VSS a_27276_4320# a_972_8460# VSS nfet_03v3 ad=0.45p pd=2.9u as=0.26p ps=1.52u w=1u l=0.28u
X239 VSS a_11436_4320# a_12076_4320# VSS nfet_03v3 ad=0.26p pd=1.52u as=0.26p ps=1.52u w=1u l=0.28u
X240 VDD a_972_8460# a_1036_6700# VDD pfet_03v3 ad=1.125p pd=5.9u as=0.65p ps=3.02u w=2.5u l=0.28u
X241 CDB a_21516_4320# VDD VDD pfet_03v3 ad=0.65p pd=3.02u as=0.65p ps=3.02u w=2.5u l=0.28u
X242 VSS a_1036_340# a_1516_340# VSS nfet_03v3 ad=0.45p pd=2.9u as=0.26p ps=1.52u w=1u l=0.28u
X243 NCIA a_21516_340# VSS VSS nfet_03v3 ad=0.26p pd=1.52u as=0.26p ps=1.52u w=1u l=0.28u
X244 VSS a_21516_4320# CDB VSS nfet_03v3 ad=0.26p pd=1.52u as=0.26p ps=1.52u w=1u l=0.28u
X245 NCIA a_21516_340# VDD VDD pfet_03v3 ad=0.65p pd=3.02u as=0.65p ps=3.02u w=2.5u l=0.28u
X246 CDB a_21516_4320# VDD VDD pfet_03v3 ad=0.65p pd=3.02u as=0.65p ps=3.02u w=2.5u l=0.28u
X247 VDD a_1292_12000# NCDA VDD pfet_03v3 ad=2.6p pd=10.52u as=2.6p ps=10.52u w=10u l=0.28u
X248 VDD a_1036_4320# CIB VDD pfet_03v3 ad=0.65p pd=3.02u as=0.65p ps=3.02u w=2.5u l=0.28u
X249 VSS a_16876_340# CIA VSS nfet_03v3 ad=0.26p pd=1.52u as=0.26p ps=1.52u w=1u l=0.28u
X250 NCIA a_21516_340# VDD VDD pfet_03v3 ad=0.65p pd=3.02u as=0.65p ps=3.02u w=2.5u l=0.28u
X251 CDA a_12076_4320# VDD VDD pfet_03v3 ad=0.65p pd=3.02u as=0.65p ps=3.02u w=2.5u l=0.28u
X252 VSS a_12076_4320# CDA VSS nfet_03v3 ad=0.26p pd=1.52u as=0.26p ps=1.52u w=1u l=0.28u
X253 CIB a_1036_4320# VSS VSS nfet_03v3 ad=0.26p pd=1.52u as=0.45p ps=2.9u w=1u l=0.28u
X254 VSS a_12076_4320# CDA VSS nfet_03v3 ad=0.45p pd=2.9u as=0.26p ps=1.52u w=1u l=0.28u
X255 a_5380_1540# a_3940_1540# VDD VDD pfet_03v3 ad=0.45p pd=2.9u as=0.45p ps=2.9u w=1u l=2u
X256 VDD a_1036_4320# CIB VDD pfet_03v3 ad=0.65p pd=3.02u as=0.65p ps=3.02u w=2.5u l=0.28u
X257 a_8556_1540# a_6820_1540# VDD VDD pfet_03v3 ad=0.65p pd=3.02u as=1.125p ps=5.9u w=2.5u l=0.28u
X258 CDB a_21516_4320# VDD VDD pfet_03v3 ad=0.65p pd=3.02u as=0.65p ps=3.02u w=2.5u l=0.28u
X259 a_21516_340# a_20876_340# VSS VSS nfet_03v3 ad=0.26p pd=1.52u as=0.45p ps=2.9u w=1u l=0.28u
X260 a_972_8460# a_27276_4320# VSS VSS nfet_03v3 ad=0.26p pd=1.52u as=0.45p ps=2.9u w=1u l=0.28u
X261 CIA a_16876_340# VSS VSS nfet_03v3 ad=0.26p pd=1.52u as=0.26p ps=1.52u w=1u l=0.28u
X262 VSS a_5036_4320# a_5676_4320# VSS nfet_03v3 ad=0.45p pd=2.9u as=0.26p ps=1.52u w=1u l=0.28u
X263 a_9196_340# a_8556_1540# VSS VSS nfet_03v3 ad=0.45p pd=2.9u as=0.45p ps=2.9u w=1u l=0.28u
X264 VSS a_20876_340# a_21516_340# VSS nfet_03v3 ad=0.26p pd=1.52u as=0.26p ps=1.52u w=1u l=0.28u
X265 NCIB a_5676_4320# VDD VDD pfet_03v3 ad=0.65p pd=3.02u as=0.65p ps=3.02u w=2.5u l=0.28u
X266 VDD a_18316_4320# a_1292_12000# VDD pfet_03v3 ad=1.125p pd=5.9u as=0.65p ps=3.02u w=2.5u l=0.28u
X267 VDD a_18316_4320# a_1292_12000# VDD pfet_03v3 ad=0.65p pd=3.02u as=0.65p ps=3.02u w=2.5u l=0.28u
X268 VDD a_21516_340# NCIA VDD pfet_03v3 ad=0.65p pd=3.02u as=0.65p ps=3.02u w=2.5u l=0.28u
X269 a_10020_1540# a_1516_340# VSS VSS nfet_03v3 ad=0.45p pd=2.9u as=0.45p ps=2.9u w=1u l=4u
X270 VSS a_21516_340# NCIA VSS nfet_03v3 ad=0.26p pd=1.52u as=0.26p ps=1.52u w=1u l=0.28u
X271 VDD a_20876_340# a_21516_340# VDD pfet_03v3 ad=1.125p pd=5.9u as=0.65p ps=3.02u w=2.5u l=0.28u
X272 CDA a_12076_4320# VSS VSS nfet_03v3 ad=0.26p pd=1.52u as=0.45p ps=2.9u w=1u l=0.28u
X273 VDD a_12076_4320# CDA VDD pfet_03v3 ad=0.65p pd=3.02u as=0.65p ps=3.02u w=2.5u l=0.28u
X274 VDD a_21516_4320# CDB VDD pfet_03v3 ad=0.65p pd=3.02u as=0.65p ps=3.02u w=2.5u l=0.28u
X275 NCDB a_1036_6700# VDD VDD pfet_03v3 ad=2.6p pd=10.52u as=2.6p ps=10.52u w=10u l=0.28u
X276 a_16876_340# a_16236_340# VSS VSS nfet_03v3 ad=0.26p pd=1.52u as=0.26p ps=1.52u w=1u l=0.28u
X277 NCIA a_21516_340# VSS VSS nfet_03v3 ad=0.26p pd=1.52u as=0.26p ps=1.52u w=1u l=0.28u
X278 CDB a_21516_4320# VSS VSS nfet_03v3 ad=0.26p pd=1.52u as=0.26p ps=1.52u w=1u l=0.28u
X279 VDD a_21516_4320# CDB VDD pfet_03v3 ad=0.65p pd=3.02u as=0.65p ps=3.02u w=2.5u l=0.28u
X280 a_1292_12000# a_18316_4320# VDD VDD pfet_03v3 ad=0.65p pd=3.02u as=1.125p ps=5.9u w=2.5u l=0.28u
X281 CIB a_1036_4320# VDD VDD pfet_03v3 ad=0.65p pd=3.02u as=0.65p ps=3.02u w=2.5u l=0.28u
X282 a_20396_340# a_14476_1540# VSS VSS nfet_03v3 ad=0.45p pd=2.9u as=0.45p ps=2.9u w=1u l=0.28u
X283 VDD a_4492_4188# a_972_4188# VDD pfet_03v3 ad=1.125p pd=5.9u as=0.65p ps=3.02u w=2.5u l=0.28u
X284 VSS a_16236_340# a_16876_340# VSS nfet_03v3 ad=0.45p pd=2.9u as=0.26p ps=1.52u w=1u l=0.28u
X285 VDD a_1292_12000# NCDA VDD pfet_03v3 ad=4.5p pd=20.9u as=2.6p ps=10.52u w=10u l=0.28u
X286 VSS a_17836_4320# a_18316_4320# VSS nfet_03v3 ad=0.45p pd=2.9u as=0.26p ps=1.52u w=1u l=0.28u
X287 VSS a_1036_4320# CIB VSS nfet_03v3 ad=0.26p pd=1.52u as=0.26p ps=1.52u w=1u l=0.28u
X288 a_1292_12000# a_18316_4320# VDD VDD pfet_03v3 ad=0.65p pd=3.02u as=0.65p ps=3.02u w=2.5u l=0.28u
X289 a_10020_1540# a_1516_340# VDD VDD pfet_03v3 ad=0.45p pd=2.9u as=0.45p ps=2.9u w=1u l=2u
X290 VSS a_1036_6700# NCDB VSS nfet_03v3 ad=2.08p pd=8.52u as=2.08p ps=8.52u w=8u l=0.28u
X291 a_21516_340# a_20876_340# VDD VDD pfet_03v3 ad=0.65p pd=3.02u as=0.65p ps=3.02u w=2.5u l=0.28u
X292 VSS a_6820_1540# a_7916_340# VSS nfet_03v3 ad=0.45p pd=2.9u as=0.26p ps=1.52u w=1u l=0.28u
X293 NCIB a_5676_4320# VDD VDD pfet_03v3 ad=0.65p pd=3.02u as=0.65p ps=3.02u w=2.5u l=0.28u
X294 a_20876_340# a_20396_340# VSS VSS nfet_03v3 ad=0.26p pd=1.52u as=0.45p ps=2.9u w=1u l=0.28u
X295 a_13380_1540# a_11940_1540# VDD VDD pfet_03v3 ad=0.45p pd=2.9u as=0.45p ps=2.9u w=1u l=2u
X296 VSS a_5676_4320# NCIB VSS nfet_03v3 ad=0.26p pd=1.52u as=0.26p ps=1.52u w=1u l=0.28u
X297 NCIB a_5676_4320# VSS VSS nfet_03v3 ad=0.26p pd=1.52u as=0.26p ps=1.52u w=1u l=0.28u
X298 NCIA a_21516_340# VSS VSS nfet_03v3 ad=0.26p pd=1.52u as=0.26p ps=1.52u w=1u l=0.28u
X299 a_1516_340# a_1036_340# VDD VDD pfet_03v3 ad=0.65p pd=3.02u as=1.125p ps=5.9u w=2.5u l=0.28u
X300 a_8556_340# a_6820_1540# VSS VSS nfet_03v3 ad=0.52p pd=2.52u as=0.9p ps=4.9u w=2u l=0.28u
X301 a_21516_4320# a_20876_4320# VDD VDD pfet_03v3 ad=0.65p pd=3.02u as=1.125p ps=5.9u w=2.5u l=0.28u
X302 VDD a_5676_4320# NCIB VDD pfet_03v3 ad=0.65p pd=3.02u as=0.65p ps=3.02u w=2.5u l=0.28u
X303 CIB a_1036_4320# VSS VSS nfet_03v3 ad=0.26p pd=1.52u as=0.26p ps=1.52u w=1u l=0.28u
X304 VDD a_1036_4320# CIB VDD pfet_03v3 ad=0.65p pd=3.02u as=0.65p ps=3.02u w=2.5u l=0.28u
X305 NCIB a_5676_4320# VSS VSS nfet_03v3 ad=0.26p pd=1.52u as=0.26p ps=1.52u w=1u l=0.28u
X306 NCDB a_1036_6700# VSS VSS nfet_03v3 ad=2.08p pd=8.52u as=2.08p ps=8.52u w=8u l=0.28u
X307 a_972_4188# a_4492_4188# VDD VDD pfet_03v3 ad=0.65p pd=3.02u as=1.125p ps=5.9u w=2.5u l=0.28u
X308 VSS a_21516_340# NCIA VSS nfet_03v3 ad=0.26p pd=1.52u as=0.26p ps=1.52u w=1u l=0.28u
X309 VSS a_12076_4320# CDA VSS nfet_03v3 ad=0.26p pd=1.52u as=0.26p ps=1.52u w=1u l=0.28u
X310 CIB a_1036_4320# VSS VSS nfet_03v3 ad=0.26p pd=1.52u as=0.26p ps=1.52u w=1u l=0.28u
X311 CDA a_12076_4320# VDD VDD pfet_03v3 ad=0.65p pd=3.02u as=0.65p ps=3.02u w=2.5u l=0.28u
X312 VDD a_1036_4320# CIB VDD pfet_03v3 ad=1.125p pd=5.9u as=0.65p ps=3.02u w=2.5u l=0.28u
X313 CDB a_21516_4320# VDD VDD pfet_03v3 ad=0.65p pd=3.02u as=0.65p ps=3.02u w=2.5u l=0.28u
X314 NCDA a_1292_12000# VSS VSS nfet_03v3 ad=2.08p pd=8.52u as=3.6p ps=16.9u w=8u l=0.28u
X315 VSS a_12076_4320# CDA VSS nfet_03v3 ad=0.26p pd=1.52u as=0.26p ps=1.52u w=1u l=0.28u
X316 CDB a_21516_4320# VDD VDD pfet_03v3 ad=0.65p pd=3.02u as=0.65p ps=3.02u w=2.5u l=0.28u
X317 VSS a_21516_4320# CDB VSS nfet_03v3 ad=0.26p pd=1.52u as=0.26p ps=1.52u w=1u l=0.28u
X318 NCIB a_5676_4320# VSS VSS nfet_03v3 ad=0.26p pd=1.52u as=0.26p ps=1.52u w=1u l=0.28u
X319 VSS a_5676_4320# NCIB VSS nfet_03v3 ad=0.26p pd=1.52u as=0.26p ps=1.52u w=1u l=0.28u
X320 a_5036_4320# a_4556_4320# VDD VDD pfet_03v3 ad=0.65p pd=3.02u as=1.125p ps=5.9u w=2.5u l=0.28u
X321 NCIB a_5676_4320# VDD VDD pfet_03v3 ad=0.65p pd=3.02u as=0.65p ps=3.02u w=2.5u l=0.28u
X322 a_1292_12000# a_18316_4320# VSS VSS nfet_03v3 ad=0.26p pd=1.52u as=0.26p ps=1.52u w=1u l=0.28u
X323 a_1036_6700# a_972_8460# VSS VSS nfet_03v3 ad=0.26p pd=1.52u as=0.45p ps=2.9u w=1u l=0.28u
X324 VSS a_5676_4320# NCIB VSS nfet_03v3 ad=0.26p pd=1.52u as=0.26p ps=1.52u w=1u l=0.28u
X325 VDD a_21516_340# NCIA VDD pfet_03v3 ad=0.65p pd=3.02u as=0.65p ps=3.02u w=2.5u l=0.28u
X326 VSS a_21516_340# NCIA VSS nfet_03v3 ad=0.26p pd=1.52u as=0.26p ps=1.52u w=1u l=0.28u
X327 NCDA a_1292_12000# VDD VDD pfet_03v3 ad=2.6p pd=10.52u as=2.6p ps=10.52u w=10u l=0.28u
X328 VDD a_11436_4320# a_12076_4320# VDD pfet_03v3 ad=0.65p pd=3.02u as=0.65p ps=3.02u w=2.5u l=0.28u
X329 a_11436_4320# a_7916_340# VSS VSS nfet_03v3 ad=0.26p pd=1.52u as=0.45p ps=2.9u w=1u l=0.28u
X330 VDD a_16236_340# a_16876_340# VDD pfet_03v3 ad=1.125p pd=5.9u as=0.65p ps=3.02u w=2.5u l=0.28u
X331 VSS a_5676_4320# NCIB VSS nfet_03v3 ad=0.26p pd=1.52u as=0.26p ps=1.52u w=1u l=0.28u
X332 NCIB a_5676_4320# VDD VDD pfet_03v3 ad=0.65p pd=3.02u as=0.65p ps=3.02u w=2.5u l=0.28u
X333 a_21516_4320# a_20876_4320# VSS VSS nfet_03v3 ad=0.26p pd=1.52u as=0.26p ps=1.52u w=1u l=0.28u
X334 NCIA a_21516_340# VSS VSS nfet_03v3 ad=0.26p pd=1.52u as=0.26p ps=1.52u w=1u l=0.28u
X335 VDD a_20876_4320# a_21516_4320# VDD pfet_03v3 ad=1.125p pd=5.9u as=0.65p ps=3.02u w=2.5u l=0.28u
X336 CDB a_21516_4320# VSS VSS nfet_03v3 ad=0.26p pd=1.52u as=0.26p ps=1.52u w=1u l=0.28u
X337 VDD a_21516_4320# CDB VDD pfet_03v3 ad=0.65p pd=3.02u as=0.65p ps=3.02u w=2.5u l=0.28u
X338 VSS a_972_8460# a_1036_6700# VSS nfet_03v3 ad=0.26p pd=1.52u as=0.26p ps=1.52u w=1u l=0.28u
X339 a_972_4188# a_4492_4188# VSS VSS nfet_03v3 ad=0.26p pd=1.52u as=0.45p ps=2.9u w=1u l=0.28u
X340 VDD a_12076_4320# CDA VDD pfet_03v3 ad=0.65p pd=3.02u as=0.65p ps=3.02u w=2.5u l=0.28u
X341 CDA a_12076_4320# VSS VSS nfet_03v3 ad=0.26p pd=1.52u as=0.26p ps=1.52u w=1u l=0.28u
X342 VDD a_4556_4320# a_5036_4320# VDD pfet_03v3 ad=1.125p pd=5.9u as=0.65p ps=3.02u w=2.5u l=0.28u
X343 VSS a_5676_4320# NCIB VSS nfet_03v3 ad=0.45p pd=2.9u as=0.26p ps=1.52u w=1u l=0.28u
X344 CDA a_12076_4320# VSS VSS nfet_03v3 ad=0.26p pd=1.52u as=0.26p ps=1.52u w=1u l=0.28u
X345 CDB a_21516_4320# VSS VSS nfet_03v3 ad=0.26p pd=1.52u as=0.26p ps=1.52u w=1u l=0.28u
X346 a_12076_4320# a_11436_4320# VDD VDD pfet_03v3 ad=0.65p pd=3.02u as=1.125p ps=5.9u w=2.5u l=0.28u
X347 NCIB a_5676_4320# VSS VSS nfet_03v3 ad=0.26p pd=1.52u as=0.26p ps=1.52u w=1u l=0.28u
X348 VDD a_972_8460# a_1036_6700# VDD pfet_03v3 ad=0.65p pd=3.02u as=0.65p ps=3.02u w=2.5u l=0.28u
X349 VDD a_5676_4320# NCIB VDD pfet_03v3 ad=0.65p pd=3.02u as=0.65p ps=3.02u w=2.5u l=0.28u
X350 VSS a_20876_4320# a_21516_4320# VSS nfet_03v3 ad=0.26p pd=1.52u as=0.26p ps=1.52u w=1u l=0.28u
X351 a_21516_340# a_20876_340# VSS VSS nfet_03v3 ad=0.26p pd=1.52u as=0.26p ps=1.52u w=1u l=0.28u
X352 a_21516_4320# a_20876_4320# VDD VDD pfet_03v3 ad=0.65p pd=3.02u as=0.65p ps=3.02u w=2.5u l=0.28u
X353 a_1036_6700# a_972_8460# VSS VSS nfet_03v3 ad=0.26p pd=1.52u as=0.26p ps=1.52u w=1u l=0.28u
X354 NCIB a_5676_4320# VSS VSS nfet_03v3 ad=0.26p pd=1.52u as=0.26p ps=1.52u w=1u l=0.28u
X355 VDD a_1036_6700# NCDB VDD pfet_03v3 ad=2.6p pd=10.52u as=2.6p ps=10.52u w=10u l=0.28u
X356 NCIA a_21516_340# VDD VDD pfet_03v3 ad=0.65p pd=3.02u as=0.65p ps=3.02u w=2.5u l=0.28u
X357 a_12076_4320# a_11436_4320# VDD VDD pfet_03v3 ad=0.65p pd=3.02u as=0.65p ps=3.02u w=2.5u l=0.28u
X358 VSS a_12076_4320# CDA VSS nfet_03v3 ad=0.26p pd=1.52u as=0.26p ps=1.52u w=1u l=0.28u
X359 CDA a_12076_4320# VDD VDD pfet_03v3 ad=0.65p pd=3.02u as=0.65p ps=3.02u w=2.5u l=0.28u
X360 VDD a_972_4188# a_1036_4320# VDD pfet_03v3 ad=0.65p pd=3.02u as=0.65p ps=3.02u w=2.5u l=0.28u
X361 CIA a_16876_340# VDD VDD pfet_03v3 ad=0.65p pd=3.02u as=0.65p ps=3.02u w=2.5u l=0.28u
X362 VSS a_12076_4320# CDA VSS nfet_03v3 ad=0.26p pd=1.52u as=0.26p ps=1.52u w=1u l=0.28u
X363 VSS a_21516_340# NCIA VSS nfet_03v3 ad=0.26p pd=1.52u as=0.26p ps=1.52u w=1u l=0.28u
X364 VSS a_21516_4320# CDB VSS nfet_03v3 ad=0.26p pd=1.52u as=0.26p ps=1.52u w=1u l=0.28u
X365 a_27276_4320# a_9196_340# VDD VDD pfet_03v3 ad=1.125p pd=5.9u as=1.125p ps=5.9u w=2.5u l=0.28u
X366 a_5676_4320# a_5036_4320# VDD VDD pfet_03v3 ad=0.65p pd=3.02u as=0.65p ps=3.02u w=2.5u l=0.28u
X367 CIA a_16876_340# VDD VDD pfet_03v3 ad=0.65p pd=3.02u as=0.65p ps=3.02u w=2.5u l=0.28u
X368 VSS a_12076_4320# CDA VSS nfet_03v3 ad=0.26p pd=1.52u as=0.26p ps=1.52u w=1u l=0.28u
X369 a_17836_4320# a_7916_340# VDD VDD pfet_03v3 ad=1.125p pd=5.9u as=1.125p ps=5.9u w=2.5u l=0.28u
X370 VSS a_20396_340# a_20876_340# VSS nfet_03v3 ad=0.45p pd=2.9u as=0.26p ps=1.52u w=1u l=0.28u
X371 a_5676_4320# a_5036_4320# VDD VDD pfet_03v3 ad=0.65p pd=3.02u as=0.65p ps=3.02u w=2.5u l=0.28u
X372 VDD a_20396_340# a_20876_340# VDD pfet_03v3 ad=1.125p pd=5.9u as=0.65p ps=3.02u w=2.5u l=0.28u
X373 VDD a_21516_340# NCIA VDD pfet_03v3 ad=0.65p pd=3.02u as=0.65p ps=3.02u w=2.5u l=0.28u
X374 VDD a_11436_4320# a_12076_4320# VDD pfet_03v3 ad=0.65p pd=3.02u as=0.65p ps=3.02u w=2.5u l=0.28u
X375 a_1036_6700# a_972_8460# VDD VDD pfet_03v3 ad=0.65p pd=3.02u as=0.65p ps=3.02u w=2.5u l=0.28u
X376 a_1036_4320# a_972_4188# VSS VSS nfet_03v3 ad=0.26p pd=1.52u as=0.45p ps=2.9u w=1u l=0.28u
X377 a_1036_4320# a_972_4188# VDD VDD pfet_03v3 ad=0.65p pd=3.02u as=0.65p ps=3.02u w=2.5u l=0.28u
X378 VDD a_1036_6700# NCDB VDD pfet_03v3 ad=2.6p pd=10.52u as=2.6p ps=10.52u w=10u l=0.28u
X379 a_8556_1540# a_1516_340# a_8556_340# VSS nfet_03v3 ad=0.9p pd=4.9u as=0.52p ps=2.52u w=2u l=0.28u
X380 VDD a_11436_4320# a_12076_4320# VDD pfet_03v3 ad=1.125p pd=5.9u as=0.65p ps=3.02u w=2.5u l=0.28u
X381 a_12076_4320# a_11436_4320# VSS VSS nfet_03v3 ad=0.26p pd=1.52u as=0.26p ps=1.52u w=1u l=0.28u
X382 a_1036_6700# a_972_8460# VDD VDD pfet_03v3 ad=0.65p pd=3.02u as=0.65p ps=3.02u w=2.5u l=0.28u
X383 a_3940_1540# a_2500_1540# VDD VDD pfet_03v3 ad=0.45p pd=2.9u as=0.45p ps=2.9u w=1u l=2u
X384 VSS a_5676_4320# NCIB VSS nfet_03v3 ad=0.26p pd=1.52u as=0.26p ps=1.52u w=1u l=0.28u
X385 VDD a_21516_4320# CDB VDD pfet_03v3 ad=0.65p pd=3.02u as=0.65p ps=3.02u w=2.5u l=0.28u
X386 a_16236_340# a_14476_1540# VSS VSS nfet_03v3 ad=0.26p pd=1.52u as=0.45p ps=2.9u w=1u l=0.28u
X387 NCIA a_21516_340# VSS VSS nfet_03v3 ad=0.26p pd=1.52u as=0.26p ps=1.52u w=1u l=0.28u
X388 VSS a_1292_12000# NCDA VSS nfet_03v3 ad=3.6p pd=16.9u as=2.08p ps=8.52u w=8u l=0.28u
X389 VDD a_21516_340# NCIA VDD pfet_03v3 ad=0.65p pd=3.02u as=0.65p ps=3.02u w=2.5u l=0.28u
X390 CDB a_21516_4320# VSS VSS nfet_03v3 ad=0.26p pd=1.52u as=0.45p ps=2.9u w=1u l=0.28u
X391 VSS a_972_4188# a_1036_4320# VSS nfet_03v3 ad=0.45p pd=2.9u as=0.26p ps=1.52u w=1u l=0.28u
X392 CDA a_12076_4320# VSS VSS nfet_03v3 ad=0.26p pd=1.52u as=0.26p ps=1.52u w=1u l=0.28u
X393 CIB a_1036_4320# VDD VDD pfet_03v3 ad=0.65p pd=3.02u as=0.65p ps=3.02u w=2.5u l=0.28u
X394 a_3940_1540# a_2500_1540# VSS VSS nfet_03v3 ad=0.45p pd=2.9u as=0.45p ps=2.9u w=1u l=4u
X395 VDD a_5036_4320# a_5676_4320# VDD pfet_03v3 ad=0.65p pd=3.02u as=0.65p ps=3.02u w=2.5u l=0.28u
X396 NCDB a_1036_6700# VSS VSS nfet_03v3 ad=2.08p pd=8.52u as=3.6p ps=16.9u w=8u l=0.28u
X397 a_20876_340# a_20396_340# VDD VDD pfet_03v3 ad=0.65p pd=3.02u as=1.125p ps=5.9u w=2.5u l=0.28u
X398 NCDB a_1036_6700# VDD VDD pfet_03v3 ad=2.6p pd=10.52u as=2.6p ps=10.52u w=10u l=0.28u
X399 VDD a_16876_340# CIA VDD pfet_03v3 ad=1.125p pd=5.9u as=0.65p ps=3.02u w=2.5u l=0.28u
X400 CDA a_12076_4320# VSS VSS nfet_03v3 ad=0.26p pd=1.52u as=0.26p ps=1.52u w=1u l=0.28u
X401 NCDA a_1292_12000# VDD VDD pfet_03v3 ad=2.6p pd=10.52u as=4.5p ps=20.9u w=10u l=0.28u
X402 a_11116_340# a_10020_1540# VSS VSS nfet_03v3 ad=0.45p pd=2.9u as=0.45p ps=2.9u w=1u l=0.28u
X403 VDD a_972_8460# a_1036_6700# VDD pfet_03v3 ad=0.65p pd=3.02u as=0.65p ps=3.02u w=2.5u l=0.28u
X404 a_5676_4320# a_5036_4320# VSS VSS nfet_03v3 ad=0.26p pd=1.52u as=0.26p ps=1.52u w=1u l=0.28u
X405 NCIA a_21516_340# VSS VSS nfet_03v3 ad=0.26p pd=1.52u as=0.26p ps=1.52u w=1u l=0.28u
X406 a_15116_340# a_13380_1540# a_15116_1540# VDD pfet_03v3 ad=2.25p pd=10.9u as=1.3p ps=5.52u w=5u l=0.28u
X407 a_11940_1540# a_11116_340# VSS VSS nfet_03v3 ad=0.45p pd=2.9u as=0.45p ps=2.9u w=1u l=4u
X408 VDD a_5676_4320# NCIB VDD pfet_03v3 ad=0.65p pd=3.02u as=0.65p ps=3.02u w=2.5u l=0.28u
X409 a_1292_12000# a_18316_4320# VDD VDD pfet_03v3 ad=0.65p pd=3.02u as=0.65p ps=3.02u w=2.5u l=0.28u
X410 VSS a_1036_6700# NCDB VSS nfet_03v3 ad=2.08p pd=8.52u as=2.08p ps=8.52u w=8u l=0.28u
X411 NCIA a_21516_340# VDD VDD pfet_03v3 ad=0.65p pd=3.02u as=0.65p ps=3.02u w=2.5u l=0.28u
X412 CDA a_12076_4320# VDD VDD pfet_03v3 ad=0.65p pd=3.02u as=0.65p ps=3.02u w=2.5u l=0.28u
X413 a_1036_4320# a_972_4188# VSS VSS nfet_03v3 ad=0.26p pd=1.52u as=0.26p ps=1.52u w=1u l=0.28u
X414 VDD a_1036_4320# CIB VDD pfet_03v3 ad=0.65p pd=3.02u as=0.65p ps=3.02u w=2.5u l=0.28u
X415 a_15116_340# a_11116_340# VSS VSS nfet_03v3 ad=0.26p pd=1.52u as=0.45p ps=2.9u w=1u l=0.28u
X416 VSS a_21516_340# NCIA VSS nfet_03v3 ad=0.26p pd=1.52u as=0.26p ps=1.52u w=1u l=0.28u
X417 CDA a_12076_4320# VDD VDD pfet_03v3 ad=0.65p pd=3.02u as=0.65p ps=3.02u w=2.5u l=0.28u
X418 CIA a_16876_340# VDD VDD pfet_03v3 ad=0.65p pd=3.02u as=0.65p ps=3.02u w=2.5u l=0.28u
X419 VSS a_21516_4320# CDB VSS nfet_03v3 ad=0.26p pd=1.52u as=0.26p ps=1.52u w=1u l=0.28u
X420 CDB a_21516_4320# VDD VDD pfet_03v3 ad=0.65p pd=3.02u as=0.65p ps=3.02u w=2.5u l=0.28u
X421 VSS a_4492_4188# a_972_4188# VSS nfet_03v3 ad=0.45p pd=2.9u as=0.26p ps=1.52u w=1u l=0.28u
X422 VSS a_21516_4320# CDB VSS nfet_03v3 ad=0.26p pd=1.52u as=0.26p ps=1.52u w=1u l=0.28u
X423 a_11940_1540# a_11116_340# VDD VDD pfet_03v3 ad=0.45p pd=2.9u as=0.45p ps=2.9u w=1u l=2u
X424 VSS a_5036_4320# a_5676_4320# VSS nfet_03v3 ad=0.26p pd=1.52u as=0.26p ps=1.52u w=1u l=0.28u
X425 CIA a_16876_340# VSS VSS nfet_03v3 ad=0.26p pd=1.52u as=0.26p ps=1.52u w=1u l=0.28u
X426 VDD a_20876_340# a_21516_340# VDD pfet_03v3 ad=0.65p pd=3.02u as=0.65p ps=3.02u w=2.5u l=0.28u
X427 VDD a_18316_4320# a_1292_12000# VDD pfet_03v3 ad=0.65p pd=3.02u as=0.65p ps=3.02u w=2.5u l=0.28u
X428 NCIB a_5676_4320# VDD VDD pfet_03v3 ad=0.65p pd=3.02u as=1.125p ps=5.9u w=2.5u l=0.28u
X429 NCDA a_1292_12000# VSS VSS nfet_03v3 ad=2.08p pd=8.52u as=2.08p ps=8.52u w=8u l=0.28u
X430 a_18316_4320# a_17836_4320# VSS VSS nfet_03v3 ad=0.26p pd=1.52u as=0.45p ps=2.9u w=1u l=0.28u
X431 VDD a_18316_4320# a_1292_12000# VDD pfet_03v3 ad=0.65p pd=3.02u as=0.65p ps=3.02u w=2.5u l=0.28u
X432 VSS a_20876_340# a_21516_340# VSS nfet_03v3 ad=0.26p pd=1.52u as=0.26p ps=1.52u w=1u l=0.28u
X433 VDD a_20876_340# a_21516_340# VDD pfet_03v3 ad=0.65p pd=3.02u as=0.65p ps=3.02u w=2.5u l=0.28u
X434 a_6820_1540# a_5380_1540# VSS VSS nfet_03v3 ad=0.45p pd=2.9u as=0.45p ps=2.9u w=1u l=4u
X435 VDD a_5676_4320# NCIB VDD pfet_03v3 ad=0.65p pd=3.02u as=0.65p ps=3.02u w=2.5u l=0.28u
X436 VSS a_16876_340# CIA VSS nfet_03v3 ad=0.26p pd=1.52u as=0.26p ps=1.52u w=1u l=0.28u
X437 VDD a_12076_4320# CDA VDD pfet_03v3 ad=0.65p pd=3.02u as=0.65p ps=3.02u w=2.5u l=0.28u
X438 VDD a_21516_4320# CDB VDD pfet_03v3 ad=0.65p pd=3.02u as=0.65p ps=3.02u w=2.5u l=0.28u
X439 VDD a_9196_340# a_20876_4320# VDD pfet_03v3 ad=1.125p pd=5.9u as=0.65p ps=3.02u w=2.5u l=0.28u
X440 CDB a_21516_4320# VSS VSS nfet_03v3 ad=0.26p pd=1.52u as=0.26p ps=1.52u w=1u l=0.28u
X441 VDD a_14476_1540# a_16236_340# VDD pfet_03v3 ad=1.125p pd=5.9u as=0.65p ps=3.02u w=2.5u l=0.28u
X442 VDD a_21516_340# NCIA VDD pfet_03v3 ad=1.125p pd=5.9u as=0.65p ps=3.02u w=2.5u l=0.28u
X443 CDB a_21516_4320# VSS VSS nfet_03v3 ad=0.26p pd=1.52u as=0.26p ps=1.52u w=1u l=0.28u
X444 VSS a_1036_4320# CIB VSS nfet_03v3 ad=0.26p pd=1.52u as=0.26p ps=1.52u w=1u l=0.28u
X445 CIB a_1036_4320# VDD VDD pfet_03v3 ad=0.65p pd=3.02u as=0.65p ps=3.02u w=2.5u l=0.28u
X446 NCIA a_21516_340# VSS VSS nfet_03v3 ad=0.26p pd=1.52u as=0.26p ps=1.52u w=1u l=0.28u
X447 a_14476_340# a_13380_1540# VSS VSS nfet_03v3 ad=0.52p pd=2.52u as=0.9p ps=4.9u w=2u l=0.28u
X448 CDA a_12076_4320# VSS VSS nfet_03v3 ad=0.26p pd=1.52u as=0.26p ps=1.52u w=1u l=0.28u
X449 VDD a_12076_4320# CDA VDD pfet_03v3 ad=0.65p pd=3.02u as=0.65p ps=3.02u w=2.5u l=0.28u
X450 VSS a_1036_4320# CIB VSS nfet_03v3 ad=0.26p pd=1.52u as=0.26p ps=1.52u w=1u l=0.28u
X451 VDD a_21516_4320# CDB VDD pfet_03v3 ad=0.65p pd=3.02u as=0.65p ps=3.02u w=2.5u l=0.28u
X452 CDB a_21516_4320# VSS VSS nfet_03v3 ad=0.26p pd=1.52u as=0.26p ps=1.52u w=1u l=0.28u
X453 a_21516_340# a_20876_340# VDD VDD pfet_03v3 ad=0.65p pd=3.02u as=0.65p ps=3.02u w=2.5u l=0.28u
X454 NCIB a_5676_4320# VDD VDD pfet_03v3 ad=0.65p pd=3.02u as=0.65p ps=3.02u w=2.5u l=0.28u
X455 VSS a_21516_340# NCIA VSS nfet_03v3 ad=0.45p pd=2.9u as=0.26p ps=1.52u w=1u l=0.28u
X456 a_20876_4320# a_9196_340# VDD VDD pfet_03v3 ad=0.65p pd=3.02u as=1.125p ps=5.9u w=2.5u l=0.28u
X457 a_1292_12000# a_18316_4320# VDD VDD pfet_03v3 ad=0.65p pd=3.02u as=0.65p ps=3.02u w=2.5u l=0.28u
X458 NCDB a_1036_6700# VDD VDD pfet_03v3 ad=2.6p pd=10.52u as=2.6p ps=10.52u w=10u l=0.28u
X459 NCIB a_5676_4320# VSS VSS nfet_03v3 ad=0.26p pd=1.52u as=0.26p ps=1.52u w=1u l=0.28u
X460 VDD a_5676_4320# NCIB VDD pfet_03v3 ad=0.65p pd=3.02u as=0.65p ps=3.02u w=2.5u l=0.28u
X461 VSS a_18316_4320# a_1292_12000# VSS nfet_03v3 ad=0.45p pd=2.9u as=0.26p ps=1.52u w=1u l=0.28u
X462 CIA a_16876_340# VSS VSS nfet_03v3 ad=0.26p pd=1.52u as=0.26p ps=1.52u w=1u l=0.28u
X463 CDA a_12076_4320# VDD VDD pfet_03v3 ad=0.65p pd=3.02u as=0.65p ps=3.02u w=2.5u l=0.28u
X464 VSS a_18316_4320# a_1292_12000# VSS nfet_03v3 ad=0.26p pd=1.52u as=0.26p ps=1.52u w=1u l=0.28u
X465 NCIA a_21516_340# VDD VDD pfet_03v3 ad=0.65p pd=3.02u as=0.65p ps=3.02u w=2.5u l=0.28u
X466 VSS a_20876_340# a_21516_340# VSS nfet_03v3 ad=0.26p pd=1.52u as=0.26p ps=1.52u w=1u l=0.28u
X467 CDA a_12076_4320# VDD VDD pfet_03v3 ad=0.65p pd=3.02u as=0.65p ps=3.02u w=2.5u l=0.28u
X468 VSS a_12076_4320# CDA VSS nfet_03v3 ad=0.26p pd=1.52u as=0.26p ps=1.52u w=1u l=0.28u
X469 VSS a_16876_340# CIA VSS nfet_03v3 ad=0.26p pd=1.52u as=0.26p ps=1.52u w=1u l=0.28u
X470 VSS a_21516_4320# CDB VSS nfet_03v3 ad=0.26p pd=1.52u as=0.26p ps=1.52u w=1u l=0.28u
X471 CDB a_21516_4320# VDD VDD pfet_03v3 ad=0.65p pd=3.02u as=0.65p ps=3.02u w=2.5u l=0.28u
X472 VSS a_21516_340# NCIA VSS nfet_03v3 ad=0.26p pd=1.52u as=0.26p ps=1.52u w=1u l=0.28u
X473 a_16876_340# a_16236_340# VDD VDD pfet_03v3 ad=0.65p pd=3.02u as=0.65p ps=3.02u w=2.5u l=0.28u
X474 VDD a_1036_6700# NCDB VDD pfet_03v3 ad=2.6p pd=10.52u as=2.6p ps=10.52u w=10u l=0.28u
X475 VSS a_21516_4320# CDB VSS nfet_03v3 ad=0.26p pd=1.52u as=0.26p ps=1.52u w=1u l=0.28u
X476 CIB a_1036_4320# VSS VSS nfet_03v3 ad=0.26p pd=1.52u as=0.26p ps=1.52u w=1u l=0.28u
X477 VDD a_18316_4320# a_1292_12000# VDD pfet_03v3 ad=0.65p pd=3.02u as=0.65p ps=3.02u w=2.5u l=0.28u
X478 a_1292_12000# a_18316_4320# VSS VSS nfet_03v3 ad=0.26p pd=1.52u as=0.45p ps=2.9u w=1u l=0.28u
X479 a_1036_340# CHOP1 VSS VSS nfet_03v3 ad=0.45p pd=2.9u as=0.45p ps=2.9u w=1u l=0.28u
X480 VDD a_1292_12000# NCDA VDD pfet_03v3 ad=2.6p pd=10.52u as=2.6p ps=10.52u w=10u l=0.28u
X481 NCIA a_21516_340# VSS VSS nfet_03v3 ad=0.26p pd=1.52u as=0.26p ps=1.52u w=1u l=0.28u
X482 a_1292_12000# a_18316_4320# VSS VSS nfet_03v3 ad=0.26p pd=1.52u as=0.26p ps=1.52u w=1u l=0.28u
X483 NCDB a_1036_6700# VDD VDD pfet_03v3 ad=2.6p pd=10.52u as=4.5p ps=20.9u w=10u l=0.28u
X484 VDD a_21516_340# NCIA VDD pfet_03v3 ad=0.65p pd=3.02u as=0.65p ps=3.02u w=2.5u l=0.28u
X485 NCIB a_5676_4320# VSS VSS nfet_03v3 ad=0.26p pd=1.52u as=0.26p ps=1.52u w=1u l=0.28u
C0 a_1292_12000# a_1036_6700# 0.26162f
C1 a_1292_12000# a_972_8460# 0.0869f
C2 a_1292_12000# a_17836_4320# 0.00997f
C3 a_1292_12000# a_18316_4320# 1.98413f
C4 a_1292_12000# a_9196_340# 0.04487f
C5 a_1292_12000# a_20876_4320# 0.09443f
C6 a_1292_12000# VDD 6.63177f
C7 a_1292_12000# NCDA 4.05397f
C8 a_1292_12000# NCDB 3.32569f
C9 a_1292_12000# CIB 0.07559f
C10 a_1292_12000# NCIB 0.07559f
C11 a_1292_12000# CDA 0.07761f
C12 a_1292_12000# CHOP1 0.33213f
C13 a_1292_12000# CIA 0.07506f
C14 a_1292_12000# NCIA 0.26677f
C15 a_1036_6700# a_972_8460# 2.19883f
C16 a_1036_6700# a_972_4188# 0
C17 a_1036_6700# a_1036_4320# 0
C18 a_1036_6700# VDD 6.80237f
C19 a_1036_6700# NCDA 0.00705f
C20 a_1036_6700# NCDB 4.24829f
C21 a_1036_6700# CHOP1 0.32789f
C22 a_1036_6700# CIA 0.39864f
C23 a_972_8460# a_972_4188# 0.00647f
C24 a_972_8460# a_1036_4320# 0.01997f
C25 a_972_8460# a_4492_4188# 0.0014f
C26 a_972_8460# a_4556_4320# 0.00452f
C27 a_972_8460# a_5036_4320# 0.01307f
C28 a_972_8460# a_5676_4320# 0.03614f
C29 a_972_8460# a_7916_340# 0.00234f
C30 a_972_8460# a_11436_4320# 0.01082f
C31 a_972_8460# a_12076_4320# 0.03311f
C32 a_972_8460# a_17836_4320# 0.00376f
C33 a_972_8460# a_18316_4320# 0.01208f
C34 a_972_8460# a_9196_340# 0.00828f
C35 a_972_8460# a_20876_4320# 0.01091f
C36 a_972_8460# a_21516_4320# 0.04662f
C37 a_972_8460# a_27276_4320# 0.48128f
C38 a_972_8460# VDD 4.75726f
C39 a_972_8460# CIB 0.27522f
C40 a_972_8460# NCIB 0.09889f
C41 a_972_8460# CDA 0.09773f
C42 a_972_8460# CDB 0.10607f
C43 a_972_8460# CHOP1 1.11682f
C44 a_972_8460# CIA 0.07936f
C45 a_972_8460# NCIA 0.74643f
C46 a_972_4188# a_1036_4320# 1.12863f
C47 a_972_4188# a_4492_4188# 2.58511f
C48 a_972_4188# a_7916_340# 3.61807f
C49 a_972_4188# a_9196_340# 0.02133f
C50 a_972_4188# a_1516_340# 0.79186f
C51 a_972_4188# a_6820_1540# 0.05997f
C52 a_972_4188# a_11116_340# 0.09267f
C53 a_972_4188# a_13380_1540# 0.06078f
C54 a_972_4188# a_1036_340# 0.0764f
C55 a_972_4188# a_2500_1540# 1.47659f
C56 a_972_4188# a_3940_1540# 1.44835f
C57 a_972_4188# a_5380_1540# 1.45137f
C58 a_972_4188# a_8556_1540# 0.02858f
C59 a_972_4188# a_10020_1540# 0.03648f
C60 a_972_4188# a_11940_1540# 1.45453f
C61 a_972_4188# a_14476_1540# 0.05511f
C62 a_972_4188# a_15116_340# 0.04261f
C63 a_972_4188# a_16236_340# 0.62445f
C64 a_972_4188# a_16876_340# 0.33693f
C65 a_972_4188# a_20396_340# 0.1255f
C66 a_972_4188# a_20876_340# 0.63415f
C67 a_972_4188# a_21516_340# 1.29273f
C68 a_972_4188# a_8556_340# 0.00403f
C69 a_972_4188# a_14476_340# 0.00403f
C70 a_972_4188# VDD 3.3062f
C71 a_972_4188# CIB 0.00527f
C72 a_972_4188# CHOP1 0.27316f
C73 a_972_4188# CIA 0.17426f
C74 a_972_4188# NCIA 0.40725f
C75 a_1036_4320# a_4492_4188# 0.0396f
C76 a_1036_4320# a_4556_4320# 0.02115f
C77 a_1036_4320# a_5036_4320# 0
C78 a_1036_4320# VDD 5.65624f
C79 a_1036_4320# CIB 2.21564f
C80 a_1036_4320# CHOP1 0.66793f
C81 a_1036_4320# CIA 0.00207f
C82 a_4492_4188# a_4556_4320# 0.22027f
C83 a_4492_4188# a_5036_4320# 0
C84 a_4492_4188# a_7916_340# 3.66898f
C85 a_4492_4188# a_9196_340# 0.65866f
C86 a_4492_4188# a_1516_340# 0.40399f
C87 a_4492_4188# a_6820_1540# 0.11621f
C88 a_4492_4188# a_11116_340# 3.68997f
C89 a_4492_4188# a_13380_1540# 0.09247f
C90 a_4492_4188# a_2500_1540# 0.19916f
C91 a_4492_4188# a_3940_1540# 0.90213f
C92 a_4492_4188# a_5380_1540# 1.50223f
C93 a_4492_4188# a_7916_1540# 0.00746f
C94 a_4492_4188# a_8556_1540# 0.17003f
C95 a_4492_4188# a_10020_1540# 0.09547f
C96 a_4492_4188# a_11940_1540# 1.46606f
C97 a_4492_4188# a_14476_1540# 1.74251f
C98 a_4492_4188# a_15116_1540# 0.00399f
C99 a_4492_4188# a_15116_340# 0.43774f
C100 a_4492_4188# a_16236_340# 0.32572f
C101 a_4492_4188# a_16876_340# 0.42026f
C102 a_4492_4188# a_20396_340# 0.63508f
C103 a_4492_4188# a_20876_340# 0.20263f
C104 a_4492_4188# a_21516_340# 0.43958f
C105 a_4492_4188# VDD 3.9204f
C106 a_4492_4188# CIB 0.01259f
C107 a_4492_4188# CIA 0.16858f
C108 a_4492_4188# NCIA 0.23677f
C109 a_4556_4320# a_5036_4320# 0.49514f
C110 a_4556_4320# a_5676_4320# 0.00648f
C111 a_4556_4320# VDD 1.31482f
C112 a_4556_4320# CIB 0.20887f
C113 a_4556_4320# CIA 0.12718f
C114 a_5036_4320# a_5676_4320# 1.67895f
C115 a_5036_4320# VDD 3.22055f
C116 a_5036_4320# CIB 0.2605f
C117 a_5036_4320# NCIB 0.00527f
C118 a_5036_4320# CIA 0.82529f
C119 a_5676_4320# a_7916_340# 0.04039f
C120 a_5676_4320# a_11436_4320# 0.01132f
C121 a_5676_4320# a_9196_340# 0.02447f
C122 a_5676_4320# a_1516_340# 0
C123 a_5676_4320# a_6820_1540# 0.00381f
C124 a_5676_4320# VDD 9.82685f
C125 a_5676_4320# CIB 0.58155f
C126 a_5676_4320# NCIB 4.40228f
C127 a_5676_4320# CIA 0.26245f
C128 a_5676_4320# NCIA 0.12059f
C129 a_7916_340# a_11436_4320# 0.55225f
C130 a_7916_340# a_12076_4320# 0.44449f
C131 a_7916_340# a_17836_4320# 0.23049f
C132 a_7916_340# a_18316_4320# 0
C133 a_7916_340# a_9196_340# 6.63292f
C134 a_7916_340# a_1516_340# 0.12668f
C135 a_7916_340# a_6820_1540# 0.26672f
C136 a_7916_340# a_11116_340# 0.52609f
C137 a_7916_340# a_13380_1540# 0
C138 a_7916_340# a_5380_1540# 0.03141f
C139 a_7916_340# a_7916_1540# 0.48595f
C140 a_7916_340# a_8556_1540# 0.15518f
C141 a_7916_340# a_10020_1540# 0.14244f
C142 a_7916_340# a_11940_1540# 0.10577f
C143 a_7916_340# a_8556_340# 0
C144 a_7916_340# VDD 2.46242f
C145 a_7916_340# CIB 0.02362f
C146 a_7916_340# NCIB 0.11091f
C147 a_7916_340# CDA 0.13749f
C148 a_7916_340# CIA 0.07456f
C149 a_7916_340# NCIA 0.14609f
C150 a_11436_4320# a_12076_4320# 1.67794f
C151 a_11436_4320# a_9196_340# 0.02966f
C152 a_11436_4320# VDD 3.28377f
C153 a_11436_4320# CIB 0.07454f
C154 a_11436_4320# NCIB 0.71857f
C155 a_11436_4320# CDA 0.00527f
C156 a_11436_4320# CIA 0.01381f
C157 a_11436_4320# NCIA 0.051f
C158 a_12076_4320# a_17836_4320# 0.02115f
C159 a_12076_4320# a_9196_340# 0.06661f
C160 a_12076_4320# a_11116_340# 0
C161 a_12076_4320# a_13380_1540# 0
C162 a_12076_4320# VDD 9.81052f
C163 a_12076_4320# CIB 0.01598f
C164 a_12076_4320# NCIB 1.23516f
C165 a_12076_4320# CDA 4.42416f
C166 a_12076_4320# CIA 0.04169f
C167 a_12076_4320# NCIA 0.21231f
C168 a_17836_4320# a_18316_4320# 0.57749f
C169 a_17836_4320# a_9196_340# 0.07976f
C170 a_17836_4320# VDD 1.30148f
C171 a_17836_4320# CDA 0.19119f
C172 a_17836_4320# CIA 0.01689f
C173 a_17836_4320# NCIA 0.08404f
C174 a_18316_4320# a_9196_340# 0.18117f
C175 a_18316_4320# a_20876_4320# 0.01144f
C176 a_18316_4320# VDD 3.8694f
C177 a_18316_4320# CDA 0.01869f
C178 a_18316_4320# NCIA 0.20324f
C179 a_9196_340# a_20876_4320# 0.50219f
C180 a_9196_340# a_21516_4320# 0.3636f
C181 a_9196_340# a_27276_4320# 0.22909f
C182 a_9196_340# a_1516_340# 0.19518f
C183 a_9196_340# a_6820_1540# 0
C184 a_9196_340# a_11116_340# 0.00753f
C185 a_9196_340# a_13380_1540# 0
C186 a_9196_340# a_7916_1540# 0
C187 a_9196_340# a_8556_1540# 0.46523f
C188 a_9196_340# a_10020_1540# 0.65985f
C189 a_9196_340# a_11940_1540# 0
C190 a_9196_340# VDD 4.32938f
C191 a_9196_340# NCIB 0.04103f
C192 a_9196_340# CDA 0
C193 a_9196_340# CDB 0.09354f
C194 a_9196_340# CIA 2.45585f
C195 a_9196_340# NCIA 0.2196f
C196 a_20876_4320# a_21516_4320# 1.68436f
C197 a_20876_4320# VDD 3.2893f
C198 a_20876_4320# CDB 0.00923f
C199 a_20876_4320# NCIA 0.19016f
C200 a_21516_4320# a_27276_4320# 0.02136f
C201 a_21516_4320# VDD 9.77073f
C202 a_21516_4320# CDB 4.42539f
C203 a_21516_4320# NCIA 1.05337f
C204 a_27276_4320# VDD 1.35183f
C205 a_27276_4320# CDB 0.09552f
C206 a_1516_340# a_6820_1540# 1.42473f
C207 a_1516_340# a_11116_340# 0.043f
C208 a_1516_340# a_1036_340# 0.73136f
C209 a_1516_340# a_2500_1540# 0.75252f
C210 a_1516_340# a_3940_1540# 0.08038f
C211 a_1516_340# a_5380_1540# 0.04724f
C212 a_1516_340# a_7916_1540# 0.06985f
C213 a_1516_340# a_8556_1540# 0.32965f
C214 a_1516_340# a_10020_1540# 0.60249f
C215 a_1516_340# a_11940_1540# 0
C216 a_1516_340# a_8556_340# 0.01883f
C217 a_1516_340# VDD 4.98459f
C218 a_1516_340# NCIB 0
C219 a_1516_340# CHOP1 0.34117f
C220 a_1516_340# CIA 0.15187f
C221 a_6820_1540# a_3940_1540# 0.01579f
C222 a_6820_1540# a_5380_1540# 0.76098f
C223 a_6820_1540# a_7916_1540# 0.06579f
C224 a_6820_1540# a_8556_1540# 0.11466f
C225 a_6820_1540# a_8556_340# 0.01937f
C226 a_6820_1540# VDD 1.2884f
C227 a_6820_1540# NCIB 0
C228 a_6820_1540# CIA 0.08602f
C229 a_11116_340# a_13380_1540# 1.13024f
C230 a_11116_340# a_10020_1540# 0.27287f
C231 a_11116_340# a_11940_1540# 0.76908f
C232 a_11116_340# a_14476_1540# 0.80433f
C233 a_11116_340# a_15116_1540# 0.07456f
C234 a_11116_340# a_15116_340# 0.2705f
C235 a_11116_340# a_16236_340# 0
C236 a_11116_340# a_14476_340# 0.01953f
C237 a_11116_340# VDD 2.70249f
C238 a_11116_340# CDA 0
C239 a_11116_340# CIA 0
C240 a_13380_1540# a_11940_1540# 0.76977f
C241 a_13380_1540# a_14476_1540# 0.26596f
C242 a_13380_1540# a_15116_1540# 0.065f
C243 a_13380_1540# a_15116_340# 0.27166f
C244 a_13380_1540# a_14476_340# 0.01892f
C245 a_13380_1540# VDD 1.24574f
C246 a_13380_1540# CDA 0
C247 a_13380_1540# CIA 0.07619f
C248 a_1036_340# a_2500_1540# 0.00408f
C249 a_1036_340# VDD 1.24997f
C250 a_1036_340# CHOP1 0.36142f
C251 a_2500_1540# a_3940_1540# 0.74239f
C252 a_2500_1540# a_5380_1540# 0.01569f
C253 a_2500_1540# VDD 1.29034f
C254 a_2500_1540# CHOP1 0.00465f
C255 a_3940_1540# a_5380_1540# 0.76655f
C256 a_3940_1540# VDD 1.27829f
C257 a_5380_1540# a_7916_1540# 0.0034f
C258 a_5380_1540# a_8556_1540# 0.00341f
C259 a_5380_1540# a_8556_340# 0.00101f
C260 a_5380_1540# VDD 1.2102f
C261 a_7916_1540# a_8556_1540# 0.00376f
C262 a_7916_1540# VDD 0.52498f
C263 a_8556_1540# a_10020_1540# 0.00695f
C264 a_8556_1540# a_8556_340# 0.19083f
C265 a_8556_1540# VDD 1.24065f
C266 a_8556_1540# CIA 0
C267 a_10020_1540# a_11940_1540# 0.00197f
C268 a_10020_1540# VDD 0.67467f
C269 a_10020_1540# CIA 0
C270 a_11940_1540# a_14476_1540# 0.03733f
C271 a_11940_1540# a_15116_1540# 0
C272 a_11940_1540# a_15116_340# 0.00238f
C273 a_11940_1540# a_14476_340# 0.00408f
C274 a_11940_1540# VDD 1.22801f
C275 a_14476_1540# a_15116_1540# 0.01107f
C276 a_14476_1540# a_15116_340# 0.44883f
C277 a_14476_1540# a_16236_340# 0.52694f
C278 a_14476_1540# a_16876_340# 0.19101f
C279 a_14476_1540# a_20396_340# 0.21345f
C280 a_14476_1540# a_20876_340# 0.00117f
C281 a_14476_1540# a_14476_340# 0.19036f
C282 a_14476_1540# VDD 2.49896f
C283 a_14476_1540# CIA 0.16778f
C284 a_15116_1540# a_15116_340# 0.51004f
C285 a_15116_1540# VDD 0.52654f
C286 a_15116_1540# CIA 0
C287 a_15116_340# a_16236_340# 0.0046f
C288 a_15116_340# a_16876_340# 0
C289 a_15116_340# VDD 0.81698f
C290 a_15116_340# CIA 0.0207f
C291 a_16236_340# a_16876_340# 1.35002f
C292 a_16236_340# VDD 2.64714f
C293 a_16236_340# CIA 0.00777f
C294 a_16876_340# a_20396_340# 0.02132f
C295 a_16876_340# a_20876_340# 0
C296 a_16876_340# VDD 5.58498f
C297 a_16876_340# CIA 2.78737f
C298 a_20396_340# a_20876_340# 0.57581f
C299 a_20396_340# a_21516_340# 0.00648f
C300 a_20396_340# VDD 1.27979f
C301 a_20396_340# CIA 0.09554f
C302 a_20876_340# a_21516_340# 1.67858f
C303 a_20876_340# VDD 3.24741f
C304 a_20876_340# CIA 0.00149f
C305 a_20876_340# NCIA 0.00527f
C306 a_21516_340# VDD 9.73719f
C307 a_21516_340# NCIA 5.09588f
C308 VDD NCDA 14.4436f
C309 VDD NCDB 14.2551f
C310 VDD CIB 4.33377f
C311 VDD NCIB 7.66902f
C312 VDD CDA 7.62881f
C313 VDD CDB 7.6047f
C314 VDD CHOP1 1.98207f
C315 VDD CIA 7.35031f
C316 VDD NCIA 8.58049f
C317 NCDA NCDB 0.11927f
C318 NCDA CIB 0.07111f
C319 NCDA NCIB 0.07111f
C320 NCDA CDA 0.07111f
C321 NCDA CHOP1 1.54004f
C322 NCDA CIA 0.07111f
C323 NCDA NCIA 0.07111f
C324 NCDB CIB 0.07559f
C325 NCDB NCIB 0.07559f
C326 NCDB CDA 0.07559f
C327 NCDB CDB 0.07939f
C328 NCDB CIA 0.95077f
C329 NCDB NCIA 0.07559f
C330 CIB NCIB 0.9961f
C331 CIB CHOP1 0.20032f
C332 CIB CIA 0.25537f
C333 CIB NCIA 3.17728f
C334 NCIB CDA 0.16736f
C335 NCIB CIA 0.05701f
C336 NCIB NCIA 1.20008f
C337 CDA CIA 0
C338 CDA NCIA 0.39562f
C339 CDB NCIA 0.22103f
C340 NCIA VSS 9.90643f
C341 CIA VSS 5.78342f
C342 CHOP1 VSS 3.03598f
C343 CDB VSS 8.14745f
C344 CDA VSS 8.2615f
C345 NCIB VSS 8.32965f
C346 CIB VSS 6.47814f
C347 NCDB VSS 11.8721f
C348 NCDA VSS 12.1402f
C349 VDD VSS 0.49794p
C350 a_14476_340# VSS 0.21577f
C351 a_8556_340# VSS 0.21644f
C352 a_21516_340# VSS 14.6538f
C353 a_20876_340# VSS 4.98593f
C354 a_20396_340# VSS 1.78182f
C355 a_16876_340# VSS 7.88571f
C356 a_16236_340# VSS 3.91855f
C357 a_15116_340# VSS 1.26611f
C358 a_15116_1540# VSS 0.00467f
C359 a_14476_1540# VSS 2.50029f
C360 a_11940_1540# VSS 3.51407f
C361 a_10020_1540# VSS 1.42703f
C362 a_8556_1540# VSS 1.15343f
C363 a_7916_1540# VSS 0.00467f
C364 a_5380_1540# VSS 3.51605f
C365 a_3940_1540# VSS 3.5114f
C366 a_2500_1540# VSS 3.54304f
C367 a_1036_340# VSS 2.03547f
C368 a_13380_1540# VSS 1.83809f
C369 a_11116_340# VSS 4.76168f
C370 a_6820_1540# VSS 1.84198f
C371 a_1516_340# VSS 7.69563f
C372 a_27276_4320# VSS 1.94058f
C373 a_21516_4320# VSS 14.6674f
C374 a_20876_4320# VSS 5.05078f
C375 a_9196_340# VSS 3.52687f
C376 a_18316_4320# VSS 6.10499f
C377 a_17836_4320# VSS 1.77057f
C378 a_12076_4320# VSS 14.7004f
C379 a_11436_4320# VSS 5.03142f
C380 a_7916_340# VSS 2.7988f
C381 a_5676_4320# VSS 14.7021f
C382 a_5036_4320# VSS 4.99475f
C383 a_4556_4320# VSS 1.80557f
C384 a_4492_4188# VSS 3.47681f
C385 a_1036_4320# VSS 8.22211f
C386 a_972_4188# VSS 8.15886f
C387 a_972_8460# VSS 12.5752f
C388 a_1036_6700# VSS 6.2939f
C389 a_1292_12000# VSS 10.2633f
.ends
