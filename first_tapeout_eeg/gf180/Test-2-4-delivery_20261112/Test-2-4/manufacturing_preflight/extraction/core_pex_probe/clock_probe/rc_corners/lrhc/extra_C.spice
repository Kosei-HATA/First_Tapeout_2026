* NGSPICE file created from eeg_adc_clk.ext - technology: gf180mcuD

.subckt eeg_adc_clk CHOP1 CIA NCIA CIB NCIB CDA NCDA CDB NCDB VDD VSS
X0 VDD.t396 a_7916_340.t5 a_11436_4320.t1 VDD.t395 pfet_03v3 ad=1.125p pd=5.9u as=0.65p ps=3.02u w=2.5u l=0.28u
X1 VSS.t151 a_16236_340.t10 a_16876_340.t0 VSS.t150 nfet_03v3 ad=0.26p pd=1.52u as=0.26p ps=1.52u w=1u l=0.28u
X2 VDD.t233 a_20876_4320.t10 a_21516_4320.t0 VDD.t220 pfet_03v3 ad=0.65p pd=3.02u as=0.65p ps=3.02u w=2.5u l=0.28u
X3 VDD.t167 a_16236_340.t11 a_16876_340.t1 VDD.t112 pfet_03v3 ad=0.65p pd=3.02u as=0.65p ps=3.02u w=2.5u l=0.28u
X4 VSS.t391 a_5676_4320.t35 NCIB.t33 VSS.t390 nfet_03v3 ad=0.26p pd=1.52u as=0.26p ps=1.52u w=1u l=0.28u
X5 NCIB.t14 a_5676_4320.t44 VDD.t359 VDD.t358 pfet_03v3 ad=0.65p pd=3.02u as=0.65p ps=3.02u w=2.5u l=0.28u
X6 a_21516_4320.t11 a_20876_4320.t5 VSS.t225 VSS.t224 nfet_03v3 ad=0.26p pd=1.52u as=0.45p ps=2.9u w=1u l=0.28u
X7 VDD.t235 a_20876_4320.t14 a_21516_4320.t4 VDD.t224 pfet_03v3 ad=0.65p pd=3.02u as=0.65p ps=3.02u w=2.5u l=0.28u
X8 VSS.t27 a_1036_4320.t31 CIB.t21 VSS.t26 nfet_03v3 ad=0.26p pd=1.52u as=0.26p ps=1.52u w=1u l=0.28u
X9 a_4556_4320.t0 a_4492_4188.t2 VDD.t319 VDD.t318 pfet_03v3 ad=1.125p pd=5.9u as=1.125p ps=5.9u w=2.5u l=0.28u
X10 VSS.t453 a_972_8460.t10 a_1036_6700.t13 VSS.t444 nfet_03v3 ad=0.26p pd=1.52u as=0.26p ps=1.52u w=1u l=0.28u
X11 VDD.t43 a_1036_6700.t27 NCDB.t3 VDD.t42 pfet_03v3 ad=2.6p pd=10.52u as=2.6p ps=10.52u w=10u l=0.28u
X12 NCIA.t30 a_21516_340.t28 VSS.t253 VSS.t252 nfet_03v3 ad=0.26p pd=1.52u as=0.26p ps=1.52u w=1u l=0.28u
X13 CDA.t36 a_12076_4320.t41 VSS.t91 VSS.t90 nfet_03v3 ad=0.26p pd=1.52u as=0.26p ps=1.52u w=1u l=0.28u
X14 VDD.t99 a_12076_4320.t50 CDA.t17 VDD.t98 pfet_03v3 ad=0.65p pd=3.02u as=0.65p ps=3.02u w=2.5u l=0.28u
X15 VSS.t31 a_1036_4320.t35 CIB.t23 VSS.t30 nfet_03v3 ad=0.45p pd=2.9u as=0.26p ps=1.52u w=1u l=0.28u
X16 CDB.t42 a_21516_4320.t53 VSS.t325 VSS.t324 nfet_03v3 ad=0.26p pd=1.52u as=0.26p ps=1.52u w=1u l=0.28u
X17 VDD.t302 a_21516_4320.t62 CDB.t23 VDD.t270 pfet_03v3 ad=1.125p pd=5.9u as=0.65p ps=3.02u w=2.5u l=0.28u
X18 a_1036_6700.t0 a_972_8460.t5 VDD.t413 VDD.t412 pfet_03v3 ad=0.65p pd=3.02u as=1.125p ps=5.9u w=2.5u l=0.28u
X19 VDD.t183 a_16876_340.t19 CIA.t3 VDD.t182 pfet_03v3 ad=0.65p pd=3.02u as=0.65p ps=3.02u w=2.5u l=0.28u
X20 VSS.t259 a_21516_340.t34 NCIA.t33 VSS.t258 nfet_03v3 ad=0.26p pd=1.52u as=0.26p ps=1.52u w=1u l=0.28u
X21 CDB.t44 a_21516_4320.t57 VSS.t329 VSS.t328 nfet_03v3 ad=0.26p pd=1.52u as=0.26p ps=1.52u w=1u l=0.28u
X22 a_5036_4320.t1 a_4556_4320.t3 VSS.t351 VSS.t350 nfet_03v3 ad=0.26p pd=1.52u as=0.45p ps=2.9u w=1u l=0.28u
X23 VDD.t331 a_5036_4320.t6 a_5676_4320.t12 VDD.t330 pfet_03v3 ad=0.65p pd=3.02u as=0.65p ps=3.02u w=2.5u l=0.28u
X24 NCIB.t32 a_5676_4320.t33 VSS.t389 VSS.t388 nfet_03v3 ad=0.26p pd=1.52u as=0.26p ps=1.52u w=1u l=0.28u
X25 a_2500_1540# a_1516_340.t5 VDD.t159 VDD.t158 pfet_03v3 ad=0.45p pd=2.9u as=0.45p ps=2.9u w=1u l=2u
X26 VDD.t357 a_5676_4320.t42 NCIB.t13 VDD.t356 pfet_03v3 ad=0.65p pd=3.02u as=0.65p ps=3.02u w=2.5u l=0.28u
X27 a_21516_4320.t2 a_20876_4320.t12 VDD.t234 VDD.t222 pfet_03v3 ad=0.65p pd=3.02u as=0.65p ps=3.02u w=2.5u l=0.28u
X28 a_1036_6700.t12 a_972_8460.t8 VSS.t452 VSS.t442 nfet_03v3 ad=0.26p pd=1.52u as=0.26p ps=1.52u w=1u l=0.28u
X29 NCIA.t8 a_21516_340.t33 VDD.t283 VDD.t282 pfet_03v3 ad=0.65p pd=3.02u as=0.65p ps=3.02u w=2.5u l=0.28u
X30 a_12076_4320.t2 a_11436_4320.t12 VDD.t71 VDD.t70 pfet_03v3 ad=0.65p pd=3.02u as=0.65p ps=3.02u w=2.5u l=0.28u
X31 NCDA.t2 a_1292_12000.t25 VDD.t135 VDD.t134 pfet_03v3 ad=2.6p pd=10.52u as=2.6p ps=10.52u w=10u l=0.28u
X32 VDD.t423 a_972_8460.t15 a_1036_6700.t5 VDD.t422 pfet_03v3 ad=0.65p pd=3.02u as=0.65p ps=3.02u w=2.5u l=0.28u
X33 VDD.t405 a_972_4188.t6 a_1036_4320.t1 VDD.t404 pfet_03v3 ad=0.65p pd=3.02u as=0.65p ps=3.02u w=2.5u l=0.28u
X34 VSS.t51 a_11436_4320.t7 a_12076_4320.t13 VSS.t50 nfet_03v3 ad=0.26p pd=1.52u as=0.26p ps=1.52u w=1u l=0.28u
X35 CIA.t2 a_16876_340.t17 VDD.t181 VDD.t180 pfet_03v3 ad=0.65p pd=3.02u as=0.65p ps=3.02u w=2.5u l=0.28u
X36 NCIB.t40 a_5676_4320.t49 VSS.t405 VSS.t404 nfet_03v3 ad=0.26p pd=1.52u as=0.26p ps=1.52u w=1u l=0.28u
X37 CDB.t2 a_21516_4320.t20 VDD.t298 VDD.t262 pfet_03v3 ad=0.65p pd=3.02u as=0.65p ps=3.02u w=2.5u l=0.28u
X38 VSS.t239 a_20876_4320.t19 a_21516_4320.t9 VSS.t238 nfet_03v3 ad=0.45p pd=2.9u as=0.26p ps=1.52u w=1u l=0.28u
X39 VSS.t43 a_1036_6700.t30 NCDB.t17 VSS.t42 nfet_03v3 ad=3.6p pd=16.9u as=2.08p ps=8.52u w=8u l=0.28u
X40 a_1516_340.t0 a_1036_340.t2 VSS.t5 VSS.t4 nfet_03v3 ad=0.26p pd=1.52u as=0.45p ps=2.9u w=1u l=0.28u
X41 VSS.t327 a_21516_4320.t55 CDB.t43 VSS.t326 nfet_03v3 ad=0.26p pd=1.52u as=0.26p ps=1.52u w=1u l=0.28u
X42 a_14476_1540.t0 a_11116_340.t4 a_14476_340.t0 VSS.t463 nfet_03v3 ad=0.9p pd=4.9u as=0.52p ps=2.52u w=2u l=0.28u
X43 a_5676_4320.t10 a_5036_4320.t4 VDD.t329 VDD.t328 pfet_03v3 ad=0.65p pd=3.02u as=1.125p ps=5.9u w=2.5u l=0.28u
X44 VSS.t117 a_1292_12000.t22 NCDA.t13 VSS.t116 nfet_03v3 ad=2.08p pd=8.52u as=2.08p ps=8.52u w=8u l=0.28u
X45 VSS.t105 a_12076_4320.t55 CDA.t43 VSS.t104 nfet_03v3 ad=0.26p pd=1.52u as=0.26p ps=1.52u w=1u l=0.28u
X46 VSS.t353 a_4556_4320.t5 a_5036_4320.t3 VSS.t352 nfet_03v3 ad=0.45p pd=2.9u as=0.26p ps=1.52u w=1u l=0.28u
X47 a_7916_1540.t0 a_1516_340.t7 VDD.t161 VDD.t160 pfet_03v3 ad=1.3p pd=5.52u as=2.25p ps=10.9u w=5u l=0.28u
X48 VDD.t315 a_27276_4320.t4 a_972_8460.t2 VDD.t314 pfet_03v3 ad=1.125p pd=5.9u as=0.65p ps=3.02u w=2.5u l=0.28u
X49 VDD.t69 a_11436_4320.t10 a_12076_4320.t0 VDD.t68 pfet_03v3 ad=0.65p pd=3.02u as=0.65p ps=3.02u w=2.5u l=0.28u
X50 a_1036_6700.t4 a_972_8460.t13 VDD.t421 VDD.t420 pfet_03v3 ad=0.65p pd=3.02u as=0.65p ps=3.02u w=2.5u l=0.28u
X51 a_12076_4320.t11 a_11436_4320.t5 VSS.t49 VSS.t48 nfet_03v3 ad=0.26p pd=1.52u as=0.45p ps=2.9u w=1u l=0.28u
X52 VSS.t163 a_16876_340.t18 CIA.t15 VSS.t162 nfet_03v3 ad=0.26p pd=1.52u as=0.26p ps=1.52u w=1u l=0.28u
X53 VSS.t403 a_5676_4320.t47 NCIB.t39 VSS.t402 nfet_03v3 ad=0.26p pd=1.52u as=0.26p ps=1.52u w=1u l=0.28u
X54 a_21516_4320.t7 a_20876_4320.t17 VSS.t237 VSS.t236 nfet_03v3 ad=0.26p pd=1.52u as=0.26p ps=1.52u w=1u l=0.28u
X55 VDD.t287 a_21516_4320.t18 CDB.t1 VDD.t240 pfet_03v3 ad=0.65p pd=3.02u as=0.65p ps=3.02u w=2.5u l=0.28u
X56 NCDA.t16 a_1292_12000.t28 VSS.t123 VSS.t122 nfet_03v3 ad=2.08p pd=8.52u as=2.08p ps=8.52u w=8u l=0.28u
X57 VSS.t461 a_972_8460.t22 a_1036_6700.t19 VSS.t10 nfet_03v3 ad=0.45p pd=2.9u as=0.26p ps=1.52u w=1u l=0.28u
X58 a_21516_340.t14 a_20876_340.t8 VSS.t213 VSS.t212 nfet_03v3 ad=0.26p pd=1.52u as=0.26p ps=1.52u w=1u l=0.28u
X59 a_15116_1540.t0 a_11116_340.t7 VDD.t61 VDD.t60 pfet_03v3 ad=1.3p pd=5.52u as=2.25p ps=10.9u w=5u l=0.28u
X60 VDD.t253 a_21516_340.t47 NCIA.t15 VDD.t252 pfet_03v3 ad=0.65p pd=3.02u as=0.65p ps=3.02u w=2.5u l=0.28u
X61 VDD.t83 a_12076_4320.t18 CDA.t1 VDD.t82 pfet_03v3 ad=0.65p pd=3.02u as=0.65p ps=3.02u w=2.5u l=0.28u
X62 CDA.t42 a_12076_4320.t53 VSS.t103 VSS.t102 nfet_03v3 ad=0.26p pd=1.52u as=0.26p ps=1.52u w=1u l=0.28u
X63 a_12076_4320.t7 a_11436_4320.t17 VSS.t61 VSS.t60 nfet_03v3 ad=0.26p pd=1.52u as=0.26p ps=1.52u w=1u l=0.28u
X64 VSS.t445 a_972_4188.t11 a_1036_4320.t9 VSS.t444 nfet_03v3 ad=0.26p pd=1.52u as=0.26p ps=1.52u w=1u l=0.28u
X65 VDD.t113 a_12076_4320.t62 CDA.t23 VDD.t112 pfet_03v3 ad=1.125p pd=5.9u as=0.65p ps=3.02u w=2.5u l=0.28u
X66 CIB.t0 a_1036_4320.t12 VDD.t9 VDD.t8 pfet_03v3 ad=0.65p pd=3.02u as=1.125p ps=5.9u w=2.5u l=0.28u
X67 a_972_8460.t0 a_27276_4320.t2 VDD.t313 VDD.t312 pfet_03v3 ad=0.65p pd=3.02u as=1.125p ps=5.9u w=2.5u l=0.28u
X68 VDD.t195 a_16876_340.t31 CIA.t9 VDD.t194 pfet_03v3 ad=0.65p pd=3.02u as=0.65p ps=3.02u w=2.5u l=0.28u
X69 a_7916_340.t2 a_6820_1540# a_7916_1540.t1 VDD.t383 pfet_03v3 ad=2.25p pd=10.9u as=1.3p ps=5.52u w=5u l=0.28u
X70 a_27276_4320.t1 a_9196_340.t7 VSS.t437 VSS.t436 nfet_03v3 ad=0.45p pd=2.9u as=0.45p ps=2.9u w=1u l=0.28u
X71 a_5676_4320.t15 a_5036_4320.t9 VSS.t359 VSS.t358 nfet_03v3 ad=0.26p pd=1.52u as=0.26p ps=1.52u w=1u l=0.28u
X72 VSS.t275 a_21516_340.t50 NCIA.t41 VSS.t274 nfet_03v3 ad=0.26p pd=1.52u as=0.26p ps=1.52u w=1u l=0.28u
X73 VDD.t343 a_5036_4320.t18 a_5676_4320.t8 VDD.t342 pfet_03v3 ad=1.125p pd=5.9u as=0.65p ps=3.02u w=2.5u l=0.28u
X74 a_17836_4320.t1 a_7916_340.t8 VSS.t429 VSS.t428 nfet_03v3 ad=0.45p pd=2.9u as=0.45p ps=2.9u w=1u l=0.28u
X75 a_5676_4320.t3 a_5036_4320.t13 VSS.t363 VSS.t362 nfet_03v3 ad=0.26p pd=1.52u as=0.26p ps=1.52u w=1u l=0.28u
X76 a_16876_340.t2 a_16236_340.t12 VSS.t153 VSS.t152 nfet_03v3 ad=0.26p pd=1.52u as=0.26p ps=1.52u w=1u l=0.28u
X77 a_21516_340.t15 a_20876_340.t9 VDD.t219 VDD.t218 pfet_03v3 ad=0.65p pd=3.02u as=0.65p ps=3.02u w=2.5u l=0.28u
X78 NCIA.t14 a_21516_340.t45 VDD.t251 VDD.t250 pfet_03v3 ad=0.65p pd=3.02u as=0.65p ps=3.02u w=2.5u l=0.28u
X79 VSS.t59 a_11436_4320.t15 a_12076_4320.t5 VSS.t58 nfet_03v3 ad=0.26p pd=1.52u as=0.26p ps=1.52u w=1u l=0.28u
X80 CDA.t0 a_12076_4320.t16 VDD.t81 VDD.t80 pfet_03v3 ad=0.65p pd=3.02u as=1.125p ps=5.9u w=2.5u l=0.28u
X81 a_1036_4320.t8 a_972_4188.t9 VSS.t443 VSS.t442 nfet_03v3 ad=0.26p pd=1.52u as=0.26p ps=1.52u w=1u l=0.28u
X82 VSS.t63 a_11436_4320.t19 a_12076_4320.t9 VSS.t62 nfet_03v3 ad=0.45p pd=2.9u as=0.26p ps=1.52u w=1u l=0.28u
X83 NCDB.t8 a_1036_6700.t34 VDD.t53 VDD.t52 pfet_03v3 ad=2.6p pd=10.52u as=2.6p ps=10.52u w=10u l=0.28u
X84 CDB.t8 a_21516_4320.t32 VDD.t308 VDD.t282 pfet_03v3 ad=0.65p pd=3.02u as=0.65p ps=3.02u w=2.5u l=0.28u
X85 VSS.t295 a_21516_4320.t23 CDB.t27 VSS.t294 nfet_03v3 ad=0.26p pd=1.52u as=0.26p ps=1.52u w=1u l=0.28u
X86 VSS.t255 a_21516_340.t30 NCIA.t31 VSS.t254 nfet_03v3 ad=0.26p pd=1.52u as=0.26p ps=1.52u w=1u l=0.28u
X87 a_16236_340.t1 a_14476_1540.t4 VDD.t151 VDD.t96 pfet_03v3 ad=0.65p pd=3.02u as=1.125p ps=5.9u w=2.5u l=0.28u
X88 NCIA.t22 a_21516_340.t61 VDD.t269 VDD.t268 pfet_03v3 ad=0.65p pd=3.02u as=0.65p ps=3.02u w=2.5u l=0.28u
X89 CIB.t14 a_1036_4320.t17 VSS.t13 VSS.t12 nfet_03v3 ad=0.26p pd=1.52u as=0.26p ps=1.52u w=1u l=0.28u
X90 VDD.t197 a_17836_4320.t4 a_18316_4320.t2 VDD.t180 pfet_03v3 ad=1.125p pd=5.9u as=0.65p ps=3.02u w=2.5u l=0.28u
X91 VDD.t27 a_1036_4320.t26 CIB.t7 VDD.t26 pfet_03v3 ad=0.65p pd=3.02u as=0.65p ps=3.02u w=2.5u l=0.28u
X92 VSS.t361 a_5036_4320.t11 a_5676_4320.t1 VSS.t360 nfet_03v3 ad=0.26p pd=1.52u as=0.26p ps=1.52u w=1u l=0.28u
X93 VDD.t217 a_20876_340.t7 a_21516_340.t13 VDD.t216 pfet_03v3 ad=0.65p pd=3.02u as=0.65p ps=3.02u w=2.5u l=0.28u
X94 NCIA.t34 a_21516_340.t36 VSS.t261 VSS.t260 nfet_03v3 ad=0.26p pd=1.52u as=0.26p ps=1.52u w=1u l=0.28u
X95 VDD.t39 a_1036_6700.t37 NCDB.t11 VDD.t38 pfet_03v3 ad=4.5p pd=20.9u as=2.6p ps=10.52u w=10u l=0.28u
X96 a_9196_340.t1 a_8556_1540.t4 VDD.t399 VDD.t354 pfet_03v3 ad=1.125p pd=5.9u as=1.125p ps=5.9u w=2.5u l=0.28u
X97 VDD.t369 a_5676_4320.t54 NCIB.t19 VDD.t368 pfet_03v3 ad=0.65p pd=3.02u as=0.65p ps=3.02u w=2.5u l=0.28u
X98 a_4492_4188.t1 a_15116_340.t4 VDD.t155 VDD.t90 pfet_03v3 ad=1.125p pd=5.9u as=1.125p ps=5.9u w=2.5u l=0.28u
X99 VSS.t133 a_14476_1540.t5 a_16236_340.t2 VSS.t132 nfet_03v3 ad=0.45p pd=2.9u as=0.26p ps=1.52u w=1u l=0.28u
X100 NCIB.t4 a_5676_4320.t24 VDD.t382 VDD.t160 pfet_03v3 ad=0.65p pd=3.02u as=0.65p ps=3.02u w=2.5u l=0.28u
X101 VDD.t145 a_1292_12000.t33 NCDA.t7 VDD.t144 pfet_03v3 ad=2.6p pd=10.52u as=2.6p ps=10.52u w=10u l=0.28u
X102 CIB.t4 a_1036_4320.t20 VDD.t21 VDD.t20 pfet_03v3 ad=0.65p pd=3.02u as=0.65p ps=3.02u w=2.5u l=0.28u
X103 VSS.t375 a_5676_4320.t19 NCIB.t25 VSS.t374 nfet_03v3 ad=0.26p pd=1.52u as=0.26p ps=1.52u w=1u l=0.28u
X104 NCIB.t6 a_5676_4320.t28 VDD.t386 VDD.t385 pfet_03v3 ad=0.65p pd=3.02u as=0.65p ps=3.02u w=2.5u l=0.28u
X105 a_1292_12000.t18 a_18316_4320.t21 VSS.t201 VSS.t200 nfet_03v3 ad=0.26p pd=1.52u as=0.26p ps=1.52u w=1u l=0.28u
X106 VDD.t267 a_21516_340.t59 NCIA.t21 VDD.t266 pfet_03v3 ad=0.65p pd=3.02u as=0.65p ps=3.02u w=2.5u l=0.28u
X107 a_16876_340.t6 a_16236_340.t4 VSS.t145 VSS.t144 nfet_03v3 ad=0.26p pd=1.52u as=0.45p ps=2.9u w=1u l=0.28u
X108 VDD.t122 a_12076_4320.t30 CDA.t7 VDD.t121 pfet_03v3 ad=0.65p pd=3.02u as=0.65p ps=3.02u w=2.5u l=0.28u
X109 CDA.t26 a_12076_4320.t21 VSS.t71 VSS.t70 nfet_03v3 ad=0.26p pd=1.52u as=0.26p ps=1.52u w=1u l=0.28u
X110 VSS.t11 a_1036_4320.t15 CIB.t13 VSS.t10 nfet_03v3 ad=0.26p pd=1.52u as=0.26p ps=1.52u w=1u l=0.28u
X111 CIB.t6 a_1036_4320.t24 VDD.t25 VDD.t24 pfet_03v3 ad=0.65p pd=3.02u as=0.65p ps=3.02u w=2.5u l=0.28u
X112 NCIA.t24 a_21516_340.t16 VSS.t241 VSS.t240 nfet_03v3 ad=0.26p pd=1.52u as=0.45p ps=2.9u w=1u l=0.28u
X113 VDD.t165 a_16236_340.t7 a_16876_340.t9 VDD.t108 pfet_03v3 ad=0.65p pd=3.02u as=0.65p ps=3.02u w=2.5u l=0.28u
X114 VDD.t125 a_12076_4320.t34 CDA.t9 VDD.t60 pfet_03v3 ad=0.65p pd=3.02u as=0.65p ps=3.02u w=2.5u l=0.28u
X115 CDA.t28 a_12076_4320.t25 VSS.t75 VSS.t74 nfet_03v3 ad=0.26p pd=1.52u as=0.26p ps=1.52u w=1u l=0.28u
X116 VDD.t293 a_21516_4320.t46 CDB.t15 VDD.t252 pfet_03v3 ad=0.65p pd=3.02u as=0.65p ps=3.02u w=2.5u l=0.28u
X117 CDB.t34 a_21516_4320.t37 VSS.t309 VSS.t308 nfet_03v3 ad=0.26p pd=1.52u as=0.26p ps=1.52u w=1u l=0.28u
X118 NCDA.t10 a_1292_12000.t36 VDD.t131 VDD.t130 pfet_03v3 ad=2.6p pd=10.52u as=2.6p ps=10.52u w=10u l=0.28u
X119 NCIB.t18 a_5676_4320.t52 VDD.t367 VDD.t366 pfet_03v3 ad=0.65p pd=3.02u as=0.65p ps=3.02u w=2.5u l=0.28u
X120 a_1036_340.t1 CHOP1.t1 VDD.t1 VDD.t0 pfet_03v3 ad=1.125p pd=5.9u as=1.125p ps=5.9u w=2.5u l=0.28u
X121 VSS.t247 a_21516_340.t22 NCIA.t27 VSS.t246 nfet_03v3 ad=0.26p pd=1.52u as=0.26p ps=1.52u w=1u l=0.28u
X122 VDD.t381 a_5676_4320.t22 NCIB.t3 VDD.t380 pfet_03v3 ad=0.65p pd=3.02u as=0.65p ps=3.02u w=2.5u l=0.28u
X123 VDD.t47 a_1036_6700.t31 NCDB.t5 VDD.t46 pfet_03v3 ad=2.6p pd=10.52u as=2.6p ps=10.52u w=10u l=0.28u
X124 a_1292_12000.t4 a_18316_4320.t12 VDD.t202 VDD.t194 pfet_03v3 ad=0.65p pd=3.02u as=0.65p ps=3.02u w=2.5u l=0.28u
X125 NCIB.t24 a_5676_4320.t17 VSS.t373 VSS.t372 nfet_03v3 ad=0.26p pd=1.52u as=0.45p ps=2.9u w=1u l=0.28u
X126 a_2500_1540# a_1516_340.t4 VSS.t141 VSS.t140 nfet_03v3 ad=0.45p pd=2.9u as=0.45p ps=2.9u w=1u l=4u
X127 VDD.t384 a_5676_4320.t26 NCIB.t5 VDD.t383 pfet_03v3 ad=0.65p pd=3.02u as=0.65p ps=3.02u w=2.5u l=0.28u
X128 VSS.t199 a_18316_4320.t19 a_1292_12000.t17 VSS.t198 nfet_03v3 ad=0.26p pd=1.52u as=0.26p ps=1.52u w=1u l=0.28u
X129 VDD.t129 a_1292_12000.t23 NCDA.t1 VDD.t128 pfet_03v3 ad=2.6p pd=10.52u as=2.6p ps=10.52u w=10u l=0.28u
X130 VSS.t129 a_13380_1540# a_15116_340.t1 VSS.t128 nfet_03v3 ad=0.45p pd=2.9u as=0.26p ps=1.52u w=1u l=0.28u
X131 VSS.t187 a_18316_4320.t7 a_1292_12000.t11 VSS.t186 nfet_03v3 ad=0.26p pd=1.52u as=0.26p ps=1.52u w=1u l=0.28u
X132 NCIA.t0 a_21516_340.t17 VDD.t239 VDD.t238 pfet_03v3 ad=0.65p pd=3.02u as=1.125p ps=5.9u w=2.5u l=0.28u
X133 VSS.t415 a_5676_4320.t59 NCIB.t45 VSS.t414 nfet_03v3 ad=0.26p pd=1.52u as=0.26p ps=1.52u w=1u l=0.28u
X134 a_11436_4320.t0 a_7916_340.t3 VDD.t394 VDD.t393 pfet_03v3 ad=0.65p pd=3.02u as=1.125p ps=5.9u w=2.5u l=0.28u
X135 VSS.t73 a_12076_4320.t23 CDA.t27 VSS.t72 nfet_03v3 ad=0.26p pd=1.52u as=0.26p ps=1.52u w=1u l=0.28u
X136 a_16876_340.t7 a_16236_340.t5 VDD.t164 VDD.t106 pfet_03v3 ad=0.65p pd=3.02u as=1.125p ps=5.9u w=2.5u l=0.28u
X137 VDD.t353 a_5676_4320.t38 NCIB.t11 VDD.t352 pfet_03v3 ad=0.65p pd=3.02u as=0.65p ps=3.02u w=2.5u l=0.28u
X138 VSS.t435 a_9196_340.t5 a_20876_4320.t3 VSS.t434 nfet_03v3 ad=0.45p pd=2.9u as=0.26p ps=1.52u w=1u l=0.28u
X139 a_4492_4188.t0 a_15116_340.t3 VSS.t137 VSS.t136 nfet_03v3 ad=0.45p pd=2.9u as=0.45p ps=2.9u w=1u l=0.28u
X140 a_21516_4320.t14 a_20876_4320.t8 VDD.t232 VDD.t218 pfet_03v3 ad=0.65p pd=3.02u as=0.65p ps=3.02u w=2.5u l=0.28u
X141 VSS.t307 a_21516_4320.t35 CDB.t33 VSS.t306 nfet_03v3 ad=0.26p pd=1.52u as=0.26p ps=1.52u w=1u l=0.28u
X142 CDB.t14 a_21516_4320.t44 VDD.t292 VDD.t250 pfet_03v3 ad=0.65p pd=3.02u as=0.65p ps=3.02u w=2.5u l=0.28u
X143 a_16876_340.t11 a_16236_340.t9 VDD.t166 VDD.t110 pfet_03v3 ad=0.65p pd=3.02u as=0.65p ps=3.02u w=2.5u l=0.28u
X144 VSS.t171 a_16876_340.t26 CIA.t19 VSS.t170 nfet_03v3 ad=0.26p pd=1.52u as=0.26p ps=1.52u w=1u l=0.28u
X145 NCDA.t4 a_1292_12000.t29 VDD.t139 VDD.t138 pfet_03v3 ad=2.6p pd=10.52u as=2.6p ps=10.52u w=10u l=0.28u
X146 CDA.t14 a_12076_4320.t44 VDD.t93 VDD.t92 pfet_03v3 ad=0.65p pd=3.02u as=0.65p ps=3.02u w=2.5u l=0.28u
X147 CIB.t20 a_1036_4320.t29 VSS.t25 VSS.t24 nfet_03v3 ad=0.26p pd=1.52u as=0.26p ps=1.52u w=1u l=0.28u
X148 VDD.t379 a_5676_4320.t62 NCIB.t23 VDD.t378 pfet_03v3 ad=1.125p pd=5.9u as=0.65p ps=3.02u w=2.5u l=0.28u
X149 a_21516_340.t6 a_20876_340.t16 VSS.t221 VSS.t220 nfet_03v3 ad=0.26p pd=1.52u as=0.26p ps=1.52u w=1u l=0.28u
X150 VSS.t89 a_12076_4320.t39 CDA.t35 VSS.t88 nfet_03v3 ad=0.26p pd=1.52u as=0.26p ps=1.52u w=1u l=0.28u
X151 CDA.t16 a_12076_4320.t48 VDD.t97 VDD.t96 pfet_03v3 ad=0.65p pd=3.02u as=0.65p ps=3.02u w=2.5u l=0.28u
X152 CIA.t22 a_16876_340.t32 VSS.t177 VSS.t176 nfet_03v3 ad=0.26p pd=1.52u as=0.26p ps=1.52u w=1u l=0.28u
X153 VSS.t323 a_21516_4320.t51 CDB.t41 VSS.t322 nfet_03v3 ad=0.26p pd=1.52u as=0.26p ps=1.52u w=1u l=0.28u
X154 CDB.t22 a_21516_4320.t60 VDD.t301 VDD.t268 pfet_03v3 ad=0.65p pd=3.02u as=0.65p ps=3.02u w=2.5u l=0.28u
X155 NCIB.t44 a_5676_4320.t57 VSS.t413 VSS.t412 nfet_03v3 ad=0.26p pd=1.52u as=0.26p ps=1.52u w=1u l=0.28u
X156 VDD.t7 a_1036_340.t5 a_1516_340.t3 VDD.t6 pfet_03v3 ad=1.125p pd=5.9u as=0.65p ps=3.02u w=2.5u l=0.28u
X157 NCIB.t10 a_5676_4320.t36 VDD.t351 VDD.t350 pfet_03v3 ad=0.65p pd=3.02u as=0.65p ps=3.02u w=2.5u l=0.28u
X158 VDD.t231 a_20876_4320.t6 a_21516_4320.t12 VDD.t216 pfet_03v3 ad=0.65p pd=3.02u as=0.65p ps=3.02u w=2.5u l=0.28u
X159 a_20876_4320.t2 a_9196_340.t3 VSS.t433 VSS.t432 nfet_03v3 ad=0.26p pd=1.52u as=0.45p ps=2.9u w=1u l=0.28u
X160 VSS.t121 a_1292_12000.t26 NCDA.t15 VSS.t120 nfet_03v3 ad=2.08p pd=8.52u as=2.08p ps=8.52u w=8u l=0.28u
X161 a_1292_12000.t16 a_18316_4320.t17 VSS.t197 VSS.t196 nfet_03v3 ad=0.26p pd=1.52u as=0.26p ps=1.52u w=1u l=0.28u
X162 VSS.t387 a_5676_4320.t31 NCIB.t31 VSS.t386 nfet_03v3 ad=0.26p pd=1.52u as=0.26p ps=1.52u w=1u l=0.28u
X163 NCIB.t12 a_5676_4320.t40 VDD.t355 VDD.t354 pfet_03v3 ad=0.65p pd=3.02u as=0.65p ps=3.02u w=2.5u l=0.28u
X164 VDD.t277 a_21516_340.t27 NCIA.t5 VDD.t276 pfet_03v3 ad=0.65p pd=3.02u as=0.65p ps=3.02u w=2.5u l=0.28u
X165 VSS.t283 a_21516_340.t58 NCIA.t45 VSS.t282 nfet_03v3 ad=0.26p pd=1.52u as=0.26p ps=1.52u w=1u l=0.28u
X166 VDD.t91 a_12076_4320.t42 CDA.t13 VDD.t90 pfet_03v3 ad=0.65p pd=3.02u as=0.65p ps=3.02u w=2.5u l=0.28u
X167 CDA.t32 a_12076_4320.t33 VSS.t83 VSS.t82 nfet_03v3 ad=0.26p pd=1.52u as=0.26p ps=1.52u w=1u l=0.28u
X168 a_5380_1540# a_3940_1540# VSS.t343 VSS.t342 nfet_03v3 ad=0.45p pd=2.9u as=0.45p ps=2.9u w=1u l=4u
X169 VSS.t451 a_972_8460.t6 a_1036_6700.t11 VSS.t440 nfet_03v3 ad=0.26p pd=1.52u as=0.26p ps=1.52u w=1u l=0.28u
X170 VDD.t281 a_21516_340.t31 NCIA.t7 VDD.t280 pfet_03v3 ad=0.65p pd=3.02u as=0.65p ps=3.02u w=2.5u l=0.28u
X171 VDD.t95 a_12076_4320.t46 CDA.t15 VDD.t94 pfet_03v3 ad=0.65p pd=3.02u as=0.65p ps=3.02u w=2.5u l=0.28u
X172 CDA.t34 a_12076_4320.t37 VSS.t87 VSS.t86 nfet_03v3 ad=0.26p pd=1.52u as=0.26p ps=1.52u w=1u l=0.28u
X173 CIA.t12 a_16876_340.t12 VSS.t157 VSS.t156 nfet_03v3 ad=0.26p pd=1.52u as=0.45p ps=2.9u w=1u l=0.28u
X174 a_6820_1540# a_5380_1540# VDD.t345 VDD.t344 pfet_03v3 ad=0.45p pd=2.9u as=0.45p ps=2.9u w=1u l=2u
X175 VDD.t300 a_21516_4320.t58 CDB.t21 VDD.t266 pfet_03v3 ad=0.65p pd=3.02u as=0.65p ps=3.02u w=2.5u l=0.28u
X176 CDB.t40 a_21516_4320.t49 VSS.t321 VSS.t320 nfet_03v3 ad=0.26p pd=1.52u as=0.26p ps=1.52u w=1u l=0.28u
X177 VDD.t175 a_16876_340.t15 CIA.t1 VDD.t174 pfet_03v3 ad=0.65p pd=3.02u as=0.65p ps=3.02u w=2.5u l=0.28u
X178 VDD.t109 a_12076_4320.t58 CDA.t21 VDD.t108 pfet_03v3 ad=0.65p pd=3.02u as=0.65p ps=3.02u w=2.5u l=0.28u
X179 VSS.t195 a_18316_4320.t15 a_1292_12000.t15 VSS.t194 nfet_03v3 ad=0.26p pd=1.52u as=0.26p ps=1.52u w=1u l=0.28u
X180 a_13380_1540# a_11940_1540# VSS.t65 VSS.t64 nfet_03v3 ad=0.45p pd=2.9u as=0.45p ps=2.9u w=1u l=4u
X181 NCIA.t4 a_21516_340.t25 VDD.t275 VDD.t274 pfet_03v3 ad=0.65p pd=3.02u as=0.65p ps=3.02u w=2.5u l=0.28u
X182 a_1036_4320.t0 a_972_4188.t4 VDD.t403 VDD.t0 pfet_03v3 ad=0.65p pd=3.02u as=1.125p ps=5.9u w=2.5u l=0.28u
X183 VSS.t427 a_7916_340.t6 a_11436_4320.t3 VSS.t426 nfet_03v3 ad=0.45p pd=2.9u as=0.26p ps=1.52u w=1u l=0.28u
X184 NCDB.t14 a_1036_6700.t24 VSS.t37 VSS.t36 nfet_03v3 ad=2.08p pd=8.52u as=2.08p ps=8.52u w=8u l=0.28u
X185 NCIA.t6 a_21516_340.t29 VDD.t279 VDD.t278 pfet_03v3 ad=0.65p pd=3.02u as=0.65p ps=3.02u w=2.5u l=0.28u
X186 a_12076_4320.t14 a_11436_4320.t8 VDD.t67 VDD.t66 pfet_03v3 ad=0.65p pd=3.02u as=0.65p ps=3.02u w=2.5u l=0.28u
X187 VDD.t419 a_972_8460.t11 a_1036_6700.t3 VDD.t418 pfet_03v3 ad=0.65p pd=3.02u as=0.65p ps=3.02u w=2.5u l=0.28u
X188 VDD.t365 a_5676_4320.t50 NCIB.t17 VDD.t364 pfet_03v3 ad=0.65p pd=3.02u as=0.65p ps=3.02u w=2.5u l=0.28u
X189 VSS.t231 a_20876_4320.t11 a_21516_4320.t1 VSS.t230 nfet_03v3 ad=0.26p pd=1.52u as=0.26p ps=1.52u w=1u l=0.28u
X190 NCIA.t38 a_21516_340.t44 VSS.t269 VSS.t268 nfet_03v3 ad=0.26p pd=1.52u as=0.26p ps=1.52u w=1u l=0.28u
X191 a_1036_6700.t16 a_972_8460.t16 VSS.t457 VSS.t456 nfet_03v3 ad=0.26p pd=1.52u as=0.26p ps=1.52u w=1u l=0.28u
X192 VSS.t147 a_16236_340.t6 a_16876_340.t8 VSS.t146 nfet_03v3 ad=0.26p pd=1.52u as=0.26p ps=1.52u w=1u l=0.28u
X193 VDD.t59 a_11116_340.t5 a_14476_1540.t1 VDD.t58 pfet_03v3 ad=1.125p pd=5.9u as=0.65p ps=3.02u w=2.5u l=0.28u
X194 NCIB.t38 a_5676_4320.t45 VSS.t401 VSS.t400 nfet_03v3 ad=0.26p pd=1.52u as=0.26p ps=1.52u w=1u l=0.28u
X195 CIA.t0 a_16876_340.t13 VDD.t173 VDD.t172 pfet_03v3 ad=0.65p pd=3.02u as=1.125p ps=5.9u w=2.5u l=0.28u
X196 VSS.t235 a_20876_4320.t15 a_21516_4320.t5 VSS.t234 nfet_03v3 ad=0.26p pd=1.52u as=0.26p ps=1.52u w=1u l=0.28u
X197 NCIA.t12 a_21516_340.t41 VDD.t247 VDD.t246 pfet_03v3 ad=0.65p pd=3.02u as=0.65p ps=3.02u w=2.5u l=0.28u
X198 CDB.t0 a_21516_4320.t16 VDD.t286 VDD.t238 pfet_03v3 ad=0.65p pd=3.02u as=1.125p ps=5.9u w=2.5u l=0.28u
X199 CDA.t20 a_12076_4320.t56 VDD.t107 VDD.t106 pfet_03v3 ad=0.65p pd=3.02u as=0.65p ps=3.02u w=2.5u l=0.28u
X200 a_4556_4320.t1 a_4492_4188.t3 VSS.t345 VSS.t344 nfet_03v3 ad=0.45p pd=2.9u as=0.45p ps=2.9u w=1u l=0.28u
X201 VDD.t411 a_972_4188.t14 a_1036_4320.t5 VDD.t410 pfet_03v3 ad=1.125p pd=5.9u as=0.65p ps=3.02u w=2.5u l=0.28u
X202 a_1036_6700.t18 a_972_8460.t20 VSS.t460 VSS.t8 nfet_03v3 ad=0.26p pd=1.52u as=0.26p ps=1.52u w=1u l=0.28u
X203 VSS.t101 a_12076_4320.t51 CDA.t41 VSS.t100 nfet_03v3 ad=0.26p pd=1.52u as=0.26p ps=1.52u w=1u l=0.28u
X204 CDA.t22 a_12076_4320.t60 VDD.t111 VDD.t110 pfet_03v3 ad=0.65p pd=3.02u as=0.65p ps=3.02u w=2.5u l=0.28u
X205 NCDB.t10 a_1036_6700.t36 VDD.t37 VDD.t36 pfet_03v3 ad=2.6p pd=10.52u as=2.6p ps=10.52u w=10u l=0.28u
X206 a_20396_340.t1 a_14476_1540.t8 VDD.t154 VDD.t153 pfet_03v3 ad=1.125p pd=5.9u as=1.125p ps=5.9u w=2.5u l=0.28u
X207 VSS.t335 a_21516_4320.t63 CDB.t47 VSS.t334 nfet_03v3 ad=0.45p pd=2.9u as=0.26p ps=1.52u w=1u l=0.28u
X208 a_7916_340.t0 a_1516_340.t6 VSS.t143 VSS.t142 nfet_03v3 ad=0.26p pd=1.52u as=0.45p ps=2.9u w=1u l=0.28u
X209 NCDA.t6 a_1292_12000.t32 VDD.t143 VDD.t142 pfet_03v3 ad=2.6p pd=10.52u as=2.6p ps=10.52u w=10u l=0.28u
X210 a_1036_6700.t2 a_972_8460.t9 VDD.t417 VDD.t416 pfet_03v3 ad=0.65p pd=3.02u as=0.65p ps=3.02u w=2.5u l=0.28u
X211 CIA.t8 a_16876_340.t29 VDD.t193 VDD.t192 pfet_03v3 ad=0.65p pd=3.02u as=0.65p ps=3.02u w=2.5u l=0.28u
X212 a_14476_1540.t2 a_13380_1540# VDD.t150 VDD.t118 pfet_03v3 ad=0.65p pd=3.02u as=1.125p ps=5.9u w=2.5u l=0.28u
X213 VSS.t357 a_5036_4320.t7 a_5676_4320.t13 VSS.t356 nfet_03v3 ad=0.26p pd=1.52u as=0.26p ps=1.52u w=1u l=0.28u
X214 VSS.t399 a_5676_4320.t43 NCIB.t37 VSS.t398 nfet_03v3 ad=0.26p pd=1.52u as=0.26p ps=1.52u w=1u l=0.28u
X215 a_5676_4320.t6 a_5036_4320.t16 VDD.t341 VDD.t340 pfet_03v3 ad=0.65p pd=3.02u as=0.65p ps=3.02u w=2.5u l=0.28u
X216 VDD.t245 a_21516_340.t39 NCIA.t11 VDD.t244 pfet_03v3 ad=0.65p pd=3.02u as=0.65p ps=3.02u w=2.5u l=0.28u
X217 a_21516_4320.t3 a_20876_4320.t13 VSS.t233 VSS.t232 nfet_03v3 ad=0.26p pd=1.52u as=0.26p ps=1.52u w=1u l=0.28u
X218 a_1036_4320.t4 a_972_4188.t12 VDD.t409 VDD.t6 pfet_03v3 ad=0.65p pd=3.02u as=0.65p ps=3.02u w=2.5u l=0.28u
X219 VSS.t459 a_972_8460.t18 a_1036_6700.t17 VSS.t458 nfet_03v3 ad=0.26p pd=1.52u as=0.26p ps=1.52u w=1u l=0.28u
X220 VDD.t249 a_21516_340.t43 NCIA.t13 VDD.t248 pfet_03v3 ad=0.65p pd=3.02u as=0.65p ps=3.02u w=2.5u l=0.28u
X221 a_12076_4320.t3 a_11436_4320.t13 VSS.t57 VSS.t56 nfet_03v3 ad=0.26p pd=1.52u as=0.26p ps=1.52u w=1u l=0.28u
X222 VDD.t187 a_16876_340.t23 CIA.t5 VDD.t186 pfet_03v3 ad=0.65p pd=3.02u as=0.65p ps=3.02u w=2.5u l=0.28u
X223 VSS.t441 a_972_4188.t7 a_1036_4320.t7 VSS.t440 nfet_03v3 ad=0.26p pd=1.52u as=0.26p ps=1.52u w=1u l=0.28u
X224 VDD.t149 a_1292_12000.t35 NCDA.t9 VDD.t148 pfet_03v3 ad=2.6p pd=10.52u as=2.6p ps=10.52u w=10u l=0.28u
X225 VDD.t305 a_21516_4320.t26 CDB.t5 VDD.t276 pfet_03v3 ad=0.65p pd=3.02u as=0.65p ps=3.02u w=2.5u l=0.28u
X226 CIA.t20 a_16876_340.t28 VSS.t173 VSS.t172 nfet_03v3 ad=0.26p pd=1.52u as=0.26p ps=1.52u w=1u l=0.28u
X227 VDD.t191 a_16876_340.t27 CIA.t7 VDD.t190 pfet_03v3 ad=0.65p pd=3.02u as=0.65p ps=3.02u w=2.5u l=0.28u
X228 CDB.t26 a_21516_4320.t21 VSS.t293 VSS.t292 nfet_03v3 ad=0.26p pd=1.52u as=0.26p ps=1.52u w=1u l=0.28u
X229 VDD.t307 a_21516_4320.t30 CDB.t7 VDD.t280 pfet_03v3 ad=0.65p pd=3.02u as=0.65p ps=3.02u w=2.5u l=0.28u
X230 a_5676_4320.t11 a_5036_4320.t5 VSS.t355 VSS.t354 nfet_03v3 ad=0.26p pd=1.52u as=0.45p ps=2.9u w=1u l=0.28u
X231 VSS.t223 a_20876_340.t18 a_21516_340.t8 VSS.t222 nfet_03v3 ad=0.45p pd=2.9u as=0.26p ps=1.52u w=1u l=0.28u
X232 VDD.t339 a_5036_4320.t14 a_5676_4320.t4 VDD.t338 pfet_03v3 ad=0.65p pd=3.02u as=0.65p ps=3.02u w=2.5u l=0.28u
X233 VSS.t179 a_16876_340.t34 CIA.t23 VSS.t178 nfet_03v3 ad=0.45p pd=2.9u as=0.26p ps=1.52u w=1u l=0.28u
X234 a_11116_340.t0 a_10020_1540# VDD.t3 VDD.t2 pfet_03v3 ad=1.125p pd=5.9u as=1.125p ps=5.9u w=2.5u l=0.28u
X235 a_18316_4320.t0 a_17836_4320.t2 VDD.t196 VDD.t174 pfet_03v3 ad=0.65p pd=3.02u as=1.125p ps=5.9u w=2.5u l=0.28u
X236 VDD.t163 a_1516_340.t9 a_8556_1540.t1 VDD.t162 pfet_03v3 ad=1.125p pd=5.9u as=0.65p ps=3.02u w=2.5u l=0.28u
X237 a_21516_340.t11 a_20876_340.t5 VDD.t215 VDD.t214 pfet_03v3 ad=0.65p pd=3.02u as=1.125p ps=5.9u w=2.5u l=0.28u
X238 VSS.t341 a_27276_4320.t5 a_972_8460.t3 VSS.t340 nfet_03v3 ad=0.45p pd=2.9u as=0.26p ps=1.52u w=1u l=0.28u
X239 VSS.t55 a_11436_4320.t11 a_12076_4320.t1 VSS.t54 nfet_03v3 ad=0.26p pd=1.52u as=0.26p ps=1.52u w=1u l=0.28u
X240 VDD.t431 a_972_8460.t23 a_1036_6700.t9 VDD.t430 pfet_03v3 ad=1.125p pd=5.9u as=0.65p ps=3.02u w=2.5u l=0.28u
X241 CDB.t4 a_21516_4320.t24 VDD.t304 VDD.t274 pfet_03v3 ad=0.65p pd=3.02u as=0.65p ps=3.02u w=2.5u l=0.28u
X242 VSS.t7 a_1036_340.t4 a_1516_340.t2 VSS.t6 nfet_03v3 ad=0.45p pd=2.9u as=0.26p ps=1.52u w=1u l=0.28u
X243 NCIA.t46 a_21516_340.t60 VSS.t285 VSS.t284 nfet_03v3 ad=0.26p pd=1.52u as=0.26p ps=1.52u w=1u l=0.28u
X244 VSS.t291 a_21516_4320.t19 CDB.t25 VSS.t290 nfet_03v3 ad=0.26p pd=1.52u as=0.26p ps=1.52u w=1u l=0.28u
X245 NCIA.t18 a_21516_340.t53 VDD.t259 VDD.t258 pfet_03v3 ad=0.65p pd=3.02u as=0.65p ps=3.02u w=2.5u l=0.28u
X246 CDB.t6 a_21516_4320.t28 VDD.t306 VDD.t278 pfet_03v3 ad=0.65p pd=3.02u as=0.65p ps=3.02u w=2.5u l=0.28u
X247 VDD.t137 a_1292_12000.t27 NCDA.t3 VDD.t136 pfet_03v3 ad=2.6p pd=10.52u as=2.6p ps=10.52u w=10u l=0.28u
X248 VDD.t19 a_1036_4320.t18 CIB.t3 VDD.t18 pfet_03v3 ad=0.65p pd=3.02u as=0.65p ps=3.02u w=2.5u l=0.28u
X249 VSS.t159 a_16876_340.t14 CIA.t13 VSS.t158 nfet_03v3 ad=0.26p pd=1.52u as=0.26p ps=1.52u w=1u l=0.28u
X250 NCIA.t20 a_21516_340.t57 VDD.t265 VDD.t264 pfet_03v3 ad=0.65p pd=3.02u as=0.65p ps=3.02u w=2.5u l=0.28u
X251 CDA.t6 a_12076_4320.t28 VDD.t120 VDD.t58 pfet_03v3 ad=0.65p pd=3.02u as=0.65p ps=3.02u w=2.5u l=0.28u
X252 VSS.t69 a_12076_4320.t19 CDA.t25 VSS.t68 nfet_03v3 ad=0.26p pd=1.52u as=0.26p ps=1.52u w=1u l=0.28u
X253 CIB.t12 a_1036_4320.t13 VSS.t9 VSS.t8 nfet_03v3 ad=0.26p pd=1.52u as=0.45p ps=2.9u w=1u l=0.28u
X254 VSS.t113 a_12076_4320.t63 CDA.t47 VSS.t112 nfet_03v3 ad=0.45p pd=2.9u as=0.26p ps=1.52u w=1u l=0.28u
X255 a_5380_1540# a_3940_1540# VDD.t317 VDD.t316 pfet_03v3 ad=0.45p pd=2.9u as=0.45p ps=2.9u w=1u l=2u
X256 VDD.t23 a_1036_4320.t22 CIB.t5 VDD.t22 pfet_03v3 ad=0.65p pd=3.02u as=0.65p ps=3.02u w=2.5u l=0.28u
X257 a_8556_1540.t2 a_6820_1540# VDD.t392 VDD.t389 pfet_03v3 ad=0.65p pd=3.02u as=1.125p ps=5.9u w=2.5u l=0.28u
X258 CDB.t12 a_21516_4320.t40 VDD.t290 VDD.t246 pfet_03v3 ad=0.65p pd=3.02u as=0.65p ps=3.02u w=2.5u l=0.28u
X259 a_21516_340.t10 a_20876_340.t4 VSS.t209 VSS.t208 nfet_03v3 ad=0.26p pd=1.52u as=0.45p ps=2.9u w=1u l=0.28u
X260 a_972_8460.t1 a_27276_4320.t3 VSS.t339 VSS.t338 nfet_03v3 ad=0.26p pd=1.52u as=0.45p ps=2.9u w=1u l=0.28u
X261 CIA.t16 a_16876_340.t20 VSS.t165 VSS.t164 nfet_03v3 ad=0.26p pd=1.52u as=0.26p ps=1.52u w=1u l=0.28u
X262 VSS.t369 a_5036_4320.t19 a_5676_4320.t9 VSS.t368 nfet_03v3 ad=0.45p pd=2.9u as=0.26p ps=1.52u w=1u l=0.28u
X263 a_9196_340.t0 a_8556_1540.t3 VSS.t431 VSS.t430 nfet_03v3 ad=0.45p pd=2.9u as=0.45p ps=2.9u w=1u l=0.28u
X264 VSS.t215 a_20876_340.t10 a_21516_340.t0 VSS.t214 nfet_03v3 ad=0.26p pd=1.52u as=0.26p ps=1.52u w=1u l=0.28u
X265 NCIB.t2 a_5676_4320.t20 VDD.t371 VDD.t370 pfet_03v3 ad=0.65p pd=3.02u as=0.65p ps=3.02u w=2.5u l=0.28u
X266 VDD.t209 a_18316_4320.t22 a_1292_12000.t9 VDD.t153 pfet_03v3 ad=1.125p pd=5.9u as=0.65p ps=3.02u w=2.5u l=0.28u
X267 VDD.t201 a_18316_4320.t10 a_1292_12000.t3 VDD.t192 pfet_03v3 ad=0.65p pd=3.02u as=0.65p ps=3.02u w=2.5u l=0.28u
X268 VDD.t261 a_21516_340.t55 NCIA.t19 VDD.t260 pfet_03v3 ad=0.65p pd=3.02u as=0.65p ps=3.02u w=2.5u l=0.28u
X269 a_10020_1540# a_1516_340.t10 VSS.t139 VSS.t138 nfet_03v3 ad=0.45p pd=2.9u as=0.45p ps=2.9u w=1u l=4u
X270 VSS.t271 a_21516_340.t46 NCIA.t39 VSS.t270 nfet_03v3 ad=0.26p pd=1.52u as=0.26p ps=1.52u w=1u l=0.28u
X271 VDD.t229 a_20876_340.t19 a_21516_340.t9 VDD.t228 pfet_03v3 ad=1.125p pd=5.9u as=0.65p ps=3.02u w=2.5u l=0.28u
X272 CDA.t24 a_12076_4320.t17 VSS.t67 VSS.t66 nfet_03v3 ad=0.26p pd=1.52u as=0.45p ps=2.9u w=1u l=0.28u
X273 VDD.t119 a_12076_4320.t26 CDA.t5 VDD.t118 pfet_03v3 ad=0.65p pd=3.02u as=0.65p ps=3.02u w=2.5u l=0.28u
X274 VDD.t289 a_21516_4320.t38 CDB.t11 VDD.t244 pfet_03v3 ad=0.65p pd=3.02u as=0.65p ps=3.02u w=2.5u l=0.28u
X275 NCDB.t2 a_1036_6700.t25 VDD.t41 VDD.t40 pfet_03v3 ad=2.6p pd=10.52u as=2.6p ps=10.52u w=10u l=0.28u
X276 a_16876_340.t10 a_16236_340.t8 VSS.t149 VSS.t148 nfet_03v3 ad=0.26p pd=1.52u as=0.26p ps=1.52u w=1u l=0.28u
X277 NCIA.t42 a_21516_340.t52 VSS.t277 VSS.t276 nfet_03v3 ad=0.26p pd=1.52u as=0.26p ps=1.52u w=1u l=0.28u
X278 CDB.t32 a_21516_4320.t33 VSS.t305 VSS.t304 nfet_03v3 ad=0.26p pd=1.52u as=0.26p ps=1.52u w=1u l=0.28u
X279 VDD.t291 a_21516_4320.t42 CDB.t13 VDD.t248 pfet_03v3 ad=0.65p pd=3.02u as=0.65p ps=3.02u w=2.5u l=0.28u
X280 a_1292_12000.t0 a_18316_4320.t4 VDD.t198 VDD.t186 pfet_03v3 ad=0.65p pd=3.02u as=1.125p ps=5.9u w=2.5u l=0.28u
X281 CIB.t10 a_1036_4320.t32 VDD.t13 VDD.t12 pfet_03v3 ad=0.65p pd=3.02u as=0.65p ps=3.02u w=2.5u l=0.28u
X282 a_20396_340.t0 a_14476_1540.t7 VSS.t135 VSS.t134 nfet_03v3 ad=0.45p pd=2.9u as=0.45p ps=2.9u w=1u l=0.28u
X283 VDD.t323 a_4492_4188.t7 a_972_4188.t3 VDD.t322 pfet_03v3 ad=1.125p pd=5.9u as=0.65p ps=3.02u w=2.5u l=0.28u
X284 VSS.t155 a_16236_340.t14 a_16876_340.t4 VSS.t154 nfet_03v3 ad=0.45p pd=2.9u as=0.26p ps=1.52u w=1u l=0.28u
X285 VDD.t133 a_1292_12000.t37 NCDA.t11 VDD.t132 pfet_03v3 ad=4.5p pd=20.9u as=2.6p ps=10.52u w=10u l=0.28u
X286 VSS.t183 a_17836_4320.t5 a_18316_4320.t3 VSS.t182 nfet_03v3 ad=0.45p pd=2.9u as=0.26p ps=1.52u w=1u l=0.28u
X287 VSS.t23 a_1036_4320.t27 CIB.t19 VSS.t22 nfet_03v3 ad=0.26p pd=1.52u as=0.26p ps=1.52u w=1u l=0.28u
X288 a_1292_12000.t2 a_18316_4320.t8 VDD.t200 VDD.t190 pfet_03v3 ad=0.65p pd=3.02u as=0.65p ps=3.02u w=2.5u l=0.28u
X289 a_10020_1540# a_1516_340.t11 VDD.t157 VDD.t156 pfet_03v3 ad=0.45p pd=2.9u as=0.45p ps=2.9u w=1u l=2u
X290 VSS.t35 a_1036_6700.t22 NCDB.t13 VSS.t34 nfet_03v3 ad=2.08p pd=8.52u as=2.08p ps=8.52u w=8u l=0.28u
X291 a_21516_340.t7 a_20876_340.t17 VDD.t227 VDD.t226 pfet_03v3 ad=0.65p pd=3.02u as=0.65p ps=3.02u w=2.5u l=0.28u
X292 VSS.t421 a_6820_1540# a_7916_340.t1 VSS.t420 nfet_03v3 ad=0.45p pd=2.9u as=0.26p ps=1.52u w=1u l=0.28u
X293 NCIB.t22 a_5676_4320.t60 VDD.t377 VDD.t376 pfet_03v3 ad=0.65p pd=3.02u as=0.65p ps=3.02u w=2.5u l=0.28u
X294 a_20876_340.t0 a_20396_340.t2 VSS.t205 VSS.t204 nfet_03v3 ad=0.26p pd=1.52u as=0.45p ps=2.9u w=1u l=0.28u
X295 a_13380_1540# a_11940_1540# VDD.t79 VDD.t78 pfet_03v3 ad=0.45p pd=2.9u as=0.45p ps=2.9u w=1u l=2u
X296 VSS.t411 a_5676_4320.t55 NCIB.t43 VSS.t410 nfet_03v3 ad=0.26p pd=1.52u as=0.26p ps=1.52u w=1u l=0.28u
X297 NCIB.t28 a_5676_4320.t25 VSS.t381 VSS.t380 nfet_03v3 ad=0.26p pd=1.52u as=0.26p ps=1.52u w=1u l=0.28u
X298 NCIA.t32 a_21516_340.t32 VSS.t257 VSS.t256 nfet_03v3 ad=0.26p pd=1.52u as=0.26p ps=1.52u w=1u l=0.28u
X299 a_1516_340.t1 a_1036_340.t3 VDD.t5 VDD.t4 pfet_03v3 ad=0.65p pd=3.02u as=1.125p ps=5.9u w=2.5u l=0.28u
X300 a_8556_340.t1 a_6820_1540# VSS.t423 VSS.t422 nfet_03v3 ad=0.52p pd=2.52u as=0.9p ps=4.9u w=2u l=0.28u
X301 a_21516_4320.t10 a_20876_4320.t4 VDD.t230 VDD.t214 pfet_03v3 ad=0.65p pd=3.02u as=1.125p ps=5.9u w=2.5u l=0.28u
X302 VDD.t391 a_5676_4320.t34 NCIB.t9 VDD.t162 pfet_03v3 ad=0.65p pd=3.02u as=0.65p ps=3.02u w=2.5u l=0.28u
X303 CIB.t16 a_1036_4320.t21 VSS.t17 VSS.t16 nfet_03v3 ad=0.26p pd=1.52u as=0.26p ps=1.52u w=1u l=0.28u
X304 VDD.t31 a_1036_4320.t30 CIB.t9 VDD.t30 pfet_03v3 ad=0.65p pd=3.02u as=0.65p ps=3.02u w=2.5u l=0.28u
X305 NCIB.t30 a_5676_4320.t29 VSS.t385 VSS.t384 nfet_03v3 ad=0.26p pd=1.52u as=0.26p ps=1.52u w=1u l=0.28u
X306 NCDB.t16 a_1036_6700.t28 VSS.t41 VSS.t40 nfet_03v3 ad=2.08p pd=8.52u as=2.08p ps=8.52u w=8u l=0.28u
X307 a_972_4188.t1 a_4492_4188.t5 VDD.t321 VDD.t320 pfet_03v3 ad=0.65p pd=3.02u as=1.125p ps=5.9u w=2.5u l=0.28u
X308 VSS.t263 a_21516_340.t38 NCIA.t35 VSS.t262 nfet_03v3 ad=0.26p pd=1.52u as=0.26p ps=1.52u w=1u l=0.28u
X309 VSS.t81 a_12076_4320.t31 CDA.t31 VSS.t80 nfet_03v3 ad=0.26p pd=1.52u as=0.26p ps=1.52u w=1u l=0.28u
X310 CIB.t18 a_1036_4320.t25 VSS.t21 VSS.t20 nfet_03v3 ad=0.26p pd=1.52u as=0.26p ps=1.52u w=1u l=0.28u
X311 CDA.t12 a_12076_4320.t40 VDD.t89 VDD.t88 pfet_03v3 ad=0.65p pd=3.02u as=0.65p ps=3.02u w=2.5u l=0.28u
X312 VDD.t15 a_1036_4320.t34 CIB.t11 VDD.t14 pfet_03v3 ad=1.125p pd=5.9u as=0.65p ps=3.02u w=2.5u l=0.28u
X313 CDB.t18 a_21516_4320.t52 VDD.t296 VDD.t258 pfet_03v3 ad=0.65p pd=3.02u as=0.65p ps=3.02u w=2.5u l=0.28u
X314 NCDA.t12 a_1292_12000.t20 VSS.t115 VSS.t114 nfet_03v3 ad=2.08p pd=8.52u as=3.6p ps=16.9u w=8u l=0.28u
X315 VSS.t85 a_12076_4320.t35 CDA.t33 VSS.t84 nfet_03v3 ad=0.26p pd=1.52u as=0.26p ps=1.52u w=1u l=0.28u
X316 CDB.t20 a_21516_4320.t56 VDD.t299 VDD.t264 pfet_03v3 ad=0.65p pd=3.02u as=0.65p ps=3.02u w=2.5u l=0.28u
X317 VSS.t319 a_21516_4320.t47 CDB.t39 VSS.t318 nfet_03v3 ad=0.26p pd=1.52u as=0.26p ps=1.52u w=1u l=0.28u
X318 NCIB.t42 a_5676_4320.t53 VSS.t409 VSS.t408 nfet_03v3 ad=0.26p pd=1.52u as=0.26p ps=1.52u w=1u l=0.28u
X319 VSS.t379 a_5676_4320.t23 NCIB.t27 VSS.t378 nfet_03v3 ad=0.26p pd=1.52u as=0.26p ps=1.52u w=1u l=0.28u
X320 a_5036_4320.t0 a_4556_4320.t2 VDD.t325 VDD.t324 pfet_03v3 ad=0.65p pd=3.02u as=1.125p ps=5.9u w=2.5u l=0.28u
X321 NCIB.t8 a_5676_4320.t32 VDD.t390 VDD.t389 pfet_03v3 ad=0.65p pd=3.02u as=0.65p ps=3.02u w=2.5u l=0.28u
X322 a_1292_12000.t14 a_18316_4320.t13 VSS.t193 VSS.t192 nfet_03v3 ad=0.26p pd=1.52u as=0.26p ps=1.52u w=1u l=0.28u
X323 a_1036_6700.t10 a_972_8460.t4 VSS.t450 VSS.t438 nfet_03v3 ad=0.26p pd=1.52u as=0.45p ps=2.9u w=1u l=0.28u
X324 VSS.t383 a_5676_4320.t27 NCIB.t29 VSS.t382 nfet_03v3 ad=0.26p pd=1.52u as=0.26p ps=1.52u w=1u l=0.28u
X325 VDD.t273 a_21516_340.t23 NCIA.t3 VDD.t272 pfet_03v3 ad=0.65p pd=3.02u as=0.65p ps=3.02u w=2.5u l=0.28u
X326 VSS.t243 a_21516_340.t18 NCIA.t25 VSS.t242 nfet_03v3 ad=0.26p pd=1.52u as=0.26p ps=1.52u w=1u l=0.28u
X327 NCDA.t8 a_1292_12000.t34 VDD.t147 VDD.t146 pfet_03v3 ad=2.6p pd=10.52u as=2.6p ps=10.52u w=10u l=0.28u
X328 VDD.t65 a_11436_4320.t6 a_12076_4320.t12 VDD.t64 pfet_03v3 ad=0.65p pd=3.02u as=0.65p ps=3.02u w=2.5u l=0.28u
X329 a_11436_4320.t2 a_7916_340.t4 VSS.t425 VSS.t424 nfet_03v3 ad=0.26p pd=1.52u as=0.45p ps=2.9u w=1u l=0.28u
X330 VDD.t171 a_16236_340.t15 a_16876_340.t5 VDD.t170 pfet_03v3 ad=1.125p pd=5.9u as=0.65p ps=3.02u w=2.5u l=0.28u
X331 VSS.t395 a_5676_4320.t39 NCIB.t35 VSS.t394 nfet_03v3 ad=0.26p pd=1.52u as=0.26p ps=1.52u w=1u l=0.28u
X332 NCIB.t16 a_5676_4320.t48 VDD.t363 VDD.t362 pfet_03v3 ad=0.65p pd=3.02u as=0.65p ps=3.02u w=2.5u l=0.28u
X333 a_21516_4320.t15 a_20876_4320.t9 VSS.t229 VSS.t228 nfet_03v3 ad=0.26p pd=1.52u as=0.26p ps=1.52u w=1u l=0.28u
X334 NCIA.t28 a_21516_340.t24 VSS.t249 VSS.t248 nfet_03v3 ad=0.26p pd=1.52u as=0.26p ps=1.52u w=1u l=0.28u
X335 VDD.t237 a_20876_4320.t18 a_21516_4320.t8 VDD.t228 pfet_03v3 ad=1.125p pd=5.9u as=0.65p ps=3.02u w=2.5u l=0.28u
X336 CDB.t38 a_21516_4320.t45 VSS.t317 VSS.t316 nfet_03v3 ad=0.26p pd=1.52u as=0.26p ps=1.52u w=1u l=0.28u
X337 VDD.t297 a_21516_4320.t54 CDB.t19 VDD.t260 pfet_03v3 ad=0.65p pd=3.02u as=0.65p ps=3.02u w=2.5u l=0.28u
X338 VSS.t455 a_972_8460.t14 a_1036_6700.t15 VSS.t448 nfet_03v3 ad=0.26p pd=1.52u as=0.26p ps=1.52u w=1u l=0.28u
X339 a_972_4188.t0 a_4492_4188.t4 VSS.t347 VSS.t346 nfet_03v3 ad=0.26p pd=1.52u as=0.45p ps=2.9u w=1u l=0.28u
X340 VDD.t103 a_12076_4320.t54 CDA.t19 VDD.t102 pfet_03v3 ad=0.65p pd=3.02u as=0.65p ps=3.02u w=2.5u l=0.28u
X341 CDA.t38 a_12076_4320.t45 VSS.t95 VSS.t94 nfet_03v3 ad=0.26p pd=1.52u as=0.26p ps=1.52u w=1u l=0.28u
X342 VDD.t327 a_4556_4320.t4 a_5036_4320.t2 VDD.t326 pfet_03v3 ad=1.125p pd=5.9u as=0.65p ps=3.02u w=2.5u l=0.28u
X343 VSS.t419 a_5676_4320.t63 NCIB.t47 VSS.t418 nfet_03v3 ad=0.45p pd=2.9u as=0.26p ps=1.52u w=1u l=0.28u
X344 CDA.t40 a_12076_4320.t49 VSS.t99 VSS.t98 nfet_03v3 ad=0.26p pd=1.52u as=0.26p ps=1.52u w=1u l=0.28u
X345 CDB.t46 a_21516_4320.t61 VSS.t333 VSS.t332 nfet_03v3 ad=0.26p pd=1.52u as=0.26p ps=1.52u w=1u l=0.28u
X346 a_12076_4320.t10 a_11436_4320.t4 VDD.t63 VDD.t62 pfet_03v3 ad=0.65p pd=3.02u as=1.125p ps=5.9u w=2.5u l=0.28u
X347 NCIB.t34 a_5676_4320.t37 VSS.t393 VSS.t392 nfet_03v3 ad=0.26p pd=1.52u as=0.26p ps=1.52u w=1u l=0.28u
X348 VDD.t415 a_972_8460.t7 a_1036_6700.t1 VDD.t414 pfet_03v3 ad=0.65p pd=3.02u as=0.65p ps=3.02u w=2.5u l=0.28u
X349 VDD.t361 a_5676_4320.t46 NCIB.t15 VDD.t360 pfet_03v3 ad=0.65p pd=3.02u as=0.65p ps=3.02u w=2.5u l=0.28u
X350 VSS.t227 a_20876_4320.t7 a_21516_4320.t13 VSS.t226 nfet_03v3 ad=0.26p pd=1.52u as=0.26p ps=1.52u w=1u l=0.28u
X351 a_21516_340.t2 a_20876_340.t12 VSS.t217 VSS.t216 nfet_03v3 ad=0.26p pd=1.52u as=0.26p ps=1.52u w=1u l=0.28u
X352 a_21516_4320.t6 a_20876_4320.t16 VDD.t236 VDD.t226 pfet_03v3 ad=0.65p pd=3.02u as=0.65p ps=3.02u w=2.5u l=0.28u
X353 a_1036_6700.t14 a_972_8460.t12 VSS.t454 VSS.t446 nfet_03v3 ad=0.26p pd=1.52u as=0.26p ps=1.52u w=1u l=0.28u
X354 NCIB.t36 a_5676_4320.t41 VSS.t397 VSS.t396 nfet_03v3 ad=0.26p pd=1.52u as=0.26p ps=1.52u w=1u l=0.28u
X355 VDD.t51 a_1036_6700.t33 NCDB.t7 VDD.t50 pfet_03v3 ad=2.6p pd=10.52u as=2.6p ps=10.52u w=10u l=0.28u
X356 NCIA.t10 a_21516_340.t37 VDD.t243 VDD.t242 pfet_03v3 ad=0.65p pd=3.02u as=0.65p ps=3.02u w=2.5u l=0.28u
X357 a_12076_4320.t6 a_11436_4320.t16 VDD.t75 VDD.t74 pfet_03v3 ad=0.65p pd=3.02u as=0.65p ps=3.02u w=2.5u l=0.28u
X358 VSS.t93 a_12076_4320.t43 CDA.t37 VSS.t92 nfet_03v3 ad=0.26p pd=1.52u as=0.26p ps=1.52u w=1u l=0.28u
X359 CDA.t18 a_12076_4320.t52 VDD.t101 VDD.t100 pfet_03v3 ad=0.65p pd=3.02u as=0.65p ps=3.02u w=2.5u l=0.28u
X360 VDD.t408 a_972_4188.t10 a_1036_4320.t3 VDD.t4 pfet_03v3 ad=0.65p pd=3.02u as=0.65p ps=3.02u w=2.5u l=0.28u
X361 CIA.t4 a_16876_340.t21 VDD.t185 VDD.t184 pfet_03v3 ad=0.65p pd=3.02u as=0.65p ps=3.02u w=2.5u l=0.28u
X362 VSS.t97 a_12076_4320.t47 CDA.t39 VSS.t96 nfet_03v3 ad=0.26p pd=1.52u as=0.26p ps=1.52u w=1u l=0.28u
X363 VSS.t279 a_21516_340.t54 NCIA.t43 VSS.t278 nfet_03v3 ad=0.26p pd=1.52u as=0.26p ps=1.52u w=1u l=0.28u
X364 VSS.t331 a_21516_4320.t59 CDB.t45 VSS.t330 nfet_03v3 ad=0.26p pd=1.52u as=0.26p ps=1.52u w=1u l=0.28u
X365 a_27276_4320.t0 a_9196_340.t6 VDD.t402 VDD.t320 pfet_03v3 ad=1.125p pd=5.9u as=1.125p ps=5.9u w=2.5u l=0.28u
X366 a_5676_4320.t14 a_5036_4320.t8 VDD.t333 VDD.t332 pfet_03v3 ad=0.65p pd=3.02u as=0.65p ps=3.02u w=2.5u l=0.28u
X367 CIA.t6 a_16876_340.t25 VDD.t189 VDD.t188 pfet_03v3 ad=0.65p pd=3.02u as=0.65p ps=3.02u w=2.5u l=0.28u
X368 VSS.t109 a_12076_4320.t59 CDA.t45 VSS.t108 nfet_03v3 ad=0.26p pd=1.52u as=0.26p ps=1.52u w=1u l=0.28u
X369 a_17836_4320.t0 a_7916_340.t7 VDD.t398 VDD.t397 pfet_03v3 ad=1.125p pd=5.9u as=1.125p ps=5.9u w=2.5u l=0.28u
X370 VSS.t207 a_20396_340.t4 a_20876_340.t2 VSS.t206 nfet_03v3 ad=0.45p pd=2.9u as=0.26p ps=1.52u w=1u l=0.28u
X371 a_5676_4320.t2 a_5036_4320.t12 VDD.t337 VDD.t336 pfet_03v3 ad=0.65p pd=3.02u as=0.65p ps=3.02u w=2.5u l=0.28u
X372 VDD.t213 a_20396_340.t5 a_20876_340.t3 VDD.t212 pfet_03v3 ad=1.125p pd=5.9u as=0.65p ps=3.02u w=2.5u l=0.28u
X373 VDD.t285 a_21516_340.t35 NCIA.t9 VDD.t284 pfet_03v3 ad=0.65p pd=3.02u as=0.65p ps=3.02u w=2.5u l=0.28u
X374 VDD.t73 a_11436_4320.t14 a_12076_4320.t4 VDD.t72 pfet_03v3 ad=0.65p pd=3.02u as=0.65p ps=3.02u w=2.5u l=0.28u
X375 a_1036_6700.t6 a_972_8460.t17 VDD.t425 VDD.t424 pfet_03v3 ad=0.65p pd=3.02u as=0.65p ps=3.02u w=2.5u l=0.28u
X376 a_1036_4320.t6 a_972_4188.t5 VSS.t439 VSS.t438 nfet_03v3 ad=0.26p pd=1.52u as=0.45p ps=2.9u w=1u l=0.28u
X377 a_1036_4320.t2 a_972_4188.t8 VDD.t407 VDD.t406 pfet_03v3 ad=0.65p pd=3.02u as=0.65p ps=3.02u w=2.5u l=0.28u
X378 VDD.t35 a_1036_6700.t23 NCDB.t1 VDD.t34 pfet_03v3 ad=2.6p pd=10.52u as=2.6p ps=10.52u w=10u l=0.28u
X379 a_8556_1540.t0 a_1516_340.t8 a_8556_340.t0 VSS.t462 nfet_03v3 ad=0.9p pd=4.9u as=0.52p ps=2.52u w=2u l=0.28u
X380 VDD.t77 a_11436_4320.t18 a_12076_4320.t8 VDD.t76 pfet_03v3 ad=1.125p pd=5.9u as=0.65p ps=3.02u w=2.5u l=0.28u
X381 a_12076_4320.t15 a_11436_4320.t9 VSS.t53 VSS.t52 nfet_03v3 ad=0.26p pd=1.52u as=0.26p ps=1.52u w=1u l=0.28u
X382 a_1036_6700.t8 a_972_8460.t21 VDD.t429 VDD.t428 pfet_03v3 ad=0.65p pd=3.02u as=0.65p ps=3.02u w=2.5u l=0.28u
X383 a_3940_1540# a_2500_1540# VDD.t311 VDD.t310 pfet_03v3 ad=0.45p pd=2.9u as=0.45p ps=2.9u w=1u l=2u
X384 VSS.t407 a_5676_4320.t51 NCIB.t41 VSS.t406 nfet_03v3 ad=0.26p pd=1.52u as=0.26p ps=1.52u w=1u l=0.28u
X385 VDD.t303 a_21516_4320.t22 CDB.t3 VDD.t272 pfet_03v3 ad=0.65p pd=3.02u as=0.65p ps=3.02u w=2.5u l=0.28u
X386 a_16236_340.t0 a_14476_1540.t3 VSS.t131 VSS.t130 nfet_03v3 ad=0.26p pd=1.52u as=0.45p ps=2.9u w=1u l=0.28u
X387 NCIA.t36 a_21516_340.t40 VSS.t265 VSS.t264 nfet_03v3 ad=0.26p pd=1.52u as=0.26p ps=1.52u w=1u l=0.28u
X388 VSS.t125 a_1292_12000.t30 NCDA.t17 VSS.t124 nfet_03v3 ad=3.6p pd=16.9u as=2.08p ps=8.52u w=8u l=0.28u
X389 VDD.t257 a_21516_340.t51 NCIA.t17 VDD.t256 pfet_03v3 ad=0.65p pd=3.02u as=0.65p ps=3.02u w=2.5u l=0.28u
X390 CDB.t24 a_21516_4320.t17 VSS.t289 VSS.t288 nfet_03v3 ad=0.26p pd=1.52u as=0.45p ps=2.9u w=1u l=0.28u
X391 VSS.t449 a_972_4188.t15 a_1036_4320.t11 VSS.t448 nfet_03v3 ad=0.45p pd=2.9u as=0.26p ps=1.52u w=1u l=0.28u
X392 CDA.t44 a_12076_4320.t57 VSS.t107 VSS.t106 nfet_03v3 ad=0.26p pd=1.52u as=0.26p ps=1.52u w=1u l=0.28u
X393 CIB.t2 a_1036_4320.t16 VDD.t17 VDD.t16 pfet_03v3 ad=0.65p pd=3.02u as=0.65p ps=3.02u w=2.5u l=0.28u
X394 a_3940_1540# a_2500_1540# VSS.t337 VSS.t336 nfet_03v3 ad=0.45p pd=2.9u as=0.45p ps=2.9u w=1u l=4u
X395 VDD.t335 a_5036_4320.t10 a_5676_4320.t0 VDD.t334 pfet_03v3 ad=0.65p pd=3.02u as=0.65p ps=3.02u w=2.5u l=0.28u
X396 NCDB.t12 a_1036_6700.t20 VSS.t33 VSS.t32 nfet_03v3 ad=2.08p pd=8.52u as=3.6p ps=16.9u w=8u l=0.28u
X397 a_20876_340.t1 a_20396_340.t3 VDD.t211 VDD.t210 pfet_03v3 ad=0.65p pd=3.02u as=1.125p ps=5.9u w=2.5u l=0.28u
X398 NCDB.t4 a_1036_6700.t29 VDD.t45 VDD.t44 pfet_03v3 ad=2.6p pd=10.52u as=2.6p ps=10.52u w=10u l=0.28u
X399 VDD.t179 a_16876_340.t35 CIA.t11 VDD.t178 pfet_03v3 ad=1.125p pd=5.9u as=0.65p ps=3.02u w=2.5u l=0.28u
X400 CDA.t46 a_12076_4320.t61 VSS.t111 VSS.t110 nfet_03v3 ad=0.26p pd=1.52u as=0.26p ps=1.52u w=1u l=0.28u
X401 NCDA.t0 a_1292_12000.t21 VDD.t127 VDD.t126 pfet_03v3 ad=2.6p pd=10.52u as=4.5p ps=20.9u w=10u l=0.28u
X402 a_11116_340.t1 a_10020_1540# VSS.t3 VSS.t2 nfet_03v3 ad=0.45p pd=2.9u as=0.45p ps=2.9u w=1u l=0.28u
X403 VDD.t427 a_972_8460.t19 a_1036_6700.t7 VDD.t426 pfet_03v3 ad=0.65p pd=3.02u as=0.65p ps=3.02u w=2.5u l=0.28u
X404 a_5676_4320.t7 a_5036_4320.t17 VSS.t367 VSS.t366 nfet_03v3 ad=0.26p pd=1.52u as=0.26p ps=1.52u w=1u l=0.28u
X405 NCIA.t26 a_21516_340.t20 VSS.t245 VSS.t244 nfet_03v3 ad=0.26p pd=1.52u as=0.26p ps=1.52u w=1u l=0.28u
X406 a_15116_340.t2 a_13380_1540# a_15116_1540.t1 VDD.t84 pfet_03v3 ad=2.25p pd=10.9u as=1.3p ps=5.52u w=5u l=0.28u
X407 a_11940_1540# a_11116_340.t2 VSS.t45 VSS.t44 nfet_03v3 ad=0.45p pd=2.9u as=0.45p ps=2.9u w=1u l=4u
X408 VDD.t349 a_5676_4320.t18 NCIB.t1 VDD.t348 pfet_03v3 ad=0.65p pd=3.02u as=0.65p ps=3.02u w=2.5u l=0.28u
X409 a_1292_12000.t8 a_18316_4320.t20 VDD.t208 VDD.t207 pfet_03v3 ad=0.65p pd=3.02u as=0.65p ps=3.02u w=2.5u l=0.28u
X410 VSS.t39 a_1036_6700.t26 NCDB.t15 VSS.t38 nfet_03v3 ad=2.08p pd=8.52u as=2.08p ps=8.52u w=8u l=0.28u
X411 NCIA.t16 a_21516_340.t49 VDD.t255 VDD.t254 pfet_03v3 ad=0.65p pd=3.02u as=0.65p ps=3.02u w=2.5u l=0.28u
X412 CDA.t2 a_12076_4320.t20 VDD.t105 VDD.t104 pfet_03v3 ad=0.65p pd=3.02u as=0.65p ps=3.02u w=2.5u l=0.28u
X413 a_1036_4320.t10 a_972_4188.t13 VSS.t447 VSS.t446 nfet_03v3 ad=0.26p pd=1.52u as=0.26p ps=1.52u w=1u l=0.28u
X414 VDD.t11 a_1036_4320.t14 CIB.t1 VDD.t10 pfet_03v3 ad=0.65p pd=3.02u as=0.65p ps=3.02u w=2.5u l=0.28u
X415 a_15116_340.t0 a_11116_340.t6 VSS.t47 VSS.t46 nfet_03v3 ad=0.26p pd=1.52u as=0.45p ps=2.9u w=1u l=0.28u
X416 VSS.t251 a_21516_340.t26 NCIA.t29 VSS.t250 nfet_03v3 ad=0.26p pd=1.52u as=0.26p ps=1.52u w=1u l=0.28u
X417 CDA.t4 a_12076_4320.t24 VDD.t117 VDD.t116 pfet_03v3 ad=0.65p pd=3.02u as=0.65p ps=3.02u w=2.5u l=0.28u
X418 CIA.t10 a_16876_340.t33 VDD.t177 VDD.t176 pfet_03v3 ad=0.65p pd=3.02u as=0.65p ps=3.02u w=2.5u l=0.28u
X419 VSS.t299 a_21516_4320.t27 CDB.t29 VSS.t298 nfet_03v3 ad=0.26p pd=1.52u as=0.26p ps=1.52u w=1u l=0.28u
X420 CDB.t10 a_21516_4320.t36 VDD.t288 VDD.t242 pfet_03v3 ad=0.65p pd=3.02u as=0.65p ps=3.02u w=2.5u l=0.28u
X421 VSS.t349 a_4492_4188.t6 a_972_4188.t2 VSS.t348 nfet_03v3 ad=0.45p pd=2.9u as=0.26p ps=1.52u w=1u l=0.28u
X422 VSS.t303 a_21516_4320.t31 CDB.t31 VSS.t302 nfet_03v3 ad=0.26p pd=1.52u as=0.26p ps=1.52u w=1u l=0.28u
X423 a_11940_1540# a_11116_340.t3 VDD.t57 VDD.t56 pfet_03v3 ad=0.45p pd=2.9u as=0.45p ps=2.9u w=1u l=2u
X424 VSS.t365 a_5036_4320.t15 a_5676_4320.t5 VSS.t364 nfet_03v3 ad=0.26p pd=1.52u as=0.26p ps=1.52u w=1u l=0.28u
X425 CIA.t18 a_16876_340.t24 VSS.t169 VSS.t168 nfet_03v3 ad=0.26p pd=1.52u as=0.26p ps=1.52u w=1u l=0.28u
X426 VDD.t221 a_20876_340.t11 a_21516_340.t1 VDD.t220 pfet_03v3 ad=0.65p pd=3.02u as=0.65p ps=3.02u w=2.5u l=0.28u
X427 VDD.t206 a_18316_4320.t18 a_1292_12000.t7 VDD.t205 pfet_03v3 ad=0.65p pd=3.02u as=0.65p ps=3.02u w=2.5u l=0.28u
X428 NCIB.t0 a_5676_4320.t16 VDD.t347 VDD.t346 pfet_03v3 ad=0.65p pd=3.02u as=1.125p ps=5.9u w=2.5u l=0.28u
X429 NCDA.t14 a_1292_12000.t24 VSS.t119 VSS.t118 nfet_03v3 ad=2.08p pd=8.52u as=2.08p ps=8.52u w=8u l=0.28u
X430 a_18316_4320.t1 a_17836_4320.t3 VSS.t181 VSS.t180 nfet_03v3 ad=0.26p pd=1.52u as=0.45p ps=2.9u w=1u l=0.28u
X431 VDD.t199 a_18316_4320.t6 a_1292_12000.t1 VDD.t188 pfet_03v3 ad=0.65p pd=3.02u as=0.65p ps=3.02u w=2.5u l=0.28u
X432 VSS.t219 a_20876_340.t14 a_21516_340.t4 VSS.t218 nfet_03v3 ad=0.26p pd=1.52u as=0.26p ps=1.52u w=1u l=0.28u
X433 VDD.t225 a_20876_340.t15 a_21516_340.t5 VDD.t224 pfet_03v3 ad=0.65p pd=3.02u as=0.65p ps=3.02u w=2.5u l=0.28u
X434 a_6820_1540# a_5380_1540# VSS.t371 VSS.t370 nfet_03v3 ad=0.45p pd=2.9u as=0.45p ps=2.9u w=1u l=4u
X435 VDD.t375 a_5676_4320.t58 NCIB.t21 VDD.t374 pfet_03v3 ad=0.65p pd=3.02u as=0.65p ps=3.02u w=2.5u l=0.28u
X436 VSS.t175 a_16876_340.t30 CIA.t21 VSS.t174 nfet_03v3 ad=0.26p pd=1.52u as=0.26p ps=1.52u w=1u l=0.28u
X437 VDD.t115 a_12076_4320.t22 CDA.t3 VDD.t114 pfet_03v3 ad=0.65p pd=3.02u as=0.65p ps=3.02u w=2.5u l=0.28u
X438 VDD.t309 a_21516_4320.t34 CDB.t9 VDD.t284 pfet_03v3 ad=0.65p pd=3.02u as=0.65p ps=3.02u w=2.5u l=0.28u
X439 VDD.t401 a_9196_340.t4 a_20876_4320.t1 VDD.t212 pfet_03v3 ad=1.125p pd=5.9u as=0.65p ps=3.02u w=2.5u l=0.28u
X440 CDB.t28 a_21516_4320.t25 VSS.t297 VSS.t296 nfet_03v3 ad=0.26p pd=1.52u as=0.26p ps=1.52u w=1u l=0.28u
X441 VDD.t152 a_14476_1540.t6 a_16236_340.t3 VDD.t98 pfet_03v3 ad=1.125p pd=5.9u as=0.65p ps=3.02u w=2.5u l=0.28u
X442 VDD.t271 a_21516_340.t63 NCIA.t23 VDD.t270 pfet_03v3 ad=1.125p pd=5.9u as=0.65p ps=3.02u w=2.5u l=0.28u
X443 CDB.t30 a_21516_4320.t29 VSS.t301 VSS.t300 nfet_03v3 ad=0.26p pd=1.52u as=0.26p ps=1.52u w=1u l=0.28u
X444 VSS.t15 a_1036_4320.t19 CIB.t15 VSS.t14 nfet_03v3 ad=0.26p pd=1.52u as=0.26p ps=1.52u w=1u l=0.28u
X445 CIB.t8 a_1036_4320.t28 VDD.t29 VDD.t28 pfet_03v3 ad=0.65p pd=3.02u as=0.65p ps=3.02u w=2.5u l=0.28u
X446 NCIA.t44 a_21516_340.t56 VSS.t281 VSS.t280 nfet_03v3 ad=0.26p pd=1.52u as=0.26p ps=1.52u w=1u l=0.28u
X447 a_14476_340.t1 a_13380_1540# VSS.t127 VSS.t126 nfet_03v3 ad=0.52p pd=2.52u as=0.9p ps=4.9u w=2u l=0.28u
X448 CDA.t30 a_12076_4320.t29 VSS.t79 VSS.t78 nfet_03v3 ad=0.26p pd=1.52u as=0.26p ps=1.52u w=1u l=0.28u
X449 VDD.t87 a_12076_4320.t38 CDA.t11 VDD.t86 pfet_03v3 ad=0.65p pd=3.02u as=0.65p ps=3.02u w=2.5u l=0.28u
X450 VSS.t19 a_1036_4320.t23 CIB.t17 VSS.t18 nfet_03v3 ad=0.26p pd=1.52u as=0.26p ps=1.52u w=1u l=0.28u
X451 VDD.t295 a_21516_4320.t50 CDB.t17 VDD.t256 pfet_03v3 ad=0.65p pd=3.02u as=0.65p ps=3.02u w=2.5u l=0.28u
X452 CDB.t36 a_21516_4320.t41 VSS.t313 VSS.t312 nfet_03v3 ad=0.26p pd=1.52u as=0.26p ps=1.52u w=1u l=0.28u
X453 a_21516_340.t3 a_20876_340.t13 VDD.t223 VDD.t222 pfet_03v3 ad=0.65p pd=3.02u as=0.65p ps=3.02u w=2.5u l=0.28u
X454 NCIB.t20 a_5676_4320.t56 VDD.t373 VDD.t372 pfet_03v3 ad=0.65p pd=3.02u as=0.65p ps=3.02u w=2.5u l=0.28u
X455 VSS.t287 a_21516_340.t62 NCIA.t47 VSS.t286 nfet_03v3 ad=0.45p pd=2.9u as=0.26p ps=1.52u w=1u l=0.28u
X456 a_20876_4320.t0 a_9196_340.t2 VDD.t400 VDD.t210 pfet_03v3 ad=0.65p pd=3.02u as=1.125p ps=5.9u w=2.5u l=0.28u
X457 a_1292_12000.t6 a_18316_4320.t16 VDD.t204 VDD.t178 pfet_03v3 ad=0.65p pd=3.02u as=0.65p ps=3.02u w=2.5u l=0.28u
X458 NCDB.t6 a_1036_6700.t32 VDD.t49 VDD.t48 pfet_03v3 ad=2.6p pd=10.52u as=2.6p ps=10.52u w=10u l=0.28u
X459 NCIB.t26 a_5676_4320.t21 VSS.t377 VSS.t376 nfet_03v3 ad=0.26p pd=1.52u as=0.26p ps=1.52u w=1u l=0.28u
X460 VDD.t388 a_5676_4320.t30 NCIB.t7 VDD.t387 pfet_03v3 ad=0.65p pd=3.02u as=0.65p ps=3.02u w=2.5u l=0.28u
X461 VSS.t203 a_18316_4320.t23 a_1292_12000.t19 VSS.t202 nfet_03v3 ad=0.45p pd=2.9u as=0.26p ps=1.52u w=1u l=0.28u
X462 CIA.t14 a_16876_340.t16 VSS.t161 VSS.t160 nfet_03v3 ad=0.26p pd=1.52u as=0.26p ps=1.52u w=1u l=0.28u
X463 CDA.t8 a_12076_4320.t32 VDD.t124 VDD.t123 pfet_03v3 ad=0.65p pd=3.02u as=0.65p ps=3.02u w=2.5u l=0.28u
X464 VSS.t191 a_18316_4320.t11 a_1292_12000.t13 VSS.t190 nfet_03v3 ad=0.26p pd=1.52u as=0.26p ps=1.52u w=1u l=0.28u
X465 NCIA.t2 a_21516_340.t21 VDD.t263 VDD.t262 pfet_03v3 ad=0.65p pd=3.02u as=0.65p ps=3.02u w=2.5u l=0.28u
X466 VSS.t211 a_20876_340.t6 a_21516_340.t12 VSS.t210 nfet_03v3 ad=0.26p pd=1.52u as=0.26p ps=1.52u w=1u l=0.28u
X467 CDA.t10 a_12076_4320.t36 VDD.t85 VDD.t84 pfet_03v3 ad=0.65p pd=3.02u as=0.65p ps=3.02u w=2.5u l=0.28u
X468 VSS.t77 a_12076_4320.t27 CDA.t29 VSS.t76 nfet_03v3 ad=0.26p pd=1.52u as=0.26p ps=1.52u w=1u l=0.28u
X469 VSS.t167 a_16876_340.t22 CIA.t17 VSS.t166 nfet_03v3 ad=0.26p pd=1.52u as=0.26p ps=1.52u w=1u l=0.28u
X470 VSS.t311 a_21516_4320.t39 CDB.t35 VSS.t310 nfet_03v3 ad=0.26p pd=1.52u as=0.26p ps=1.52u w=1u l=0.28u
X471 CDB.t16 a_21516_4320.t48 VDD.t294 VDD.t254 pfet_03v3 ad=0.65p pd=3.02u as=0.65p ps=3.02u w=2.5u l=0.28u
X472 VSS.t267 a_21516_340.t42 NCIA.t37 VSS.t266 nfet_03v3 ad=0.26p pd=1.52u as=0.26p ps=1.52u w=1u l=0.28u
X473 a_16876_340.t3 a_16236_340.t13 VDD.t169 VDD.t168 pfet_03v3 ad=0.65p pd=3.02u as=0.65p ps=3.02u w=2.5u l=0.28u
X474 VDD.t55 a_1036_6700.t35 NCDB.t9 VDD.t54 pfet_03v3 ad=2.6p pd=10.52u as=2.6p ps=10.52u w=10u l=0.28u
X475 VSS.t315 a_21516_4320.t43 CDB.t37 VSS.t314 nfet_03v3 ad=0.26p pd=1.52u as=0.26p ps=1.52u w=1u l=0.28u
X476 CIB.t22 a_1036_4320.t33 VSS.t29 VSS.t28 nfet_03v3 ad=0.26p pd=1.52u as=0.26p ps=1.52u w=1u l=0.28u
X477 VDD.t203 a_18316_4320.t14 a_1292_12000.t5 VDD.t176 pfet_03v3 ad=0.65p pd=3.02u as=0.65p ps=3.02u w=2.5u l=0.28u
X478 a_1292_12000.t10 a_18316_4320.t5 VSS.t185 VSS.t184 nfet_03v3 ad=0.26p pd=1.52u as=0.45p ps=2.9u w=1u l=0.28u
X479 a_1036_340.t0 CHOP1.t0 VSS.t1 VSS.t0 nfet_03v3 ad=0.45p pd=2.9u as=0.45p ps=2.9u w=1u l=0.28u
X480 VDD.t141 a_1292_12000.t31 NCDA.t5 VDD.t140 pfet_03v3 ad=2.6p pd=10.52u as=2.6p ps=10.52u w=10u l=0.28u
X481 NCIA.t40 a_21516_340.t48 VSS.t273 VSS.t272 nfet_03v3 ad=0.26p pd=1.52u as=0.26p ps=1.52u w=1u l=0.28u
X482 a_1292_12000.t12 a_18316_4320.t9 VSS.t189 VSS.t188 nfet_03v3 ad=0.26p pd=1.52u as=0.26p ps=1.52u w=1u l=0.28u
X483 NCDB.t0 a_1036_6700.t21 VDD.t33 VDD.t32 pfet_03v3 ad=2.6p pd=10.52u as=4.5p ps=20.9u w=10u l=0.28u
X484 VDD.t241 a_21516_340.t19 NCIA.t1 VDD.t240 pfet_03v3 ad=0.65p pd=3.02u as=0.65p ps=3.02u w=2.5u l=0.28u
X485 NCIB.t46 a_5676_4320.t61 VSS.t417 VSS.t416 nfet_03v3 ad=0.26p pd=1.52u as=0.26p ps=1.52u w=1u l=0.28u
R0 a_972_8460.t0 a_972_8460.n10 0.1045
R1 a_972_8460.n10 a_972_8460.t2 0.1045
R2 a_972_8460.n10 a_972_8460.n9 0.5805
R3 a_972_8460.n9 a_972_8460.n0 0.7705
R4 a_972_8460.n9 a_972_8460.n1 29.0225
R5 a_972_8460.n3 a_972_8460.n2 0.0805
R6 a_972_8460.n4 a_972_8460.n3 0.0805
R7 a_972_8460.n5 a_972_8460.n4 0.0805
R8 a_972_8460.n6 a_972_8460.n5 0.0805
R9 a_972_8460.n7 a_972_8460.n6 0.0805
R10 a_972_8460.n8 a_972_8460.n7 0.0805
R11 a_972_8460.n1 a_972_8460.n8 0.0805
R12 a_972_8460.n1 a_972_8460.t23 6.11621
R13 a_972_8460.t23 a_972_8460.t22 24.1076
R14 a_972_8460.n8 a_972_8460.t19 6.03621
R15 a_972_8460.t19 a_972_8460.t18 24.1076
R16 a_972_8460.n7 a_972_8460.t17 6.03621
R17 a_972_8460.t17 a_972_8460.t16 24.1076
R18 a_972_8460.n6 a_972_8460.t15 6.03621
R19 a_972_8460.t15 a_972_8460.t14 24.1076
R20 a_972_8460.n5 a_972_8460.t13 6.03621
R21 a_972_8460.t13 a_972_8460.t12 24.1076
R22 a_972_8460.n4 a_972_8460.t11 6.03621
R23 a_972_8460.t11 a_972_8460.t10 24.1076
R24 a_972_8460.n3 a_972_8460.t9 6.03621
R25 a_972_8460.t9 a_972_8460.t8 24.1076
R26 a_972_8460.n2 a_972_8460.t7 6.03621
R27 a_972_8460.t7 a_972_8460.t6 24.1076
R28 a_972_8460.n2 a_972_8460.t5 6.11621
R29 a_972_8460.t5 a_972_8460.t4 24.1076
R30 a_972_8460.n1 a_972_8460.t21 6.03621
R31 a_972_8460.t21 a_972_8460.t20 24.1076
R32 a_972_8460.n0 a_972_8460.t1 0.2605
R33 a_972_8460.n0 a_972_8460.t3 0.2605
R34 a_972_4188.t1 a_972_4188.n7 0.1045
R35 a_972_4188.n7 a_972_4188.t3 0.1045
R36 a_972_4188.n6 a_972_4188.n0 0.7705
R37 a_972_4188.n7 a_972_4188.n6 0.5805
R38 a_972_4188.n6 a_972_4188.n1 28.9905
R39 a_972_4188.n3 a_972_4188.n2 0.0805
R40 a_972_4188.n4 a_972_4188.n3 0.0805
R41 a_972_4188.n5 a_972_4188.n4 0.0805
R42 a_972_4188.n1 a_972_4188.n5 0.0805
R43 a_972_4188.n5 a_972_4188.t12 6.03621
R44 a_972_4188.t12 a_972_4188.t13 24.1076
R45 a_972_4188.n4 a_972_4188.t10 6.03621
R46 a_972_4188.t10 a_972_4188.t11 24.1076
R47 a_972_4188.n3 a_972_4188.t8 6.03621
R48 a_972_4188.t8 a_972_4188.t9 24.1076
R49 a_972_4188.n2 a_972_4188.t6 6.03621
R50 a_972_4188.t6 a_972_4188.t7 24.1076
R51 a_972_4188.n2 a_972_4188.t4 6.11621
R52 a_972_4188.t4 a_972_4188.t5 24.1076
R53 a_972_4188.n1 a_972_4188.t14 6.03621
R54 a_972_4188.t14 a_972_4188.t15 24.1076
R55 a_972_4188.n0 a_972_4188.t0 0.2605
R56 a_972_4188.n0 a_972_4188.t2 0.2605
R57 a_9196_340.t1 a_9196_340.n2 0.6845
R58 a_9196_340.n2 a_9196_340.n1 14.5985
R59 a_9196_340.n1 a_9196_340.t6 12.6082
R60 a_9196_340.t6 a_9196_340.t7 24.1076
R61 a_9196_340.n1 a_9196_340.n0 0.1725
R62 a_9196_340.n0 a_9196_340.t4 6.11621
R63 a_9196_340.t4 a_9196_340.t5 24.1076
R64 a_9196_340.n0 a_9196_340.t2 6.03621
R65 a_9196_340.t2 a_9196_340.t3 24.1076
R66 a_9196_340.n2 a_9196_340.t0 1.0305
R67 a_8556_340.t0 a_8556_340.t1 0.2605
R68 a_8556_1540.n1 a_8556_1540.t2 0.1045
R69 a_8556_1540.t1 a_8556_1540.n1 0.1045
R70 a_8556_1540.n1 a_8556_1540.n0 0.6565
R71 a_8556_1540.n0 a_8556_1540.t4 7.44221
R72 a_8556_1540.t4 a_8556_1540.t3 24.1076
R73 a_8556_1540.n0 a_8556_1540.t0 0.8765
R74 a_7916_340.t2 a_7916_340.n3 0.9585
R75 a_7916_340.n3 a_7916_340.n2 6.5265
R76 a_7916_340.n2 a_7916_340.n1 0.0365
R77 a_7916_340.n2 a_7916_340.t7 12.3122
R78 a_7916_340.t7 a_7916_340.t8 24.1076
R79 a_7916_340.n1 a_7916_340.t3 6.11621
R80 a_7916_340.t3 a_7916_340.t4 24.1076
R81 a_7916_340.n1 a_7916_340.t5 6.03621
R82 a_7916_340.t5 a_7916_340.t6 24.1076
R83 a_7916_340.n3 a_7916_340.n0 0.8465
R84 a_7916_340.n0 a_7916_340.t0 0.2605
R85 a_7916_340.n0 a_7916_340.t1 0.2605
R86 a_7916_1540.t0 a_7916_1540.t1 0.1045
R87 a_5676_4320.n35 a_5676_4320.t14 0.1045
R88 a_5676_4320.t0 a_5676_4320.n35 0.1045
R89 a_5676_4320.n35 a_5676_4320.n34 0.5805
R90 a_5676_4320.n34 a_5676_4320.n0 0.7705
R91 a_5676_4320.n34 a_5676_4320.n3 0.3045
R92 a_5676_4320.n34 a_5676_4320.n33 0.2285
R93 a_5676_4320.n33 a_5676_4320.n6 0.0765
R94 a_5676_4320.n6 a_5676_4320.n9 0.3045
R95 a_5676_4320.n33 a_5676_4320.n10 1.8865
R96 a_5676_4320.n10 a_5676_4320.n11 0.0805
R97 a_5676_4320.n11 a_5676_4320.n12 0.0805
R98 a_5676_4320.n12 a_5676_4320.n13 0.0805
R99 a_5676_4320.n13 a_5676_4320.n14 0.0805
R100 a_5676_4320.n14 a_5676_4320.n15 0.0805
R101 a_5676_4320.n15 a_5676_4320.n16 0.0805
R102 a_5676_4320.n16 a_5676_4320.n17 0.0805
R103 a_5676_4320.n17 a_5676_4320.n18 0.0805
R104 a_5676_4320.n18 a_5676_4320.n19 0.0805
R105 a_5676_4320.n19 a_5676_4320.n20 0.0805
R106 a_5676_4320.n20 a_5676_4320.n21 0.0805
R107 a_5676_4320.n21 a_5676_4320.n22 0.0805
R108 a_5676_4320.n22 a_5676_4320.n23 0.0805
R109 a_5676_4320.n23 a_5676_4320.n24 0.0805
R110 a_5676_4320.n24 a_5676_4320.n25 0.0805
R111 a_5676_4320.n25 a_5676_4320.n26 0.0805
R112 a_5676_4320.n26 a_5676_4320.n27 0.0805
R113 a_5676_4320.n27 a_5676_4320.n28 0.0805
R114 a_5676_4320.n28 a_5676_4320.n29 0.0805
R115 a_5676_4320.n29 a_5676_4320.n30 0.0805
R116 a_5676_4320.n30 a_5676_4320.n31 0.0805
R117 a_5676_4320.n31 a_5676_4320.n32 0.0805
R118 a_5676_4320.n32 a_5676_4320.t62 6.11621
R119 a_5676_4320.t62 a_5676_4320.t63 24.1076
R120 a_5676_4320.n32 a_5676_4320.t60 6.03621
R121 a_5676_4320.t60 a_5676_4320.t61 24.1076
R122 a_5676_4320.n31 a_5676_4320.t58 6.03621
R123 a_5676_4320.t58 a_5676_4320.t59 24.1076
R124 a_5676_4320.n30 a_5676_4320.t56 6.03621
R125 a_5676_4320.t56 a_5676_4320.t57 24.1076
R126 a_5676_4320.n29 a_5676_4320.t54 6.03621
R127 a_5676_4320.t54 a_5676_4320.t55 24.1076
R128 a_5676_4320.n28 a_5676_4320.t52 6.03621
R129 a_5676_4320.t52 a_5676_4320.t53 24.1076
R130 a_5676_4320.n27 a_5676_4320.t50 6.03621
R131 a_5676_4320.t50 a_5676_4320.t51 24.1076
R132 a_5676_4320.n26 a_5676_4320.t48 6.03621
R133 a_5676_4320.t48 a_5676_4320.t49 24.1076
R134 a_5676_4320.n25 a_5676_4320.t46 6.03621
R135 a_5676_4320.t46 a_5676_4320.t47 24.1076
R136 a_5676_4320.n24 a_5676_4320.t44 6.03621
R137 a_5676_4320.t44 a_5676_4320.t45 24.1076
R138 a_5676_4320.n23 a_5676_4320.t42 6.03621
R139 a_5676_4320.t42 a_5676_4320.t43 24.1076
R140 a_5676_4320.n22 a_5676_4320.t40 6.03621
R141 a_5676_4320.t40 a_5676_4320.t41 24.1076
R142 a_5676_4320.n21 a_5676_4320.t38 6.03621
R143 a_5676_4320.t38 a_5676_4320.t39 24.1076
R144 a_5676_4320.n20 a_5676_4320.t36 6.03621
R145 a_5676_4320.t36 a_5676_4320.t37 24.1076
R146 a_5676_4320.n19 a_5676_4320.t34 6.03621
R147 a_5676_4320.t34 a_5676_4320.t35 24.1076
R148 a_5676_4320.n18 a_5676_4320.t32 6.03621
R149 a_5676_4320.t32 a_5676_4320.t33 24.1076
R150 a_5676_4320.n17 a_5676_4320.t30 6.03621
R151 a_5676_4320.t30 a_5676_4320.t31 24.1076
R152 a_5676_4320.n16 a_5676_4320.t28 6.03621
R153 a_5676_4320.t28 a_5676_4320.t29 24.1076
R154 a_5676_4320.n15 a_5676_4320.t26 6.03621
R155 a_5676_4320.t26 a_5676_4320.t27 24.1076
R156 a_5676_4320.n14 a_5676_4320.t24 6.03621
R157 a_5676_4320.t24 a_5676_4320.t25 24.1076
R158 a_5676_4320.n13 a_5676_4320.t22 6.03621
R159 a_5676_4320.t22 a_5676_4320.t23 24.1076
R160 a_5676_4320.n12 a_5676_4320.t20 6.03621
R161 a_5676_4320.t20 a_5676_4320.t21 24.1076
R162 a_5676_4320.n11 a_5676_4320.t18 6.03621
R163 a_5676_4320.t18 a_5676_4320.t19 24.1076
R164 a_5676_4320.n10 a_5676_4320.t16 6.03621
R165 a_5676_4320.t16 a_5676_4320.t17 24.1076
R166 a_5676_4320.n9 a_5676_4320.n8 0.5805
R167 a_5676_4320.n9 a_5676_4320.n7 0.7705
R168 a_5676_4320.n8 a_5676_4320.t6 0.1045
R169 a_5676_4320.n8 a_5676_4320.t8 0.1045
R170 a_5676_4320.n7 a_5676_4320.t7 0.2605
R171 a_5676_4320.n7 a_5676_4320.t9 0.2605
R172 a_5676_4320.n6 a_5676_4320.n5 0.5805
R173 a_5676_4320.n6 a_5676_4320.n4 0.7705
R174 a_5676_4320.n5 a_5676_4320.t2 0.1045
R175 a_5676_4320.n5 a_5676_4320.t4 0.1045
R176 a_5676_4320.n4 a_5676_4320.t3 0.2605
R177 a_5676_4320.n4 a_5676_4320.t5 0.2605
R178 a_5676_4320.n3 a_5676_4320.n2 0.5805
R179 a_5676_4320.n3 a_5676_4320.n1 0.7705
R180 a_5676_4320.n2 a_5676_4320.t10 0.1045
R181 a_5676_4320.n2 a_5676_4320.t12 0.1045
R182 a_5676_4320.n1 a_5676_4320.t11 0.2605
R183 a_5676_4320.n1 a_5676_4320.t13 0.2605
R184 a_5676_4320.n0 a_5676_4320.t15 0.2605
R185 a_5676_4320.n0 a_5676_4320.t1 0.2605
R186 a_5036_4320.t0 a_5036_4320.n9 0.1045
R187 a_5036_4320.n9 a_5036_4320.t2 0.1045
R188 a_5036_4320.n9 a_5036_4320.n8 0.5805
R189 a_5036_4320.n8 a_5036_4320.n0 0.7705
R190 a_5036_4320.n8 a_5036_4320.n1 1.4825
R191 a_5036_4320.n1 a_5036_4320.n2 0.0805
R192 a_5036_4320.n2 a_5036_4320.n3 0.0805
R193 a_5036_4320.n3 a_5036_4320.n4 0.0805
R194 a_5036_4320.n4 a_5036_4320.n5 0.0805
R195 a_5036_4320.n5 a_5036_4320.n6 0.0805
R196 a_5036_4320.n6 a_5036_4320.n7 0.0805
R197 a_5036_4320.n7 a_5036_4320.t18 6.11621
R198 a_5036_4320.t18 a_5036_4320.t19 24.1076
R199 a_5036_4320.n7 a_5036_4320.t16 6.03621
R200 a_5036_4320.t16 a_5036_4320.t17 24.1076
R201 a_5036_4320.n6 a_5036_4320.t14 6.03621
R202 a_5036_4320.t14 a_5036_4320.t15 24.1076
R203 a_5036_4320.n5 a_5036_4320.t12 6.03621
R204 a_5036_4320.t12 a_5036_4320.t13 24.1076
R205 a_5036_4320.n4 a_5036_4320.t10 6.03621
R206 a_5036_4320.t10 a_5036_4320.t11 24.1076
R207 a_5036_4320.n3 a_5036_4320.t8 6.03621
R208 a_5036_4320.t8 a_5036_4320.t9 24.1076
R209 a_5036_4320.n2 a_5036_4320.t6 6.03621
R210 a_5036_4320.t6 a_5036_4320.t7 24.1076
R211 a_5036_4320.n1 a_5036_4320.t4 6.03621
R212 a_5036_4320.t4 a_5036_4320.t5 24.1076
R213 a_5036_4320.n0 a_5036_4320.t1 0.2605
R214 a_5036_4320.n0 a_5036_4320.t3 0.2605
R215 a_4556_4320.t0 a_4556_4320.n1 0.6845
R216 a_4556_4320.n1 a_4556_4320.n0 1.4825
R217 a_4556_4320.n0 a_4556_4320.t4 6.11621
R218 a_4556_4320.t4 a_4556_4320.t5 24.1076
R219 a_4556_4320.n0 a_4556_4320.t2 6.03621
R220 a_4556_4320.t2 a_4556_4320.t3 24.1076
R221 a_4556_4320.n1 a_4556_4320.t1 1.0305
R222 a_4492_4188.t1 a_4492_4188.n2 0.6845
R223 a_4492_4188.n2 a_4492_4188.n0 0.1985
R224 a_4492_4188.n0 a_4492_4188.n1 12.3245
R225 a_4492_4188.n1 a_4492_4188.t7 6.11621
R226 a_4492_4188.t7 a_4492_4188.t6 24.1076
R227 a_4492_4188.n1 a_4492_4188.t5 6.03621
R228 a_4492_4188.t5 a_4492_4188.t4 24.1076
R229 a_4492_4188.n0 a_4492_4188.t2 20.1282
R230 a_4492_4188.t2 a_4492_4188.t3 24.1076
R231 a_4492_4188.n2 a_4492_4188.t0 1.0305
R232 a_27276_4320.t0 a_27276_4320.n1 0.6845
R233 a_27276_4320.n1 a_27276_4320.n0 1.4825
R234 a_27276_4320.n0 a_27276_4320.t4 6.11621
R235 a_27276_4320.t4 a_27276_4320.t5 24.1076
R236 a_27276_4320.n0 a_27276_4320.t2 6.03621
R237 a_27276_4320.t2 a_27276_4320.t3 24.1076
R238 a_27276_4320.n1 a_27276_4320.t1 1.0305
R239 a_21516_4320.n35 a_21516_4320.t14 0.1045
R240 a_21516_4320.t0 a_21516_4320.n35 0.1045
R241 a_21516_4320.n35 a_21516_4320.n34 0.5805
R242 a_21516_4320.n34 a_21516_4320.n0 0.7705
R243 a_21516_4320.n34 a_21516_4320.n3 0.3045
R244 a_21516_4320.n34 a_21516_4320.n33 0.2285
R245 a_21516_4320.n33 a_21516_4320.n6 0.0765
R246 a_21516_4320.n6 a_21516_4320.n9 0.3045
R247 a_21516_4320.n33 a_21516_4320.n10 1.8865
R248 a_21516_4320.n10 a_21516_4320.n11 0.0805
R249 a_21516_4320.n11 a_21516_4320.n12 0.0805
R250 a_21516_4320.n12 a_21516_4320.n13 0.0805
R251 a_21516_4320.n13 a_21516_4320.n14 0.0805
R252 a_21516_4320.n14 a_21516_4320.n15 0.0805
R253 a_21516_4320.n15 a_21516_4320.n16 0.0805
R254 a_21516_4320.n16 a_21516_4320.n17 0.0805
R255 a_21516_4320.n17 a_21516_4320.n18 0.0805
R256 a_21516_4320.n18 a_21516_4320.n19 0.0805
R257 a_21516_4320.n19 a_21516_4320.n20 0.0805
R258 a_21516_4320.n20 a_21516_4320.n21 0.0805
R259 a_21516_4320.n21 a_21516_4320.n22 0.0805
R260 a_21516_4320.n22 a_21516_4320.n23 0.0805
R261 a_21516_4320.n23 a_21516_4320.n24 0.0805
R262 a_21516_4320.n24 a_21516_4320.n25 0.0805
R263 a_21516_4320.n25 a_21516_4320.n26 0.0805
R264 a_21516_4320.n26 a_21516_4320.n27 0.0805
R265 a_21516_4320.n27 a_21516_4320.n28 0.0805
R266 a_21516_4320.n28 a_21516_4320.n29 0.0805
R267 a_21516_4320.n29 a_21516_4320.n30 0.0805
R268 a_21516_4320.n30 a_21516_4320.n31 0.0805
R269 a_21516_4320.n31 a_21516_4320.n32 0.0805
R270 a_21516_4320.n32 a_21516_4320.t62 6.11621
R271 a_21516_4320.t62 a_21516_4320.t63 24.1076
R272 a_21516_4320.n32 a_21516_4320.t60 6.03621
R273 a_21516_4320.t60 a_21516_4320.t61 24.1076
R274 a_21516_4320.n31 a_21516_4320.t58 6.03621
R275 a_21516_4320.t58 a_21516_4320.t59 24.1076
R276 a_21516_4320.n30 a_21516_4320.t56 6.03621
R277 a_21516_4320.t56 a_21516_4320.t57 24.1076
R278 a_21516_4320.n29 a_21516_4320.t54 6.03621
R279 a_21516_4320.t54 a_21516_4320.t55 24.1076
R280 a_21516_4320.n28 a_21516_4320.t52 6.03621
R281 a_21516_4320.t52 a_21516_4320.t53 24.1076
R282 a_21516_4320.n27 a_21516_4320.t50 6.03621
R283 a_21516_4320.t50 a_21516_4320.t51 24.1076
R284 a_21516_4320.n26 a_21516_4320.t48 6.03621
R285 a_21516_4320.t48 a_21516_4320.t49 24.1076
R286 a_21516_4320.n25 a_21516_4320.t46 6.03621
R287 a_21516_4320.t46 a_21516_4320.t47 24.1076
R288 a_21516_4320.n24 a_21516_4320.t44 6.03621
R289 a_21516_4320.t44 a_21516_4320.t45 24.1076
R290 a_21516_4320.n23 a_21516_4320.t42 6.03621
R291 a_21516_4320.t42 a_21516_4320.t43 24.1076
R292 a_21516_4320.n22 a_21516_4320.t40 6.03621
R293 a_21516_4320.t40 a_21516_4320.t41 24.1076
R294 a_21516_4320.n21 a_21516_4320.t38 6.03621
R295 a_21516_4320.t38 a_21516_4320.t39 24.1076
R296 a_21516_4320.n20 a_21516_4320.t36 6.03621
R297 a_21516_4320.t36 a_21516_4320.t37 24.1076
R298 a_21516_4320.n19 a_21516_4320.t34 6.03621
R299 a_21516_4320.t34 a_21516_4320.t35 24.1076
R300 a_21516_4320.n18 a_21516_4320.t32 6.03621
R301 a_21516_4320.t32 a_21516_4320.t33 24.1076
R302 a_21516_4320.n17 a_21516_4320.t30 6.03621
R303 a_21516_4320.t30 a_21516_4320.t31 24.1076
R304 a_21516_4320.n16 a_21516_4320.t28 6.03621
R305 a_21516_4320.t28 a_21516_4320.t29 24.1076
R306 a_21516_4320.n15 a_21516_4320.t26 6.03621
R307 a_21516_4320.t26 a_21516_4320.t27 24.1076
R308 a_21516_4320.n14 a_21516_4320.t24 6.03621
R309 a_21516_4320.t24 a_21516_4320.t25 24.1076
R310 a_21516_4320.n13 a_21516_4320.t22 6.03621
R311 a_21516_4320.t22 a_21516_4320.t23 24.1076
R312 a_21516_4320.n12 a_21516_4320.t20 6.03621
R313 a_21516_4320.t20 a_21516_4320.t21 24.1076
R314 a_21516_4320.n11 a_21516_4320.t18 6.03621
R315 a_21516_4320.t18 a_21516_4320.t19 24.1076
R316 a_21516_4320.n10 a_21516_4320.t16 6.03621
R317 a_21516_4320.t16 a_21516_4320.t17 24.1076
R318 a_21516_4320.n9 a_21516_4320.n8 0.5805
R319 a_21516_4320.n9 a_21516_4320.n7 0.7705
R320 a_21516_4320.n8 a_21516_4320.t6 0.1045
R321 a_21516_4320.n8 a_21516_4320.t8 0.1045
R322 a_21516_4320.n7 a_21516_4320.t7 0.2605
R323 a_21516_4320.n7 a_21516_4320.t9 0.2605
R324 a_21516_4320.n6 a_21516_4320.n5 0.5805
R325 a_21516_4320.n6 a_21516_4320.n4 0.7705
R326 a_21516_4320.n5 a_21516_4320.t2 0.1045
R327 a_21516_4320.n5 a_21516_4320.t4 0.1045
R328 a_21516_4320.n4 a_21516_4320.t3 0.2605
R329 a_21516_4320.n4 a_21516_4320.t5 0.2605
R330 a_21516_4320.n3 a_21516_4320.n2 0.5805
R331 a_21516_4320.n3 a_21516_4320.n1 0.7705
R332 a_21516_4320.n2 a_21516_4320.t10 0.1045
R333 a_21516_4320.n2 a_21516_4320.t12 0.1045
R334 a_21516_4320.n1 a_21516_4320.t11 0.2605
R335 a_21516_4320.n1 a_21516_4320.t13 0.2605
R336 a_21516_4320.n0 a_21516_4320.t15 0.2605
R337 a_21516_4320.n0 a_21516_4320.t1 0.2605
R338 a_21516_340.n35 a_21516_340.t15 0.1045
R339 a_21516_340.t1 a_21516_340.n35 0.1045
R340 a_21516_340.n34 a_21516_340.n0 0.7705
R341 a_21516_340.n35 a_21516_340.n34 0.5805
R342 a_21516_340.n34 a_21516_340.n3 0.3045
R343 a_21516_340.n34 a_21516_340.n33 0.2285
R344 a_21516_340.n33 a_21516_340.n6 0.0765
R345 a_21516_340.n6 a_21516_340.n9 0.3045
R346 a_21516_340.n33 a_21516_340.n10 1.9145
R347 a_21516_340.n10 a_21516_340.n11 0.0805
R348 a_21516_340.n11 a_21516_340.n12 0.0805
R349 a_21516_340.n12 a_21516_340.n13 0.0805
R350 a_21516_340.n13 a_21516_340.n14 0.0805
R351 a_21516_340.n14 a_21516_340.n15 0.0805
R352 a_21516_340.n15 a_21516_340.n16 0.0805
R353 a_21516_340.n16 a_21516_340.n17 0.0805
R354 a_21516_340.n17 a_21516_340.n18 0.0805
R355 a_21516_340.n18 a_21516_340.n19 0.0805
R356 a_21516_340.n19 a_21516_340.n20 0.0805
R357 a_21516_340.n20 a_21516_340.n21 0.0805
R358 a_21516_340.n21 a_21516_340.n22 0.0805
R359 a_21516_340.n22 a_21516_340.n23 0.0805
R360 a_21516_340.n23 a_21516_340.n24 0.0805
R361 a_21516_340.n24 a_21516_340.n25 0.0805
R362 a_21516_340.n25 a_21516_340.n26 0.0805
R363 a_21516_340.n26 a_21516_340.n27 0.0805
R364 a_21516_340.n27 a_21516_340.n28 0.0805
R365 a_21516_340.n28 a_21516_340.n29 0.0805
R366 a_21516_340.n29 a_21516_340.n30 0.0805
R367 a_21516_340.n30 a_21516_340.n31 0.0805
R368 a_21516_340.n31 a_21516_340.n32 0.0805
R369 a_21516_340.n32 a_21516_340.t63 6.11621
R370 a_21516_340.t63 a_21516_340.t62 24.1076
R371 a_21516_340.n32 a_21516_340.t61 6.03621
R372 a_21516_340.t61 a_21516_340.t60 24.1076
R373 a_21516_340.n31 a_21516_340.t59 6.03621
R374 a_21516_340.t59 a_21516_340.t58 24.1076
R375 a_21516_340.n30 a_21516_340.t57 6.03621
R376 a_21516_340.t57 a_21516_340.t56 24.1076
R377 a_21516_340.n29 a_21516_340.t55 6.03621
R378 a_21516_340.t55 a_21516_340.t54 24.1076
R379 a_21516_340.n28 a_21516_340.t53 6.03621
R380 a_21516_340.t53 a_21516_340.t52 24.1076
R381 a_21516_340.n27 a_21516_340.t51 6.03621
R382 a_21516_340.t51 a_21516_340.t50 24.1076
R383 a_21516_340.n26 a_21516_340.t49 6.03621
R384 a_21516_340.t49 a_21516_340.t48 24.1076
R385 a_21516_340.n25 a_21516_340.t47 6.03621
R386 a_21516_340.t47 a_21516_340.t46 24.1076
R387 a_21516_340.n24 a_21516_340.t45 6.03621
R388 a_21516_340.t45 a_21516_340.t44 24.1076
R389 a_21516_340.n23 a_21516_340.t43 6.03621
R390 a_21516_340.t43 a_21516_340.t42 24.1076
R391 a_21516_340.n22 a_21516_340.t41 6.03621
R392 a_21516_340.t41 a_21516_340.t40 24.1076
R393 a_21516_340.n21 a_21516_340.t39 6.03621
R394 a_21516_340.t39 a_21516_340.t38 24.1076
R395 a_21516_340.n20 a_21516_340.t37 6.03621
R396 a_21516_340.t37 a_21516_340.t36 24.1076
R397 a_21516_340.n19 a_21516_340.t35 6.03621
R398 a_21516_340.t35 a_21516_340.t34 24.1076
R399 a_21516_340.n18 a_21516_340.t33 6.03621
R400 a_21516_340.t33 a_21516_340.t32 24.1076
R401 a_21516_340.n17 a_21516_340.t31 6.03621
R402 a_21516_340.t31 a_21516_340.t30 24.1076
R403 a_21516_340.n16 a_21516_340.t29 6.03621
R404 a_21516_340.t29 a_21516_340.t28 24.1076
R405 a_21516_340.n15 a_21516_340.t27 6.03621
R406 a_21516_340.t27 a_21516_340.t26 24.1076
R407 a_21516_340.n14 a_21516_340.t25 6.03621
R408 a_21516_340.t25 a_21516_340.t24 24.1076
R409 a_21516_340.n13 a_21516_340.t23 6.03621
R410 a_21516_340.t23 a_21516_340.t22 24.1076
R411 a_21516_340.n12 a_21516_340.t21 6.03621
R412 a_21516_340.t21 a_21516_340.t20 24.1076
R413 a_21516_340.n11 a_21516_340.t19 6.03621
R414 a_21516_340.t19 a_21516_340.t18 24.1076
R415 a_21516_340.n10 a_21516_340.t17 6.03621
R416 a_21516_340.t17 a_21516_340.t16 24.1076
R417 a_21516_340.n9 a_21516_340.n8 0.7705
R418 a_21516_340.n9 a_21516_340.n7 0.5805
R419 a_21516_340.n8 a_21516_340.t6 0.2605
R420 a_21516_340.n8 a_21516_340.t8 0.2605
R421 a_21516_340.n7 a_21516_340.t7 0.1045
R422 a_21516_340.n7 a_21516_340.t9 0.1045
R423 a_21516_340.n6 a_21516_340.n5 0.7705
R424 a_21516_340.n6 a_21516_340.n4 0.5805
R425 a_21516_340.n5 a_21516_340.t2 0.2605
R426 a_21516_340.n5 a_21516_340.t4 0.2605
R427 a_21516_340.n4 a_21516_340.t3 0.1045
R428 a_21516_340.n4 a_21516_340.t5 0.1045
R429 a_21516_340.n3 a_21516_340.n2 0.7705
R430 a_21516_340.n3 a_21516_340.n1 0.5805
R431 a_21516_340.n2 a_21516_340.t10 0.2605
R432 a_21516_340.n2 a_21516_340.t12 0.2605
R433 a_21516_340.n1 a_21516_340.t11 0.1045
R434 a_21516_340.n1 a_21516_340.t13 0.1045
R435 a_21516_340.n0 a_21516_340.t14 0.2605
R436 a_21516_340.n0 a_21516_340.t0 0.2605
R437 a_20876_4320.t0 a_20876_4320.n9 0.1045
R438 a_20876_4320.n9 a_20876_4320.t1 0.1045
R439 a_20876_4320.n9 a_20876_4320.n8 0.5805
R440 a_20876_4320.n8 a_20876_4320.n0 0.7705
R441 a_20876_4320.n8 a_20876_4320.n1 1.4825
R442 a_20876_4320.n1 a_20876_4320.n2 0.0805
R443 a_20876_4320.n2 a_20876_4320.n3 0.0805
R444 a_20876_4320.n3 a_20876_4320.n4 0.0805
R445 a_20876_4320.n4 a_20876_4320.n5 0.0805
R446 a_20876_4320.n5 a_20876_4320.n6 0.0805
R447 a_20876_4320.n6 a_20876_4320.n7 0.0805
R448 a_20876_4320.n7 a_20876_4320.t18 6.11621
R449 a_20876_4320.t18 a_20876_4320.t19 24.1076
R450 a_20876_4320.n7 a_20876_4320.t16 6.03621
R451 a_20876_4320.t16 a_20876_4320.t17 24.1076
R452 a_20876_4320.n6 a_20876_4320.t14 6.03621
R453 a_20876_4320.t14 a_20876_4320.t15 24.1076
R454 a_20876_4320.n5 a_20876_4320.t12 6.03621
R455 a_20876_4320.t12 a_20876_4320.t13 24.1076
R456 a_20876_4320.n4 a_20876_4320.t10 6.03621
R457 a_20876_4320.t10 a_20876_4320.t11 24.1076
R458 a_20876_4320.n3 a_20876_4320.t8 6.03621
R459 a_20876_4320.t8 a_20876_4320.t9 24.1076
R460 a_20876_4320.n2 a_20876_4320.t6 6.03621
R461 a_20876_4320.t6 a_20876_4320.t7 24.1076
R462 a_20876_4320.n1 a_20876_4320.t4 6.03621
R463 a_20876_4320.t4 a_20876_4320.t5 24.1076
R464 a_20876_4320.n0 a_20876_4320.t2 0.2605
R465 a_20876_4320.n0 a_20876_4320.t3 0.2605
R466 a_20876_340.t1 a_20876_340.n9 0.1045
R467 a_20876_340.n9 a_20876_340.t3 0.1045
R468 a_20876_340.n8 a_20876_340.n0 0.7705
R469 a_20876_340.n9 a_20876_340.n8 0.5805
R470 a_20876_340.n8 a_20876_340.n1 1.5105
R471 a_20876_340.n1 a_20876_340.n2 0.0805
R472 a_20876_340.n2 a_20876_340.n3 0.0805
R473 a_20876_340.n3 a_20876_340.n4 0.0805
R474 a_20876_340.n4 a_20876_340.n5 0.0805
R475 a_20876_340.n5 a_20876_340.n6 0.0805
R476 a_20876_340.n6 a_20876_340.n7 0.0805
R477 a_20876_340.n7 a_20876_340.t19 6.11621
R478 a_20876_340.t19 a_20876_340.t18 24.1076
R479 a_20876_340.n7 a_20876_340.t17 6.03621
R480 a_20876_340.t17 a_20876_340.t16 24.1076
R481 a_20876_340.n6 a_20876_340.t15 6.03621
R482 a_20876_340.t15 a_20876_340.t14 24.1076
R483 a_20876_340.n5 a_20876_340.t13 6.03621
R484 a_20876_340.t13 a_20876_340.t12 24.1076
R485 a_20876_340.n4 a_20876_340.t11 6.03621
R486 a_20876_340.t11 a_20876_340.t10 24.1076
R487 a_20876_340.n3 a_20876_340.t9 6.03621
R488 a_20876_340.t9 a_20876_340.t8 24.1076
R489 a_20876_340.n2 a_20876_340.t7 6.03621
R490 a_20876_340.t7 a_20876_340.t6 24.1076
R491 a_20876_340.n1 a_20876_340.t5 6.03621
R492 a_20876_340.t5 a_20876_340.t4 24.1076
R493 a_20876_340.n0 a_20876_340.t0 0.2605
R494 a_20876_340.n0 a_20876_340.t2 0.2605
R495 a_20396_340.t1 a_20396_340.n1 0.6845
R496 a_20396_340.n1 a_20396_340.n0 1.4825
R497 a_20396_340.n0 a_20396_340.t5 6.11621
R498 a_20396_340.t5 a_20396_340.t4 24.1076
R499 a_20396_340.n0 a_20396_340.t3 6.03621
R500 a_20396_340.t3 a_20396_340.t2 24.1076
R501 a_20396_340.n1 a_20396_340.t0 1.0305
R502 a_18316_4320.t0 a_18316_4320.n11 0.1045
R503 a_18316_4320.n11 a_18316_4320.t2 0.1045
R504 a_18316_4320.n11 a_18316_4320.n10 0.5805
R505 a_18316_4320.n10 a_18316_4320.n0 0.7705
R506 a_18316_4320.n10 a_18316_4320.n1 1.4825
R507 a_18316_4320.n1 a_18316_4320.n2 0.0805
R508 a_18316_4320.n2 a_18316_4320.n3 0.0805
R509 a_18316_4320.n3 a_18316_4320.n4 0.0805
R510 a_18316_4320.n4 a_18316_4320.n5 0.0805
R511 a_18316_4320.n5 a_18316_4320.n6 0.0805
R512 a_18316_4320.n6 a_18316_4320.n7 0.0805
R513 a_18316_4320.n7 a_18316_4320.n8 0.0805
R514 a_18316_4320.n8 a_18316_4320.n9 0.0805
R515 a_18316_4320.n9 a_18316_4320.t22 6.11621
R516 a_18316_4320.t22 a_18316_4320.t23 24.1076
R517 a_18316_4320.n9 a_18316_4320.t20 6.03621
R518 a_18316_4320.t20 a_18316_4320.t21 24.1076
R519 a_18316_4320.n8 a_18316_4320.t18 6.03621
R520 a_18316_4320.t18 a_18316_4320.t19 24.1076
R521 a_18316_4320.n7 a_18316_4320.t16 6.03621
R522 a_18316_4320.t16 a_18316_4320.t17 24.1076
R523 a_18316_4320.n6 a_18316_4320.t14 6.03621
R524 a_18316_4320.t14 a_18316_4320.t15 24.1076
R525 a_18316_4320.n5 a_18316_4320.t12 6.03621
R526 a_18316_4320.t12 a_18316_4320.t13 24.1076
R527 a_18316_4320.n4 a_18316_4320.t10 6.03621
R528 a_18316_4320.t10 a_18316_4320.t11 24.1076
R529 a_18316_4320.n3 a_18316_4320.t8 6.03621
R530 a_18316_4320.t8 a_18316_4320.t9 24.1076
R531 a_18316_4320.n2 a_18316_4320.t6 6.03621
R532 a_18316_4320.t6 a_18316_4320.t7 24.1076
R533 a_18316_4320.n1 a_18316_4320.t4 6.03621
R534 a_18316_4320.t4 a_18316_4320.t5 24.1076
R535 a_18316_4320.n0 a_18316_4320.t1 0.2605
R536 a_18316_4320.n0 a_18316_4320.t3 0.2605
R537 a_17836_4320.t0 a_17836_4320.n1 0.6845
R538 a_17836_4320.n1 a_17836_4320.n0 1.4825
R539 a_17836_4320.n0 a_17836_4320.t4 6.11621
R540 a_17836_4320.t4 a_17836_4320.t5 24.1076
R541 a_17836_4320.n0 a_17836_4320.t2 6.03621
R542 a_17836_4320.t2 a_17836_4320.t3 24.1076
R543 a_17836_4320.n1 a_17836_4320.t1 1.0305
R544 a_16876_340.n20 a_16876_340.t11 0.1045
R545 a_16876_340.t1 a_16876_340.n20 0.1045
R546 a_16876_340.n19 a_16876_340.n0 0.7705
R547 a_16876_340.n20 a_16876_340.n19 0.5805
R548 a_16876_340.n19 a_16876_340.n3 0.3045
R549 a_16876_340.n19 a_16876_340.n18 0.0765
R550 a_16876_340.n18 a_16876_340.n6 0.2285
R551 a_16876_340.n18 a_16876_340.n7 1.7265
R552 a_16876_340.n7 a_16876_340.n8 0.0805
R553 a_16876_340.n8 a_16876_340.n9 0.0805
R554 a_16876_340.n9 a_16876_340.n10 0.0805
R555 a_16876_340.n10 a_16876_340.n11 0.0805
R556 a_16876_340.n11 a_16876_340.n12 0.0805
R557 a_16876_340.n12 a_16876_340.n13 0.0805
R558 a_16876_340.n13 a_16876_340.n14 0.0805
R559 a_16876_340.n14 a_16876_340.n15 0.0805
R560 a_16876_340.n15 a_16876_340.n16 0.0805
R561 a_16876_340.n16 a_16876_340.n17 0.0805
R562 a_16876_340.n17 a_16876_340.t35 6.11621
R563 a_16876_340.t35 a_16876_340.t34 24.1076
R564 a_16876_340.n17 a_16876_340.t33 6.03621
R565 a_16876_340.t33 a_16876_340.t32 24.1076
R566 a_16876_340.n16 a_16876_340.t31 6.03621
R567 a_16876_340.t31 a_16876_340.t30 24.1076
R568 a_16876_340.n15 a_16876_340.t29 6.03621
R569 a_16876_340.t29 a_16876_340.t28 24.1076
R570 a_16876_340.n14 a_16876_340.t27 6.03621
R571 a_16876_340.t27 a_16876_340.t26 24.1076
R572 a_16876_340.n13 a_16876_340.t25 6.03621
R573 a_16876_340.t25 a_16876_340.t24 24.1076
R574 a_16876_340.n12 a_16876_340.t23 6.03621
R575 a_16876_340.t23 a_16876_340.t22 24.1076
R576 a_16876_340.n11 a_16876_340.t21 6.03621
R577 a_16876_340.t21 a_16876_340.t20 24.1076
R578 a_16876_340.n10 a_16876_340.t19 6.03621
R579 a_16876_340.t19 a_16876_340.t18 24.1076
R580 a_16876_340.n9 a_16876_340.t17 6.03621
R581 a_16876_340.t17 a_16876_340.t16 24.1076
R582 a_16876_340.n8 a_16876_340.t15 6.03621
R583 a_16876_340.t15 a_16876_340.t14 24.1076
R584 a_16876_340.n7 a_16876_340.t13 6.03621
R585 a_16876_340.t13 a_16876_340.t12 24.1076
R586 a_16876_340.n6 a_16876_340.n5 0.7705
R587 a_16876_340.n6 a_16876_340.n4 0.5805
R588 a_16876_340.n5 a_16876_340.t2 0.2605
R589 a_16876_340.n5 a_16876_340.t4 0.2605
R590 a_16876_340.n4 a_16876_340.t3 0.1045
R591 a_16876_340.n4 a_16876_340.t5 0.1045
R592 a_16876_340.n3 a_16876_340.n2 0.7705
R593 a_16876_340.n3 a_16876_340.n1 0.5805
R594 a_16876_340.n2 a_16876_340.t6 0.2605
R595 a_16876_340.n2 a_16876_340.t8 0.2605
R596 a_16876_340.n1 a_16876_340.t7 0.1045
R597 a_16876_340.n1 a_16876_340.t9 0.1045
R598 a_16876_340.n0 a_16876_340.t10 0.2605
R599 a_16876_340.n0 a_16876_340.t0 0.2605
R600 a_16236_340.t1 a_16236_340.n7 0.1045
R601 a_16236_340.n7 a_16236_340.t3 0.1045
R602 a_16236_340.n6 a_16236_340.n0 0.7705
R603 a_16236_340.n7 a_16236_340.n6 0.5805
R604 a_16236_340.n6 a_16236_340.n1 1.5105
R605 a_16236_340.n1 a_16236_340.n2 0.0805
R606 a_16236_340.n2 a_16236_340.n3 0.0805
R607 a_16236_340.n3 a_16236_340.n4 0.0805
R608 a_16236_340.n4 a_16236_340.n5 0.0805
R609 a_16236_340.n5 a_16236_340.t15 6.11621
R610 a_16236_340.t15 a_16236_340.t14 24.1076
R611 a_16236_340.n5 a_16236_340.t13 6.03621
R612 a_16236_340.t13 a_16236_340.t12 24.1076
R613 a_16236_340.n4 a_16236_340.t11 6.03621
R614 a_16236_340.t11 a_16236_340.t10 24.1076
R615 a_16236_340.n3 a_16236_340.t9 6.03621
R616 a_16236_340.t9 a_16236_340.t8 24.1076
R617 a_16236_340.n2 a_16236_340.t7 6.03621
R618 a_16236_340.t7 a_16236_340.t6 24.1076
R619 a_16236_340.n1 a_16236_340.t5 6.03621
R620 a_16236_340.t5 a_16236_340.t4 24.1076
R621 a_16236_340.n0 a_16236_340.t0 0.2605
R622 a_16236_340.n0 a_16236_340.t2 0.2605
R623 a_1516_340.t1 a_1516_340.n7 0.1045
R624 a_1516_340.n7 a_1516_340.t3 0.1045
R625 a_1516_340.n6 a_1516_340.n0 0.7705
R626 a_1516_340.n7 a_1516_340.n6 0.5805
R627 a_1516_340.n6 a_1516_340.n5 2.1825
R628 a_1516_340.n5 a_1516_340.n1 0.0405
R629 a_1516_340.n5 a_1516_340.n2 5.3445
R630 a_1516_340.n2 a_1516_340.n3 0.8005
R631 a_1516_340.n3 a_1516_340.n4 1.7165
R632 a_1516_340.n4 a_1516_340.t10 3.0979
R633 a_1516_340.n4 a_1516_340.t11 0.4905
R634 a_1516_340.n3 a_1516_340.t9 6.32021
R635 a_1516_340.t9 a_1516_340.t8 22.3219
R636 a_1516_340.n2 a_1516_340.t7 10.7165
R637 a_1516_340.t7 a_1516_340.t6 28.5719
R638 a_1516_340.n1 a_1516_340.t4 2.3279
R639 a_1516_340.n1 a_1516_340.t5 1.2605
R640 a_1516_340.n0 a_1516_340.t0 0.2605
R641 a_1516_340.n0 a_1516_340.t2 0.2605
R642 a_15116_340.t2 a_15116_340.n1 0.9585
R643 a_15116_340.n1 a_15116_340.t4 7.46621
R644 a_15116_340.t4 a_15116_340.t3 24.1076
R645 a_15116_340.n1 a_15116_340.n0 0.8465
R646 a_15116_340.n0 a_15116_340.t0 0.2605
R647 a_15116_340.n0 a_15116_340.t1 0.2605
R648 a_15116_1540.t0 a_15116_1540.t1 0.1045
R649 a_14476_340.t0 a_14476_340.t1 0.2605
R650 a_14476_1540.n2 a_14476_1540.t2 0.1045
R651 a_14476_1540.t1 a_14476_1540.n2 0.1045
R652 a_14476_1540.n2 a_14476_1540.n1 0.5805
R653 a_14476_1540.n1 a_14476_1540.n0 2.9225
R654 a_14476_1540.n0 a_14476_1540.t8 10.0602
R655 a_14476_1540.t8 a_14476_1540.t7 24.1076
R656 a_14476_1540.n0 a_14476_1540.t4 6.11621
R657 a_14476_1540.t4 a_14476_1540.t3 24.1076
R658 a_14476_1540.n0 a_14476_1540.t6 6.03621
R659 a_14476_1540.t6 a_14476_1540.t5 24.1076
R660 a_14476_1540.n1 a_14476_1540.t0 0.9525
R661 a_1292_12000.t0 a_1292_12000.n31 0.1045
R662 a_1292_12000.n31 a_1292_12000.t1 0.1045
R663 a_1292_12000.n31 a_1292_12000.n30 0.5805
R664 a_1292_12000.n30 a_1292_12000.n0 0.7705
R665 a_1292_12000.n30 a_1292_12000.n3 0.3045
R666 a_1292_12000.n3 a_1292_12000.n6 0.3045
R667 a_1292_12000.n6 a_1292_12000.n29 0.0765
R668 a_1292_12000.n29 a_1292_12000.n9 0.2285
R669 a_1292_12000.n9 a_1292_12000.n12 0.3045
R670 a_1292_12000.n13 a_1292_12000.n21 0.0215574
R671 a_1292_12000.n29 a_1292_12000.n13 23.9182
R672 a_1292_12000.n15 a_1292_12000.n14 0.0302787
R673 a_1292_12000.n15 a_1292_12000.n16 0.00216552
R674 a_1292_12000.n17 a_1292_12000.n15 0.026418
R675 a_1292_12000.n17 a_1292_12000.n18 0.00542094
R676 a_1292_12000.n19 a_1292_12000.n17 0.026418
R677 a_1292_12000.n19 a_1292_12000.n20 0.00542094
R678 a_1292_12000.n21 a_1292_12000.n19 0.026418
R679 a_1292_12000.n21 a_1292_12000.n22 0.00216552
R680 a_1292_12000.n13 a_1292_12000.n23 0.00922131
R681 a_1292_12000.n23 a_1292_12000.n24 0.134336
R682 a_1292_12000.n24 a_1292_12000.n25 0.1605
R683 a_1292_12000.n25 a_1292_12000.n26 0.1605
R684 a_1292_12000.n26 a_1292_12000.n27 0.1605
R685 a_1292_12000.n27 a_1292_12000.n28 0.1605
R686 a_1292_12000.n28 a_1292_12000.t37 19.5891
R687 a_1292_12000.n28 a_1292_12000.t36 19.4291
R688 a_1292_12000.n27 a_1292_12000.t35 19.4291
R689 a_1292_12000.n26 a_1292_12000.t34 19.4291
R690 a_1292_12000.n25 a_1292_12000.t33 19.4291
R691 a_1292_12000.n24 a_1292_12000.t32 19.4291
R692 a_1292_12000.n23 a_1292_12000.t31 19.4291
R693 a_1292_12000.n23 a_1292_12000.t30 15.8576
R694 a_1292_12000.n22 a_1292_12000.t29 19.4291
R695 a_1292_12000.n22 a_1292_12000.t28 15.8576
R696 a_1292_12000.n20 a_1292_12000.t27 19.4291
R697 a_1292_12000.n20 a_1292_12000.t26 15.8576
R698 a_1292_12000.n18 a_1292_12000.t25 19.4291
R699 a_1292_12000.n18 a_1292_12000.t24 15.8576
R700 a_1292_12000.n16 a_1292_12000.t23 19.4291
R701 a_1292_12000.n16 a_1292_12000.t22 15.8576
R702 a_1292_12000.n14 a_1292_12000.t21 19.4291
R703 a_1292_12000.n14 a_1292_12000.t20 15.8576
R704 a_1292_12000.n12 a_1292_12000.n11 0.5805
R705 a_1292_12000.n12 a_1292_12000.n10 0.7705
R706 a_1292_12000.n11 a_1292_12000.t8 0.1045
R707 a_1292_12000.n11 a_1292_12000.t9 0.1045
R708 a_1292_12000.n10 a_1292_12000.t18 0.2605
R709 a_1292_12000.n10 a_1292_12000.t19 0.2605
R710 a_1292_12000.n9 a_1292_12000.n8 0.5805
R711 a_1292_12000.n9 a_1292_12000.n7 0.7705
R712 a_1292_12000.n8 a_1292_12000.t6 0.1045
R713 a_1292_12000.n8 a_1292_12000.t7 0.1045
R714 a_1292_12000.n7 a_1292_12000.t16 0.2605
R715 a_1292_12000.n7 a_1292_12000.t17 0.2605
R716 a_1292_12000.n6 a_1292_12000.n5 0.5805
R717 a_1292_12000.n6 a_1292_12000.n4 0.7705
R718 a_1292_12000.n5 a_1292_12000.t4 0.1045
R719 a_1292_12000.n5 a_1292_12000.t5 0.1045
R720 a_1292_12000.n4 a_1292_12000.t14 0.2605
R721 a_1292_12000.n4 a_1292_12000.t15 0.2605
R722 a_1292_12000.n3 a_1292_12000.n2 0.5805
R723 a_1292_12000.n3 a_1292_12000.n1 0.7705
R724 a_1292_12000.n2 a_1292_12000.t2 0.1045
R725 a_1292_12000.n2 a_1292_12000.t3 0.1045
R726 a_1292_12000.n1 a_1292_12000.t12 0.2605
R727 a_1292_12000.n1 a_1292_12000.t13 0.2605
R728 a_1292_12000.n0 a_1292_12000.t10 0.2605
R729 a_1292_12000.n0 a_1292_12000.t11 0.2605
R730 a_12076_4320.n35 a_12076_4320.t14 0.1045
R731 a_12076_4320.t0 a_12076_4320.n35 0.1045
R732 a_12076_4320.n35 a_12076_4320.n34 0.5805
R733 a_12076_4320.n34 a_12076_4320.n0 0.7705
R734 a_12076_4320.n34 a_12076_4320.n3 0.3045
R735 a_12076_4320.n34 a_12076_4320.n33 0.2285
R736 a_12076_4320.n33 a_12076_4320.n6 0.0765
R737 a_12076_4320.n6 a_12076_4320.n9 0.3045
R738 a_12076_4320.n33 a_12076_4320.n10 1.8865
R739 a_12076_4320.n10 a_12076_4320.n11 0.0805
R740 a_12076_4320.n11 a_12076_4320.n12 0.0805
R741 a_12076_4320.n12 a_12076_4320.n13 0.0805
R742 a_12076_4320.n13 a_12076_4320.n14 0.0805
R743 a_12076_4320.n14 a_12076_4320.n15 0.0805
R744 a_12076_4320.n15 a_12076_4320.n16 0.0805
R745 a_12076_4320.n16 a_12076_4320.n17 0.0805
R746 a_12076_4320.n17 a_12076_4320.n18 0.0805
R747 a_12076_4320.n18 a_12076_4320.n19 0.0805
R748 a_12076_4320.n19 a_12076_4320.n20 0.0805
R749 a_12076_4320.n20 a_12076_4320.n21 0.0805
R750 a_12076_4320.n21 a_12076_4320.n22 0.0805
R751 a_12076_4320.n22 a_12076_4320.n23 0.0805
R752 a_12076_4320.n23 a_12076_4320.n24 0.0805
R753 a_12076_4320.n24 a_12076_4320.n25 0.0805
R754 a_12076_4320.n25 a_12076_4320.n26 0.0805
R755 a_12076_4320.n26 a_12076_4320.n27 0.0805
R756 a_12076_4320.n27 a_12076_4320.n28 0.0805
R757 a_12076_4320.n28 a_12076_4320.n29 0.0805
R758 a_12076_4320.n29 a_12076_4320.n30 0.0805
R759 a_12076_4320.n30 a_12076_4320.n31 0.0805
R760 a_12076_4320.n31 a_12076_4320.n32 0.0805
R761 a_12076_4320.n32 a_12076_4320.t62 6.11621
R762 a_12076_4320.t62 a_12076_4320.t63 24.1076
R763 a_12076_4320.n32 a_12076_4320.t60 6.03621
R764 a_12076_4320.t60 a_12076_4320.t61 24.1076
R765 a_12076_4320.n31 a_12076_4320.t58 6.03621
R766 a_12076_4320.t58 a_12076_4320.t59 24.1076
R767 a_12076_4320.n30 a_12076_4320.t56 6.03621
R768 a_12076_4320.t56 a_12076_4320.t57 24.1076
R769 a_12076_4320.n29 a_12076_4320.t54 6.03621
R770 a_12076_4320.t54 a_12076_4320.t55 24.1076
R771 a_12076_4320.n28 a_12076_4320.t52 6.03621
R772 a_12076_4320.t52 a_12076_4320.t53 24.1076
R773 a_12076_4320.n27 a_12076_4320.t50 6.03621
R774 a_12076_4320.t50 a_12076_4320.t51 24.1076
R775 a_12076_4320.n26 a_12076_4320.t48 6.03621
R776 a_12076_4320.t48 a_12076_4320.t49 24.1076
R777 a_12076_4320.n25 a_12076_4320.t46 6.03621
R778 a_12076_4320.t46 a_12076_4320.t47 24.1076
R779 a_12076_4320.n24 a_12076_4320.t44 6.03621
R780 a_12076_4320.t44 a_12076_4320.t45 24.1076
R781 a_12076_4320.n23 a_12076_4320.t42 6.03621
R782 a_12076_4320.t42 a_12076_4320.t43 24.1076
R783 a_12076_4320.n22 a_12076_4320.t40 6.03621
R784 a_12076_4320.t40 a_12076_4320.t41 24.1076
R785 a_12076_4320.n21 a_12076_4320.t38 6.03621
R786 a_12076_4320.t38 a_12076_4320.t39 24.1076
R787 a_12076_4320.n20 a_12076_4320.t36 6.03621
R788 a_12076_4320.t36 a_12076_4320.t37 24.1076
R789 a_12076_4320.n19 a_12076_4320.t34 6.03621
R790 a_12076_4320.t34 a_12076_4320.t35 24.1076
R791 a_12076_4320.n18 a_12076_4320.t32 6.03621
R792 a_12076_4320.t32 a_12076_4320.t33 24.1076
R793 a_12076_4320.n17 a_12076_4320.t30 6.03621
R794 a_12076_4320.t30 a_12076_4320.t31 24.1076
R795 a_12076_4320.n16 a_12076_4320.t28 6.03621
R796 a_12076_4320.t28 a_12076_4320.t29 24.1076
R797 a_12076_4320.n15 a_12076_4320.t26 6.03621
R798 a_12076_4320.t26 a_12076_4320.t27 24.1076
R799 a_12076_4320.n14 a_12076_4320.t24 6.03621
R800 a_12076_4320.t24 a_12076_4320.t25 24.1076
R801 a_12076_4320.n13 a_12076_4320.t22 6.03621
R802 a_12076_4320.t22 a_12076_4320.t23 24.1076
R803 a_12076_4320.n12 a_12076_4320.t20 6.03621
R804 a_12076_4320.t20 a_12076_4320.t21 24.1076
R805 a_12076_4320.n11 a_12076_4320.t18 6.03621
R806 a_12076_4320.t18 a_12076_4320.t19 24.1076
R807 a_12076_4320.n10 a_12076_4320.t16 6.03621
R808 a_12076_4320.t16 a_12076_4320.t17 24.1076
R809 a_12076_4320.n9 a_12076_4320.n8 0.5805
R810 a_12076_4320.n9 a_12076_4320.n7 0.7705
R811 a_12076_4320.n8 a_12076_4320.t6 0.1045
R812 a_12076_4320.n8 a_12076_4320.t8 0.1045
R813 a_12076_4320.n7 a_12076_4320.t7 0.2605
R814 a_12076_4320.n7 a_12076_4320.t9 0.2605
R815 a_12076_4320.n6 a_12076_4320.n5 0.5805
R816 a_12076_4320.n6 a_12076_4320.n4 0.7705
R817 a_12076_4320.n5 a_12076_4320.t2 0.1045
R818 a_12076_4320.n5 a_12076_4320.t4 0.1045
R819 a_12076_4320.n4 a_12076_4320.t3 0.2605
R820 a_12076_4320.n4 a_12076_4320.t5 0.2605
R821 a_12076_4320.n3 a_12076_4320.n2 0.5805
R822 a_12076_4320.n3 a_12076_4320.n1 0.7705
R823 a_12076_4320.n2 a_12076_4320.t10 0.1045
R824 a_12076_4320.n2 a_12076_4320.t12 0.1045
R825 a_12076_4320.n1 a_12076_4320.t11 0.2605
R826 a_12076_4320.n1 a_12076_4320.t13 0.2605
R827 a_12076_4320.n0 a_12076_4320.t15 0.2605
R828 a_12076_4320.n0 a_12076_4320.t1 0.2605
R829 a_11436_4320.t0 a_11436_4320.n9 0.1045
R830 a_11436_4320.n9 a_11436_4320.t1 0.1045
R831 a_11436_4320.n9 a_11436_4320.n8 0.5805
R832 a_11436_4320.n8 a_11436_4320.n0 0.7705
R833 a_11436_4320.n8 a_11436_4320.n1 1.4825
R834 a_11436_4320.n1 a_11436_4320.n2 0.0805
R835 a_11436_4320.n2 a_11436_4320.n3 0.0805
R836 a_11436_4320.n3 a_11436_4320.n4 0.0805
R837 a_11436_4320.n4 a_11436_4320.n5 0.0805
R838 a_11436_4320.n5 a_11436_4320.n6 0.0805
R839 a_11436_4320.n6 a_11436_4320.n7 0.0805
R840 a_11436_4320.n7 a_11436_4320.t18 6.11621
R841 a_11436_4320.t18 a_11436_4320.t19 24.1076
R842 a_11436_4320.n7 a_11436_4320.t16 6.03621
R843 a_11436_4320.t16 a_11436_4320.t17 24.1076
R844 a_11436_4320.n6 a_11436_4320.t14 6.03621
R845 a_11436_4320.t14 a_11436_4320.t15 24.1076
R846 a_11436_4320.n5 a_11436_4320.t12 6.03621
R847 a_11436_4320.t12 a_11436_4320.t13 24.1076
R848 a_11436_4320.n4 a_11436_4320.t10 6.03621
R849 a_11436_4320.t10 a_11436_4320.t11 24.1076
R850 a_11436_4320.n3 a_11436_4320.t8 6.03621
R851 a_11436_4320.t8 a_11436_4320.t9 24.1076
R852 a_11436_4320.n2 a_11436_4320.t6 6.03621
R853 a_11436_4320.t6 a_11436_4320.t7 24.1076
R854 a_11436_4320.n1 a_11436_4320.t4 6.03621
R855 a_11436_4320.t4 a_11436_4320.t5 24.1076
R856 a_11436_4320.n0 a_11436_4320.t2 0.2605
R857 a_11436_4320.n0 a_11436_4320.t3 0.2605
R858 a_11116_340.t0 a_11116_340.n3 0.6845
R859 a_11116_340.n3 a_11116_340.n2 0.9745
R860 a_11116_340.n2 a_11116_340.n1 0.3805
R861 a_11116_340.n1 a_11116_340.t2 3.0979
R862 a_11116_340.n1 a_11116_340.t3 0.4905
R863 a_11116_340.n2 a_11116_340.n0 3.5485
R864 a_11116_340.n0 a_11116_340.t7 11.4805
R865 a_11116_340.t7 a_11116_340.t6 28.5719
R866 a_11116_340.n0 a_11116_340.t5 6.03621
R867 a_11116_340.t5 a_11116_340.t4 22.3219
R868 a_11116_340.n3 a_11116_340.t1 1.0305
R869 a_1036_6700.t0 a_1036_6700.n31 0.1045
R870 a_1036_6700.n31 a_1036_6700.t1 0.1045
R871 a_1036_6700.n30 a_1036_6700.n0 0.7705
R872 a_1036_6700.n31 a_1036_6700.n30 0.5805
R873 a_1036_6700.n30 a_1036_6700.n3 0.3045
R874 a_1036_6700.n3 a_1036_6700.n6 0.3045
R875 a_1036_6700.n6 a_1036_6700.n29 0.0765
R876 a_1036_6700.n29 a_1036_6700.n9 0.2285
R877 a_1036_6700.n9 a_1036_6700.n12 0.3045
R878 a_1036_6700.n29 a_1036_6700.n28 6.73889
R879 a_1036_6700.n28 a_1036_6700.n13 0.00922131
R880 a_1036_6700.n28 a_1036_6700.n14 0.0215574
R881 a_1036_6700.n14 a_1036_6700.n15 0.00216552
R882 a_1036_6700.n14 a_1036_6700.n16 0.026418
R883 a_1036_6700.n16 a_1036_6700.n17 0.00542094
R884 a_1036_6700.n16 a_1036_6700.n18 0.026418
R885 a_1036_6700.n18 a_1036_6700.n19 0.00542094
R886 a_1036_6700.n18 a_1036_6700.n20 0.026418
R887 a_1036_6700.n20 a_1036_6700.n21 0.00216552
R888 a_1036_6700.n20 a_1036_6700.n22 0.0302787
R889 a_1036_6700.n22 a_1036_6700.n23 0.134336
R890 a_1036_6700.n23 a_1036_6700.n24 0.1605
R891 a_1036_6700.n24 a_1036_6700.n25 0.1605
R892 a_1036_6700.n25 a_1036_6700.n26 0.1605
R893 a_1036_6700.n26 a_1036_6700.n27 0.1605
R894 a_1036_6700.n27 a_1036_6700.t37 19.5891
R895 a_1036_6700.n27 a_1036_6700.t36 19.4291
R896 a_1036_6700.n26 a_1036_6700.t35 19.4291
R897 a_1036_6700.n25 a_1036_6700.t34 19.4291
R898 a_1036_6700.n24 a_1036_6700.t33 19.4291
R899 a_1036_6700.n23 a_1036_6700.t32 19.4291
R900 a_1036_6700.n22 a_1036_6700.t31 19.4291
R901 a_1036_6700.n22 a_1036_6700.t30 15.8576
R902 a_1036_6700.n21 a_1036_6700.t29 19.4291
R903 a_1036_6700.n21 a_1036_6700.t28 15.8576
R904 a_1036_6700.n19 a_1036_6700.t27 19.4291
R905 a_1036_6700.n19 a_1036_6700.t26 15.8576
R906 a_1036_6700.n17 a_1036_6700.t25 19.4291
R907 a_1036_6700.n17 a_1036_6700.t24 15.8576
R908 a_1036_6700.n15 a_1036_6700.t23 19.4291
R909 a_1036_6700.n15 a_1036_6700.t22 15.8576
R910 a_1036_6700.n13 a_1036_6700.t21 19.4291
R911 a_1036_6700.n13 a_1036_6700.t20 15.8576
R912 a_1036_6700.n12 a_1036_6700.n11 0.7705
R913 a_1036_6700.n12 a_1036_6700.n10 0.5805
R914 a_1036_6700.n11 a_1036_6700.t18 0.2605
R915 a_1036_6700.n11 a_1036_6700.t19 0.2605
R916 a_1036_6700.n10 a_1036_6700.t8 0.1045
R917 a_1036_6700.n10 a_1036_6700.t9 0.1045
R918 a_1036_6700.n9 a_1036_6700.n8 0.7705
R919 a_1036_6700.n9 a_1036_6700.n7 0.5805
R920 a_1036_6700.n8 a_1036_6700.t16 0.2605
R921 a_1036_6700.n8 a_1036_6700.t17 0.2605
R922 a_1036_6700.n7 a_1036_6700.t6 0.1045
R923 a_1036_6700.n7 a_1036_6700.t7 0.1045
R924 a_1036_6700.n6 a_1036_6700.n5 0.7705
R925 a_1036_6700.n6 a_1036_6700.n4 0.5805
R926 a_1036_6700.n5 a_1036_6700.t14 0.2605
R927 a_1036_6700.n5 a_1036_6700.t15 0.2605
R928 a_1036_6700.n4 a_1036_6700.t4 0.1045
R929 a_1036_6700.n4 a_1036_6700.t5 0.1045
R930 a_1036_6700.n3 a_1036_6700.n2 0.7705
R931 a_1036_6700.n3 a_1036_6700.n1 0.5805
R932 a_1036_6700.n2 a_1036_6700.t12 0.2605
R933 a_1036_6700.n2 a_1036_6700.t13 0.2605
R934 a_1036_6700.n1 a_1036_6700.t2 0.1045
R935 a_1036_6700.n1 a_1036_6700.t3 0.1045
R936 a_1036_6700.n0 a_1036_6700.t10 0.2605
R937 a_1036_6700.n0 a_1036_6700.t11 0.2605
R938 a_1036_4320.t0 a_1036_4320.n20 0.1045
R939 a_1036_4320.n20 a_1036_4320.t1 0.1045
R940 a_1036_4320.n20 a_1036_4320.n19 0.5805
R941 a_1036_4320.n19 a_1036_4320.n0 0.7705
R942 a_1036_4320.n19 a_1036_4320.n3 0.3045
R943 a_1036_4320.n3 a_1036_4320.n18 0.0765
R944 a_1036_4320.n18 a_1036_4320.n6 0.2285
R945 a_1036_4320.n18 a_1036_4320.n7 1.7265
R946 a_1036_4320.n7 a_1036_4320.n8 0.0805
R947 a_1036_4320.n8 a_1036_4320.n9 0.0805
R948 a_1036_4320.n9 a_1036_4320.n10 0.0805
R949 a_1036_4320.n10 a_1036_4320.n11 0.0805
R950 a_1036_4320.n11 a_1036_4320.n12 0.0805
R951 a_1036_4320.n12 a_1036_4320.n13 0.0805
R952 a_1036_4320.n13 a_1036_4320.n14 0.0805
R953 a_1036_4320.n14 a_1036_4320.n15 0.0805
R954 a_1036_4320.n15 a_1036_4320.n16 0.0805
R955 a_1036_4320.n16 a_1036_4320.n17 0.0805
R956 a_1036_4320.n17 a_1036_4320.t34 6.11621
R957 a_1036_4320.t34 a_1036_4320.t35 24.1076
R958 a_1036_4320.n17 a_1036_4320.t32 6.03621
R959 a_1036_4320.t32 a_1036_4320.t33 24.1076
R960 a_1036_4320.n16 a_1036_4320.t30 6.03621
R961 a_1036_4320.t30 a_1036_4320.t31 24.1076
R962 a_1036_4320.n15 a_1036_4320.t28 6.03621
R963 a_1036_4320.t28 a_1036_4320.t29 24.1076
R964 a_1036_4320.n14 a_1036_4320.t26 6.03621
R965 a_1036_4320.t26 a_1036_4320.t27 24.1076
R966 a_1036_4320.n13 a_1036_4320.t24 6.03621
R967 a_1036_4320.t24 a_1036_4320.t25 24.1076
R968 a_1036_4320.n12 a_1036_4320.t22 6.03621
R969 a_1036_4320.t22 a_1036_4320.t23 24.1076
R970 a_1036_4320.n11 a_1036_4320.t20 6.03621
R971 a_1036_4320.t20 a_1036_4320.t21 24.1076
R972 a_1036_4320.n10 a_1036_4320.t18 6.03621
R973 a_1036_4320.t18 a_1036_4320.t19 24.1076
R974 a_1036_4320.n9 a_1036_4320.t16 6.03621
R975 a_1036_4320.t16 a_1036_4320.t17 24.1076
R976 a_1036_4320.n8 a_1036_4320.t14 6.03621
R977 a_1036_4320.t14 a_1036_4320.t15 24.1076
R978 a_1036_4320.n7 a_1036_4320.t12 6.03621
R979 a_1036_4320.t12 a_1036_4320.t13 24.1076
R980 a_1036_4320.n6 a_1036_4320.n5 0.5805
R981 a_1036_4320.n6 a_1036_4320.n4 0.7705
R982 a_1036_4320.n5 a_1036_4320.t4 0.1045
R983 a_1036_4320.n5 a_1036_4320.t5 0.1045
R984 a_1036_4320.n4 a_1036_4320.t10 0.2605
R985 a_1036_4320.n4 a_1036_4320.t11 0.2605
R986 a_1036_4320.n3 a_1036_4320.n2 0.5805
R987 a_1036_4320.n3 a_1036_4320.n1 0.7705
R988 a_1036_4320.n2 a_1036_4320.t2 0.1045
R989 a_1036_4320.n2 a_1036_4320.t3 0.1045
R990 a_1036_4320.n1 a_1036_4320.t8 0.2605
R991 a_1036_4320.n1 a_1036_4320.t9 0.2605
R992 a_1036_4320.n0 a_1036_4320.t6 0.2605
R993 a_1036_4320.n0 a_1036_4320.t7 0.2605
R994 a_1036_340.t1 a_1036_340.n1 0.6845
R995 a_1036_340.n1 a_1036_340.n0 1.4825
R996 a_1036_340.n0 a_1036_340.t5 6.11621
R997 a_1036_340.t5 a_1036_340.t4 24.1076
R998 a_1036_340.n0 a_1036_340.t3 6.03621
R999 a_1036_340.t3 a_1036_340.t2 24.1076
R1000 a_1036_340.n1 a_1036_340.t0 1.0305
R1001 VSS VSS.n0 0.934667
R1002 VSS.n55 VSS.n13 0.0352
R1003 VSS.n13 VSS.n351 0.1601
R1004 VSS.n351 VSS.n12 0.0106333
R1005 VSS.n327 VSS.n5 0.0896667
R1006 VSS.n5 VSS.n4 0.0790333
R1007 VSS.n312 VSS.n3 0.0111333
R1008 VSS.n298 VSS.n2 0.0998
R1009 VSS.n2 VSS.n1 0.0790333
R1010 VSS.n351 VSS.t141 0.58388
R1011 VSS.n11 VSS.t337 0.589041
R1012 VSS.n10 VSS.t343 0.589041
R1013 VSS.n9 VSS.t371 0.589041
R1014 VSS.n8 VSS.t139 0.589097
R1015 VSS.n7 VSS.t45 0.589097
R1016 VSS.n6 VSS.t65 0.589041
R1017 VSS VSS.n350 0.2993
R1018 VSS.n350 VSS.n279 0.0369667
R1019 VSS.n279 VSS.n281 0.0108065
R1020 VSS.n279 VSS.n349 0.118033
R1021 VSS.n349 VSS.n55 0.0623
R1022 VSS.n55 VSS.n56 0.0054129
R1023 VSS.n13 VSS.n348 0.0131667
R1024 VSS.n348 VSS.n12 0.157567
R1025 VSS.n12 VSS.n53 0.211267
R1026 VSS.n53 VSS.n54 0.00998925
R1027 VSS.n53 VSS.n11 0.242167
R1028 VSS.n11 VSS.n51 0.216833
R1029 VSS.n51 VSS.n52 0.00998925
R1030 VSS.n51 VSS.n10 0.242167
R1031 VSS.n10 VSS.n49 0.216833
R1032 VSS.n49 VSS.n50 0.00998925
R1033 VSS.n49 VSS.n9 0.242167
R1034 VSS.n9 VSS.n47 0.216833
R1035 VSS.n47 VSS.n48 0.00998925
R1036 VSS.n47 VSS.n347 0.270033
R1037 VSS.n347 VSS.n45 0.0623
R1038 VSS.n45 VSS.n46 0.0054129
R1039 VSS.n45 VSS.n346 0.0420333
R1040 VSS.n346 VSS.n345 0.102833
R1041 VSS.n345 VSS.n43 0.0623
R1042 VSS.n43 VSS.n44 0.0054129
R1043 VSS.n43 VSS.n344 0.143367
R1044 VSS.n344 VSS.n41 0.0369667
R1045 VSS.n41 VSS.n42 0.0108065
R1046 VSS.n41 VSS.n8 0.0901667
R1047 VSS.n8 VSS.n39 0.216833
R1048 VSS.n39 VSS.n40 0.00998925
R1049 VSS.n39 VSS.n343 0.270033
R1050 VSS.n343 VSS.n37 0.0369667
R1051 VSS.n37 VSS.n38 0.0108065
R1052 VSS.n37 VSS.n7 0.0901667
R1053 VSS.n7 VSS.n35 0.216833
R1054 VSS.n35 VSS.n36 0.00998925
R1055 VSS.n35 VSS.n6 0.242167
R1056 VSS.n6 VSS.n33 0.216833
R1057 VSS.n33 VSS.n34 0.00998925
R1058 VSS.n33 VSS.n342 0.270033
R1059 VSS.n342 VSS.n31 0.0623
R1060 VSS.n31 VSS.n32 0.0054129
R1061 VSS.n31 VSS.n341 0.143367
R1062 VSS.n341 VSS.n29 0.0623
R1063 VSS.n29 VSS.n30 0.0054129
R1064 VSS.n29 VSS.n340 0.0420333
R1065 VSS.n340 VSS.n339 0.102833
R1066 VSS.n339 VSS.n27 0.0369667
R1067 VSS.n27 VSS.n28 0.0108065
R1068 VSS.n27 VSS.n338 0.118033
R1069 VSS.n338 VSS.n25 0.0623
R1070 VSS.n25 VSS.n26 0.0054129
R1071 VSS.n25 VSS.n337 0.0420333
R1072 VSS.n337 VSS.n336 0.102833
R1073 VSS.n336 VSS.n335 0.102833
R1074 VSS.n335 VSS.n23 0.0623
R1075 VSS.n23 VSS.n24 0.00909032
R1076 VSS.n23 VSS.n333 0.0420333
R1077 VSS.n333 VSS.n331 0.102833
R1078 VSS.n331 VSS.n330 0.102833
R1079 VSS.n330 VSS.n329 0.102833
R1080 VSS.n329 VSS.n327 0.102833
R1081 VSS.n5 VSS.n325 0.0258333
R1082 VSS.n325 VSS.n22 0.0207667
R1083 VSS.n22 VSS.n4 0.0334333
R1084 VSS.n4 VSS.n323 0.0757333
R1085 VSS.n323 VSS.n321 0.102833
R1086 VSS.n321 VSS.n319 0.102833
R1087 VSS.n319 VSS.n318 0.102833
R1088 VSS.n318 VSS.n20 0.0369667
R1089 VSS.n20 VSS.n21 0.0108065
R1090 VSS.n20 VSS.n317 0.118033
R1091 VSS.n317 VSS.n18 0.0623
R1092 VSS.n18 VSS.n19 0.0054129
R1093 VSS.n18 VSS.n316 0.0420333
R1094 VSS.n316 VSS.n315 0.102833
R1095 VSS.n315 VSS.n314 0.102833
R1096 VSS.n314 VSS.n312 0.102833
R1097 VSS.n3 VSS.n310 0.0922
R1098 VSS.n310 VSS.n308 0.102833
R1099 VSS.n308 VSS.n307 0.102833
R1100 VSS.n307 VSS.n306 0.102833
R1101 VSS.n306 VSS.n304 0.102833
R1102 VSS.n304 VSS.n302 0.102833
R1103 VSS.n302 VSS.n300 0.102833
R1104 VSS.n300 VSS.n298 0.102833
R1105 VSS.n2 VSS.n296 0.00556667
R1106 VSS.n296 VSS.n17 0.0207667
R1107 VSS.n17 VSS.n1 0.0537
R1108 VSS.n1 VSS.n294 0.0656
R1109 VSS.n294 VSS.n292 0.102833
R1110 VSS.n292 VSS.n290 0.102833
R1111 VSS.n290 VSS.n288 0.102833
R1112 VSS.n288 VSS.n286 0.102833
R1113 VSS.n286 VSS.n284 0.102833
R1114 VSS.n284 VSS.n283 0.102833
R1115 VSS.n283 VSS.n15 0.0623
R1116 VSS.n15 VSS.n16 0.0054129
R1117 VSS.n15 VSS.n282 0.0420333
R1118 VSS.n282 VSS.n14 0.148606
R1119 VSS.n350 VSS.t1 0.590561
R1120 VSS.n349 VSS.t5 0.590561
R1121 VSS.n348 VSS.t7 0.5805
R1122 VSS.n347 VSS.t143 0.590561
R1123 VSS.n346 VSS.t421 0.586861
R1124 VSS.n345 VSS.t423 0.560561
R1125 VSS.n344 VSS.t431 0.590561
R1126 VSS.n343 VSS.t3 0.590561
R1127 VSS.n342 VSS.t127 0.560561
R1128 VSS.n341 VSS.t47 0.590561
R1129 VSS.n340 VSS.t129 0.586861
R1130 VSS.n339 VSS.t137 0.590561
R1131 VSS.n338 VSS.t131 0.590561
R1132 VSS.n337 VSS.t133 0.586861
R1133 VSS.n336 VSS.t145 0.590561
R1134 VSS.n335 VSS.n334 0.326312
R1135 VSS.n334 VSS.t147 0.2605
R1136 VSS.n334 VSS.t149 0.2605
R1137 VSS.n333 VSS.n332 0.328518
R1138 VSS.n332 VSS.t151 0.2605
R1139 VSS.n332 VSS.t153 0.2605
R1140 VSS.n331 VSS.t155 0.591907
R1141 VSS.n330 VSS.t157 0.590561
R1142 VSS.n329 VSS.n328 0.326312
R1143 VSS.n328 VSS.t159 0.2605
R1144 VSS.n328 VSS.t161 0.2605
R1145 VSS.n327 VSS.n326 0.328518
R1146 VSS.n326 VSS.t163 0.2605
R1147 VSS.n326 VSS.t165 0.2605
R1148 VSS.n325 VSS.n324 0.3205
R1149 VSS.n324 VSS.t167 0.2605
R1150 VSS.n324 VSS.t169 0.2605
R1151 VSS.n323 VSS.n322 0.324432
R1152 VSS.n322 VSS.t171 0.2605
R1153 VSS.n322 VSS.t173 0.2605
R1154 VSS.n321 VSS.n320 0.330806
R1155 VSS.n320 VSS.t175 0.2605
R1156 VSS.n320 VSS.t177 0.2605
R1157 VSS.n319 VSS.t179 0.583454
R1158 VSS.n318 VSS.t135 0.590561
R1159 VSS.n317 VSS.t205 0.590561
R1160 VSS.n316 VSS.t207 0.586861
R1161 VSS.n315 VSS.t209 0.590561
R1162 VSS.n314 VSS.n313 0.326312
R1163 VSS.n313 VSS.t211 0.2605
R1164 VSS.n313 VSS.t213 0.2605
R1165 VSS.n312 VSS.n311 0.328518
R1166 VSS.n311 VSS.t215 0.2605
R1167 VSS.n311 VSS.t217 0.2605
R1168 VSS.n310 VSS.n309 0.329581
R1169 VSS.n309 VSS.t219 0.2605
R1170 VSS.n309 VSS.t221 0.2605
R1171 VSS.n308 VSS.t223 0.584432
R1172 VSS.n307 VSS.t241 0.590561
R1173 VSS.n306 VSS.n305 0.326312
R1174 VSS.n305 VSS.t243 0.2605
R1175 VSS.n305 VSS.t245 0.2605
R1176 VSS.n304 VSS.n303 0.328518
R1177 VSS.n303 VSS.t247 0.2605
R1178 VSS.n303 VSS.t249 0.2605
R1179 VSS.n302 VSS.n301 0.329581
R1180 VSS.n301 VSS.t251 0.2605
R1181 VSS.n301 VSS.t253 0.2605
R1182 VSS.n300 VSS.n299 0.324432
R1183 VSS.n299 VSS.t255 0.2605
R1184 VSS.n299 VSS.t257 0.2605
R1185 VSS.n298 VSS.n297 0.330806
R1186 VSS.n297 VSS.t259 0.2605
R1187 VSS.n297 VSS.t261 0.2605
R1188 VSS.n296 VSS.n295 0.3205
R1189 VSS.n295 VSS.t263 0.2605
R1190 VSS.n295 VSS.t265 0.2605
R1191 VSS.n294 VSS.n293 0.329989
R1192 VSS.n293 VSS.t267 0.2605
R1193 VSS.n293 VSS.t269 0.2605
R1194 VSS.n292 VSS.n291 0.327865
R1195 VSS.n291 VSS.t271 0.2605
R1196 VSS.n291 VSS.t273 0.2605
R1197 VSS.n290 VSS.n289 0.327129
R1198 VSS.n289 VSS.t275 0.2605
R1199 VSS.n289 VSS.t277 0.2605
R1200 VSS.n288 VSS.n287 0.330316
R1201 VSS.n287 VSS.t279 0.2605
R1202 VSS.n287 VSS.t281 0.2605
R1203 VSS.n286 VSS.n285 0.322226
R1204 VSS.n285 VSS.t283 0.2605
R1205 VSS.n285 VSS.t285 0.2605
R1206 VSS.n284 VSS.t287 0.590725
R1207 VSS.n283 VSS.t347 0.590561
R1208 VSS.n282 VSS.t349 0.586861
R1209 VSS.n281 VSS.t0 63.0308
R1210 VSS.n280 VSS.t4 175.474
R1211 VSS.n56 VSS.n280 1.26643
R1212 VSS.n56 VSS.t6 94.546
R1213 VSS.t6 VSS.t140 1678.18
R1214 VSS.n54 VSS.t140 275.759
R1215 VSS.n54 VSS.n267 14.689
R1216 VSS.n267 VSS.t336 247.52
R1217 VSS.n52 VSS.n268 14.689
R1218 VSS.n268 VSS.t342 247.52
R1219 VSS.n50 VSS.n269 14.689
R1220 VSS.n269 VSS.t370 247.52
R1221 VSS.n48 VSS.n270 10.486
R1222 VSS.n270 VSS.t142 195.72
R1223 VSS.n46 VSS.t420 94.546
R1224 VSS.t420 VSS.t422 945.456
R1225 VSS.n44 VSS.t422 220.607
R1226 VSS.n44 VSS.t462 94.546
R1227 VSS.t462 VSS.t430 945.456
R1228 VSS.n42 VSS.t430 63.0308
R1229 VSS.n42 VSS.n271 9.26573
R1230 VSS.n271 VSS.t138 234.192
R1231 VSS.n40 VSS.n272 10.486
R1232 VSS.n272 VSS.t2 60.5808
R1233 VSS.n38 VSS.n273 9.26573
R1234 VSS.n273 VSS.t44 234.192
R1235 VSS.n36 VSS.n274 14.689
R1236 VSS.n274 VSS.t64 247.52
R1237 VSS.n34 VSS.n275 10.486
R1238 VSS.n275 VSS.t126 195.72
R1239 VSS.n32 VSS.t463 94.546
R1240 VSS.t463 VSS.t46 945.456
R1241 VSS.n30 VSS.t46 220.607
R1242 VSS.n30 VSS.t128 94.546
R1243 VSS.t128 VSS.t136 945.456
R1244 VSS.n28 VSS.t136 63.0308
R1245 VSS.n28 VSS.n276 5.06271
R1246 VSS.n276 VSS.t130 175.474
R1247 VSS.n26 VSS.t132 94.546
R1248 VSS.t132 VSS.t144 945.456
R1249 VSS.t146 VSS.t144 315.151
R1250 VSS.t148 VSS.t146 315.151
R1251 VSS.n24 VSS.t148 220.607
R1252 VSS.n24 VSS.t150 94.546
R1253 VSS.t150 VSS.t152 315.151
R1254 VSS.t152 VSS.t154 315.151
R1255 VSS.t154 VSS.t156 945.456
R1256 VSS.t156 VSS.t158 315.151
R1257 VSS.t160 VSS.t158 315.151
R1258 VSS.t162 VSS.t160 315.151
R1259 VSS.t164 VSS.t162 315.151
R1260 VSS.t166 VSS.t164 315.151
R1261 VSS.n22 VSS.t166 220.607
R1262 VSS.n22 VSS.t168 94.546
R1263 VSS.t168 VSS.t170 315.151
R1264 VSS.t170 VSS.t172 315.151
R1265 VSS.t172 VSS.t174 315.151
R1266 VSS.t174 VSS.t176 315.151
R1267 VSS.t178 VSS.t176 315.151
R1268 VSS.t134 VSS.t178 945.456
R1269 VSS.n21 VSS.t134 63.0308
R1270 VSS.n21 VSS.n277 5.06271
R1271 VSS.n277 VSS.t204 175.474
R1272 VSS.n19 VSS.t206 94.546
R1273 VSS.t206 VSS.t208 945.456
R1274 VSS.t208 VSS.t210 315.151
R1275 VSS.t212 VSS.t210 315.151
R1276 VSS.t214 VSS.t212 315.151
R1277 VSS.n3 VSS.t214 220.607
R1278 VSS.n3 VSS.t216 94.546
R1279 VSS.t216 VSS.t218 315.151
R1280 VSS.t218 VSS.t220 315.151
R1281 VSS.t220 VSS.t222 315.151
R1282 VSS.t222 VSS.t240 945.456
R1283 VSS.t240 VSS.t242 315.151
R1284 VSS.t242 VSS.t244 315.151
R1285 VSS.t244 VSS.t246 315.151
R1286 VSS.t248 VSS.t246 315.151
R1287 VSS.t250 VSS.t248 315.151
R1288 VSS.t252 VSS.t250 315.151
R1289 VSS.t254 VSS.t252 315.151
R1290 VSS.t256 VSS.t254 315.151
R1291 VSS.t258 VSS.t256 315.151
R1292 VSS.t260 VSS.t258 315.151
R1293 VSS.t262 VSS.t260 315.151
R1294 VSS.n17 VSS.t262 220.607
R1295 VSS.n17 VSS.t264 94.546
R1296 VSS.t264 VSS.t266 315.151
R1297 VSS.t266 VSS.t268 315.151
R1298 VSS.t268 VSS.t270 315.151
R1299 VSS.t270 VSS.t272 315.151
R1300 VSS.t272 VSS.t274 315.151
R1301 VSS.t274 VSS.t276 315.151
R1302 VSS.t276 VSS.t278 315.151
R1303 VSS.t278 VSS.t280 315.151
R1304 VSS.t282 VSS.t280 315.151
R1305 VSS.t284 VSS.t282 315.151
R1306 VSS.t286 VSS.t284 315.151
R1307 VSS.t346 VSS.t286 945.456
R1308 VSS.n16 VSS.t346 220.607
R1309 VSS.n16 VSS.n278 0.543326
R1310 VSS.n278 VSS.t348 85.9467
R1311 VSS.n281 VSS.n280 5.06271
R1312 VSS.n56 VSS.n54 11.8187
R1313 VSS.n52 VSS.n267 1.58278
R1314 VSS.n50 VSS.n268 1.58278
R1315 VSS.n48 VSS.n269 1.58278
R1316 VSS.n46 VSS.n270 1.26643
R1317 VSS.n46 VSS.n44 7.27323
R1318 VSS.n44 VSS.n42 6.36414
R1319 VSS.n40 VSS.n271 1.58278
R1320 VSS.n38 VSS.n272 0.362551
R1321 VSS.n36 VSS.n273 1.58278
R1322 VSS.n34 VSS.n274 1.58278
R1323 VSS.n32 VSS.n275 1.26643
R1324 VSS.n32 VSS.n30 7.27323
R1325 VSS.n30 VSS.n28 6.36414
R1326 VSS.n26 VSS.n276 1.26643
R1327 VSS.n26 VSS.n24 10.9096
R1328 VSS.n24 VSS.n22 20.0005
R1329 VSS.n22 VSS.n21 15.455
R1330 VSS.n19 VSS.n277 1.26643
R1331 VSS.n19 VSS.n3 12.7278
R1332 VSS.n3 VSS.n17 32.7278
R1333 VSS.n17 VSS.n16 27.2732
R1334 VSS.n278 VSS.n14 5.78581
R1335 VSS.t0 VSS.n57 17694.9
R1336 VSS.t438 VSS.n57 658.966
R1337 VSS.t440 VSS.t438 179.31
R1338 VSS.t442 VSS.t440 179.31
R1339 VSS.n58 VSS.t442 125.517
R1340 VSS.n58 VSS.t444 53.7936
R1341 VSS.t444 VSS.t446 179.31
R1342 VSS.n246 VSS.t446 125.517
R1343 VSS.n246 VSS.t448 53.7936
R1344 VSS.t448 VSS.t456 179.31
R1345 VSS.t456 VSS.t458 179.31
R1346 VSS.t8 VSS.t458 179.31
R1347 VSS.n59 VSS.t8 131.121
R1348 VSS.n59 VSS.t10 48.1902
R1349 VSS.t10 VSS.t12 179.31
R1350 VSS.t12 VSS.t14 179.31
R1351 VSS.t14 VSS.t16 179.31
R1352 VSS.t18 VSS.t16 179.31
R1353 VSS.n60 VSS.t18 125.517
R1354 VSS.n60 VSS.t20 53.7936
R1355 VSS.t20 VSS.t22 179.31
R1356 VSS.n61 VSS.t22 125.517
R1357 VSS.n61 VSS.t24 53.7936
R1358 VSS.t24 VSS.t26 179.31
R1359 VSS.t26 VSS.t28 179.31
R1360 VSS.t28 VSS.t30 179.31
R1361 VSS.t344 VSS.t30 537.932
R1362 VSS.n62 VSS.t344 35.8626
R1363 VSS.n62 VSS.n63 2.53361
R1364 VSS.n63 VSS.t350 99.9083
R1365 VSS.n64 VSS.t352 53.7936
R1366 VSS.t352 VSS.t354 537.932
R1367 VSS.t354 VSS.t356 179.31
R1368 VSS.t358 VSS.t356 179.31
R1369 VSS.t360 VSS.t358 179.31
R1370 VSS.n65 VSS.t360 125.517
R1371 VSS.n65 VSS.t362 53.7936
R1372 VSS.t362 VSS.t364 179.31
R1373 VSS.t364 VSS.t366 179.31
R1374 VSS.t366 VSS.t368 179.31
R1375 VSS.t368 VSS.t372 537.932
R1376 VSS.t372 VSS.t374 179.31
R1377 VSS.t374 VSS.t376 179.31
R1378 VSS.t376 VSS.t378 179.31
R1379 VSS.t380 VSS.t378 179.31
R1380 VSS.t382 VSS.t380 179.31
R1381 VSS.t384 VSS.t382 179.31
R1382 VSS.t386 VSS.t384 179.31
R1383 VSS.t388 VSS.t386 179.31
R1384 VSS.t390 VSS.t388 179.31
R1385 VSS.t392 VSS.t390 179.31
R1386 VSS.t394 VSS.t392 179.31
R1387 VSS.n66 VSS.t394 125.517
R1388 VSS.n66 VSS.t396 53.7936
R1389 VSS.t396 VSS.t398 179.31
R1390 VSS.t398 VSS.t400 179.31
R1391 VSS.t400 VSS.t402 179.31
R1392 VSS.t402 VSS.t404 179.31
R1393 VSS.t404 VSS.t406 179.31
R1394 VSS.t406 VSS.t408 179.31
R1395 VSS.t408 VSS.t410 179.31
R1396 VSS.t410 VSS.t412 179.31
R1397 VSS.t414 VSS.t412 179.31
R1398 VSS.t416 VSS.t414 179.31
R1399 VSS.t418 VSS.t416 179.31
R1400 VSS.t424 VSS.t418 537.932
R1401 VSS.n67 VSS.t424 125.517
R1402 VSS.n67 VSS.t426 53.7936
R1403 VSS.t426 VSS.t48 537.932
R1404 VSS.t48 VSS.t50 179.31
R1405 VSS.t52 VSS.t50 179.31
R1406 VSS.t54 VSS.t52 179.31
R1407 VSS.n68 VSS.t54 125.517
R1408 VSS.n68 VSS.t56 53.7936
R1409 VSS.t56 VSS.t58 179.31
R1410 VSS.t58 VSS.t60 179.31
R1411 VSS.t60 VSS.t62 179.31
R1412 VSS.t62 VSS.t66 537.932
R1413 VSS.t66 VSS.t68 179.31
R1414 VSS.t68 VSS.t70 179.31
R1415 VSS.t70 VSS.t72 179.31
R1416 VSS.t74 VSS.t72 179.31
R1417 VSS.t76 VSS.t74 179.31
R1418 VSS.t78 VSS.t76 179.31
R1419 VSS.t80 VSS.t78 179.31
R1420 VSS.t82 VSS.t80 179.31
R1421 VSS.t84 VSS.t82 179.31
R1422 VSS.t86 VSS.t84 179.31
R1423 VSS.t88 VSS.t86 179.31
R1424 VSS.n80 VSS.t88 35.8626
R1425 VSS.n80 VSS.n69 0.452753
R1426 VSS.n69 VSS.t90 53.7936
R1427 VSS.t90 VSS.t92 179.31
R1428 VSS.t92 VSS.t94 179.31
R1429 VSS.t94 VSS.t96 179.31
R1430 VSS.t96 VSS.t98 179.31
R1431 VSS.t98 VSS.t100 179.31
R1432 VSS.t100 VSS.t102 179.31
R1433 VSS.t102 VSS.t104 179.31
R1434 VSS.t106 VSS.t104 179.31
R1435 VSS.t108 VSS.t106 179.31
R1436 VSS.t110 VSS.t108 179.31
R1437 VSS.t112 VSS.t110 179.31
R1438 VSS.t428 VSS.t112 537.932
R1439 VSS.n70 VSS.t428 35.8626
R1440 VSS.n70 VSS.n71 2.53361
R1441 VSS.n71 VSS.t180 99.9083
R1442 VSS.n72 VSS.t182 53.7936
R1443 VSS.t182 VSS.t184 537.932
R1444 VSS.t184 VSS.t186 179.31
R1445 VSS.t188 VSS.t186 179.31
R1446 VSS.t190 VSS.t188 179.31
R1447 VSS.t192 VSS.t190 179.31
R1448 VSS.n73 VSS.t192 125.517
R1449 VSS.n73 VSS.t194 53.7936
R1450 VSS.t194 VSS.t196 179.31
R1451 VSS.t196 VSS.t198 179.31
R1452 VSS.t198 VSS.t200 179.31
R1453 VSS.t200 VSS.t202 179.31
R1454 VSS.t432 VSS.t202 537.932
R1455 VSS.n74 VSS.t432 125.517
R1456 VSS.n74 VSS.t434 53.7936
R1457 VSS.t434 VSS.t224 537.932
R1458 VSS.t224 VSS.t226 179.31
R1459 VSS.t228 VSS.t226 179.31
R1460 VSS.t230 VSS.t228 179.31
R1461 VSS.n75 VSS.t230 125.517
R1462 VSS.n75 VSS.t232 53.7936
R1463 VSS.t232 VSS.t234 179.31
R1464 VSS.t234 VSS.t236 179.31
R1465 VSS.t236 VSS.t238 179.31
R1466 VSS.t238 VSS.t288 537.932
R1467 VSS.t288 VSS.t290 179.31
R1468 VSS.t290 VSS.t292 179.31
R1469 VSS.t292 VSS.t294 179.31
R1470 VSS.t296 VSS.t294 179.31
R1471 VSS.t298 VSS.t296 179.31
R1472 VSS.t300 VSS.t298 179.31
R1473 VSS.t302 VSS.t300 179.31
R1474 VSS.t304 VSS.t302 179.31
R1475 VSS.t306 VSS.t304 179.31
R1476 VSS.t308 VSS.t306 179.31
R1477 VSS.t310 VSS.t308 179.31
R1478 VSS.n76 VSS.t310 125.517
R1479 VSS.n76 VSS.t312 53.7936
R1480 VSS.t312 VSS.t314 179.31
R1481 VSS.t314 VSS.t316 179.31
R1482 VSS.t316 VSS.t318 179.31
R1483 VSS.t318 VSS.t320 179.31
R1484 VSS.t320 VSS.t322 179.31
R1485 VSS.t322 VSS.t324 179.31
R1486 VSS.t324 VSS.t326 179.31
R1487 VSS.t328 VSS.t326 179.31
R1488 VSS.t330 VSS.t328 179.31
R1489 VSS.t332 VSS.t330 179.31
R1490 VSS.t334 VSS.t332 179.31
R1491 VSS.t436 VSS.t334 537.932
R1492 VSS.n77 VSS.t436 35.8626
R1493 VSS.n77 VSS.n78 2.53361
R1494 VSS.n78 VSS.t338 99.9083
R1495 VSS.n79 VSS.t340 53.7936
R1496 VSS.t340 VSS.n266 842.76
R1497 VSS.n14 VSS.n266 14196.6
R1498 VSS.n265 VSS.n266 16743.4
R1499 VSS.n265 VSS.n247 4576.53
R1500 VSS.t114 VSS.n264 1122.05
R1501 VSS.t116 VSS.t114 197.72
R1502 VSS.t118 VSS.t116 197.72
R1503 VSS.t120 VSS.t118 197.72
R1504 VSS.t122 VSS.t120 197.72
R1505 VSS.n248 VSS.t122 138.404
R1506 VSS.n248 VSS.t124 59.3161
R1507 VSS.t124 VSS.n263 1720.15
R1508 VSS.n263 VSS.t32 850.191
R1509 VSS.t34 VSS.t32 197.72
R1510 VSS.t36 VSS.t34 197.72
R1511 VSS.t38 VSS.t36 197.72
R1512 VSS.t40 VSS.t38 197.72
R1513 VSS.n262 VSS.t40 138.404
R1514 VSS.n262 VSS.t42 59.3161
R1515 VSS.t42 VSS.n265 1571.86
R1516 VSS.n57 VSS.n264 8459.56
R1517 VSS.n264 VSS.n247 17232.2
R1518 VSS.n263 VSS.n247 34260.4
R1519 VSS.n249 VSS.n262 0.00590833
R1520 VSS.n252 VSS.t33 0.996753
R1521 VSS.n251 VSS.n261 0.965581
R1522 VSS.n261 VSS.t35 0.033
R1523 VSS.n261 VSS.t37 0.033
R1524 VSS.n250 VSS.n260 0.961904
R1525 VSS.n260 VSS.t39 0.033
R1526 VSS.n260 VSS.t41 0.033
R1527 VSS.n249 VSS.t43 1.01965
R1528 VSS.n254 VSS.n252 0.388467
R1529 VSS.n252 VSS.n251 0.0521667
R1530 VSS.n251 VSS.n250 0.0521667
R1531 VSS.n250 VSS.n249 0.0319
R1532 VSS.n0 VSS.n259 0.7477
R1533 VSS.n259 VSS.n258 0.0521667
R1534 VSS.n258 VSS.n256 0.0521667
R1535 VSS.n256 VSS.n253 0.0319
R1536 VSS.n253 VSS.n248 0.00590833
R1537 VSS.n253 VSS.n254 0.0217667
R1538 VSS.n259 VSS.t115 0.996753
R1539 VSS.n258 VSS.n257 0.965581
R1540 VSS.n257 VSS.t117 0.033
R1541 VSS.n257 VSS.t119 0.033
R1542 VSS.n256 VSS.n255 0.961904
R1543 VSS.n255 VSS.t121 0.033
R1544 VSS.n255 VSS.t123 0.033
R1545 VSS.n254 VSS.t125 0.998388
R1546 VSS.n58 VSS.n246 1.81868
R1547 VSS.n246 VSS.n59 3.66527
R1548 VSS.n59 VSS.n60 4.51755
R1549 VSS.n60 VSS.n61 1.81868
R1550 VSS.n61 VSS.n62 5.90959
R1551 VSS.n64 VSS.n63 0.634154
R1552 VSS.n64 VSS.n65 6.36414
R1553 VSS.n65 VSS.n66 16.3641
R1554 VSS.n66 VSS.n67 13.6369
R1555 VSS.n67 VSS.n68 6.36414
R1556 VSS.n68 VSS.n80 15.9096
R1557 VSS.n69 VSS.n70 13.1823
R1558 VSS.n72 VSS.n71 0.634154
R1559 VSS.n72 VSS.n73 7.27323
R1560 VSS.n73 VSS.n74 7.27323
R1561 VSS.n74 VSS.n75 6.36414
R1562 VSS.n75 VSS.n76 16.3641
R1563 VSS.n76 VSS.n77 13.1823
R1564 VSS.n79 VSS.n78 0.634154
R1565 VSS.n81 VSS.n194 0.00578065
R1566 VSS.n82 VSS.n193 0.00365591
R1567 VSS.n83 VSS.n58 0.00504516
R1568 VSS.n84 VSS.n190 0.00475914
R1569 VSS.n85 VSS.n246 0.00504516
R1570 VSS.n181 VSS.n187 0.00529032
R1571 VSS.n181 VSS.n180 0.0521667
R1572 VSS.n180 VSS.n185 0.00262857
R1573 VSS.n180 VSS.n179 0.0326917
R1574 VSS.n179 VSS.n59 0.00349375
R1575 VSS.n179 VSS.n178 0.020975
R1576 VSS.n178 VSS.n183 0.0034127
R1577 VSS.n177 VSS.n176 0.0485
R1578 VSS.n176 VSS.n197 0.00683333
R1579 VSS.n197 VSS.n60 0.0106333
R1580 VSS.n60 VSS.n86 0.0169667
R1581 VSS.n175 VSS.n61 0.00606667
R1582 VSS.n174 VSS.n173 0.0521667
R1583 VSS.n171 VSS.n62 0.00534286
R1584 VSS.n170 VSS.n169 0.0319
R1585 VSS.n169 VSS.n64 0.00208571
R1586 VSS.n169 VSS.n168 0.0217667
R1587 VSS.n165 VSS.n65 0.00606667
R1588 VSS.n162 VSS.n161 0.0516667
R1589 VSS.n156 VSS.n154 0.0521667
R1590 VSS.n155 VSS.n66 0.00355769
R1591 VSS.n148 VSS.n147 0.0521667
R1592 VSS.n147 VSS.n146 0.0319
R1593 VSS.n146 VSS.n67 0.003
R1594 VSS.n146 VSS.n145 0.0217667
R1595 VSS.n144 VSS.n143 0.0521667
R1596 VSS.n142 VSS.n68 0.00606667
R1597 VSS.n68 VSS.n141 0.0466
R1598 VSS.n139 VSS.n138 0.0521667
R1599 VSS.n137 VSS.n136 0.0521667
R1600 VSS.n135 VSS.n134 0.0521667
R1601 VSS.n133 VSS.n80 0.00280952
R1602 VSS.n133 VSS.n87 0.00733333
R1603 VSS.n87 VSS.n222 0.00303333
R1604 VSS.n222 VSS.n69 0.0106333
R1605 VSS.n69 VSS.n132 0.00936667
R1606 VSS.n131 VSS.n130 0.0521667
R1607 VSS.n129 VSS.n128 0.0521667
R1608 VSS.n127 VSS.n126 0.0516667
R1609 VSS.n126 VSS.n88 0.0516667
R1610 VSS.n89 VSS.n70 0.00590323
R1611 VSS.n125 VSS.n72 0.0314
R1612 VSS.n124 VSS.n123 0.0521667
R1613 VSS.n123 VSS.n122 0.0521667
R1614 VSS.n122 VSS.n121 0.0521667
R1615 VSS.n121 VSS.n120 0.0319
R1616 VSS.n120 VSS.n73 0.00499
R1617 VSS.n120 VSS.n119 0.0217667
R1618 VSS.n119 VSS.n118 0.0521667
R1619 VSS.n118 VSS.n117 0.0521667
R1620 VSS.n116 VSS.n115 0.0319
R1621 VSS.n115 VSS.n74 0.00285778
R1622 VSS.n115 VSS.n114 0.0217667
R1623 VSS.n113 VSS.n112 0.0521667
R1624 VSS.n111 VSS.n75 0.00606667
R1625 VSS.n75 VSS.n110 0.0461
R1626 VSS.n107 VSS.n106 0.0521667
R1627 VSS.n105 VSS.n104 0.0521667
R1628 VSS.n102 VSS.n90 0.0504
R1629 VSS.n90 VSS.n240 0.00303333
R1630 VSS.n240 VSS.n76 0.0106333
R1631 VSS.n76 VSS.n101 0.0043
R1632 VSS.n100 VSS.n99 0.0521667
R1633 VSS.n98 VSS.n97 0.0521667
R1634 VSS.n95 VSS.n94 0.0521667
R1635 VSS.n94 VSS.n93 0.0192333
R1636 VSS.n93 VSS.n77 0.00522222
R1637 VSS.n93 VSS.n91 0.0597667
R1638 VSS.n92 VSS.n79 0.00320645
R1639 VSS.n91 VSS.t339 0.585781
R1640 VSS.n94 VSS.t437 0.5848
R1641 VSS.n95 VSS.t335 0.58297
R1642 VSS.n96 VSS.n245 0.321598
R1643 VSS.n245 VSS.t331 0.2605
R1644 VSS.n245 VSS.t333 0.2605
R1645 VSS.n97 VSS.n244 0.321585
R1646 VSS.n244 VSS.t327 0.2605
R1647 VSS.n244 VSS.t329 0.2605
R1648 VSS.n98 VSS.n243 0.323533
R1649 VSS.n243 VSS.t323 0.2605
R1650 VSS.n243 VSS.t325 0.2605
R1651 VSS.n99 VSS.n242 0.323046
R1652 VSS.n242 VSS.t319 0.2605
R1653 VSS.n242 VSS.t321 0.2605
R1654 VSS.n100 VSS.n241 0.323709
R1655 VSS.n241 VSS.t315 0.2605
R1656 VSS.n241 VSS.t317 0.2605
R1657 VSS.n240 VSS.n239 0.3205
R1658 VSS.n239 VSS.t311 0.2605
R1659 VSS.n239 VSS.t313 0.2605
R1660 VSS.n102 VSS.n238 0.322126
R1661 VSS.n238 VSS.t307 0.2605
R1662 VSS.n238 VSS.t309 0.2605
R1663 VSS.n103 VSS.n237 0.322583
R1664 VSS.n237 VSS.t303 0.2605
R1665 VSS.n237 VSS.t305 0.2605
R1666 VSS.n104 VSS.n236 0.322462
R1667 VSS.n236 VSS.t299 0.2605
R1668 VSS.n236 VSS.t301 0.2605
R1669 VSS.n105 VSS.n235 0.323815
R1670 VSS.n235 VSS.t295 0.2605
R1671 VSS.n235 VSS.t297 0.2605
R1672 VSS.n106 VSS.n234 0.322949
R1673 VSS.n234 VSS.t291 0.2605
R1674 VSS.n234 VSS.t293 0.2605
R1675 VSS.n107 VSS.t289 0.583287
R1676 VSS.n108 VSS.t239 0.582629
R1677 VSS.n111 VSS.n233 0.324137
R1678 VSS.n233 VSS.t231 0.2605
R1679 VSS.n233 VSS.t233 0.2605
R1680 VSS.n112 VSS.n232 0.322583
R1681 VSS.n232 VSS.t227 0.2605
R1682 VSS.n232 VSS.t229 0.2605
R1683 VSS.n113 VSS.t225 0.584137
R1684 VSS.n114 VSS.t435 0.583111
R1685 VSS.n116 VSS.t433 0.582544
R1686 VSS.n117 VSS.t203 0.58575
R1687 VSS.n118 VSS.n231 0.322182
R1688 VSS.n231 VSS.t199 0.2605
R1689 VSS.n231 VSS.t201 0.2605
R1690 VSS.n119 VSS.n230 0.325222
R1691 VSS.n230 VSS.t195 0.2605
R1692 VSS.n230 VSS.t197 0.2605
R1693 VSS.n121 VSS.n229 0.324399
R1694 VSS.n229 VSS.t191 0.2605
R1695 VSS.n229 VSS.t193 0.2605
R1696 VSS.n122 VSS.n228 0.323639
R1697 VSS.n228 VSS.t187 0.2605
R1698 VSS.n228 VSS.t189 0.2605
R1699 VSS.n123 VSS.t185 0.58556
R1700 VSS.n124 VSS.t183 0.581613
R1701 VSS.n125 VSS.t181 0.585269
R1702 VSS.n88 VSS.t429 0.585781
R1703 VSS.n127 VSS.n227 0.321588
R1704 VSS.n227 VSS.t109 0.2605
R1705 VSS.n227 VSS.t111 0.2605
R1706 VSS.n128 VSS.n226 0.323235
R1707 VSS.n226 VSS.t105 0.2605
R1708 VSS.n226 VSS.t107 0.2605
R1709 VSS.n129 VSS.n225 0.323171
R1710 VSS.n225 VSS.t101 0.2605
R1711 VSS.n225 VSS.t103 0.2605
R1712 VSS.n130 VSS.n224 0.323608
R1713 VSS.n224 VSS.t97 0.2605
R1714 VSS.n224 VSS.t99 0.2605
R1715 VSS.n131 VSS.n223 0.322493
R1716 VSS.n223 VSS.t93 0.2605
R1717 VSS.n223 VSS.t95 0.2605
R1718 VSS.n222 VSS.n221 0.3205
R1719 VSS.n221 VSS.t89 0.2605
R1720 VSS.n221 VSS.t91 0.2605
R1721 VSS.n134 VSS.n220 0.322118
R1722 VSS.n220 VSS.t85 0.2605
R1723 VSS.n220 VSS.t87 0.2605
R1724 VSS.n135 VSS.n219 0.322493
R1725 VSS.n219 VSS.t81 0.2605
R1726 VSS.n219 VSS.t83 0.2605
R1727 VSS.n136 VSS.n218 0.323608
R1728 VSS.n218 VSS.t77 0.2605
R1729 VSS.n218 VSS.t79 0.2605
R1730 VSS.n137 VSS.n217 0.323171
R1731 VSS.n217 VSS.t73 0.2605
R1732 VSS.n217 VSS.t75 0.2605
R1733 VSS.n138 VSS.n216 0.323235
R1734 VSS.n216 VSS.t69 0.2605
R1735 VSS.n216 VSS.t71 0.2605
R1736 VSS.n139 VSS.t67 0.581588
R1737 VSS.n140 VSS.t63 0.582565
R1738 VSS.n141 VSS.n215 0.32281
R1739 VSS.n215 VSS.t59 0.2605
R1740 VSS.n215 VSS.t61 0.2605
R1741 VSS.n142 VSS.n214 0.323682
R1742 VSS.n214 VSS.t55 0.2605
R1743 VSS.n214 VSS.t57 0.2605
R1744 VSS.n143 VSS.n213 0.323036
R1745 VSS.n213 VSS.t51 0.2605
R1746 VSS.n213 VSS.t53 0.2605
R1747 VSS.n144 VSS.t49 0.582937
R1748 VSS.n145 VSS.t427 0.583333
R1749 VSS.n147 VSS.t425 0.5816
R1750 VSS.n148 VSS.t419 0.585092
R1751 VSS.n149 VSS.n212 0.321609
R1752 VSS.n212 VSS.t415 0.2605
R1753 VSS.n212 VSS.t417 0.2605
R1754 VSS.n150 VSS.n211 0.32424
R1755 VSS.n211 VSS.t411 0.2605
R1756 VSS.n211 VSS.t413 0.2605
R1757 VSS.n151 VSS.n210 0.323923
R1758 VSS.n210 VSS.t407 0.2605
R1759 VSS.n210 VSS.t409 0.2605
R1760 VSS.n152 VSS.n209 0.322169
R1761 VSS.n209 VSS.t403 0.2605
R1762 VSS.n209 VSS.t405 0.2605
R1763 VSS.n153 VSS.n208 0.325019
R1764 VSS.n208 VSS.t399 0.2605
R1765 VSS.n208 VSS.t401 0.2605
R1766 VSS.n154 VSS.n207 0.32176
R1767 VSS.n207 VSS.t395 0.2605
R1768 VSS.n207 VSS.t397 0.2605
R1769 VSS.n156 VSS.n206 0.324897
R1770 VSS.n206 VSS.t391 0.2605
R1771 VSS.n206 VSS.t393 0.2605
R1772 VSS.n157 VSS.n205 0.322681
R1773 VSS.n205 VSS.t387 0.2605
R1774 VSS.n205 VSS.t389 0.2605
R1775 VSS.n158 VSS.n204 0.323558
R1776 VSS.n204 VSS.t383 0.2605
R1777 VSS.n204 VSS.t385 0.2605
R1778 VSS.n159 VSS.n203 0.324508
R1779 VSS.n203 VSS.t379 0.2605
R1780 VSS.n203 VSS.t381 0.2605
R1781 VSS.n162 VSS.t373 0.585117
R1782 VSS.n163 VSS.t369 0.582703
R1783 VSS.n164 VSS.n202 0.324669
R1784 VSS.n202 VSS.t365 0.2605
R1785 VSS.n202 VSS.t367 0.2605
R1786 VSS.n165 VSS.n201 0.324669
R1787 VSS.n201 VSS.t361 0.2605
R1788 VSS.n201 VSS.t363 0.2605
R1789 VSS.n166 VSS.n200 0.322703
R1790 VSS.n200 VSS.t357 0.2605
R1791 VSS.n200 VSS.t359 0.2605
R1792 VSS.n167 VSS.t355 0.585543
R1793 VSS.n168 VSS.t353 0.581905
R1794 VSS.n170 VSS.t351 0.584774
R1795 VSS.n172 VSS.t345 0.585411
R1796 VSS.n173 VSS.t31 0.58176
R1797 VSS.n174 VSS.n199 0.324897
R1798 VSS.n199 VSS.t27 0.2605
R1799 VSS.n199 VSS.t29 0.2605
R1800 VSS.n175 VSS.n198 0.322681
R1801 VSS.n198 VSS.t23 0.2605
R1802 VSS.n198 VSS.t25 0.2605
R1803 VSS.n197 VSS.n196 0.3205
R1804 VSS.n196 VSS.t19 0.2605
R1805 VSS.n196 VSS.t21 0.2605
R1806 VSS.n177 VSS.n195 0.324508
R1807 VSS.n195 VSS.t15 0.2605
R1808 VSS.n195 VSS.t17 0.2605
R1809 VSS.n194 VSS.t450 0.5805
R1810 VSS.n194 VSS.t439 0.5805
R1811 VSS.n193 VSS.n191 0.3205
R1812 VSS.n193 VSS.n192 0.3205
R1813 VSS.n192 VSS.t451 0.2605
R1814 VSS.n192 VSS.t452 0.2605
R1815 VSS.n191 VSS.t441 0.2605
R1816 VSS.n191 VSS.t443 0.2605
R1817 VSS.n190 VSS.n188 0.3205
R1818 VSS.n190 VSS.n189 0.3205
R1819 VSS.n189 VSS.t453 0.2605
R1820 VSS.n189 VSS.t454 0.2605
R1821 VSS.n188 VSS.t445 0.2605
R1822 VSS.n188 VSS.t447 0.2605
R1823 VSS.n187 VSS.n186 0.3205
R1824 VSS.n186 VSS.t455 0.2605
R1825 VSS.n186 VSS.t457 0.2605
R1826 VSS.n187 VSS.t449 0.5805
R1827 VSS.n185 VSS.n184 0.3205
R1828 VSS.n184 VSS.t459 0.2605
R1829 VSS.n184 VSS.t460 0.2605
R1830 VSS.n185 VSS.t9 0.5805
R1831 VSS.n183 VSS.n182 0.3205
R1832 VSS.n183 VSS.t461 0.5805
R1833 VSS.n182 VSS.t11 0.2605
R1834 VSS.n182 VSS.t13 0.2605
R1835 VSS.n0 VSS.n81 0.123233
R1836 VSS.n81 VSS.n82 0.0521667
R1837 VSS.n82 VSS.n83 0.0319
R1838 VSS.n83 VSS.n84 0.0217667
R1839 VSS.n84 VSS.n85 0.0319
R1840 VSS.n85 VSS.n181 0.0217667
R1841 VSS.n178 VSS.n177 0.0521667
R1842 VSS.n176 VSS.n86 0.0334333
R1843 VSS.n86 VSS.n175 0.0383667
R1844 VSS.n61 VSS.n174 0.0466
R1845 VSS.n173 VSS.n172 0.0521667
R1846 VSS.n172 VSS.n171 0.0192333
R1847 VSS.n171 VSS.n170 0.0597667
R1848 VSS.n168 VSS.n167 0.0521667
R1849 VSS.n167 VSS.n166 0.0521667
R1850 VSS.n166 VSS.n165 0.0521667
R1851 VSS.n65 VSS.n164 0.0466
R1852 VSS.n164 VSS.n163 0.0521667
R1853 VSS.n163 VSS.n162 0.0521667
R1854 VSS.n161 VSS.n159 0.0516667
R1855 VSS.n159 VSS.n158 0.0521667
R1856 VSS.n158 VSS.n157 0.0521667
R1857 VSS.n157 VSS.n156 0.0521667
R1858 VSS.n154 VSS.n155 0.00656667
R1859 VSS.n155 VSS.n153 0.0471
R1860 VSS.n153 VSS.n152 0.0521667
R1861 VSS.n152 VSS.n151 0.0521667
R1862 VSS.n151 VSS.n150 0.0521667
R1863 VSS.n150 VSS.n149 0.0521667
R1864 VSS.n149 VSS.n148 0.0521667
R1865 VSS.n145 VSS.n144 0.0521667
R1866 VSS.n143 VSS.n142 0.0521667
R1867 VSS.n141 VSS.n140 0.0521667
R1868 VSS.n140 VSS.n139 0.0521667
R1869 VSS.n138 VSS.n137 0.0521667
R1870 VSS.n136 VSS.n135 0.0521667
R1871 VSS.n134 VSS.n133 0.0445667
R1872 VSS.n87 VSS.n132 0.0220333
R1873 VSS.n132 VSS.n131 0.0421667
R1874 VSS.n130 VSS.n129 0.0521667
R1875 VSS.n128 VSS.n127 0.0521667
R1876 VSS.n88 VSS.n89 0.0192333
R1877 VSS.n89 VSS.n125 0.0597667
R1878 VSS.n72 VSS.n124 0.0212667
R1879 VSS.n117 VSS.n116 0.0521667
R1880 VSS.n114 VSS.n113 0.0521667
R1881 VSS.n112 VSS.n111 0.0521667
R1882 VSS.n110 VSS.n108 0.0516667
R1883 VSS.n108 VSS.n107 0.0521667
R1884 VSS.n106 VSS.n105 0.0521667
R1885 VSS.n104 VSS.n103 0.0521667
R1886 VSS.n103 VSS.n102 0.0521667
R1887 VSS.n90 VSS.n101 0.0169667
R1888 VSS.n101 VSS.n100 0.0447
R1889 VSS.n99 VSS.n98 0.0521667
R1890 VSS.n97 VSS.n96 0.0521667
R1891 VSS.n96 VSS.n95 0.0521667
R1892 VSS.n91 VSS.n92 0.0319
R1893 VSS.n92 VSS.t341 0.604433
R1894 VSS.n161 VSS.n160 0.3205
R1895 VSS.n160 VSS.t375 0.2605
R1896 VSS.n160 VSS.t377 0.2605
R1897 VSS.n126 VSS.t113 0.5805
R1898 VSS.n110 VSS.n109 0.3205
R1899 VSS.n109 VSS.t235 0.2605
R1900 VSS.n109 VSS.t237 0.2605
R1901 VDD VDD.n37 0.431167
R1902 VDD.n37 VDD.n36 0.9885
R1903 VDD.n36 VDD.n26 8.0608
R1904 VDD.n82 VDD.n193 0.0263333
R1905 VDD.n80 VDD.n85 0.0220833
R1906 VDD.n38 VDD.n87 0.0132841
R1907 VDD.n78 VDD.n91 0.0458333
R1908 VDD.n40 VDD.n174 0.0458333
R1909 VDD.n40 VDD.n277 0.00333067
R1910 VDD.n77 VDD.n172 0.0585
R1911 VDD.n41 VDD.n93 0.0511613
R1912 VDD.n74 VDD.n98 0.0205
R1913 VDD.n68 VDD.n112 0.0205
R1914 VDD.n66 VDD.n116 0.0458333
R1915 VDD.n42 VDD.n118 0.0385157
R1916 VDD.n63 VDD.n121 0.0569167
R1917 VDD.n60 VDD.n129 0.0453333
R1918 VDD.n60 VDD.n291 0.0258333
R1919 VDD.n43 VDD.n291 0.00556667
R1920 VDD.n57 VDD.n137 0.0585
R1921 VDD.n55 VDD.n141 0.0220833
R1922 VDD.n54 VDD.n163 0.0585
R1923 VDD.n52 VDD.n236 0.00331304
R1924 VDD.n44 VDD.n159 0.0585
R1925 VDD.n44 VDD.n233 0.00338209
R1926 VDD.n46 VDD.n45 0.134
R1927 VDD.n46 VDD.n224 0.00336158
R1928 VDD.n47 VDD.n157 0.337167
R1929 VDD.n47 VDD.n199 0.00332222
R1930 VDD.n48 VDD.n49 0.0397667
R1931 VDD.n50 VDD.n49 0.0397667
R1932 VDD.n51 VDD.n50 0.0155667
R1933 VDD.n37 VDD.n152 0.3411
R1934 VDD.n53 VDD.t154 1.33288
R1935 VDD.n56 VDD.n296 1.22885
R1936 VDD.n296 VDD.n297 0.2437
R1937 VDD.n297 VDD.n298 0.2437
R1938 VDD.n298 VDD.n299 0.2437
R1939 VDD.n299 VDD.n300 0.2437
R1940 VDD.n300 VDD.n301 0.2437
R1941 VDD.n301 VDD.t179 0.3477
R1942 VDD.n301 VDD.t195 0.1045
R1943 VDD.n301 VDD.t177 0.1045
R1944 VDD.n300 VDD.t191 0.1045
R1945 VDD.n300 VDD.t193 0.1045
R1946 VDD.n299 VDD.t187 0.1045
R1947 VDD.n299 VDD.t189 0.1045
R1948 VDD.n298 VDD.t183 0.1045
R1949 VDD.n298 VDD.t185 0.1045
R1950 VDD.n297 VDD.t175 0.1045
R1951 VDD.n297 VDD.t181 0.1045
R1952 VDD.n296 VDD.t173 0.1045
R1953 VDD.n58 VDD.n293 1.22901
R1954 VDD.n293 VDD.n294 0.2437
R1955 VDD.n294 VDD.n295 0.2437
R1956 VDD.n295 VDD.t171 0.3477
R1957 VDD.n295 VDD.t167 0.1045
R1958 VDD.n295 VDD.t169 0.1045
R1959 VDD.n294 VDD.t165 0.1045
R1960 VDD.n294 VDD.t166 0.1045
R1961 VDD.n293 VDD.t164 0.1045
R1962 VDD.n59 VDD.n292 1.22891
R1963 VDD.n292 VDD.t152 0.3477
R1964 VDD.n292 VDD.t151 0.1045
R1965 VDD.n291 VDD.t155 1.33038
R1966 VDD.n61 VDD.t61 1.04338
R1967 VDD.n62 VDD.n290 1.22869
R1968 VDD.n290 VDD.t59 0.3477
R1969 VDD.n290 VDD.t150 0.1045
R1970 VDD.n64 VDD.t79 1.63147
R1971 VDD.n67 VDD.t57 1.63079
R1972 VDD.n69 VDD.t3 1.33308
R1973 VDD.n70 VDD.t157 1.63099
R1974 VDD.n71 VDD.t399 1.33274
R1975 VDD.n72 VDD.n289 1.2284
R1976 VDD.n289 VDD.t163 0.3477
R1977 VDD.n289 VDD.t392 0.1045
R1978 VDD.n73 VDD.t161 1.04189
R1979 VDD.n75 VDD.t345 1.63119
R1980 VDD.n79 VDD.t311 1.6309
R1981 VDD.n81 VDD.t159 1.6316
R1982 VDD.n196 VDD.n288 1.22904
R1983 VDD.n288 VDD.t7 0.3477
R1984 VDD.n288 VDD.t5 0.1045
R1985 VDD.n287 VDD.n284 1.22638
R1986 VDD.n284 VDD.n285 0.2437
R1987 VDD.n285 VDD.n286 0.2437
R1988 VDD.n286 VDD.t411 0.3477
R1989 VDD.n286 VDD.t408 0.1045
R1990 VDD.n286 VDD.t409 0.1045
R1991 VDD.n285 VDD.t405 0.1045
R1992 VDD.n285 VDD.t407 0.1045
R1993 VDD.n284 VDD.t403 0.1045
R1994 VDD.n287 VDD.t1 1.33038
R1995 VDD.n80 VDD.n278 1.22829
R1996 VDD.n278 VDD.n279 0.2437
R1997 VDD.n279 VDD.n280 0.2437
R1998 VDD.n280 VDD.n281 0.2437
R1999 VDD.n281 VDD.n282 0.2437
R2000 VDD.n282 VDD.n283 0.2437
R2001 VDD.n283 VDD.t15 0.3477
R2002 VDD.n283 VDD.t31 0.1045
R2003 VDD.n283 VDD.t13 0.1045
R2004 VDD.n282 VDD.t27 0.1045
R2005 VDD.n282 VDD.t29 0.1045
R2006 VDD.n281 VDD.t23 0.1045
R2007 VDD.n281 VDD.t25 0.1045
R2008 VDD.n280 VDD.t19 0.1045
R2009 VDD.n280 VDD.t21 0.1045
R2010 VDD.n279 VDD.t11 0.1045
R2011 VDD.n279 VDD.t17 0.1045
R2012 VDD.n278 VDD.t9 0.1045
R2013 VDD.n78 VDD.t319 1.33297
R2014 VDD.n277 VDD.n276 1.22638
R2015 VDD.n276 VDD.t327 0.3477
R2016 VDD.n276 VDD.t325 0.1045
R2017 VDD.n277 VDD.t317 1.62888
R2018 VDD.n77 VDD.n272 1.22739
R2019 VDD.n272 VDD.n273 0.2437
R2020 VDD.n273 VDD.n274 0.2437
R2021 VDD.n274 VDD.n275 0.2437
R2022 VDD.n275 VDD.t343 0.3477
R2023 VDD.n275 VDD.t339 0.1045
R2024 VDD.n275 VDD.t341 0.1045
R2025 VDD.n274 VDD.t335 0.1045
R2026 VDD.n274 VDD.t337 0.1045
R2027 VDD.n273 VDD.t331 0.1045
R2028 VDD.n273 VDD.t333 0.1045
R2029 VDD.n272 VDD.t329 0.1045
R2030 VDD.n74 VDD.n260 1.22869
R2031 VDD.n260 VDD.n261 0.2437
R2032 VDD.n261 VDD.n262 0.2437
R2033 VDD.n262 VDD.n263 0.2437
R2034 VDD.n263 VDD.n264 0.2437
R2035 VDD.n264 VDD.n265 0.2437
R2036 VDD.n265 VDD.n266 0.2437
R2037 VDD.n266 VDD.n267 0.2437
R2038 VDD.n267 VDD.n268 0.2437
R2039 VDD.n268 VDD.n269 0.2437
R2040 VDD.n269 VDD.n270 0.2437
R2041 VDD.n270 VDD.n271 0.2437
R2042 VDD.n271 VDD.t379 0.3477
R2043 VDD.n271 VDD.t375 0.1045
R2044 VDD.n271 VDD.t377 0.1045
R2045 VDD.n270 VDD.t369 0.1045
R2046 VDD.n270 VDD.t373 0.1045
R2047 VDD.n269 VDD.t365 0.1045
R2048 VDD.n269 VDD.t367 0.1045
R2049 VDD.n268 VDD.t361 0.1045
R2050 VDD.n268 VDD.t363 0.1045
R2051 VDD.n267 VDD.t357 0.1045
R2052 VDD.n267 VDD.t359 0.1045
R2053 VDD.n266 VDD.t353 0.1045
R2054 VDD.n266 VDD.t355 0.1045
R2055 VDD.n265 VDD.t391 0.1045
R2056 VDD.n265 VDD.t351 0.1045
R2057 VDD.n264 VDD.t388 0.1045
R2058 VDD.n264 VDD.t390 0.1045
R2059 VDD.n263 VDD.t384 0.1045
R2060 VDD.n263 VDD.t386 0.1045
R2061 VDD.n262 VDD.t381 0.1045
R2062 VDD.n262 VDD.t382 0.1045
R2063 VDD.n261 VDD.t349 0.1045
R2064 VDD.n261 VDD.t371 0.1045
R2065 VDD.n260 VDD.t347 0.1045
R2066 VDD.n68 VDD.n259 1.22885
R2067 VDD.n259 VDD.t396 0.3477
R2068 VDD.n259 VDD.t394 0.1045
R2069 VDD.n66 VDD.n255 1.22904
R2070 VDD.n255 VDD.n256 0.2437
R2071 VDD.n256 VDD.n257 0.2437
R2072 VDD.n257 VDD.n258 0.2437
R2073 VDD.n258 VDD.t77 0.3477
R2074 VDD.n258 VDD.t73 0.1045
R2075 VDD.n258 VDD.t75 0.1045
R2076 VDD.n257 VDD.t69 0.1045
R2077 VDD.n257 VDD.t71 0.1045
R2078 VDD.n256 VDD.t65 0.1045
R2079 VDD.n256 VDD.t67 0.1045
R2080 VDD.n255 VDD.t63 0.1045
R2081 VDD.n63 VDD.n243 1.22739
R2082 VDD.n243 VDD.n244 0.2437
R2083 VDD.n244 VDD.n245 0.2437
R2084 VDD.n245 VDD.n246 0.2437
R2085 VDD.n246 VDD.n247 0.2437
R2086 VDD.n247 VDD.n248 0.2437
R2087 VDD.n248 VDD.n249 0.2437
R2088 VDD.n249 VDD.n250 0.2437
R2089 VDD.n250 VDD.n251 0.2437
R2090 VDD.n251 VDD.n252 0.2437
R2091 VDD.n252 VDD.n253 0.2437
R2092 VDD.n253 VDD.n254 0.2437
R2093 VDD.n254 VDD.t113 0.3477
R2094 VDD.n254 VDD.t109 0.1045
R2095 VDD.n254 VDD.t111 0.1045
R2096 VDD.n253 VDD.t103 0.1045
R2097 VDD.n253 VDD.t107 0.1045
R2098 VDD.n252 VDD.t99 0.1045
R2099 VDD.n252 VDD.t101 0.1045
R2100 VDD.n251 VDD.t95 0.1045
R2101 VDD.n251 VDD.t97 0.1045
R2102 VDD.n250 VDD.t91 0.1045
R2103 VDD.n250 VDD.t93 0.1045
R2104 VDD.n249 VDD.t87 0.1045
R2105 VDD.n249 VDD.t89 0.1045
R2106 VDD.n248 VDD.t125 0.1045
R2107 VDD.n248 VDD.t85 0.1045
R2108 VDD.n247 VDD.t122 0.1045
R2109 VDD.n247 VDD.t124 0.1045
R2110 VDD.n246 VDD.t119 0.1045
R2111 VDD.n246 VDD.t120 0.1045
R2112 VDD.n245 VDD.t115 0.1045
R2113 VDD.n245 VDD.t117 0.1045
R2114 VDD.n244 VDD.t83 0.1045
R2115 VDD.n244 VDD.t105 0.1045
R2116 VDD.n243 VDD.t81 0.1045
R2117 VDD.n57 VDD.t398 1.33297
R2118 VDD.n55 VDD.n242 1.22829
R2119 VDD.n242 VDD.t197 0.3477
R2120 VDD.n242 VDD.t196 0.1045
R2121 VDD.n54 VDD.n237 1.22869
R2122 VDD.n237 VDD.n238 0.2437
R2123 VDD.n238 VDD.n239 0.2437
R2124 VDD.n239 VDD.n240 0.2437
R2125 VDD.n240 VDD.n241 0.2437
R2126 VDD.n241 VDD.t209 0.3477
R2127 VDD.n241 VDD.t206 0.1045
R2128 VDD.n241 VDD.t208 0.1045
R2129 VDD.n240 VDD.t203 0.1045
R2130 VDD.n240 VDD.t204 0.1045
R2131 VDD.n239 VDD.t201 0.1045
R2132 VDD.n239 VDD.t202 0.1045
R2133 VDD.n238 VDD.t199 0.1045
R2134 VDD.n238 VDD.t200 0.1045
R2135 VDD.n237 VDD.t198 0.1045
R2136 VDD.n236 VDD.n235 1.22638
R2137 VDD.n235 VDD.t401 0.3477
R2138 VDD.n235 VDD.t400 0.1045
R2139 VDD.n236 VDD.n234 1.22638
R2140 VDD.n234 VDD.t213 0.3477
R2141 VDD.n234 VDD.t211 0.1045
R2142 VDD.n233 VDD.n229 1.22638
R2143 VDD.n229 VDD.n230 0.2437
R2144 VDD.n230 VDD.n231 0.2437
R2145 VDD.n231 VDD.n232 0.2437
R2146 VDD.n232 VDD.t237 0.3477
R2147 VDD.n232 VDD.t235 0.1045
R2148 VDD.n232 VDD.t236 0.1045
R2149 VDD.n231 VDD.t233 0.1045
R2150 VDD.n231 VDD.t234 0.1045
R2151 VDD.n230 VDD.t231 0.1045
R2152 VDD.n230 VDD.t232 0.1045
R2153 VDD.n229 VDD.t230 0.1045
R2154 VDD.n233 VDD.n225 1.22638
R2155 VDD.n225 VDD.n226 0.2437
R2156 VDD.n226 VDD.n227 0.2437
R2157 VDD.n227 VDD.n228 0.2437
R2158 VDD.n228 VDD.t229 0.3477
R2159 VDD.n228 VDD.t225 0.1045
R2160 VDD.n228 VDD.t227 0.1045
R2161 VDD.n227 VDD.t221 0.1045
R2162 VDD.n227 VDD.t223 0.1045
R2163 VDD.n226 VDD.t217 0.1045
R2164 VDD.n226 VDD.t219 0.1045
R2165 VDD.n225 VDD.t215 0.1045
R2166 VDD.n224 VDD.n212 1.22638
R2167 VDD.n212 VDD.n213 0.2437
R2168 VDD.n213 VDD.n214 0.2437
R2169 VDD.n214 VDD.n215 0.2437
R2170 VDD.n215 VDD.n216 0.2437
R2171 VDD.n216 VDD.n217 0.2437
R2172 VDD.n217 VDD.n218 0.2437
R2173 VDD.n218 VDD.n219 0.2437
R2174 VDD.n219 VDD.n220 0.2437
R2175 VDD.n220 VDD.n221 0.2437
R2176 VDD.n221 VDD.n222 0.2437
R2177 VDD.n222 VDD.n223 0.2437
R2178 VDD.n223 VDD.t302 0.3477
R2179 VDD.n223 VDD.t300 0.1045
R2180 VDD.n223 VDD.t301 0.1045
R2181 VDD.n222 VDD.t297 0.1045
R2182 VDD.n222 VDD.t299 0.1045
R2183 VDD.n221 VDD.t295 0.1045
R2184 VDD.n221 VDD.t296 0.1045
R2185 VDD.n220 VDD.t293 0.1045
R2186 VDD.n220 VDD.t294 0.1045
R2187 VDD.n219 VDD.t291 0.1045
R2188 VDD.n219 VDD.t292 0.1045
R2189 VDD.n218 VDD.t289 0.1045
R2190 VDD.n218 VDD.t290 0.1045
R2191 VDD.n217 VDD.t309 0.1045
R2192 VDD.n217 VDD.t288 0.1045
R2193 VDD.n216 VDD.t307 0.1045
R2194 VDD.n216 VDD.t308 0.1045
R2195 VDD.n215 VDD.t305 0.1045
R2196 VDD.n215 VDD.t306 0.1045
R2197 VDD.n214 VDD.t303 0.1045
R2198 VDD.n214 VDD.t304 0.1045
R2199 VDD.n213 VDD.t287 0.1045
R2200 VDD.n213 VDD.t298 0.1045
R2201 VDD.n212 VDD.t286 0.1045
R2202 VDD.n224 VDD.n200 1.22638
R2203 VDD.n200 VDD.n201 0.2437
R2204 VDD.n201 VDD.n202 0.2437
R2205 VDD.n202 VDD.n203 0.2437
R2206 VDD.n203 VDD.n204 0.2437
R2207 VDD.n204 VDD.n205 0.2437
R2208 VDD.n205 VDD.n206 0.2437
R2209 VDD.n206 VDD.n207 0.2437
R2210 VDD.n207 VDD.n208 0.2437
R2211 VDD.n208 VDD.n209 0.2437
R2212 VDD.n209 VDD.n210 0.2437
R2213 VDD.n210 VDD.n211 0.2437
R2214 VDD.n211 VDD.t271 0.3477
R2215 VDD.n211 VDD.t267 0.1045
R2216 VDD.n211 VDD.t269 0.1045
R2217 VDD.n210 VDD.t261 0.1045
R2218 VDD.n210 VDD.t265 0.1045
R2219 VDD.n209 VDD.t257 0.1045
R2220 VDD.n209 VDD.t259 0.1045
R2221 VDD.n208 VDD.t253 0.1045
R2222 VDD.n208 VDD.t255 0.1045
R2223 VDD.n207 VDD.t249 0.1045
R2224 VDD.n207 VDD.t251 0.1045
R2225 VDD.n206 VDD.t245 0.1045
R2226 VDD.n206 VDD.t247 0.1045
R2227 VDD.n205 VDD.t285 0.1045
R2228 VDD.n205 VDD.t243 0.1045
R2229 VDD.n204 VDD.t281 0.1045
R2230 VDD.n204 VDD.t283 0.1045
R2231 VDD.n203 VDD.t277 0.1045
R2232 VDD.n203 VDD.t279 0.1045
R2233 VDD.n202 VDD.t273 0.1045
R2234 VDD.n202 VDD.t275 0.1045
R2235 VDD.n201 VDD.t241 0.1045
R2236 VDD.n201 VDD.t263 0.1045
R2237 VDD.n200 VDD.t239 0.1045
R2238 VDD.n199 VDD.t402 1.33038
R2239 VDD.n199 VDD.n198 1.22638
R2240 VDD.n198 VDD.t323 0.3477
R2241 VDD.n198 VDD.t321 0.1045
R2242 VDD.n51 VDD.n197 1.22904
R2243 VDD.n197 VDD.t315 0.3477
R2244 VDD.n197 VDD.t313 0.1045
R2245 VDD.n83 VDD.n287 0.0352
R2246 VDD.n83 VDD.n84 0.00590323
R2247 VDD.n196 VDD.n83 0.0458333
R2248 VDD.n193 VDD.n196 0.0205
R2249 VDD.n193 VDD.n195 0.00358025
R2250 VDD.n81 VDD.n82 0.058
R2251 VDD.n85 VDD.n81 0.00625
R2252 VDD.n85 VDD.n86 0.0029664
R2253 VDD.n87 VDD.n80 0.0838652
R2254 VDD.n87 VDD.n88 0.00211673
R2255 VDD.n39 VDD.n176 0.00350024
R2256 VDD.n79 VDD.n39 0.0337368
R2257 VDD.n89 VDD.n79 0.0711667
R2258 VDD.n89 VDD.n90 0.00413651
R2259 VDD.n91 VDD.n89 0.0395
R2260 VDD.n91 VDD.n92 0.00431746
R2261 VDD.n174 VDD.n78 0.0331667
R2262 VDD.n174 VDD.n175 0.00408406
R2263 VDD.n172 VDD.n40 0.0458333
R2264 VDD.n172 VDD.n173 0.00320645
R2265 VDD.n93 VDD.n77 0.00783333
R2266 VDD.n93 VDD.n94 0.00392308
R2267 VDD.n41 VDD.n95 0.00377539
R2268 VDD.n75 VDD.n76 0.00733333
R2269 VDD.n96 VDD.n75 0.0600833
R2270 VDD.n96 VDD.n97 0.00293393
R2271 VDD.n98 VDD.n96 0.0505833
R2272 VDD.n98 VDD.n99 0.00549462
R2273 VDD.n100 VDD.n74 0.046625
R2274 VDD.n100 VDD.n101 0.00329816
R2275 VDD.n73 VDD.n100 0.0577083
R2276 VDD.n102 VDD.n73 0.0458333
R2277 VDD.n102 VDD.n103 0.00314359
R2278 VDD.n72 VDD.n102 0.0585
R2279 VDD.n104 VDD.n72 0.0458333
R2280 VDD.n104 VDD.n105 0.00305079
R2281 VDD.n71 VDD.n104 0.0585
R2282 VDD.n170 VDD.n71 0.0205
R2283 VDD.n170 VDD.n171 0.00311111
R2284 VDD.n106 VDD.n170 0.0141667
R2285 VDD.n106 VDD.n107 0.00159375
R2286 VDD.n70 VDD.n106 0.0458333
R2287 VDD.n108 VDD.n70 0.109167
R2288 VDD.n108 VDD.n109 0.004135
R2289 VDD.n69 VDD.n108 0.121833
R2290 VDD.n110 VDD.n69 0.0212917
R2291 VDD.n110 VDD.n111 0.00307813
R2292 VDD.n112 VDD.n110 0.013375
R2293 VDD.n112 VDD.n113 0.00572889
R2294 VDD.n114 VDD.n68 0.00625
R2295 VDD.n114 VDD.n115 0.0029664
R2296 VDD.n67 VDD.n114 0.0220833
R2297 VDD.n168 VDD.n67 0.0205
R2298 VDD.n168 VDD.n169 0.00240741
R2299 VDD.n116 VDD.n168 0.0141667
R2300 VDD.n116 VDD.n117 0.00402273
R2301 VDD.n118 VDD.n66 0.0331667
R2302 VDD.n118 VDD.n119 0.0051284
R2303 VDD.n42 VDD.n120 0.00451979
R2304 VDD.n64 VDD.n65 0.0326667
R2305 VDD.n121 VDD.n64 0.0474167
R2306 VDD.n121 VDD.n122 0.00177187
R2307 VDD.n123 VDD.n63 0.00783333
R2308 VDD.n123 VDD.n124 0.00392308
R2309 VDD.n125 VDD.n123 0.0529583
R2310 VDD.n125 VDD.n126 0.0014613
R2311 VDD.n62 VDD.n125 0.070375
R2312 VDD.n127 VDD.n62 0.0458333
R2313 VDD.n127 VDD.n128 0.00293725
R2314 VDD.n61 VDD.n127 0.0585
R2315 VDD.n129 VDD.n61 0.0458333
R2316 VDD.n129 VDD.n130 0.00268889
R2317 VDD.n167 VDD.n60 0.0131667
R2318 VDD.n43 VDD.n167 0.0182333
R2319 VDD.n131 VDD.n43 0.0301333
R2320 VDD.n131 VDD.n132 0.00437778
R2321 VDD.n59 VDD.n131 0.0458333
R2322 VDD.n133 VDD.n59 0.0458333
R2323 VDD.n133 VDD.n134 0.00261212
R2324 VDD.n58 VDD.n133 0.0585
R2325 VDD.n135 VDD.n58 0.0719583
R2326 VDD.n135 VDD.n136 0.00450075
R2327 VDD.n137 VDD.n135 0.0260417
R2328 VDD.n137 VDD.n138 0.004648
R2329 VDD.n139 VDD.n57 0.0205
R2330 VDD.n139 VDD.n140 0.00347826
R2331 VDD.n165 VDD.n139 0.0141667
R2332 VDD.n165 VDD.n166 0.00590323
R2333 VDD.n56 VDD.n165 0.0205
R2334 VDD.n141 VDD.n56 0.00625
R2335 VDD.n141 VDD.n142 0.0029664
R2336 VDD.n163 VDD.n55 0.0458333
R2337 VDD.n163 VDD.n164 0.00307273
R2338 VDD.n143 VDD.n54 0.0458333
R2339 VDD.n143 VDD.n144 0.00293725
R2340 VDD.n145 VDD.n143 0.0640417
R2341 VDD.n145 VDD.n146 0.00363346
R2342 VDD.n161 VDD.n145 0.0402917
R2343 VDD.n161 VDD.n162 0.00368235
R2344 VDD.n53 VDD.n161 0.0838333
R2345 VDD.n147 VDD.n53 0.0331667
R2346 VDD.n147 VDD.n148 0.0026
R2347 VDD.n52 VDD.n147 0.0458333
R2348 VDD.n159 VDD.n52 0.0458333
R2349 VDD.n159 VDD.n160 0.00320645
R2350 VDD.n45 VDD.n44 0.121333
R2351 VDD.n157 VDD.n46 0.3245
R2352 VDD.n157 VDD.n158 0.00529032
R2353 VDD.n48 VDD.n47 0.0231667
R2354 VDD.n156 VDD.n48 0.0195
R2355 VDD.n155 VDD.n49 0.00121895
R2356 VDD.n149 VDD.n155 0.00579297
R2357 VDD.n50 VDD.n149 0.0347
R2358 VDD.n150 VDD.n51 0.00783333
R2359 VDD.n150 VDD.n151 0.00406452
R2360 VDD.n153 VDD.n150 0.0395
R2361 VDD.n153 VDD.n154 0.00240741
R2362 VDD.n152 VDD.n153 0.0141667
R2363 VDD.n84 VDD.t0 7.39934
R2364 VDD.n84 VDD.t404 29.5959
R2365 VDD.t404 VDD.t406 36.9947
R2366 VDD.n195 VDD.t406 25.8965
R2367 VDD.n194 VDD.t4 7.58346
R2368 VDD.n194 VDD.n82 0.622101
R2369 VDD.n82 VDD.t6 11.0988
R2370 VDD.t6 VDD.t410 36.9947
R2371 VDD.n86 VDD.t410 42.0814
R2372 VDD.n86 VDD.t8 68.9022
R2373 VDD.t8 VDD.t158 2.77507
R2374 VDD.t158 VDD.t10 34.2202
R2375 VDD.t16 VDD.t10 36.9947
R2376 VDD.n88 VDD.t16 7.39934
R2377 VDD.n38 VDD.t18 11.0988
R2378 VDD.t18 VDD.t20 36.9947
R2379 VDD.t20 VDD.t22 36.9947
R2380 VDD.n176 VDD.t22 25.8965
R2381 VDD.n176 VDD.t24 11.0988
R2382 VDD.t24 VDD.t26 36.9947
R2383 VDD.t26 VDD.t28 36.9947
R2384 VDD.t30 VDD.t28 36.9947
R2385 VDD.t310 VDD.t30 2.77507
R2386 VDD.n90 VDD.t310 23.1219
R2387 VDD.n90 VDD.t12 11.0988
R2388 VDD.t12 VDD.t14 36.9947
R2389 VDD.n92 VDD.t14 7.39934
R2390 VDD.n92 VDD.n177 2.4854
R2391 VDD.n177 VDD.t318 6.74096
R2392 VDD.n175 VDD.n178 2.4854
R2393 VDD.n178 VDD.t324 20.2209
R2394 VDD.n173 VDD.t326 11.0988
R2395 VDD.t326 VDD.t316 2.77507
R2396 VDD.t316 VDD.n94 78.6132
R2397 VDD.n94 VDD.t328 29.5959
R2398 VDD.t328 VDD.t330 36.9947
R2399 VDD.n95 VDD.t330 5.08721
R2400 VDD.n95 VDD.t332 31.908
R2401 VDD.t332 VDD.t334 36.9947
R2402 VDD.n76 VDD.t334 25.8965
R2403 VDD.n76 VDD.t336 11.0988
R2404 VDD.t336 VDD.t338 36.9947
R2405 VDD.t340 VDD.t338 36.9947
R2406 VDD.t344 VDD.t340 2.77507
R2407 VDD.n97 VDD.t344 6.93692
R2408 VDD.n97 VDD.n179 0.655374
R2409 VDD.n179 VDD.t342 16.4937
R2410 VDD.n99 VDD.n180 1.59812
R2411 VDD.n180 VDD.t346 18.7766
R2412 VDD.n101 VDD.t348 9.9427
R2413 VDD.t348 VDD.t370 36.9947
R2414 VDD.t370 VDD.t380 36.9947
R2415 VDD.t160 VDD.t380 36.9947
R2416 VDD.n103 VDD.t160 25.8965
R2417 VDD.n103 VDD.t383 11.0988
R2418 VDD.t383 VDD.t385 36.9947
R2419 VDD.t385 VDD.t387 36.9947
R2420 VDD.t389 VDD.t387 36.9947
R2421 VDD.n105 VDD.t389 25.8965
R2422 VDD.n105 VDD.t162 11.0988
R2423 VDD.t162 VDD.t350 36.9947
R2424 VDD.t350 VDD.t352 36.9947
R2425 VDD.n171 VDD.t352 25.8965
R2426 VDD.n171 VDD.n181 0.267186
R2427 VDD.n181 VDD.t354 4.33383
R2428 VDD.n107 VDD.t356 29.5959
R2429 VDD.t356 VDD.t358 36.9947
R2430 VDD.t358 VDD.t360 36.9947
R2431 VDD.t360 VDD.t362 36.9947
R2432 VDD.t156 VDD.t362 2.77507
R2433 VDD.t364 VDD.t156 34.2202
R2434 VDD.t366 VDD.t364 36.9947
R2435 VDD.n109 VDD.t366 7.39934
R2436 VDD.n109 VDD.t368 29.5959
R2437 VDD.t368 VDD.t372 36.9947
R2438 VDD.t372 VDD.t374 36.9947
R2439 VDD.t376 VDD.t374 36.9947
R2440 VDD.t378 VDD.t376 36.9947
R2441 VDD.n111 VDD.t378 27.0525
R2442 VDD.n111 VDD.n182 0.239458
R2443 VDD.n182 VDD.t2 4.14126
R2444 VDD.n113 VDD.n115 0.832331
R2445 VDD.n115 VDD.n183 0.766285
R2446 VDD.n183 VDD.t393 13.9527
R2447 VDD.n169 VDD.n184 0.267186
R2448 VDD.n184 VDD.t395 4.33383
R2449 VDD.n117 VDD.t56 32.3704
R2450 VDD.t56 VDD.t62 71.2144
R2451 VDD.n119 VDD.t62 7.39934
R2452 VDD.n119 VDD.n185 0.71083
R2453 VDD.n185 VDD.t64 12.8111
R2454 VDD.n120 VDD.t66 13.4109
R2455 VDD.t66 VDD.t68 36.9947
R2456 VDD.n65 VDD.t68 25.8965
R2457 VDD.n65 VDD.t70 11.0988
R2458 VDD.t70 VDD.t72 36.9947
R2459 VDD.t72 VDD.t74 36.9947
R2460 VDD.n122 VDD.t74 28.2086
R2461 VDD.n122 VDD.t76 8.78663
R2462 VDD.t76 VDD.t78 2.77507
R2463 VDD.t78 VDD.n124 78.6132
R2464 VDD.n124 VDD.t80 29.5959
R2465 VDD.t80 VDD.t82 36.9947
R2466 VDD.n126 VDD.t82 8.55541
R2467 VDD.n126 VDD.t104 28.4398
R2468 VDD.t104 VDD.t114 36.9947
R2469 VDD.t114 VDD.t116 36.9947
R2470 VDD.t118 VDD.t116 36.9947
R2471 VDD.n128 VDD.t118 25.8965
R2472 VDD.n128 VDD.t58 11.0988
R2473 VDD.t58 VDD.t121 36.9947
R2474 VDD.t121 VDD.t123 36.9947
R2475 VDD.t60 VDD.t123 36.9947
R2476 VDD.n130 VDD.t60 25.8965
R2477 VDD.n130 VDD.t84 11.0988
R2478 VDD.t84 VDD.t86 36.9947
R2479 VDD.n167 VDD.t86 25.8965
R2480 VDD.n167 VDD.t88 11.0988
R2481 VDD.t88 VDD.t90 36.9947
R2482 VDD.n132 VDD.t90 7.39934
R2483 VDD.n132 VDD.t92 29.5959
R2484 VDD.t92 VDD.t94 36.9947
R2485 VDD.t96 VDD.t94 36.9947
R2486 VDD.n134 VDD.t96 25.8965
R2487 VDD.n134 VDD.t98 11.0988
R2488 VDD.t98 VDD.t100 36.9947
R2489 VDD.t100 VDD.t102 36.9947
R2490 VDD.t102 VDD.t106 36.9947
R2491 VDD.t108 VDD.t106 36.9947
R2492 VDD.n136 VDD.t108 27.0525
R2493 VDD.n136 VDD.n186 0.239458
R2494 VDD.n186 VDD.t110 7.01273
R2495 VDD.n138 VDD.t112 11.0988
R2496 VDD.t112 VDD.t168 36.9947
R2497 VDD.t168 VDD.t170 36.9947
R2498 VDD.n140 VDD.t170 25.8965
R2499 VDD.n140 VDD.n187 0.267186
R2500 VDD.n187 VDD.t397 4.33383
R2501 VDD.n166 VDD.n142 0.832331
R2502 VDD.n142 VDD.t172 31.908
R2503 VDD.t172 VDD.t174 36.9947
R2504 VDD.n164 VDD.t174 25.8965
R2505 VDD.n164 VDD.t180 11.0988
R2506 VDD.t180 VDD.t182 36.9947
R2507 VDD.t182 VDD.t184 36.9947
R2508 VDD.t186 VDD.t184 36.9947
R2509 VDD.n144 VDD.t186 25.8965
R2510 VDD.n144 VDD.t188 11.0988
R2511 VDD.t188 VDD.t190 36.9947
R2512 VDD.t192 VDD.t190 36.9947
R2513 VDD.n146 VDD.t192 6.24327
R2514 VDD.n146 VDD.n188 0.738557
R2515 VDD.n188 VDD.t194 13.7216
R2516 VDD.n162 VDD.t176 11.0988
R2517 VDD.t176 VDD.t178 36.9947
R2518 VDD.t178 VDD.t205 36.9947
R2519 VDD.t207 VDD.t205 36.9947
R2520 VDD.t153 VDD.t207 36.9947
R2521 VDD.n148 VDD.t153 7.39934
R2522 VDD.n148 VDD.n189 2.4854
R2523 VDD.n189 VDD.t210 20.2209
R2524 VDD.n160 VDD.t212 11.0988
R2525 VDD.t212 VDD.t214 110.984
R2526 VDD.t214 VDD.t216 36.9947
R2527 VDD.t218 VDD.t216 36.9947
R2528 VDD.t220 VDD.t218 36.9947
R2529 VDD.n45 VDD.t220 25.8965
R2530 VDD.n45 VDD.t222 11.0988
R2531 VDD.t222 VDD.t224 36.9947
R2532 VDD.t224 VDD.t226 36.9947
R2533 VDD.t226 VDD.t228 36.9947
R2534 VDD.t228 VDD.t238 110.984
R2535 VDD.t238 VDD.t240 36.9947
R2536 VDD.t240 VDD.t262 36.9947
R2537 VDD.t262 VDD.t272 36.9947
R2538 VDD.t274 VDD.t272 36.9947
R2539 VDD.t276 VDD.t274 36.9947
R2540 VDD.t278 VDD.t276 36.9947
R2541 VDD.t280 VDD.t278 36.9947
R2542 VDD.t282 VDD.t280 36.9947
R2543 VDD.t284 VDD.t282 36.9947
R2544 VDD.t242 VDD.t284 36.9947
R2545 VDD.t244 VDD.t242 36.9947
R2546 VDD.n158 VDD.t244 25.8965
R2547 VDD.n158 VDD.t246 11.0988
R2548 VDD.t246 VDD.t248 36.9947
R2549 VDD.t248 VDD.t250 36.9947
R2550 VDD.t250 VDD.t252 36.9947
R2551 VDD.t252 VDD.t254 36.9947
R2552 VDD.t254 VDD.t256 36.9947
R2553 VDD.t256 VDD.t258 36.9947
R2554 VDD.t258 VDD.t260 36.9947
R2555 VDD.t264 VDD.t260 36.9947
R2556 VDD.t266 VDD.t264 36.9947
R2557 VDD.t268 VDD.t266 36.9947
R2558 VDD.t270 VDD.t268 36.9947
R2559 VDD.t320 VDD.t270 110.984
R2560 VDD.n156 VDD.t320 7.39934
R2561 VDD.n155 VDD.n156 0.0201719
R2562 VDD.n149 VDD.n190 0.267186
R2563 VDD.n190 VDD.t322 8.66666
R2564 VDD.n151 VDD.n191 0.710829
R2565 VDD.n191 VDD.t312 13.4809
R2566 VDD.n154 VDD.n192 0.267186
R2567 VDD.n192 VDD.t314 4.33383
R2568 VDD.n84 VDD.n195 2.27323
R2569 VDD.n195 VDD.n194 0.267186
R2570 VDD.n82 VDD.n86 2.21641
R2571 VDD.n86 VDD.n88 3.69368
R2572 VDD.n39 VDD.n38 0.0753445
R2573 VDD.n176 VDD.n90 3.63686
R2574 VDD.n90 VDD.n92 1.36414
R2575 VDD.n175 VDD.n177 0.178457
R2576 VDD.n173 VDD.n178 0.622101
R2577 VDD.n173 VDD.n94 2.27323
R2578 VDD.n94 VDD.n95 1.76186
R2579 VDD.n76 VDD.n41 0.064554
R2580 VDD.n76 VDD.n97 2.33005
R2581 VDD.n179 VDD.n99 1.06574
R2582 VDD.n101 VDD.n180 0.649829
R2583 VDD.n101 VDD.n103 3.60845
R2584 VDD.n103 VDD.n105 3.63686
R2585 VDD.n105 VDD.n171 2.72777
R2586 VDD.n107 VDD.n181 0.178457
R2587 VDD.n107 VDD.n109 5.45505
R2588 VDD.n109 VDD.n111 5.02891
R2589 VDD.n113 VDD.n182 0.178457
R2590 VDD.n169 VDD.n183 0.622101
R2591 VDD.n117 VDD.n184 0.178457
R2592 VDD.n117 VDD.n119 2.72777
R2593 VDD.n120 VDD.n185 0.566645
R2594 VDD.n65 VDD.n42 0.0522103
R2595 VDD.n65 VDD.n122 2.78459
R2596 VDD.n122 VDD.n124 2.21641
R2597 VDD.n124 VDD.n126 1.84709
R2598 VDD.n126 VDD.n128 4.063
R2599 VDD.n128 VDD.n130 3.63686
R2600 VDD.n130 VDD.n167 1.81868
R2601 VDD.n167 VDD.n132 1.36414
R2602 VDD.n132 VDD.n134 3.18232
R2603 VDD.n134 VDD.n136 4.57436
R2604 VDD.n186 VDD.n138 0.622101
R2605 VDD.n138 VDD.n140 2.72777
R2606 VDD.n166 VDD.n187 0.178457
R2607 VDD.n142 VDD.n164 2.33005
R2608 VDD.n164 VDD.n144 3.63686
R2609 VDD.n144 VDD.n146 2.24482
R2610 VDD.n162 VDD.n188 0.622101
R2611 VDD.n162 VDD.n148 4.09141
R2612 VDD.n160 VDD.n189 0.622101
R2613 VDD.n160 VDD.n45 6.36414
R2614 VDD.n45 VDD.n158 16.3641
R2615 VDD.n158 VDD.n156 13.1823
R2616 VDD.n190 VDD.n151 1.06574
R2617 VDD.n154 VDD.n191 0.622101
R2618 VDD.n152 VDD.n192 0.18198
R2619 VDD.n36 VDD.n27 4.6446
R2620 VDD.n31 VDD.n32 0.2437
R2621 VDD.n32 VDD.n33 0.2437
R2622 VDD.n33 VDD.n34 0.2437
R2623 VDD.n34 VDD.n35 0.2437
R2624 VDD.n35 VDD.t431 0.3477
R2625 VDD.n35 VDD.t427 0.1045
R2626 VDD.n35 VDD.t429 0.1045
R2627 VDD.n34 VDD.t423 0.1045
R2628 VDD.n34 VDD.t425 0.1045
R2629 VDD.n33 VDD.t419 0.1045
R2630 VDD.n33 VDD.t421 0.1045
R2631 VDD.n32 VDD.t415 0.1045
R2632 VDD.n32 VDD.t417 0.1045
R2633 VDD.n31 VDD.t413 0.1045
R2634 VDD.n29 VDD.n31 1.52328
R2635 VDD.n29 VDD.n30 0.00909032
R2636 VDD.n27 VDD.n29 4.3335
R2637 VDD.n27 VDD.n28 0.0054129
R2638 VDD.t414 VDD.t412 72.3169
R2639 VDD.t416 VDD.t414 72.3169
R2640 VDD.t418 VDD.t416 72.3169
R2641 VDD.t420 VDD.t418 72.3169
R2642 VDD.n30 VDD.t420 50.622
R2643 VDD.n30 VDD.t422 21.6954
R2644 VDD.t422 VDD.t424 72.3169
R2645 VDD.t424 VDD.t426 72.3169
R2646 VDD.t426 VDD.t428 72.3169
R2647 VDD.t428 VDD.t430 72.3169
R2648 VDD.t430 VDD.n28 5872.09
R2649 VDD.n30 VDD.n28 155.456
R2650 VDD.n15 VDD.n12 0.236467
R2651 VDD.n17 VDD.n15 0.0521667
R2652 VDD.n19 VDD.n17 0.0521667
R2653 VDD.n13 VDD.n19 0.0319
R2654 VDD.n13 VDD.n14 0.00590833
R2655 VDD.n21 VDD.n13 0.0217667
R2656 VDD.n23 VDD.n21 0.0521667
R2657 VDD.n25 VDD.n23 0.0521667
R2658 VDD.n26 VDD.n25 0.0521667
R2659 VDD.n26 VDD.t39 1.19091
R2660 VDD.n25 VDD.n24 1.16517
R2661 VDD.n24 VDD.t55 0.0265
R2662 VDD.n24 VDD.t37 0.0265
R2663 VDD.n23 VDD.n22 1.16297
R2664 VDD.n22 VDD.t51 0.0265
R2665 VDD.n22 VDD.t53 0.0265
R2666 VDD.n21 VDD.n20 1.16589
R2667 VDD.n20 VDD.t47 0.0265
R2668 VDD.n20 VDD.t49 0.0265
R2669 VDD.n19 VDD.n18 1.1619
R2670 VDD.n18 VDD.t43 0.0265
R2671 VDD.n18 VDD.t45 0.0265
R2672 VDD.n17 VDD.n16 1.16558
R2673 VDD.n16 VDD.t35 0.0265
R2674 VDD.n16 VDD.t41 0.0265
R2675 VDD.n15 VDD.t33 1.19025
R2676 VDD.t34 VDD.t32 50.5934
R2677 VDD.t40 VDD.t34 50.5934
R2678 VDD.t42 VDD.t40 50.5934
R2679 VDD.t44 VDD.t42 50.5934
R2680 VDD.n14 VDD.t44 35.4155
R2681 VDD.n14 VDD.t46 15.1784
R2682 VDD.t46 VDD.t48 50.5934
R2683 VDD.t48 VDD.t50 50.5934
R2684 VDD.t50 VDD.t52 50.5934
R2685 VDD.t52 VDD.t54 50.5934
R2686 VDD.t54 VDD.t36 50.5934
R2687 VDD.t36 VDD.t38 50.5934
R2688 VDD.n3 VDD.t127 1.24192
R2689 VDD.n5 VDD.n3 0.0521667
R2690 VDD.n0 VDD.n5 0.0319
R2691 VDD.n0 VDD.n1 0.00590833
R2692 VDD.n7 VDD.n0 0.0217667
R2693 VDD.n9 VDD.n7 0.0521667
R2694 VDD.n11 VDD.n9 0.0521667
R2695 VDD.n12 VDD.n11 0.0521667
R2696 VDD.n12 VDD.t133 1.19091
R2697 VDD.n11 VDD.n10 1.16517
R2698 VDD.n10 VDD.t149 0.0265
R2699 VDD.n10 VDD.t131 0.0265
R2700 VDD.n9 VDD.n8 1.16297
R2701 VDD.n8 VDD.t145 0.0265
R2702 VDD.n8 VDD.t147 0.0265
R2703 VDD.n7 VDD.n6 1.16589
R2704 VDD.n6 VDD.t141 0.0265
R2705 VDD.n6 VDD.t143 0.0265
R2706 VDD.n5 VDD.n4 1.1619
R2707 VDD.n4 VDD.t137 0.0265
R2708 VDD.n4 VDD.t139 0.0265
R2709 VDD.n3 VDD.n2 1.16558
R2710 VDD.n2 VDD.t129 0.0265
R2711 VDD.n2 VDD.t135 0.0265
R2712 VDD.t128 VDD.t126 50.5934
R2713 VDD.t134 VDD.t128 50.5934
R2714 VDD.t136 VDD.t134 50.5934
R2715 VDD.t138 VDD.t136 50.5934
R2716 VDD.n1 VDD.t138 35.4155
R2717 VDD.n1 VDD.t140 15.1784
R2718 VDD.t140 VDD.t142 50.5934
R2719 VDD.t142 VDD.t144 50.5934
R2720 VDD.t144 VDD.t146 50.5934
R2721 VDD.t146 VDD.t148 50.5934
R2722 VDD.t148 VDD.t130 50.5934
R2723 VDD.t130 VDD.t132 50.5934
R2724 NCIB.n5 NCIB.n2 0.3045
R2725 NCIB.n8 NCIB.n5 0.3045
R2726 NCIB.n11 NCIB.n8 0.3045
R2727 NCIB.n14 NCIB.n11 0.3045
R2728 NCIB.n17 NCIB.n14 0.3045
R2729 NCIB.n20 NCIB.n17 0.3045
R2730 NCIB.n23 NCIB.n20 0.3045
R2731 NCIB.n26 NCIB.n23 0.3045
R2732 NCIB.n29 NCIB.n26 0.3045
R2733 NCIB.n32 NCIB.n29 0.3045
R2734 NCIB.n35 NCIB.n32 0.3045
R2735 NCIB NCIB.n35 15.2929
R2736 NCIB.n35 NCIB.n34 0.5805
R2737 NCIB.n35 NCIB.n33 0.7705
R2738 NCIB.n34 NCIB.t22 0.1045
R2739 NCIB.n34 NCIB.t23 0.1045
R2740 NCIB.n33 NCIB.t46 0.2605
R2741 NCIB.n33 NCIB.t47 0.2605
R2742 NCIB.n32 NCIB.n31 0.5805
R2743 NCIB.n32 NCIB.n30 0.7705
R2744 NCIB.n31 NCIB.t20 0.1045
R2745 NCIB.n31 NCIB.t21 0.1045
R2746 NCIB.n30 NCIB.t44 0.2605
R2747 NCIB.n30 NCIB.t45 0.2605
R2748 NCIB.n29 NCIB.n28 0.5805
R2749 NCIB.n29 NCIB.n27 0.7705
R2750 NCIB.n28 NCIB.t18 0.1045
R2751 NCIB.n28 NCIB.t19 0.1045
R2752 NCIB.n27 NCIB.t42 0.2605
R2753 NCIB.n27 NCIB.t43 0.2605
R2754 NCIB.n26 NCIB.n25 0.5805
R2755 NCIB.n26 NCIB.n24 0.7705
R2756 NCIB.n25 NCIB.t16 0.1045
R2757 NCIB.n25 NCIB.t17 0.1045
R2758 NCIB.n24 NCIB.t40 0.2605
R2759 NCIB.n24 NCIB.t41 0.2605
R2760 NCIB.n23 NCIB.n22 0.5805
R2761 NCIB.n23 NCIB.n21 0.7705
R2762 NCIB.n22 NCIB.t14 0.1045
R2763 NCIB.n22 NCIB.t15 0.1045
R2764 NCIB.n21 NCIB.t38 0.2605
R2765 NCIB.n21 NCIB.t39 0.2605
R2766 NCIB.n20 NCIB.n19 0.5805
R2767 NCIB.n20 NCIB.n18 0.7705
R2768 NCIB.n19 NCIB.t12 0.1045
R2769 NCIB.n19 NCIB.t13 0.1045
R2770 NCIB.n18 NCIB.t36 0.2605
R2771 NCIB.n18 NCIB.t37 0.2605
R2772 NCIB.n17 NCIB.n16 0.5805
R2773 NCIB.n17 NCIB.n15 0.7705
R2774 NCIB.n16 NCIB.t10 0.1045
R2775 NCIB.n16 NCIB.t11 0.1045
R2776 NCIB.n15 NCIB.t34 0.2605
R2777 NCIB.n15 NCIB.t35 0.2605
R2778 NCIB.n14 NCIB.n13 0.5805
R2779 NCIB.n14 NCIB.n12 0.7705
R2780 NCIB.n13 NCIB.t8 0.1045
R2781 NCIB.n13 NCIB.t9 0.1045
R2782 NCIB.n12 NCIB.t32 0.2605
R2783 NCIB.n12 NCIB.t33 0.2605
R2784 NCIB.n11 NCIB.n10 0.5805
R2785 NCIB.n11 NCIB.n9 0.7705
R2786 NCIB.n10 NCIB.t6 0.1045
R2787 NCIB.n10 NCIB.t7 0.1045
R2788 NCIB.n9 NCIB.t30 0.2605
R2789 NCIB.n9 NCIB.t31 0.2605
R2790 NCIB.n8 NCIB.n7 0.5805
R2791 NCIB.n8 NCIB.n6 0.7705
R2792 NCIB.n7 NCIB.t4 0.1045
R2793 NCIB.n7 NCIB.t5 0.1045
R2794 NCIB.n6 NCIB.t28 0.2605
R2795 NCIB.n6 NCIB.t29 0.2605
R2796 NCIB.n5 NCIB.n4 0.5805
R2797 NCIB.n5 NCIB.n3 0.7705
R2798 NCIB.n4 NCIB.t2 0.1045
R2799 NCIB.n4 NCIB.t3 0.1045
R2800 NCIB.n3 NCIB.t26 0.2605
R2801 NCIB.n3 NCIB.t27 0.2605
R2802 NCIB.n2 NCIB.n1 0.5805
R2803 NCIB.n2 NCIB.n0 0.7705
R2804 NCIB.n1 NCIB.t0 0.1045
R2805 NCIB.n1 NCIB.t1 0.1045
R2806 NCIB.n0 NCIB.t24 0.2605
R2807 NCIB.n0 NCIB.t25 0.2605
R2808 NCIA NCIA.n36 30.1969
R2809 NCIA.n36 NCIA.n2 0.0765
R2810 NCIA.n36 NCIA.n5 0.2285
R2811 NCIA.n5 NCIA.n8 0.3045
R2812 NCIA.n8 NCIA.n11 0.3045
R2813 NCIA.n11 NCIA.n14 0.3045
R2814 NCIA.n14 NCIA.n17 0.3045
R2815 NCIA.n17 NCIA.n20 0.3045
R2816 NCIA.n20 NCIA.n23 0.3045
R2817 NCIA.n23 NCIA.n26 0.3045
R2818 NCIA.n26 NCIA.n29 0.3045
R2819 NCIA.n29 NCIA.n32 0.3045
R2820 NCIA.n32 NCIA.n35 0.3045
R2821 NCIA.n35 NCIA.n34 0.7705
R2822 NCIA.n35 NCIA.n33 0.5805
R2823 NCIA.n34 NCIA.t46 0.2605
R2824 NCIA.n34 NCIA.t47 0.2605
R2825 NCIA.n33 NCIA.t22 0.1045
R2826 NCIA.n33 NCIA.t23 0.1045
R2827 NCIA.n32 NCIA.n31 0.7705
R2828 NCIA.n32 NCIA.n30 0.5805
R2829 NCIA.n31 NCIA.t44 0.2605
R2830 NCIA.n31 NCIA.t45 0.2605
R2831 NCIA.n30 NCIA.t20 0.1045
R2832 NCIA.n30 NCIA.t21 0.1045
R2833 NCIA.n29 NCIA.n28 0.7705
R2834 NCIA.n29 NCIA.n27 0.5805
R2835 NCIA.n28 NCIA.t42 0.2605
R2836 NCIA.n28 NCIA.t43 0.2605
R2837 NCIA.n27 NCIA.t18 0.1045
R2838 NCIA.n27 NCIA.t19 0.1045
R2839 NCIA.n26 NCIA.n25 0.7705
R2840 NCIA.n26 NCIA.n24 0.5805
R2841 NCIA.n25 NCIA.t40 0.2605
R2842 NCIA.n25 NCIA.t41 0.2605
R2843 NCIA.n24 NCIA.t16 0.1045
R2844 NCIA.n24 NCIA.t17 0.1045
R2845 NCIA.n23 NCIA.n22 0.7705
R2846 NCIA.n23 NCIA.n21 0.5805
R2847 NCIA.n22 NCIA.t38 0.2605
R2848 NCIA.n22 NCIA.t39 0.2605
R2849 NCIA.n21 NCIA.t14 0.1045
R2850 NCIA.n21 NCIA.t15 0.1045
R2851 NCIA.n20 NCIA.n19 0.7705
R2852 NCIA.n20 NCIA.n18 0.5805
R2853 NCIA.n19 NCIA.t36 0.2605
R2854 NCIA.n19 NCIA.t37 0.2605
R2855 NCIA.n18 NCIA.t12 0.1045
R2856 NCIA.n18 NCIA.t13 0.1045
R2857 NCIA.n17 NCIA.n16 0.7705
R2858 NCIA.n17 NCIA.n15 0.5805
R2859 NCIA.n16 NCIA.t34 0.2605
R2860 NCIA.n16 NCIA.t35 0.2605
R2861 NCIA.n15 NCIA.t10 0.1045
R2862 NCIA.n15 NCIA.t11 0.1045
R2863 NCIA.n14 NCIA.n13 0.7705
R2864 NCIA.n14 NCIA.n12 0.5805
R2865 NCIA.n13 NCIA.t32 0.2605
R2866 NCIA.n13 NCIA.t33 0.2605
R2867 NCIA.n12 NCIA.t8 0.1045
R2868 NCIA.n12 NCIA.t9 0.1045
R2869 NCIA.n11 NCIA.n10 0.7705
R2870 NCIA.n11 NCIA.n9 0.5805
R2871 NCIA.n10 NCIA.t30 0.2605
R2872 NCIA.n10 NCIA.t31 0.2605
R2873 NCIA.n9 NCIA.t6 0.1045
R2874 NCIA.n9 NCIA.t7 0.1045
R2875 NCIA.n8 NCIA.n7 0.7705
R2876 NCIA.n8 NCIA.n6 0.5805
R2877 NCIA.n7 NCIA.t28 0.2605
R2878 NCIA.n7 NCIA.t29 0.2605
R2879 NCIA.n6 NCIA.t4 0.1045
R2880 NCIA.n6 NCIA.t5 0.1045
R2881 NCIA.n5 NCIA.n4 0.7705
R2882 NCIA.n5 NCIA.n3 0.5805
R2883 NCIA.n4 NCIA.t26 0.2605
R2884 NCIA.n4 NCIA.t27 0.2605
R2885 NCIA.n3 NCIA.t2 0.1045
R2886 NCIA.n3 NCIA.t3 0.1045
R2887 NCIA.n2 NCIA.n1 0.7705
R2888 NCIA.n2 NCIA.n0 0.5805
R2889 NCIA.n1 NCIA.t24 0.2605
R2890 NCIA.n1 NCIA.t25 0.2605
R2891 NCIA.n0 NCIA.t0 0.1045
R2892 NCIA.n0 NCIA.t1 0.1045
R2893 NCDB NCDB.n36 26.7992
R2894 NCDB.n28 NCDB.n29 0.0879
R2895 NCDB.n27 NCDB.n32 0.0688815
R2896 NCDB.n36 NCDB.n27 0.159967
R2897 NCDB.n36 NCDB.n2 0.130833
R2898 NCDB.n2 NCDB.n3 0.0688815
R2899 NCDB.n1 NCDB.n0 0.0879
R2900 NCDB.n29 NCDB.n30 0.08334
R2901 NCDB.n30 NCDB.n31 0.5221
R2902 NCDB.n34 NCDB.n31 0.0618
R2903 NCDB.n30 NCDB.n35 0.4005
R2904 NCDB.n34 NCDB.n27 0.28384
R2905 NCDB.n32 NCDB.n28 0.00699664
R2906 NCDB.n28 NCDB.n35 0.08334
R2907 NCDB.n35 NCDB.n34 0.0476258
R2908 NCDB.n35 NCDB.t14 0.033
R2909 NCDB.n35 NCDB.t15 0.033
R2910 NCDB.n29 NCDB.n33 0.43926
R2911 NCDB.n32 NCDB.n33 0.031104
R2912 NCDB.n33 NCDB.t12 0.033
R2913 NCDB.n33 NCDB.t13 0.033
R2914 NCDB.n31 NCDB.t16 0.033
R2915 NCDB.n31 NCDB.t17 0.033
R2916 NCDB.n2 NCDB.n4 0.08334
R2917 NCDB.n4 NCDB.n5 0.1221
R2918 NCDB.n5 NCDB.n6 0.1221
R2919 NCDB.n13 NCDB.n7 0.2618
R2920 NCDB.n8 NCDB.n9 0.151721
R2921 NCDB.n9 NCDB.n10 0.1221
R2922 NCDB.n10 NCDB.n11 0.1221
R2923 NCDB.n25 NCDB.n7 0.2618
R2924 NCDB.n6 NCDB.n13 0.3226
R2925 NCDB.n14 NCDB.n12 0.2005
R2926 NCDB.n12 NCDB.n26 0.2005
R2927 NCDB.n25 NCDB.n11 0.3226
R2928 NCDB.n0 NCDB.n8 0.00699664
R2929 NCDB.n0 NCDB.n15 0.08334
R2930 NCDB.n15 NCDB.n16 0.1221
R2931 NCDB.n16 NCDB.n24 0.1221
R2932 NCDB.n24 NCDB.n26 0.1221
R2933 NCDB.n26 NCDB.n25 0.0476258
R2934 NCDB.n6 NCDB.n23 0.4005
R2935 NCDB.n23 NCDB.n17 0.2005
R2936 NCDB.n17 NCDB.n24 0.2005
R2937 NCDB.n24 NCDB.n11 0.4005
R2938 NCDB.n3 NCDB.n1 0.00699664
R2939 NCDB.n1 NCDB.n20 0.08334
R2940 NCDB.n20 NCDB.n22 0.1221
R2941 NCDB.n22 NCDB.n23 0.1221
R2942 NCDB.n23 NCDB.n14 0.1221
R2943 NCDB.n14 NCDB.n13 0.0476258
R2944 NCDB.n5 NCDB.n22 0.4005
R2945 NCDB.n22 NCDB.n21 0.2005
R2946 NCDB.n21 NCDB.n16 0.2005
R2947 NCDB.n16 NCDB.n10 0.4005
R2948 NCDB.n21 NCDB.t4 0.0265
R2949 NCDB.n21 NCDB.t5 0.0265
R2950 NCDB.n4 NCDB.n20 0.4005
R2951 NCDB.n20 NCDB.n19 0.2005
R2952 NCDB.n19 NCDB.n15 0.2005
R2953 NCDB.n15 NCDB.n9 0.4005
R2954 NCDB.n19 NCDB.t2 0.0265
R2955 NCDB.n19 NCDB.t3 0.0265
R2956 NCDB.n3 NCDB.n18 0.231104
R2957 NCDB.n18 NCDB.n8 0.231104
R2958 NCDB.n18 NCDB.t0 0.0265
R2959 NCDB.n18 NCDB.t1 0.0265
R2960 NCDB.n17 NCDB.t6 0.0265
R2961 NCDB.n17 NCDB.t7 0.0265
R2962 NCDB.n12 NCDB.t8 0.0265
R2963 NCDB.n12 NCDB.t9 0.0265
R2964 NCDB.n7 NCDB.t10 0.0265
R2965 NCDB.n7 NCDB.t11 0.0265
R2966 NCDA NCDA.n36 23.5992
R2967 NCDA.n28 NCDA.n29 0.0879
R2968 NCDA.n27 NCDA.n32 0.0688815
R2969 NCDA.n36 NCDA.n27 0.159967
R2970 NCDA.n36 NCDA.n2 0.130833
R2971 NCDA.n2 NCDA.n3 0.0688815
R2972 NCDA.n1 NCDA.n0 0.0879
R2973 NCDA.n29 NCDA.n30 0.08334
R2974 NCDA.n30 NCDA.n31 0.5221
R2975 NCDA.n34 NCDA.n31 0.0618
R2976 NCDA.n30 NCDA.n35 0.4005
R2977 NCDA.n34 NCDA.n27 0.28384
R2978 NCDA.n32 NCDA.n28 0.00699664
R2979 NCDA.n28 NCDA.n35 0.08334
R2980 NCDA.n35 NCDA.n34 0.0476258
R2981 NCDA.n35 NCDA.t14 0.033
R2982 NCDA.n35 NCDA.t15 0.033
R2983 NCDA.n29 NCDA.n33 0.43926
R2984 NCDA.n32 NCDA.n33 0.031104
R2985 NCDA.n33 NCDA.t12 0.033
R2986 NCDA.n33 NCDA.t13 0.033
R2987 NCDA.n31 NCDA.t16 0.033
R2988 NCDA.n31 NCDA.t17 0.033
R2989 NCDA.n2 NCDA.n4 0.08334
R2990 NCDA.n4 NCDA.n5 0.1221
R2991 NCDA.n5 NCDA.n6 0.1221
R2992 NCDA.n13 NCDA.n7 0.2618
R2993 NCDA.n8 NCDA.n9 0.151721
R2994 NCDA.n9 NCDA.n10 0.1221
R2995 NCDA.n10 NCDA.n11 0.1221
R2996 NCDA.n25 NCDA.n7 0.2618
R2997 NCDA.n6 NCDA.n13 0.3226
R2998 NCDA.n14 NCDA.n12 0.2005
R2999 NCDA.n12 NCDA.n26 0.2005
R3000 NCDA.n25 NCDA.n11 0.3226
R3001 NCDA.n0 NCDA.n8 0.00699664
R3002 NCDA.n0 NCDA.n15 0.08334
R3003 NCDA.n15 NCDA.n16 0.1221
R3004 NCDA.n16 NCDA.n24 0.1221
R3005 NCDA.n24 NCDA.n26 0.1221
R3006 NCDA.n26 NCDA.n25 0.0476258
R3007 NCDA.n6 NCDA.n23 0.4005
R3008 NCDA.n23 NCDA.n17 0.2005
R3009 NCDA.n17 NCDA.n24 0.2005
R3010 NCDA.n24 NCDA.n11 0.4005
R3011 NCDA.n3 NCDA.n1 0.00699664
R3012 NCDA.n1 NCDA.n20 0.08334
R3013 NCDA.n20 NCDA.n22 0.1221
R3014 NCDA.n22 NCDA.n23 0.1221
R3015 NCDA.n23 NCDA.n14 0.1221
R3016 NCDA.n14 NCDA.n13 0.0476258
R3017 NCDA.n5 NCDA.n22 0.4005
R3018 NCDA.n22 NCDA.n21 0.2005
R3019 NCDA.n21 NCDA.n16 0.2005
R3020 NCDA.n16 NCDA.n10 0.4005
R3021 NCDA.n21 NCDA.t4 0.0265
R3022 NCDA.n21 NCDA.t5 0.0265
R3023 NCDA.n4 NCDA.n20 0.4005
R3024 NCDA.n20 NCDA.n19 0.2005
R3025 NCDA.n19 NCDA.n15 0.2005
R3026 NCDA.n15 NCDA.n9 0.4005
R3027 NCDA.n19 NCDA.t2 0.0265
R3028 NCDA.n19 NCDA.t3 0.0265
R3029 NCDA.n3 NCDA.n18 0.231104
R3030 NCDA.n18 NCDA.n8 0.231104
R3031 NCDA.n18 NCDA.t0 0.0265
R3032 NCDA.n18 NCDA.t1 0.0265
R3033 NCDA.n17 NCDA.t6 0.0265
R3034 NCDA.n17 NCDA.t7 0.0265
R3035 NCDA.n12 NCDA.t8 0.0265
R3036 NCDA.n12 NCDA.t9 0.0265
R3037 NCDA.n7 NCDA.t10 0.0265
R3038 NCDA.n7 NCDA.t11 0.0265
R3039 CIB.n5 CIB.n2 0.3045
R3040 CIB.n8 CIB.n5 0.3045
R3041 CIB.n11 CIB.n8 0.3045
R3042 CIB.n14 CIB.n11 0.3045
R3043 CIB.n17 CIB.n14 0.3045
R3044 CIB CIB.n17 19.1329
R3045 CIB.n17 CIB.n16 0.5805
R3046 CIB.n17 CIB.n15 0.7705
R3047 CIB.n16 CIB.t10 0.1045
R3048 CIB.n16 CIB.t11 0.1045
R3049 CIB.n15 CIB.t22 0.2605
R3050 CIB.n15 CIB.t23 0.2605
R3051 CIB.n14 CIB.n13 0.5805
R3052 CIB.n14 CIB.n12 0.7705
R3053 CIB.n13 CIB.t8 0.1045
R3054 CIB.n13 CIB.t9 0.1045
R3055 CIB.n12 CIB.t20 0.2605
R3056 CIB.n12 CIB.t21 0.2605
R3057 CIB.n11 CIB.n10 0.5805
R3058 CIB.n11 CIB.n9 0.7705
R3059 CIB.n10 CIB.t6 0.1045
R3060 CIB.n10 CIB.t7 0.1045
R3061 CIB.n9 CIB.t18 0.2605
R3062 CIB.n9 CIB.t19 0.2605
R3063 CIB.n8 CIB.n7 0.5805
R3064 CIB.n8 CIB.n6 0.7705
R3065 CIB.n7 CIB.t4 0.1045
R3066 CIB.n7 CIB.t5 0.1045
R3067 CIB.n6 CIB.t16 0.2605
R3068 CIB.n6 CIB.t17 0.2605
R3069 CIB.n5 CIB.n4 0.5805
R3070 CIB.n5 CIB.n3 0.7705
R3071 CIB.n4 CIB.t2 0.1045
R3072 CIB.n4 CIB.t3 0.1045
R3073 CIB.n3 CIB.t14 0.2605
R3074 CIB.n3 CIB.t15 0.2605
R3075 CIB.n2 CIB.n1 0.5805
R3076 CIB.n2 CIB.n0 0.7705
R3077 CIB.n1 CIB.t0 0.1045
R3078 CIB.n1 CIB.t1 0.1045
R3079 CIB.n0 CIB.t12 0.2605
R3080 CIB.n0 CIB.t13 0.2605
R3081 CIA CIA.n18 28.2769
R3082 CIA.n18 CIA.n2 0.0765
R3083 CIA.n18 CIA.n5 0.2285
R3084 CIA.n5 CIA.n8 0.3045
R3085 CIA.n8 CIA.n11 0.3045
R3086 CIA.n11 CIA.n14 0.3045
R3087 CIA.n14 CIA.n17 0.3045
R3088 CIA.n17 CIA.n16 0.7705
R3089 CIA.n17 CIA.n15 0.5805
R3090 CIA.n16 CIA.t22 0.2605
R3091 CIA.n16 CIA.t23 0.2605
R3092 CIA.n15 CIA.t10 0.1045
R3093 CIA.n15 CIA.t11 0.1045
R3094 CIA.n14 CIA.n13 0.7705
R3095 CIA.n14 CIA.n12 0.5805
R3096 CIA.n13 CIA.t20 0.2605
R3097 CIA.n13 CIA.t21 0.2605
R3098 CIA.n12 CIA.t8 0.1045
R3099 CIA.n12 CIA.t9 0.1045
R3100 CIA.n11 CIA.n10 0.7705
R3101 CIA.n11 CIA.n9 0.5805
R3102 CIA.n10 CIA.t18 0.2605
R3103 CIA.n10 CIA.t19 0.2605
R3104 CIA.n9 CIA.t6 0.1045
R3105 CIA.n9 CIA.t7 0.1045
R3106 CIA.n8 CIA.n7 0.7705
R3107 CIA.n8 CIA.n6 0.5805
R3108 CIA.n7 CIA.t16 0.2605
R3109 CIA.n7 CIA.t17 0.2605
R3110 CIA.n6 CIA.t4 0.1045
R3111 CIA.n6 CIA.t5 0.1045
R3112 CIA.n5 CIA.n4 0.7705
R3113 CIA.n5 CIA.n3 0.5805
R3114 CIA.n4 CIA.t14 0.2605
R3115 CIA.n4 CIA.t15 0.2605
R3116 CIA.n3 CIA.t2 0.1045
R3117 CIA.n3 CIA.t3 0.1045
R3118 CIA.n2 CIA.n1 0.7705
R3119 CIA.n2 CIA.n0 0.5805
R3120 CIA.n1 CIA.t12 0.2605
R3121 CIA.n1 CIA.t13 0.2605
R3122 CIA.n0 CIA.t0 0.1045
R3123 CIA.n0 CIA.t1 0.1045
R3124 CHOP1 CHOP1.t1 22.0266
R3125 CHOP1.t1 CHOP1.t0 24.1076
R3126 CDB CDB.n36 11.5369
R3127 CDB.n5 CDB.n2 0.3045
R3128 CDB.n36 CDB.n5 0.2285
R3129 CDB.n36 CDB.n8 0.0765
R3130 CDB.n8 CDB.n11 0.3045
R3131 CDB.n11 CDB.n14 0.3045
R3132 CDB.n14 CDB.n17 0.3045
R3133 CDB.n17 CDB.n20 0.3045
R3134 CDB.n20 CDB.n23 0.3045
R3135 CDB.n23 CDB.n26 0.3045
R3136 CDB.n26 CDB.n29 0.3045
R3137 CDB.n29 CDB.n32 0.3045
R3138 CDB.n32 CDB.n35 0.3045
R3139 CDB.n35 CDB.n34 0.5805
R3140 CDB.n35 CDB.n33 0.7705
R3141 CDB.n34 CDB.t22 0.1045
R3142 CDB.n34 CDB.t23 0.1045
R3143 CDB.n33 CDB.t46 0.2605
R3144 CDB.n33 CDB.t47 0.2605
R3145 CDB.n32 CDB.n31 0.5805
R3146 CDB.n32 CDB.n30 0.7705
R3147 CDB.n31 CDB.t20 0.1045
R3148 CDB.n31 CDB.t21 0.1045
R3149 CDB.n30 CDB.t44 0.2605
R3150 CDB.n30 CDB.t45 0.2605
R3151 CDB.n29 CDB.n28 0.5805
R3152 CDB.n29 CDB.n27 0.7705
R3153 CDB.n28 CDB.t18 0.1045
R3154 CDB.n28 CDB.t19 0.1045
R3155 CDB.n27 CDB.t42 0.2605
R3156 CDB.n27 CDB.t43 0.2605
R3157 CDB.n26 CDB.n25 0.5805
R3158 CDB.n26 CDB.n24 0.7705
R3159 CDB.n25 CDB.t16 0.1045
R3160 CDB.n25 CDB.t17 0.1045
R3161 CDB.n24 CDB.t40 0.2605
R3162 CDB.n24 CDB.t41 0.2605
R3163 CDB.n23 CDB.n22 0.5805
R3164 CDB.n23 CDB.n21 0.7705
R3165 CDB.n22 CDB.t14 0.1045
R3166 CDB.n22 CDB.t15 0.1045
R3167 CDB.n21 CDB.t38 0.2605
R3168 CDB.n21 CDB.t39 0.2605
R3169 CDB.n20 CDB.n19 0.5805
R3170 CDB.n20 CDB.n18 0.7705
R3171 CDB.n19 CDB.t12 0.1045
R3172 CDB.n19 CDB.t13 0.1045
R3173 CDB.n18 CDB.t36 0.2605
R3174 CDB.n18 CDB.t37 0.2605
R3175 CDB.n17 CDB.n16 0.5805
R3176 CDB.n17 CDB.n15 0.7705
R3177 CDB.n16 CDB.t10 0.1045
R3178 CDB.n16 CDB.t11 0.1045
R3179 CDB.n15 CDB.t34 0.2605
R3180 CDB.n15 CDB.t35 0.2605
R3181 CDB.n14 CDB.n13 0.5805
R3182 CDB.n14 CDB.n12 0.7705
R3183 CDB.n13 CDB.t8 0.1045
R3184 CDB.n13 CDB.t9 0.1045
R3185 CDB.n12 CDB.t32 0.2605
R3186 CDB.n12 CDB.t33 0.2605
R3187 CDB.n11 CDB.n10 0.5805
R3188 CDB.n11 CDB.n9 0.7705
R3189 CDB.n10 CDB.t6 0.1045
R3190 CDB.n10 CDB.t7 0.1045
R3191 CDB.n9 CDB.t30 0.2605
R3192 CDB.n9 CDB.t31 0.2605
R3193 CDB.n8 CDB.n7 0.5805
R3194 CDB.n8 CDB.n6 0.7705
R3195 CDB.n7 CDB.t4 0.1045
R3196 CDB.n7 CDB.t5 0.1045
R3197 CDB.n6 CDB.t28 0.2605
R3198 CDB.n6 CDB.t29 0.2605
R3199 CDB.n5 CDB.n4 0.5805
R3200 CDB.n5 CDB.n3 0.7705
R3201 CDB.n4 CDB.t2 0.1045
R3202 CDB.n4 CDB.t3 0.1045
R3203 CDB.n3 CDB.t26 0.2605
R3204 CDB.n3 CDB.t27 0.2605
R3205 CDB.n2 CDB.n1 0.5805
R3206 CDB.n2 CDB.n0 0.7705
R3207 CDB.n1 CDB.t0 0.1045
R3208 CDB.n1 CDB.t1 0.1045
R3209 CDB.n0 CDB.t24 0.2605
R3210 CDB.n0 CDB.t25 0.2605
R3211 CDA.n5 CDA.n2 0.3045
R3212 CDA.n8 CDA.n5 0.3045
R3213 CDA.n11 CDA.n8 0.3045
R3214 CDA.n14 CDA.n11 0.3045
R3215 CDA.n17 CDA.n14 0.3045
R3216 CDA.n20 CDA.n17 0.3045
R3217 CDA.n23 CDA.n20 0.3045
R3218 CDA.n26 CDA.n23 0.3045
R3219 CDA.n29 CDA.n26 0.3045
R3220 CDA.n32 CDA.n29 0.3045
R3221 CDA.n35 CDA.n32 0.3045
R3222 CDA CDA.n35 11.9529
R3223 CDA.n35 CDA.n34 0.5805
R3224 CDA.n35 CDA.n33 0.7705
R3225 CDA.n34 CDA.t22 0.1045
R3226 CDA.n34 CDA.t23 0.1045
R3227 CDA.n33 CDA.t46 0.2605
R3228 CDA.n33 CDA.t47 0.2605
R3229 CDA.n32 CDA.n31 0.5805
R3230 CDA.n32 CDA.n30 0.7705
R3231 CDA.n31 CDA.t20 0.1045
R3232 CDA.n31 CDA.t21 0.1045
R3233 CDA.n30 CDA.t44 0.2605
R3234 CDA.n30 CDA.t45 0.2605
R3235 CDA.n29 CDA.n28 0.5805
R3236 CDA.n29 CDA.n27 0.7705
R3237 CDA.n28 CDA.t18 0.1045
R3238 CDA.n28 CDA.t19 0.1045
R3239 CDA.n27 CDA.t42 0.2605
R3240 CDA.n27 CDA.t43 0.2605
R3241 CDA.n26 CDA.n25 0.5805
R3242 CDA.n26 CDA.n24 0.7705
R3243 CDA.n25 CDA.t16 0.1045
R3244 CDA.n25 CDA.t17 0.1045
R3245 CDA.n24 CDA.t40 0.2605
R3246 CDA.n24 CDA.t41 0.2605
R3247 CDA.n23 CDA.n22 0.5805
R3248 CDA.n23 CDA.n21 0.7705
R3249 CDA.n22 CDA.t14 0.1045
R3250 CDA.n22 CDA.t15 0.1045
R3251 CDA.n21 CDA.t38 0.2605
R3252 CDA.n21 CDA.t39 0.2605
R3253 CDA.n20 CDA.n19 0.5805
R3254 CDA.n20 CDA.n18 0.7705
R3255 CDA.n19 CDA.t12 0.1045
R3256 CDA.n19 CDA.t13 0.1045
R3257 CDA.n18 CDA.t36 0.2605
R3258 CDA.n18 CDA.t37 0.2605
R3259 CDA.n17 CDA.n16 0.5805
R3260 CDA.n17 CDA.n15 0.7705
R3261 CDA.n16 CDA.t10 0.1045
R3262 CDA.n16 CDA.t11 0.1045
R3263 CDA.n15 CDA.t34 0.2605
R3264 CDA.n15 CDA.t35 0.2605
R3265 CDA.n14 CDA.n13 0.5805
R3266 CDA.n14 CDA.n12 0.7705
R3267 CDA.n13 CDA.t8 0.1045
R3268 CDA.n13 CDA.t9 0.1045
R3269 CDA.n12 CDA.t32 0.2605
R3270 CDA.n12 CDA.t33 0.2605
R3271 CDA.n11 CDA.n10 0.5805
R3272 CDA.n11 CDA.n9 0.7705
R3273 CDA.n10 CDA.t6 0.1045
R3274 CDA.n10 CDA.t7 0.1045
R3275 CDA.n9 CDA.t30 0.2605
R3276 CDA.n9 CDA.t31 0.2605
R3277 CDA.n8 CDA.n7 0.5805
R3278 CDA.n8 CDA.n6 0.7705
R3279 CDA.n7 CDA.t4 0.1045
R3280 CDA.n7 CDA.t5 0.1045
R3281 CDA.n6 CDA.t28 0.2605
R3282 CDA.n6 CDA.t29 0.2605
R3283 CDA.n5 CDA.n4 0.5805
R3284 CDA.n5 CDA.n3 0.7705
R3285 CDA.n4 CDA.t2 0.1045
R3286 CDA.n4 CDA.t3 0.1045
R3287 CDA.n3 CDA.t26 0.2605
R3288 CDA.n3 CDA.t27 0.2605
R3289 CDA.n2 CDA.n1 0.5805
R3290 CDA.n2 CDA.n0 0.7705
R3291 CDA.n1 CDA.t0 0.1045
R3292 CDA.n1 CDA.t1 0.1045
R3293 CDA.n0 CDA.t24 0.2605
R3294 CDA.n0 CDA.t25 0.2605
C0 a_972_8460.n9 a_972_4188.n6 0.00647f
C1 a_972_8460.n9 a_9196_340.n1 0.00828f
C2 a_972_8460.n9 a_7916_340.n2 0.00234f
C3 a_972_8460.n9 a_5676_4320.n10 0.03614f
C4 a_972_8460.n9 a_5036_4320.n8 0.01307f
C5 a_972_8460.n9 a_4556_4320.n1 0.00452f
C6 a_972_8460.n9 a_4492_4188.n0 0.0014f
C7 a_972_8460.n9 a_27276_4320.n1 0.48128f
C8 a_972_8460.n9 a_21516_4320.n10 0.04662f
C9 a_972_8460.n9 a_20876_4320.n8 0.01091f
C10 a_972_8460.n9 a_18316_4320.n10 0.01208f
C11 a_972_8460.n9 a_17836_4320.n1 0.00376f
C12 a_972_8460.n9 a_1292_12000.n13 0.0869f
C13 a_972_8460.n9 a_12076_4320.n10 0.03311f
C14 a_972_8460.n9 a_11436_4320.n8 0.01082f
C15 a_972_8460.n9 a_1036_6700.n28 2.19883f
C16 a_972_8460.n9 a_1036_4320.n7 0.01997f
C17 a_972_8460.n9 VDD 4.75726f
C18 a_972_8460.n9 CIB 0.27522f
C19 a_972_8460.n9 NCIB 0.09889f
C20 a_972_8460.n9 CDA 0.09773f
C21 a_972_8460.n9 CDB 0.10607f
C22 a_972_8460.n9 CHOP1 1.11682f
C23 a_972_8460.n9 CIA 0.07936f
C24 a_972_8460.n9 NCIA 0.74643f
C25 a_972_4188.n6 a_9196_340.n1 0.02133f
C26 a_972_4188.n6 a_8556_340.t0 0.00403f
C27 a_972_4188.n6 a_8556_1540.n0 0.02858f
C28 a_972_4188.n6 a_7916_340.n2 3.61807f
C29 a_972_4188.n6 a_4492_4188.n0 2.58511f
C30 a_972_4188.n6 a_21516_340.n10 1.29273f
C31 a_972_4188.n6 a_20876_340.n8 0.63415f
C32 a_972_4188.n6 a_20396_340.n1 0.1255f
C33 a_972_4188.n6 a_16876_340.n7 0.33693f
C34 a_972_4188.n6 a_16236_340.n6 0.62445f
C35 a_972_4188.n6 a_1516_340.t10 0.79186f
C36 a_972_4188.n6 a_15116_340.n1 0.04261f
C37 a_972_4188.n6 a_14476_340.t0 0.00403f
C38 a_972_4188.n6 a_14476_1540.n0 0.05511f
C39 a_972_4188.n6 a_11116_340.t2 0.09267f
C40 a_972_4188.n6 a_1036_6700.n28 0
C41 a_972_4188.n6 a_1036_4320.n7 1.12863f
C42 a_972_4188.n6 a_1036_340.n1 0.0764f
C43 a_972_4188.n6 a_6820_1540# 0.05997f
C44 a_972_4188.n6 a_13380_1540# 0.06078f
C45 a_972_4188.n6 a_2500_1540# 1.47659f
C46 a_972_4188.n6 a_3940_1540# 1.44835f
C47 a_972_4188.n6 a_5380_1540# 1.45137f
C48 a_972_4188.n6 a_10020_1540# 0.03648f
C49 a_972_4188.n6 a_11940_1540# 1.45453f
C50 a_972_4188.n6 VDD 3.3062f
C51 a_972_4188.n6 CIB 0.00527f
C52 a_972_4188.n6 CHOP1 0.27316f
C53 a_972_4188.n6 CIA 0.17426f
C54 a_972_4188.n6 NCIA 0.40725f
C55 a_9196_340.n1 a_8556_1540.n0 0.46523f
C56 a_9196_340.n1 a_7916_340.n2 6.63292f
C57 a_9196_340.n1 a_7916_1540.t0 0
C58 a_9196_340.n1 a_5676_4320.n10 0.02447f
C59 a_9196_340.n1 a_4492_4188.n0 0.65866f
C60 a_9196_340.n1 a_27276_4320.n1 0.22909f
C61 a_9196_340.n1 a_21516_4320.n10 0.3636f
C62 a_9196_340.n1 a_20876_4320.n8 0.50219f
C63 a_9196_340.n1 a_18316_4320.n10 0.18117f
C64 a_9196_340.n1 a_17836_4320.n1 0.07976f
C65 a_9196_340.n1 a_1516_340.t10 0.19518f
C66 a_9196_340.n1 a_1292_12000.n13 0.04487f
C67 a_9196_340.n1 a_12076_4320.n10 0.06661f
C68 a_9196_340.n1 a_11436_4320.n8 0.02966f
C69 a_9196_340.n1 a_11116_340.t2 0.00753f
C70 a_9196_340.n1 a_6820_1540# 0
C71 a_9196_340.n1 a_13380_1540# 0
C72 a_9196_340.n1 a_10020_1540# 0.65985f
C73 a_9196_340.n1 a_11940_1540# 0
C74 a_9196_340.n1 VDD 4.32938f
C75 a_9196_340.n1 NCIB 0.04103f
C76 a_9196_340.n1 CDA 0
C77 a_9196_340.n1 CDB 0.09354f
C78 a_9196_340.n1 CIA 2.45585f
C79 a_9196_340.n1 NCIA 0.2196f
C80 a_8556_340.t0 a_8556_1540.n0 0.19083f
C81 a_8556_340.t0 a_7916_340.n2 0
C82 a_8556_340.t0 a_1516_340.t10 0.01883f
C83 a_8556_340.t0 a_6820_1540# 0.01937f
C84 a_8556_340.t0 a_5380_1540# 0.00101f
C85 a_8556_1540.n0 a_7916_340.n2 0.15518f
C86 a_8556_1540.n0 a_7916_1540.t0 0.00376f
C87 a_8556_1540.n0 a_4492_4188.n0 0.17003f
C88 a_8556_1540.n0 a_1516_340.t10 0.32965f
C89 a_8556_1540.n0 a_6820_1540# 0.11466f
C90 a_8556_1540.n0 a_5380_1540# 0.00341f
C91 a_8556_1540.n0 a_10020_1540# 0.00695f
C92 a_8556_1540.n0 VDD 1.24065f
C93 a_8556_1540.n0 CIA 0
C94 a_7916_340.n2 a_7916_1540.t0 0.48595f
C95 a_7916_340.n2 a_5676_4320.n10 0.04039f
C96 a_7916_340.n2 a_4492_4188.n0 3.66898f
C97 a_7916_340.n2 a_18316_4320.n10 0
C98 a_7916_340.n2 a_17836_4320.n1 0.23049f
C99 a_7916_340.n2 a_1516_340.t10 0.12668f
C100 a_7916_340.n2 a_12076_4320.n10 0.44449f
C101 a_7916_340.n2 a_11436_4320.n8 0.55225f
C102 a_7916_340.n2 a_11116_340.t2 0.52609f
C103 a_7916_340.n2 a_6820_1540# 0.26672f
C104 a_7916_340.n2 a_13380_1540# 0
C105 a_7916_340.n2 a_5380_1540# 0.03141f
C106 a_7916_340.n2 a_10020_1540# 0.14244f
C107 a_7916_340.n2 a_11940_1540# 0.10577f
C108 a_7916_340.n2 VDD 2.46242f
C109 a_7916_340.n2 CIB 0.02362f
C110 a_7916_340.n2 NCIB 0.11091f
C111 a_7916_340.n2 CDA 0.13749f
C112 a_7916_340.n2 CIA 0.07456f
C113 a_7916_340.n2 NCIA 0.14609f
C114 a_7916_1540.t0 a_4492_4188.n0 0.00746f
C115 a_7916_1540.t0 a_1516_340.t10 0.06985f
C116 a_7916_1540.t0 a_6820_1540# 0.06579f
C117 a_7916_1540.t0 a_5380_1540# 0.0034f
C118 a_7916_1540.t0 VDD 0.52498f
C119 a_5676_4320.n10 a_5036_4320.n8 1.67895f
C120 a_5676_4320.n10 a_4556_4320.n1 0.00648f
C121 a_5676_4320.n10 a_1516_340.t10 0
C122 a_5676_4320.n10 a_11436_4320.n8 0.01132f
C123 a_5676_4320.n10 a_6820_1540# 0.00381f
C124 a_5676_4320.n10 VDD 9.82685f
C125 a_5676_4320.n10 CIB 0.58155f
C126 a_5676_4320.n10 NCIB 4.40228f
C127 a_5676_4320.n10 CIA 0.26245f
C128 a_5676_4320.n10 NCIA 0.12059f
C129 a_5036_4320.n8 a_4556_4320.n1 0.49514f
C130 a_5036_4320.n8 a_4492_4188.n0 0
C131 a_5036_4320.n8 a_1036_4320.n7 0
C132 a_5036_4320.n8 VDD 3.22055f
C133 a_5036_4320.n8 CIB 0.2605f
C134 a_5036_4320.n8 NCIB 0.00527f
C135 a_5036_4320.n8 CIA 0.82529f
C136 a_4556_4320.n1 a_4492_4188.n0 0.22027f
C137 a_4556_4320.n1 a_1036_4320.n7 0.02115f
C138 a_4556_4320.n1 VDD 1.31482f
C139 a_4556_4320.n1 CIB 0.20887f
C140 a_4556_4320.n1 CIA 0.12718f
C141 a_4492_4188.n0 a_21516_340.n10 0.43958f
C142 a_4492_4188.n0 a_20876_340.n8 0.20263f
C143 a_4492_4188.n0 a_20396_340.n1 0.63508f
C144 a_4492_4188.n0 a_16876_340.n7 0.42026f
C145 a_4492_4188.n0 a_16236_340.n6 0.32572f
C146 a_4492_4188.n0 a_1516_340.t10 0.40399f
C147 a_4492_4188.n0 a_15116_340.n1 0.43774f
C148 a_4492_4188.n0 a_15116_1540.t0 0.00399f
C149 a_4492_4188.n0 a_14476_1540.n0 1.74251f
C150 a_4492_4188.n0 a_11116_340.t2 3.68997f
C151 a_4492_4188.n0 a_1036_4320.n7 0.0396f
C152 a_4492_4188.n0 a_6820_1540# 0.11621f
C153 a_4492_4188.n0 a_13380_1540# 0.09247f
C154 a_4492_4188.n0 a_2500_1540# 0.19916f
C155 a_4492_4188.n0 a_3940_1540# 0.90213f
C156 a_4492_4188.n0 a_5380_1540# 1.50223f
C157 a_4492_4188.n0 a_10020_1540# 0.09547f
C158 a_4492_4188.n0 a_11940_1540# 1.46606f
C159 a_4492_4188.n0 VDD 3.9204f
C160 a_4492_4188.n0 CIB 0.01259f
C161 a_4492_4188.n0 CIA 0.16858f
C162 a_4492_4188.n0 NCIA 0.23677f
C163 a_27276_4320.n1 a_21516_4320.n10 0.02136f
C164 a_27276_4320.n1 VDD 1.35183f
C165 a_27276_4320.n1 CDB 0.09552f
C166 a_21516_4320.n10 a_20876_4320.n8 1.68436f
C167 a_21516_4320.n10 VDD 9.77073f
C168 a_21516_4320.n10 CDB 4.42539f
C169 a_21516_4320.n10 NCIA 1.05337f
C170 a_21516_340.n10 a_20876_340.n8 1.67858f
C171 a_21516_340.n10 a_20396_340.n1 0.00648f
C172 a_21516_340.n10 VDD 9.73719f
C173 a_21516_340.n10 NCIA 5.09588f
C174 a_20876_4320.n8 a_18316_4320.n10 0.01144f
C175 a_20876_4320.n8 a_1292_12000.n13 0.09443f
C176 a_20876_4320.n8 VDD 3.2893f
C177 a_20876_4320.n8 CDB 0.00923f
C178 a_20876_4320.n8 NCIA 0.19016f
C179 a_20876_340.n8 a_20396_340.n1 0.57581f
C180 a_20876_340.n8 a_16876_340.n7 0
C181 a_20876_340.n8 a_14476_1540.n0 0.00117f
C182 a_20876_340.n8 VDD 3.24741f
C183 a_20876_340.n8 CIA 0.00149f
C184 a_20876_340.n8 NCIA 0.00527f
C185 a_20396_340.n1 a_16876_340.n7 0.02132f
C186 a_20396_340.n1 a_14476_1540.n0 0.21345f
C187 a_20396_340.n1 VDD 1.27979f
C188 a_20396_340.n1 CIA 0.09554f
C189 a_18316_4320.n10 a_17836_4320.n1 0.57749f
C190 a_18316_4320.n10 a_1292_12000.n13 1.98413f
C191 a_18316_4320.n10 VDD 3.8694f
C192 a_18316_4320.n10 CDA 0.01869f
C193 a_18316_4320.n10 NCIA 0.20324f
C194 a_17836_4320.n1 a_1292_12000.n13 0.00997f
C195 a_17836_4320.n1 a_12076_4320.n10 0.02115f
C196 a_17836_4320.n1 VDD 1.30148f
C197 a_17836_4320.n1 CDA 0.19119f
C198 a_17836_4320.n1 CIA 0.01689f
C199 a_17836_4320.n1 NCIA 0.08404f
C200 a_16876_340.n7 a_16236_340.n6 1.35002f
C201 a_16876_340.n7 a_15116_340.n1 0
C202 a_16876_340.n7 a_14476_1540.n0 0.19101f
C203 a_16876_340.n7 VDD 5.58498f
C204 a_16876_340.n7 CIA 2.78737f
C205 a_16236_340.n6 a_15116_340.n1 0.0046f
C206 a_16236_340.n6 a_14476_1540.n0 0.52694f
C207 a_16236_340.n6 a_11116_340.t2 0
C208 a_16236_340.n6 VDD 2.64714f
C209 a_16236_340.n6 CIA 0.00777f
C210 a_1516_340.t10 a_11116_340.t2 0.043f
C211 a_1516_340.t10 a_1036_340.n1 0.73136f
C212 a_1516_340.t10 a_6820_1540# 1.42473f
C213 a_1516_340.t10 a_2500_1540# 0.75252f
C214 a_1516_340.t10 a_3940_1540# 0.08038f
C215 a_1516_340.t10 a_5380_1540# 0.04724f
C216 a_1516_340.t10 a_10020_1540# 0.60249f
C217 a_1516_340.t10 a_11940_1540# 0
C218 a_1516_340.t10 VDD 4.98459f
C219 a_1516_340.t10 NCIB 0
C220 a_1516_340.t10 CHOP1 0.34117f
C221 a_1516_340.t10 CIA 0.15187f
C222 a_15116_340.n1 a_15116_1540.t0 0.51004f
C223 a_15116_340.n1 a_14476_1540.n0 0.44883f
C224 a_15116_340.n1 a_11116_340.t2 0.2705f
C225 a_15116_340.n1 a_13380_1540# 0.27166f
C226 a_15116_340.n1 a_11940_1540# 0.00238f
C227 a_15116_340.n1 VDD 0.81698f
C228 a_15116_340.n1 CIA 0.0207f
C229 a_15116_1540.t0 a_14476_1540.n0 0.01107f
C230 a_15116_1540.t0 a_11116_340.t2 0.07456f
C231 a_15116_1540.t0 a_13380_1540# 0.065f
C232 a_15116_1540.t0 a_11940_1540# 0
C233 a_15116_1540.t0 VDD 0.52654f
C234 a_15116_1540.t0 CIA 0
C235 a_14476_340.t0 a_14476_1540.n0 0.19036f
C236 a_14476_340.t0 a_11116_340.t2 0.01953f
C237 a_14476_340.t0 a_13380_1540# 0.01892f
C238 a_14476_340.t0 a_11940_1540# 0.00408f
C239 a_14476_1540.n0 a_11116_340.t2 0.80433f
C240 a_14476_1540.n0 a_13380_1540# 0.26596f
C241 a_14476_1540.n0 a_11940_1540# 0.03733f
C242 a_14476_1540.n0 VDD 2.49896f
C243 a_14476_1540.n0 CIA 0.16778f
C244 a_1292_12000.n13 a_1036_6700.n28 0.26162f
C245 a_1292_12000.n13 VDD 6.63177f
C246 a_1292_12000.n13 NCDA 4.05397f
C247 a_1292_12000.n13 NCDB 3.32569f
C248 a_1292_12000.n13 CIB 0.07559f
C249 a_1292_12000.n13 NCIB 0.07559f
C250 a_1292_12000.n13 CDA 0.07761f
C251 a_1292_12000.n13 CHOP1 0.33213f
C252 a_1292_12000.n13 CIA 0.07506f
C253 a_1292_12000.n13 NCIA 0.26677f
C254 a_12076_4320.n10 a_11436_4320.n8 1.67794f
C255 a_12076_4320.n10 a_11116_340.t2 0
C256 a_12076_4320.n10 a_13380_1540# 0
C257 a_12076_4320.n10 VDD 9.81052f
C258 a_12076_4320.n10 CIB 0.01598f
C259 a_12076_4320.n10 NCIB 1.23516f
C260 a_12076_4320.n10 CDA 4.42416f
C261 a_12076_4320.n10 CIA 0.04169f
C262 a_12076_4320.n10 NCIA 0.21231f
C263 a_11436_4320.n8 VDD 3.28377f
C264 a_11436_4320.n8 CIB 0.07454f
C265 a_11436_4320.n8 NCIB 0.71857f
C266 a_11436_4320.n8 CDA 0.00527f
C267 a_11436_4320.n8 CIA 0.01381f
C268 a_11436_4320.n8 NCIA 0.051f
C269 a_11116_340.t2 a_13380_1540# 1.13024f
C270 a_11116_340.t2 a_10020_1540# 0.27287f
C271 a_11116_340.t2 a_11940_1540# 0.76908f
C272 a_11116_340.t2 VDD 2.70249f
C273 a_11116_340.t2 CDA 0
C274 a_11116_340.t2 CIA 0
C275 a_1036_6700.n28 a_1036_4320.n7 0
C276 a_1036_6700.n28 VDD 6.80237f
C277 a_1036_6700.n28 NCDA 0.00705f
C278 a_1036_6700.n28 NCDB 4.24829f
C279 a_1036_6700.n28 CHOP1 0.32789f
C280 a_1036_6700.n28 CIA 0.39864f
C281 a_1036_4320.n7 VDD 5.65624f
C282 a_1036_4320.n7 CIB 2.21564f
C283 a_1036_4320.n7 CHOP1 0.66793f
C284 a_1036_4320.n7 CIA 0.00207f
C285 a_1036_340.n1 a_2500_1540# 0.00408f
C286 a_1036_340.n1 VDD 1.24997f
C287 a_1036_340.n1 CHOP1 0.36142f
C288 a_6820_1540# a_3940_1540# 0.01579f
C289 a_6820_1540# a_5380_1540# 0.76098f
C290 a_6820_1540# VDD 1.2884f
C291 a_6820_1540# NCIB 0
C292 a_6820_1540# CIA 0.08602f
C293 a_13380_1540# a_11940_1540# 0.76977f
C294 a_13380_1540# VDD 1.24574f
C295 a_13380_1540# CDA 0
C296 a_13380_1540# CIA 0.07619f
C297 a_2500_1540# a_3940_1540# 0.74239f
C298 a_2500_1540# a_5380_1540# 0.01569f
C299 a_2500_1540# VDD 1.29034f
C300 a_2500_1540# CHOP1 0.00465f
C301 a_3940_1540# a_5380_1540# 0.76655f
C302 a_3940_1540# VDD 1.27829f
C303 a_5380_1540# VDD 1.2102f
C304 a_10020_1540# a_11940_1540# 0.00197f
C305 a_10020_1540# VDD 0.67467f
C306 a_10020_1540# CIA 0
C307 a_11940_1540# VDD 1.22801f
C308 VDD NCDA 14.4436f
C309 VDD NCDB 14.2551f
C310 VDD CIB 4.33377f
C311 VDD NCIB 7.66902f
C312 VDD CDA 7.62881f
C313 VDD CDB 7.6047f
C314 VDD CHOP1 1.98207f
C315 VDD CIA 7.35031f
C316 VDD NCIA 8.58049f
C317 NCDA NCDB 0.11927f
C318 NCDA CIB 0.07111f
C319 NCDA NCIB 0.07111f
C320 NCDA CDA 0.07111f
C321 NCDA CHOP1 1.54004f
C322 NCDA CIA 0.07111f
C323 NCDA NCIA 0.07111f
C324 NCDB CIB 0.07559f
C325 NCDB NCIB 0.07559f
C326 NCDB CDA 0.07559f
C327 NCDB CDB 0.07939f
C328 NCDB CIA 0.95077f
C329 NCDB NCIA 0.07559f
C330 CIB NCIB 0.9961f
C331 CIB CHOP1 0.20032f
C332 CIB CIA 0.25537f
C333 CIB NCIA 3.17728f
C334 NCIB CDA 0.16736f
C335 NCIB CIA 0.05701f
C336 NCIB NCIA 1.20008f
C337 CDA CIA 0
C338 CDA NCIA 0.39562f
C339 CDB NCIA 0.22103f
C340 NCIA VSS 2.26493f
C341 CIA VSS 1.764f
C342 CHOP1 VSS 1.76552f
C343 CDB VSS 0.98707f
C344 CDA VSS 1.02752f
C345 NCIB VSS 1.2428f
C346 CIB VSS 1.66687f
C347 NCDB VSS 1.5575f
C348 NCDA VSS 1.4501f
C349 VDD VSS 2.072f
C350 a_11940_1540# VSS 3.51407f
C351 a_10020_1540# VSS 1.42703f
C352 a_5380_1540# VSS 3.51605f
C353 a_3940_1540# VSS 3.5114f
C354 a_2500_1540# VSS 3.54304f
C355 a_13380_1540# VSS 1.83809f
C356 a_6820_1540# VSS 1.84198f
C357 CDA.t24 VSS 0.01182f
C358 CDA.t25 VSS 0.01182f
C359 CDA.n0 VSS 0.10539f
C360 CDA.t0 VSS 0.02956f
C361 CDA.t1 VSS 0.02956f
C362 CDA.n1 VSS 0.15037f
C363 CDA.n2 VSS 0.17995f
C364 CDA.t26 VSS 0.01182f
C365 CDA.t27 VSS 0.01182f
C366 CDA.n3 VSS 0.10539f
C367 CDA.t2 VSS 0.02956f
C368 CDA.t3 VSS 0.02956f
C369 CDA.n4 VSS 0.15037f
C370 CDA.n5 VSS 0.17486f
C371 CDA.t28 VSS 0.01182f
C372 CDA.t29 VSS 0.01182f
C373 CDA.n6 VSS 0.10539f
C374 CDA.t4 VSS 0.02956f
C375 CDA.t5 VSS 0.02956f
C376 CDA.n7 VSS 0.15037f
C377 CDA.n8 VSS 0.17486f
C378 CDA.t30 VSS 0.01182f
C379 CDA.t31 VSS 0.01182f
C380 CDA.n9 VSS 0.10539f
C381 CDA.t6 VSS 0.02956f
C382 CDA.t7 VSS 0.02956f
C383 CDA.n10 VSS 0.15037f
C384 CDA.n11 VSS 0.17486f
C385 CDA.t32 VSS 0.01182f
C386 CDA.t33 VSS 0.01182f
C387 CDA.n12 VSS 0.10539f
C388 CDA.t8 VSS 0.02956f
C389 CDA.t9 VSS 0.02956f
C390 CDA.n13 VSS 0.15037f
C391 CDA.n14 VSS 0.17486f
C392 CDA.t34 VSS 0.01182f
C393 CDA.t35 VSS 0.01182f
C394 CDA.n15 VSS 0.10539f
C395 CDA.t10 VSS 0.02956f
C396 CDA.t11 VSS 0.02956f
C397 CDA.n16 VSS 0.15037f
C398 CDA.n17 VSS 0.17486f
C399 CDA.t36 VSS 0.01182f
C400 CDA.t37 VSS 0.01182f
C401 CDA.n18 VSS 0.10539f
C402 CDA.t12 VSS 0.02956f
C403 CDA.t13 VSS 0.02956f
C404 CDA.n19 VSS 0.15037f
C405 CDA.n20 VSS 0.17486f
C406 CDA.t38 VSS 0.01182f
C407 CDA.t39 VSS 0.01182f
C408 CDA.n21 VSS 0.10539f
C409 CDA.t14 VSS 0.02956f
C410 CDA.t15 VSS 0.02956f
C411 CDA.n22 VSS 0.15037f
C412 CDA.n23 VSS 0.17486f
C413 CDA.t40 VSS 0.01182f
C414 CDA.t41 VSS 0.01182f
C415 CDA.n24 VSS 0.10539f
C416 CDA.t16 VSS 0.02956f
C417 CDA.t17 VSS 0.02956f
C418 CDA.n25 VSS 0.15037f
C419 CDA.n26 VSS 0.17486f
C420 CDA.t42 VSS 0.01182f
C421 CDA.t43 VSS 0.01182f
C422 CDA.n27 VSS 0.10539f
C423 CDA.t18 VSS 0.02956f
C424 CDA.t19 VSS 0.02956f
C425 CDA.n28 VSS 0.15037f
C426 CDA.n29 VSS 0.17486f
C427 CDA.t44 VSS 0.01182f
C428 CDA.t45 VSS 0.01182f
C429 CDA.n30 VSS 0.10539f
C430 CDA.t20 VSS 0.02956f
C431 CDA.t21 VSS 0.02956f
C432 CDA.n31 VSS 0.15037f
C433 CDA.n32 VSS 0.17486f
C434 CDA.t46 VSS 0.01182f
C435 CDA.t47 VSS 0.01182f
C436 CDA.n33 VSS 0.10539f
C437 CDA.t22 VSS 0.02956f
C438 CDA.t23 VSS 0.02956f
C439 CDA.n34 VSS 0.15037f
C440 CDA.n35 VSS 1.24315f
C441 CDB.t24 VSS 0.01178f
C442 CDB.t25 VSS 0.01178f
C443 CDB.n0 VSS 0.10499f
C444 CDB.t0 VSS 0.02945f
C445 CDB.t1 VSS 0.02945f
C446 CDB.n1 VSS 0.1498f
C447 CDB.n2 VSS 0.17928f
C448 CDB.t26 VSS 0.01178f
C449 CDB.t27 VSS 0.01178f
C450 CDB.n3 VSS 0.10499f
C451 CDB.t2 VSS 0.02945f
C452 CDB.t3 VSS 0.02945f
C453 CDB.n4 VSS 0.1498f
C454 CDB.n5 VSS 0.16695f
C455 CDB.t28 VSS 0.01178f
C456 CDB.t29 VSS 0.01178f
C457 CDB.n6 VSS 0.10499f
C458 CDB.t4 VSS 0.02945f
C459 CDB.t5 VSS 0.02945f
C460 CDB.n7 VSS 0.1498f
C461 CDB.n8 VSS 0.15246f
C462 CDB.t30 VSS 0.01178f
C463 CDB.t31 VSS 0.01178f
C464 CDB.n9 VSS 0.10499f
C465 CDB.t6 VSS 0.02945f
C466 CDB.t7 VSS 0.02945f
C467 CDB.n10 VSS 0.1498f
C468 CDB.n11 VSS 0.1742f
C469 CDB.t32 VSS 0.01178f
C470 CDB.t33 VSS 0.01178f
C471 CDB.n12 VSS 0.10499f
C472 CDB.t8 VSS 0.02945f
C473 CDB.t9 VSS 0.02945f
C474 CDB.n13 VSS 0.1498f
C475 CDB.n14 VSS 0.1742f
C476 CDB.t34 VSS 0.01178f
C477 CDB.t35 VSS 0.01178f
C478 CDB.n15 VSS 0.10499f
C479 CDB.t10 VSS 0.02945f
C480 CDB.t11 VSS 0.02945f
C481 CDB.n16 VSS 0.1498f
C482 CDB.n17 VSS 0.1742f
C483 CDB.t36 VSS 0.01178f
C484 CDB.t37 VSS 0.01178f
C485 CDB.n18 VSS 0.10499f
C486 CDB.t12 VSS 0.02945f
C487 CDB.t13 VSS 0.02945f
C488 CDB.n19 VSS 0.1498f
C489 CDB.n20 VSS 0.1742f
C490 CDB.t38 VSS 0.01178f
C491 CDB.t39 VSS 0.01178f
C492 CDB.n21 VSS 0.10499f
C493 CDB.t14 VSS 0.02945f
C494 CDB.t15 VSS 0.02945f
C495 CDB.n22 VSS 0.1498f
C496 CDB.n23 VSS 0.1742f
C497 CDB.t40 VSS 0.01178f
C498 CDB.t41 VSS 0.01178f
C499 CDB.n24 VSS 0.10499f
C500 CDB.t16 VSS 0.02945f
C501 CDB.t17 VSS 0.02945f
C502 CDB.n25 VSS 0.1498f
C503 CDB.n26 VSS 0.1742f
C504 CDB.t42 VSS 0.01178f
C505 CDB.t43 VSS 0.01178f
C506 CDB.n27 VSS 0.10499f
C507 CDB.t18 VSS 0.02945f
C508 CDB.t19 VSS 0.02945f
C509 CDB.n28 VSS 0.1498f
C510 CDB.n29 VSS 0.1742f
C511 CDB.t44 VSS 0.01178f
C512 CDB.t45 VSS 0.01178f
C513 CDB.n30 VSS 0.10499f
C514 CDB.t20 VSS 0.02945f
C515 CDB.t21 VSS 0.02945f
C516 CDB.n31 VSS 0.1498f
C517 CDB.n32 VSS 0.1742f
C518 CDB.t46 VSS 0.01178f
C519 CDB.t47 VSS 0.01178f
C520 CDB.n33 VSS 0.10499f
C521 CDB.t22 VSS 0.02945f
C522 CDB.t23 VSS 0.02945f
C523 CDB.n34 VSS 0.1498f
C524 CDB.n35 VSS 0.19087f
C525 CDB.n36 VSS 1.0302f
C526 CHOP1.t1 VSS 1.16496f
C527 CHOP1.t0 VSS 0.1055f
C528 CIA.t0 VSS 0.02132f
C529 CIA.t1 VSS 0.02132f
C530 CIA.n0 VSS 0.10846f
C531 CIA.t12 VSS 0.00853f
C532 CIA.t13 VSS 0.00853f
C533 CIA.n1 VSS 0.07602f
C534 CIA.n2 VSS 0.11406f
C535 CIA.t2 VSS 0.02132f
C536 CIA.t3 VSS 0.02132f
C537 CIA.n3 VSS 0.10846f
C538 CIA.t14 VSS 0.00853f
C539 CIA.t15 VSS 0.00853f
C540 CIA.n4 VSS 0.07602f
C541 CIA.n5 VSS 0.12088f
C542 CIA.t4 VSS 0.02132f
C543 CIA.t5 VSS 0.02132f
C544 CIA.n6 VSS 0.10846f
C545 CIA.t16 VSS 0.00853f
C546 CIA.t17 VSS 0.00853f
C547 CIA.n7 VSS 0.07602f
C548 CIA.n8 VSS 0.12613f
C549 CIA.t6 VSS 0.02132f
C550 CIA.t7 VSS 0.02132f
C551 CIA.n9 VSS 0.10846f
C552 CIA.t18 VSS 0.00853f
C553 CIA.t19 VSS 0.00853f
C554 CIA.n10 VSS 0.07602f
C555 CIA.n11 VSS 0.12613f
C556 CIA.t8 VSS 0.02132f
C557 CIA.t9 VSS 0.02132f
C558 CIA.n12 VSS 0.10846f
C559 CIA.t20 VSS 0.00853f
C560 CIA.t21 VSS 0.00853f
C561 CIA.n13 VSS 0.07602f
C562 CIA.n14 VSS 0.12613f
C563 CIA.t10 VSS 0.02132f
C564 CIA.t11 VSS 0.02132f
C565 CIA.n15 VSS 0.10846f
C566 CIA.t22 VSS 0.00853f
C567 CIA.t23 VSS 0.00853f
C568 CIA.n16 VSS 0.07602f
C569 CIA.n17 VSS 0.1382f
C570 CIA.n18 VSS 1.80277f
C571 CIB.t12 VSS 0.01192f
C572 CIB.t13 VSS 0.01192f
C573 CIB.n0 VSS 0.10628f
C574 CIB.t0 VSS 0.02981f
C575 CIB.t1 VSS 0.02981f
C576 CIB.n1 VSS 0.15164f
C577 CIB.n2 VSS 0.18148f
C578 CIB.t14 VSS 0.01192f
C579 CIB.t15 VSS 0.01192f
C580 CIB.n3 VSS 0.10628f
C581 CIB.t2 VSS 0.02981f
C582 CIB.t3 VSS 0.02981f
C583 CIB.n4 VSS 0.15164f
C584 CIB.n5 VSS 0.17634f
C585 CIB.t16 VSS 0.01192f
C586 CIB.t17 VSS 0.01192f
C587 CIB.n6 VSS 0.10628f
C588 CIB.t4 VSS 0.02981f
C589 CIB.t5 VSS 0.02981f
C590 CIB.n7 VSS 0.15164f
C591 CIB.n8 VSS 0.17634f
C592 CIB.t18 VSS 0.01192f
C593 CIB.t19 VSS 0.01192f
C594 CIB.n9 VSS 0.10628f
C595 CIB.t6 VSS 0.02981f
C596 CIB.t7 VSS 0.02981f
C597 CIB.n10 VSS 0.15164f
C598 CIB.n11 VSS 0.17634f
C599 CIB.t20 VSS 0.01192f
C600 CIB.t21 VSS 0.01192f
C601 CIB.n12 VSS 0.10628f
C602 CIB.t8 VSS 0.02981f
C603 CIB.t9 VSS 0.02981f
C604 CIB.n13 VSS 0.15164f
C605 CIB.n14 VSS 0.17634f
C606 CIB.t22 VSS 0.01192f
C607 CIB.t23 VSS 0.01192f
C608 CIB.n15 VSS 0.10628f
C609 CIB.t10 VSS 0.02981f
C610 CIB.t11 VSS 0.02981f
C611 CIB.n16 VSS 0.15164f
C612 CIB.n17 VSS 1.87608f
C613 NCDA.n0 VSS 0.2059f
C614 NCDA.n1 VSS 0.2059f
C615 NCDA.n2 VSS 0.33843f
C616 NCDA.n3 VSS 0.0771f
C617 NCDA.n4 VSS 0.15843f
C618 NCDA.n5 VSS 0.17484f
C619 NCDA.n6 VSS 0.34839f
C620 NCDA.t10 VSS 0.08365f
C621 NCDA.t11 VSS 0.08365f
C622 NCDA.n7 VSS 0.25368f
C623 NCDA.n8 VSS 0.22569f
C624 NCDA.n9 VSS 0.28109f
C625 NCDA.n10 VSS 0.17484f
C626 NCDA.n11 VSS 0.34839f
C627 NCDA.t8 VSS 0.08365f
C628 NCDA.t9 VSS 0.08365f
C629 NCDA.n12 VSS 0.19175f
C630 NCDA.n13 VSS 0.20628f
C631 NCDA.n14 VSS 0.13963f
C632 NCDA.n15 VSS 0.12322f
C633 NCDA.n16 VSS 0.13963f
C634 NCDA.t6 VSS 0.08365f
C635 NCDA.t7 VSS 0.08365f
C636 NCDA.n17 VSS 0.19175f
C637 NCDA.t0 VSS 0.08365f
C638 NCDA.t1 VSS 0.08365f
C639 NCDA.n18 VSS 0.21534f
C640 NCDA.t2 VSS 0.08365f
C641 NCDA.t3 VSS 0.08365f
C642 NCDA.n19 VSS 0.19175f
C643 NCDA.n20 VSS 0.12322f
C644 NCDA.t4 VSS 0.08365f
C645 NCDA.t5 VSS 0.08365f
C646 NCDA.n21 VSS 0.19175f
C647 NCDA.n22 VSS 0.13963f
C648 NCDA.n23 VSS 0.13963f
C649 NCDA.n24 VSS 0.13963f
C650 NCDA.n25 VSS 0.20628f
C651 NCDA.n26 VSS 0.13963f
C652 NCDA.n27 VSS 0.56014f
C653 NCDA.n28 VSS 0.2059f
C654 NCDA.n29 VSS 0.27125f
C655 NCDA.n30 VSS 0.26241f
C656 NCDA.t16 VSS 0.06692f
C657 NCDA.t17 VSS 0.06692f
C658 NCDA.n31 VSS 0.30966f
C659 NCDA.t12 VSS 0.06692f
C660 NCDA.t13 VSS 0.06692f
C661 NCDA.n33 VSS 0.24503f
C662 NCDA.t14 VSS 0.06692f
C663 NCDA.t15 VSS 0.06692f
C664 NCDA.n34 VSS 0.07672f
C665 NCDA.n35 VSS 0.26928f
C666 NCDA.n36 VSS 1.81259f
C667 NCDB.n0 VSS 0.19536f
C668 NCDB.n1 VSS 0.19536f
C669 NCDB.n2 VSS 0.3211f
C670 NCDB.n3 VSS 0.07315f
C671 NCDB.n4 VSS 0.15032f
C672 NCDB.n5 VSS 0.16589f
C673 NCDB.n6 VSS 0.33055f
C674 NCDB.t10 VSS 0.07936f
C675 NCDB.t11 VSS 0.07936f
C676 NCDB.n7 VSS 0.24069f
C677 NCDB.n8 VSS 0.21414f
C678 NCDB.n9 VSS 0.2667f
C679 NCDB.n10 VSS 0.16589f
C680 NCDB.n11 VSS 0.33055f
C681 NCDB.t8 VSS 0.07936f
C682 NCDB.t9 VSS 0.07936f
C683 NCDB.n12 VSS 0.18193f
C684 NCDB.n13 VSS 0.19572f
C685 NCDB.n14 VSS 0.13248f
C686 NCDB.n15 VSS 0.11691f
C687 NCDB.n16 VSS 0.13248f
C688 NCDB.t6 VSS 0.07936f
C689 NCDB.t7 VSS 0.07936f
C690 NCDB.n17 VSS 0.18193f
C691 NCDB.t0 VSS 0.07936f
C692 NCDB.t1 VSS 0.07936f
C693 NCDB.n18 VSS 0.20432f
C694 NCDB.t2 VSS 0.07936f
C695 NCDB.t3 VSS 0.07936f
C696 NCDB.n19 VSS 0.18193f
C697 NCDB.n20 VSS 0.11691f
C698 NCDB.t4 VSS 0.07936f
C699 NCDB.t5 VSS 0.07936f
C700 NCDB.n21 VSS 0.18193f
C701 NCDB.n22 VSS 0.13248f
C702 NCDB.n23 VSS 0.13248f
C703 NCDB.n24 VSS 0.13248f
C704 NCDB.n25 VSS 0.19572f
C705 NCDB.n26 VSS 0.13248f
C706 NCDB.n27 VSS 0.53146f
C707 NCDB.n28 VSS 0.19536f
C708 NCDB.n29 VSS 0.25736f
C709 NCDB.n30 VSS 0.24897f
C710 NCDB.t16 VSS 0.06349f
C711 NCDB.t17 VSS 0.06349f
C712 NCDB.n31 VSS 0.2938f
C713 NCDB.t12 VSS 0.06349f
C714 NCDB.t13 VSS 0.06349f
C715 NCDB.n33 VSS 0.23248f
C716 NCDB.t14 VSS 0.06349f
C717 NCDB.t15 VSS 0.06349f
C718 NCDB.n34 VSS 0.07279f
C719 NCDB.n35 VSS 0.25549f
C720 NCDB.n36 VSS 1.89171f
C721 NCIA.t0 VSS 0.02562f
C722 NCIA.t1 VSS 0.02562f
C723 NCIA.n0 VSS 0.13032f
C724 NCIA.t24 VSS 0.01025f
C725 NCIA.t25 VSS 0.01025f
C726 NCIA.n1 VSS 0.09134f
C727 NCIA.n2 VSS 0.13705f
C728 NCIA.t2 VSS 0.02562f
C729 NCIA.t3 VSS 0.02562f
C730 NCIA.n3 VSS 0.13032f
C731 NCIA.t26 VSS 0.01025f
C732 NCIA.t27 VSS 0.01025f
C733 NCIA.n4 VSS 0.09134f
C734 NCIA.n5 VSS 0.14525f
C735 NCIA.t4 VSS 0.02562f
C736 NCIA.t5 VSS 0.02562f
C737 NCIA.n6 VSS 0.13032f
C738 NCIA.t28 VSS 0.01025f
C739 NCIA.t29 VSS 0.01025f
C740 NCIA.n7 VSS 0.09134f
C741 NCIA.n8 VSS 0.15155f
C742 NCIA.t6 VSS 0.02562f
C743 NCIA.t7 VSS 0.02562f
C744 NCIA.n9 VSS 0.13032f
C745 NCIA.t30 VSS 0.01025f
C746 NCIA.t31 VSS 0.01025f
C747 NCIA.n10 VSS 0.09134f
C748 NCIA.n11 VSS 0.15155f
C749 NCIA.t8 VSS 0.02562f
C750 NCIA.t9 VSS 0.02562f
C751 NCIA.n12 VSS 0.13032f
C752 NCIA.t32 VSS 0.01025f
C753 NCIA.t33 VSS 0.01025f
C754 NCIA.n13 VSS 0.09134f
C755 NCIA.n14 VSS 0.15155f
C756 NCIA.t10 VSS 0.02562f
C757 NCIA.t11 VSS 0.02562f
C758 NCIA.n15 VSS 0.13032f
C759 NCIA.t34 VSS 0.01025f
C760 NCIA.t35 VSS 0.01025f
C761 NCIA.n16 VSS 0.09134f
C762 NCIA.n17 VSS 0.15155f
C763 NCIA.t12 VSS 0.02562f
C764 NCIA.t13 VSS 0.02562f
C765 NCIA.n18 VSS 0.13032f
C766 NCIA.t36 VSS 0.01025f
C767 NCIA.t37 VSS 0.01025f
C768 NCIA.n19 VSS 0.09134f
C769 NCIA.n20 VSS 0.15155f
C770 NCIA.t14 VSS 0.02562f
C771 NCIA.t15 VSS 0.02562f
C772 NCIA.n21 VSS 0.13032f
C773 NCIA.t38 VSS 0.01025f
C774 NCIA.t39 VSS 0.01025f
C775 NCIA.n22 VSS 0.09134f
C776 NCIA.n23 VSS 0.15155f
C777 NCIA.t16 VSS 0.02562f
C778 NCIA.t17 VSS 0.02562f
C779 NCIA.n24 VSS 0.13032f
C780 NCIA.t40 VSS 0.01025f
C781 NCIA.t41 VSS 0.01025f
C782 NCIA.n25 VSS 0.09134f
C783 NCIA.n26 VSS 0.15155f
C784 NCIA.t18 VSS 0.02562f
C785 NCIA.t19 VSS 0.02562f
C786 NCIA.n27 VSS 0.13032f
C787 NCIA.t42 VSS 0.01025f
C788 NCIA.t43 VSS 0.01025f
C789 NCIA.n28 VSS 0.09134f
C790 NCIA.n29 VSS 0.15155f
C791 NCIA.t20 VSS 0.02562f
C792 NCIA.t21 VSS 0.02562f
C793 NCIA.n30 VSS 0.13032f
C794 NCIA.t44 VSS 0.01025f
C795 NCIA.t45 VSS 0.01025f
C796 NCIA.n31 VSS 0.09134f
C797 NCIA.n32 VSS 0.15155f
C798 NCIA.t22 VSS 0.02562f
C799 NCIA.t23 VSS 0.02562f
C800 NCIA.n33 VSS 0.13032f
C801 NCIA.t46 VSS 0.01025f
C802 NCIA.t47 VSS 0.01025f
C803 NCIA.n34 VSS 0.09134f
C804 NCIA.n35 VSS 0.16606f
C805 NCIA.n36 VSS 2.30832f
C806 NCIB.t24 VSS 0.01114f
C807 NCIB.t25 VSS 0.01114f
C808 NCIB.n0 VSS 0.0993f
C809 NCIB.t0 VSS 0.02785f
C810 NCIB.t1 VSS 0.02785f
C811 NCIB.n1 VSS 0.14168f
C812 NCIB.n2 VSS 0.16956f
C813 NCIB.t26 VSS 0.01114f
C814 NCIB.t27 VSS 0.01114f
C815 NCIB.n3 VSS 0.0993f
C816 NCIB.t2 VSS 0.02785f
C817 NCIB.t3 VSS 0.02785f
C818 NCIB.n4 VSS 0.14168f
C819 NCIB.n5 VSS 0.16476f
C820 NCIB.t28 VSS 0.01114f
C821 NCIB.t29 VSS 0.01114f
C822 NCIB.n6 VSS 0.0993f
C823 NCIB.t4 VSS 0.02785f
C824 NCIB.t5 VSS 0.02785f
C825 NCIB.n7 VSS 0.14168f
C826 NCIB.n8 VSS 0.16476f
C827 NCIB.t30 VSS 0.01114f
C828 NCIB.t31 VSS 0.01114f
C829 NCIB.n9 VSS 0.0993f
C830 NCIB.t6 VSS 0.02785f
C831 NCIB.t7 VSS 0.02785f
C832 NCIB.n10 VSS 0.14168f
C833 NCIB.n11 VSS 0.16476f
C834 NCIB.t32 VSS 0.01114f
C835 NCIB.t33 VSS 0.01114f
C836 NCIB.n12 VSS 0.0993f
C837 NCIB.t8 VSS 0.02785f
C838 NCIB.t9 VSS 0.02785f
C839 NCIB.n13 VSS 0.14168f
C840 NCIB.n14 VSS 0.16476f
C841 NCIB.t34 VSS 0.01114f
C842 NCIB.t35 VSS 0.01114f
C843 NCIB.n15 VSS 0.0993f
C844 NCIB.t10 VSS 0.02785f
C845 NCIB.t11 VSS 0.02785f
C846 NCIB.n16 VSS 0.14168f
C847 NCIB.n17 VSS 0.16476f
C848 NCIB.t36 VSS 0.01114f
C849 NCIB.t37 VSS 0.01114f
C850 NCIB.n18 VSS 0.0993f
C851 NCIB.t12 VSS 0.02785f
C852 NCIB.t13 VSS 0.02785f
C853 NCIB.n19 VSS 0.14168f
C854 NCIB.n20 VSS 0.16476f
C855 NCIB.t38 VSS 0.01114f
C856 NCIB.t39 VSS 0.01114f
C857 NCIB.n21 VSS 0.0993f
C858 NCIB.t14 VSS 0.02785f
C859 NCIB.t15 VSS 0.02785f
C860 NCIB.n22 VSS 0.14168f
C861 NCIB.n23 VSS 0.16476f
C862 NCIB.t40 VSS 0.01114f
C863 NCIB.t41 VSS 0.01114f
C864 NCIB.n24 VSS 0.0993f
C865 NCIB.t16 VSS 0.02785f
C866 NCIB.t17 VSS 0.02785f
C867 NCIB.n25 VSS 0.14168f
C868 NCIB.n26 VSS 0.16476f
C869 NCIB.t42 VSS 0.01114f
C870 NCIB.t43 VSS 0.01114f
C871 NCIB.n27 VSS 0.0993f
C872 NCIB.t18 VSS 0.02785f
C873 NCIB.t19 VSS 0.02785f
C874 NCIB.n28 VSS 0.14168f
C875 NCIB.n29 VSS 0.16476f
C876 NCIB.t44 VSS 0.01114f
C877 NCIB.t45 VSS 0.01114f
C878 NCIB.n30 VSS 0.0993f
C879 NCIB.t20 VSS 0.02785f
C880 NCIB.t21 VSS 0.02785f
C881 NCIB.n31 VSS 0.14168f
C882 NCIB.n32 VSS 0.16476f
C883 NCIB.t46 VSS 0.01114f
C884 NCIB.t47 VSS 0.01114f
C885 NCIB.n33 VSS 0.0993f
C886 NCIB.t22 VSS 0.02785f
C887 NCIB.t23 VSS 0.02785f
C888 NCIB.n34 VSS 0.14168f
C889 NCIB.n35 VSS 1.44215f
C890 VDD.t126 VSS 3.61151f
C891 VDD.t128 VSS 0.89173f
C892 VDD.t134 VSS 0.89173f
C893 VDD.t136 VSS 0.89173f
C894 VDD.t138 VSS 0.75797f
C895 VDD.t140 VSS 0.57963f
C896 VDD.t142 VSS 0.89173f
C897 VDD.t144 VSS 0.89173f
C898 VDD.t146 VSS 0.89173f
C899 VDD.t148 VSS 0.89173f
C900 VDD.t130 VSS 0.89173f
C901 VDD.t132 VSS 2.18474f
C902 VDD.n0 VSS 0.13282f
C903 VDD.n1 VSS 0.95235f
C904 VDD.t127 VSS 0.67885f
C905 VDD.t129 VSS 0.11455f
C906 VDD.t135 VSS 0.11455f
C907 VDD.n2 VSS 0.49218f
C908 VDD.n3 VSS 1.15244f
C909 VDD.t137 VSS 0.11455f
C910 VDD.t139 VSS 0.11455f
C911 VDD.n4 VSS 0.49177f
C912 VDD.n5 VSS 0.37375f
C913 VDD.t141 VSS 0.11455f
C914 VDD.t143 VSS 0.11455f
C915 VDD.n6 VSS 0.49221f
C916 VDD.n7 VSS 0.33195f
C917 VDD.t145 VSS 0.11455f
C918 VDD.t147 VSS 0.11455f
C919 VDD.n8 VSS 0.49189f
C920 VDD.n9 VSS 0.43829f
C921 VDD.t149 VSS 0.11455f
C922 VDD.t131 VSS 0.11455f
C923 VDD.n10 VSS 0.49214f
C924 VDD.n11 VSS 0.43323f
C925 VDD.t133 VSS 0.64762f
C926 VDD.n12 VSS 0.63857f
C927 VDD.t32 VSS 3.61151f
C928 VDD.t34 VSS 0.89173f
C929 VDD.t40 VSS 0.89173f
C930 VDD.t42 VSS 0.89173f
C931 VDD.t44 VSS 0.75797f
C932 VDD.t46 VSS 0.57963f
C933 VDD.t48 VSS 0.89173f
C934 VDD.t50 VSS 0.89173f
C935 VDD.t52 VSS 0.89173f
C936 VDD.t54 VSS 0.89173f
C937 VDD.t36 VSS 0.89173f
C938 VDD.t38 VSS 2.18474f
C939 VDD.n13 VSS 0.13282f
C940 VDD.n14 VSS 0.95235f
C941 VDD.t33 VSS 0.64755f
C942 VDD.n15 VSS 0.76364f
C943 VDD.t35 VSS 0.11455f
C944 VDD.t41 VSS 0.11455f
C945 VDD.n16 VSS 0.49218f
C946 VDD.n17 VSS 0.43157f
C947 VDD.t43 VSS 0.11455f
C948 VDD.t45 VSS 0.11455f
C949 VDD.n18 VSS 0.49177f
C950 VDD.n19 VSS 0.37375f
C951 VDD.t47 VSS 0.11455f
C952 VDD.t49 VSS 0.11455f
C953 VDD.n20 VSS 0.49221f
C954 VDD.n21 VSS 0.33195f
C955 VDD.t51 VSS 0.11455f
C956 VDD.t53 VSS 0.11455f
C957 VDD.n22 VSS 0.49189f
C958 VDD.n23 VSS 0.43829f
C959 VDD.t55 VSS 0.11455f
C960 VDD.t37 VSS 0.11455f
C961 VDD.n24 VSS 0.49214f
C962 VDD.n25 VSS 0.43323f
C963 VDD.t39 VSS 0.64762f
C964 VDD.n26 VSS 7.55955f
C965 VDD.n27 VSS 7.42124f
C966 VDD.n28 VSS 78.8896f
C967 VDD.t412 VSS 1.27891f
C968 VDD.t414 VSS 0.62386f
C969 VDD.t416 VSS 0.62386f
C970 VDD.t418 VSS 0.62386f
C971 VDD.t420 VSS 0.53028f
C972 VDD.t422 VSS 0.40551f
C973 VDD.t424 VSS 0.62386f
C974 VDD.t426 VSS 0.62386f
C975 VDD.t428 VSS 0.62386f
C976 VDD.t430 VSS 25.6406f
C977 VDD.n29 VSS 4.14866f
C978 VDD.n30 VSS 1.84038f
C979 VDD.t413 VSS 0.02864f
C980 VDD.n31 VSS 0.38738f
C981 VDD.t415 VSS 0.02864f
C982 VDD.t417 VSS 0.02864f
C983 VDD.n32 VSS 0.20746f
C984 VDD.t419 VSS 0.02864f
C985 VDD.t421 VSS 0.02864f
C986 VDD.n33 VSS 0.20746f
C987 VDD.t423 VSS 0.02864f
C988 VDD.t425 VSS 0.02864f
C989 VDD.n34 VSS 0.20746f
C990 VDD.t427 VSS 0.02864f
C991 VDD.t429 VSS 0.02864f
C992 VDD.n35 VSS 0.26551f
C993 VDD.t431 VSS 0.16439f
C994 VDD.n36 VSS 19.0769f
C995 VDD.n37 VSS 5.1808f
C996 VDD.n38 VSS 0.89662f
C997 VDD.n39 VSS 0.3272f
C998 VDD.n40 VSS 0.24153f
C999 VDD.n41 VSS 0.34678f
C1000 VDD.n42 VSS 0.26071f
C1001 VDD.n43 VSS 0.12085f
C1002 VDD.n44 VSS 0.51699f
C1003 VDD.n45 VSS 2.23674f
C1004 VDD.n46 VSS 1.45781f
C1005 VDD.n47 VSS 1.13657f
C1006 VDD.n48 VSS 0.13033f
C1007 VDD.n49 VSS 0.08671f
C1008 VDD.n50 VSS 0.1142f
C1009 VDD.n51 VSS 0.18478f
C1010 VDD.n52 VSS 0.24519f
C1011 VDD.n53 VSS 0.51723f
C1012 VDD.n54 VSS 0.45293f
C1013 VDD.n55 VSS 0.33312f
C1014 VDD.n56 VSS 0.20578f
C1015 VDD.n57 VSS 0.39074f
C1016 VDD.n58 VSS 0.53969f
C1017 VDD.n59 VSS 0.41052f
C1018 VDD.n60 VSS 0.18174f
C1019 VDD.n61 VSS 0.45096f
C1020 VDD.n62 VSS 0.49246f
C1021 VDD.n63 VSS 0.33222f
C1022 VDD.n64 VSS 0.41566f
C1023 VDD.n65 VSS 1.0546f
C1024 VDD.n66 VSS 0.36992f
C1025 VDD.n67 VSS 0.29398f
C1026 VDD.n68 VSS 0.20522f
C1027 VDD.n69 VSS 0.60268f
C1028 VDD.n70 VSS 0.66853f
C1029 VDD.n71 VSS 0.39024f
C1030 VDD.n72 VSS 0.45376f
C1031 VDD.n73 VSS 0.45105f
C1032 VDD.n74 VSS 0.33424f
C1033 VDD.n75 VSS 0.37293f
C1034 VDD.n76 VSS 1.01361f
C1035 VDD.n77 VSS 0.33816f
C1036 VDD.n78 VSS 0.39169f
C1037 VDD.n79 VSS 0.50653f
C1038 VDD.n80 VSS 0.45948f
C1039 VDD.n81 VSS 0.36235f
C1040 VDD.n82 VSS 0.99852f
C1041 VDD.n83 VSS 0.22338f
C1042 VDD.n84 VSS 0.81313f
C1043 VDD.n85 VSS 0.05235f
C1044 VDD.n86 VSS 2.06367f
C1045 VDD.n87 VSS 0.29145f
C1046 VDD.n88 VSS 0.59161f
C1047 VDD.n89 VSS 0.33665f
C1048 VDD.n90 VSS 0.75682f
C1049 VDD.n91 VSS 0.25194f
C1050 VDD.n92 VSS 1.99106f
C1051 VDD.n93 VSS 0.14952f
C1052 VDD.n94 VSS 1.94868f
C1053 VDD.n95 VSS 0.77683f
C1054 VDD.n96 VSS 0.34717f
C1055 VDD.n97 VSS 0.71841f
C1056 VDD.n98 VSS 0.18653f
C1057 VDD.n99 VSS 2.00067f
C1058 VDD.n100 VSS 0.31959f
C1059 VDD.n101 VSS 0.82934f
C1060 VDD.n102 VSS 0.30894f
C1061 VDD.n103 VSS 0.88442f
C1062 VDD.n104 VSS 0.31521f
C1063 VDD.n105 VSS 0.84908f
C1064 VDD.n106 VSS 0.17617f
C1065 VDD.n107 VSS 0.82829f
C1066 VDD.n108 VSS 0.73964f
C1067 VDD.n109 VSS 0.98857f
C1068 VDD.n110 VSS 0.08116f
C1069 VDD.n111 VSS 0.82758f
C1070 VDD.n112 VSS 0.06032f
C1071 VDD.n113 VSS 0.76894f
C1072 VDD.n114 VSS 0.04454f
C1073 VDD.n115 VSS 1.20789f
C1074 VDD.n116 VSS 0.16287f
C1075 VDD.n117 VSS 0.78731f
C1076 VDD.n118 VSS 0.20122f
C1077 VDD.n119 VSS 0.77595f
C1078 VDD.n120 VSS 0.74687f
C1079 VDD.n121 VSS 0.33102f
C1080 VDD.n122 VSS 0.78881f
C1081 VDD.n123 VSS 0.15236f
C1082 VDD.n124 VSS 1.94965f
C1083 VDD.n125 VSS 0.37567f
C1084 VDD.n126 VSS 0.83886f
C1085 VDD.n127 VSS 0.32023f
C1086 VDD.n128 VSS 0.89041f
C1087 VDD.n129 VSS 0.28189f
C1088 VDD.n130 VSS 0.80855f
C1089 VDD.n131 VSS 0.21441f
C1090 VDD.n132 VSS 0.79022f
C1091 VDD.n133 VSS 0.32776f
C1092 VDD.n134 VSS 0.886f
C1093 VDD.n135 VSS 0.29057f
C1094 VDD.n136 VSS 0.82229f
C1095 VDD.n137 VSS 0.24457f
C1096 VDD.n138 VSS 0.75929f
C1097 VDD.n139 VSS 0.08856f
C1098 VDD.n140 VSS 0.74264f
C1099 VDD.n141 VSS 0.04454f
C1100 VDD.n142 VSS 1.23891f
C1101 VDD.n143 VSS 0.33896f
C1102 VDD.n144 VSS 0.82837f
C1103 VDD.n145 VSS 0.32006f
C1104 VDD.n146 VSS 0.7518f
C1105 VDD.n147 VSS 0.23506f
C1106 VDD.n148 VSS 2.09751f
C1107 VDD.n149 VSS 0.58262f
C1108 VDD.n150 VSS 0.10843f
C1109 VDD.n151 VSS 1.34535f
C1110 VDD.n152 VSS 2.78046f
C1111 VDD.n153 VSS 0.16485f
C1112 VDD.n154 VSS 0.68131f
C1113 VDD.n156 VSS 0.92486f
C1114 VDD.n157 VSS 2.16653f
C1115 VDD.n158 VSS 1.65058f
C1116 VDD.n159 VSS 0.30765f
C1117 VDD.n160 VSS 0.96821f
C1118 VDD.n161 VSS 0.38631f
C1119 VDD.n162 VSS 0.81481f
C1120 VDD.n163 VSS 0.31396f
C1121 VDD.n164 VSS 0.83657f
C1122 VDD.n165 VSS 0.06011f
C1123 VDD.n166 VSS 0.77097f
C1124 VDD.n167 VSS 0.7437f
C1125 VDD.n168 VSS 0.09973f
C1126 VDD.n169 VSS 0.68325f
C1127 VDD.n170 VSS 0.08732f
C1128 VDD.n171 VSS 0.73418f
C1129 VDD.n172 VSS 0.3062f
C1130 VDD.n173 VSS 0.82864f
C1131 VDD.n174 VSS 0.22919f
C1132 VDD.n175 VSS 2.05521f
C1133 VDD.n176 VSS 0.85014f
C1134 VDD.t0 VSS 2.01221f
C1135 VDD.t404 VSS 1.09757f
C1136 VDD.t406 VSS 1.03659f
C1137 VDD.t4 VSS 0.60976f
C1138 VDD.t6 VSS 0.79269f
C1139 VDD.t410 VSS 1.30336f
C1140 VDD.t158 VSS 0.60976f
C1141 VDD.t8 VSS 1.18141f
C1142 VDD.t10 VSS 1.17379f
C1143 VDD.t16 VSS 0.73171f
C1144 VDD.t18 VSS 0.79269f
C1145 VDD.t20 VSS 1.21952f
C1146 VDD.t22 VSS 1.03659f
C1147 VDD.t24 VSS 0.79269f
C1148 VDD.t26 VSS 1.21952f
C1149 VDD.t310 VSS 0.42683f
C1150 VDD.t28 VSS 1.21952f
C1151 VDD.t30 VSS 0.65549f
C1152 VDD.t12 VSS 0.79269f
C1153 VDD.t14 VSS 0.73171f
C1154 VDD.t318 VSS 1.82928f
C1155 VDD.t316 VSS 1.34147f
C1156 VDD.t324 VSS 2.13416f
C1157 VDD.t326 VSS 0.22866f
C1158 VDD.t328 VSS 1.09757f
C1159 VDD.t330 VSS 0.6936f
C1160 VDD.t332 VSS 1.13568f
C1161 VDD.t334 VSS 1.03659f
C1162 VDD.t336 VSS 0.79269f
C1163 VDD.t344 VSS 0.16006f
C1164 VDD.t338 VSS 1.21952f
C1165 VDD.t340 VSS 0.65549f
C1166 VDD.t342 VSS 1.18141f
C1167 VDD.t346 VSS 1.54346f
C1168 VDD.t348 VSS 0.77363f
C1169 VDD.t370 VSS 1.21952f
C1170 VDD.t380 VSS 1.21952f
C1171 VDD.t160 VSS 1.03659f
C1172 VDD.t383 VSS 0.79269f
C1173 VDD.t385 VSS 1.21952f
C1174 VDD.t387 VSS 1.21952f
C1175 VDD.t389 VSS 1.03659f
C1176 VDD.t162 VSS 0.79269f
C1177 VDD.t350 VSS 1.21952f
C1178 VDD.t352 VSS 1.03659f
C1179 VDD.t354 VSS 0.30488f
C1180 VDD.t356 VSS 1.09757f
C1181 VDD.t358 VSS 1.21952f
C1182 VDD.t156 VSS 0.60976f
C1183 VDD.t360 VSS 1.21952f
C1184 VDD.t362 VSS 0.65549f
C1185 VDD.t364 VSS 1.17379f
C1186 VDD.t366 VSS 0.73171f
C1187 VDD.t368 VSS 1.09757f
C1188 VDD.t372 VSS 1.21952f
C1189 VDD.t374 VSS 1.21952f
C1190 VDD.t376 VSS 1.21952f
C1191 VDD.t378 VSS 1.05565f
C1192 VDD.t2 VSS 0.28583f
C1193 VDD.t393 VSS 0.95275f
C1194 VDD.t56 VSS 1.70733f
C1195 VDD.t395 VSS 0.30488f
C1196 VDD.t62 VSS 1.29574f
C1197 VDD.t64 VSS 0.87653f
C1198 VDD.t66 VSS 0.8308f
C1199 VDD.t68 VSS 1.03659f
C1200 VDD.t70 VSS 0.79269f
C1201 VDD.t72 VSS 1.21952f
C1202 VDD.t78 VSS 1.34147f
C1203 VDD.t74 VSS 1.0747f
C1204 VDD.t76 VSS 0.19055f
C1205 VDD.t80 VSS 1.09757f
C1206 VDD.t82 VSS 0.75077f
C1207 VDD.t104 VSS 1.07851f
C1208 VDD.t114 VSS 1.21952f
C1209 VDD.t116 VSS 1.21952f
C1210 VDD.t118 VSS 1.03659f
C1211 VDD.t58 VSS 0.79269f
C1212 VDD.t121 VSS 1.21952f
C1213 VDD.t123 VSS 1.21952f
C1214 VDD.t60 VSS 1.03659f
C1215 VDD.t84 VSS 0.79269f
C1216 VDD.t86 VSS 1.03659f
C1217 VDD.t88 VSS 0.79269f
C1218 VDD.t90 VSS 0.73171f
C1219 VDD.t92 VSS 1.09757f
C1220 VDD.t94 VSS 1.21952f
C1221 VDD.t96 VSS 1.03659f
C1222 VDD.t98 VSS 0.79269f
C1223 VDD.t100 VSS 1.21952f
C1224 VDD.t102 VSS 1.21952f
C1225 VDD.t106 VSS 1.21952f
C1226 VDD.t108 VSS 1.05565f
C1227 VDD.t110 VSS 0.5907f
C1228 VDD.t112 VSS 0.79269f
C1229 VDD.t168 VSS 1.21952f
C1230 VDD.t170 VSS 1.03659f
C1231 VDD.t397 VSS 0.30488f
C1232 VDD.t172 VSS 1.13568f
C1233 VDD.t174 VSS 1.03659f
C1234 VDD.t180 VSS 0.79269f
C1235 VDD.t182 VSS 1.21952f
C1236 VDD.t184 VSS 1.21952f
C1237 VDD.t186 VSS 1.03659f
C1238 VDD.t188 VSS 0.79269f
C1239 VDD.t190 VSS 1.21952f
C1240 VDD.t192 VSS 0.71266f
C1241 VDD.t194 VSS 0.9337f
C1242 VDD.t176 VSS 0.79269f
C1243 VDD.t178 VSS 1.21952f
C1244 VDD.t205 VSS 1.21952f
C1245 VDD.t207 VSS 1.21952f
C1246 VDD.t153 VSS 0.73171f
C1247 VDD.t210 VSS 2.13416f
C1248 VDD.t212 VSS 2.01221f
C1249 VDD.t214 VSS 2.43904f
C1250 VDD.t216 VSS 1.21952f
C1251 VDD.t218 VSS 1.21952f
C1252 VDD.t220 VSS 1.03659f
C1253 VDD.t222 VSS 0.79269f
C1254 VDD.t224 VSS 1.21952f
C1255 VDD.t226 VSS 1.21952f
C1256 VDD.t228 VSS 2.43904f
C1257 VDD.t238 VSS 2.43904f
C1258 VDD.t240 VSS 1.21952f
C1259 VDD.t262 VSS 1.21952f
C1260 VDD.t272 VSS 1.21952f
C1261 VDD.t274 VSS 1.21952f
C1262 VDD.t276 VSS 1.21952f
C1263 VDD.t278 VSS 1.21952f
C1264 VDD.t280 VSS 1.21952f
C1265 VDD.t282 VSS 1.21952f
C1266 VDD.t284 VSS 1.21952f
C1267 VDD.t242 VSS 1.21952f
C1268 VDD.t244 VSS 1.03659f
C1269 VDD.t246 VSS 0.79269f
C1270 VDD.t248 VSS 1.21952f
C1271 VDD.t250 VSS 1.21952f
C1272 VDD.t252 VSS 1.21952f
C1273 VDD.t254 VSS 1.21952f
C1274 VDD.t256 VSS 1.21952f
C1275 VDD.t258 VSS 1.21952f
C1276 VDD.t260 VSS 1.21952f
C1277 VDD.t264 VSS 1.21952f
C1278 VDD.t266 VSS 1.21952f
C1279 VDD.t268 VSS 1.21952f
C1280 VDD.t270 VSS 2.43904f
C1281 VDD.t320 VSS 1.95123f
C1282 VDD.t322 VSS 0.91464f
C1283 VDD.t312 VSS 0.91464f
C1284 VDD.n192 VSS 0.04635f
C1285 VDD.t314 VSS 0.30488f
C1286 VDD.n193 VSS 0.11558f
C1287 VDD.n195 VSS 0.74687f
C1288 VDD.n196 VSS 0.3272f
C1289 VDD.t313 VSS 0.02864f
C1290 VDD.n197 VSS 0.37261f
C1291 VDD.t315 VSS 0.16439f
C1292 VDD.t321 VSS 0.02864f
C1293 VDD.n198 VSS 0.37231f
C1294 VDD.t323 VSS 0.16439f
C1295 VDD.t402 VSS 0.29354f
C1296 VDD.n199 VSS 0.30198f
C1297 VDD.t239 VSS 0.02864f
C1298 VDD.n200 VSS 0.31425f
C1299 VDD.t241 VSS 0.02864f
C1300 VDD.t263 VSS 0.02864f
C1301 VDD.n201 VSS 0.20746f
C1302 VDD.t273 VSS 0.02864f
C1303 VDD.t275 VSS 0.02864f
C1304 VDD.n202 VSS 0.20746f
C1305 VDD.t277 VSS 0.02864f
C1306 VDD.t279 VSS 0.02864f
C1307 VDD.n203 VSS 0.20746f
C1308 VDD.t281 VSS 0.02864f
C1309 VDD.t283 VSS 0.02864f
C1310 VDD.n204 VSS 0.20746f
C1311 VDD.t285 VSS 0.02864f
C1312 VDD.t243 VSS 0.02864f
C1313 VDD.n205 VSS 0.20746f
C1314 VDD.t245 VSS 0.02864f
C1315 VDD.t247 VSS 0.02864f
C1316 VDD.n206 VSS 0.20746f
C1317 VDD.t249 VSS 0.02864f
C1318 VDD.t251 VSS 0.02864f
C1319 VDD.n207 VSS 0.20746f
C1320 VDD.t253 VSS 0.02864f
C1321 VDD.t255 VSS 0.02864f
C1322 VDD.n208 VSS 0.20746f
C1323 VDD.t257 VSS 0.02864f
C1324 VDD.t259 VSS 0.02864f
C1325 VDD.n209 VSS 0.20746f
C1326 VDD.t261 VSS 0.02864f
C1327 VDD.t265 VSS 0.02864f
C1328 VDD.n210 VSS 0.20746f
C1329 VDD.t267 VSS 0.02864f
C1330 VDD.t269 VSS 0.02864f
C1331 VDD.n211 VSS 0.26551f
C1332 VDD.t271 VSS 0.16439f
C1333 VDD.t286 VSS 0.02864f
C1334 VDD.n212 VSS 0.31425f
C1335 VDD.t287 VSS 0.02864f
C1336 VDD.t298 VSS 0.02864f
C1337 VDD.n213 VSS 0.20746f
C1338 VDD.t303 VSS 0.02864f
C1339 VDD.t304 VSS 0.02864f
C1340 VDD.n214 VSS 0.20746f
C1341 VDD.t305 VSS 0.02864f
C1342 VDD.t306 VSS 0.02864f
C1343 VDD.n215 VSS 0.20746f
C1344 VDD.t307 VSS 0.02864f
C1345 VDD.t308 VSS 0.02864f
C1346 VDD.n216 VSS 0.20746f
C1347 VDD.t309 VSS 0.02864f
C1348 VDD.t288 VSS 0.02864f
C1349 VDD.n217 VSS 0.20746f
C1350 VDD.t289 VSS 0.02864f
C1351 VDD.t290 VSS 0.02864f
C1352 VDD.n218 VSS 0.20746f
C1353 VDD.t291 VSS 0.02864f
C1354 VDD.t292 VSS 0.02864f
C1355 VDD.n219 VSS 0.20746f
C1356 VDD.t293 VSS 0.02864f
C1357 VDD.t294 VSS 0.02864f
C1358 VDD.n220 VSS 0.20746f
C1359 VDD.t295 VSS 0.02864f
C1360 VDD.t296 VSS 0.02864f
C1361 VDD.n221 VSS 0.20746f
C1362 VDD.t297 VSS 0.02864f
C1363 VDD.t299 VSS 0.02864f
C1364 VDD.n222 VSS 0.20746f
C1365 VDD.t300 VSS 0.02864f
C1366 VDD.t301 VSS 0.02864f
C1367 VDD.n223 VSS 0.26551f
C1368 VDD.t302 VSS 0.16439f
C1369 VDD.n224 VSS 0.29114f
C1370 VDD.t215 VSS 0.02864f
C1371 VDD.n225 VSS 0.31425f
C1372 VDD.t217 VSS 0.02864f
C1373 VDD.t219 VSS 0.02864f
C1374 VDD.n226 VSS 0.20746f
C1375 VDD.t221 VSS 0.02864f
C1376 VDD.t223 VSS 0.02864f
C1377 VDD.n227 VSS 0.20746f
C1378 VDD.t225 VSS 0.02864f
C1379 VDD.t227 VSS 0.02864f
C1380 VDD.n228 VSS 0.26551f
C1381 VDD.t229 VSS 0.16439f
C1382 VDD.t230 VSS 0.02864f
C1383 VDD.n229 VSS 0.31425f
C1384 VDD.t231 VSS 0.02864f
C1385 VDD.t232 VSS 0.02864f
C1386 VDD.n230 VSS 0.20746f
C1387 VDD.t233 VSS 0.02864f
C1388 VDD.t234 VSS 0.02864f
C1389 VDD.n231 VSS 0.20746f
C1390 VDD.t235 VSS 0.02864f
C1391 VDD.t236 VSS 0.02864f
C1392 VDD.n232 VSS 0.26551f
C1393 VDD.t237 VSS 0.16439f
C1394 VDD.n233 VSS 0.2996f
C1395 VDD.t211 VSS 0.02864f
C1396 VDD.n234 VSS 0.37231f
C1397 VDD.t213 VSS 0.16439f
C1398 VDD.t400 VSS 0.02864f
C1399 VDD.n235 VSS 0.37231f
C1400 VDD.t401 VSS 0.16439f
C1401 VDD.n236 VSS 0.27739f
C1402 VDD.t198 VSS 0.02864f
C1403 VDD.n237 VSS 0.3145f
C1404 VDD.t199 VSS 0.02864f
C1405 VDD.t200 VSS 0.02864f
C1406 VDD.n238 VSS 0.20746f
C1407 VDD.t201 VSS 0.02864f
C1408 VDD.t202 VSS 0.02864f
C1409 VDD.n239 VSS 0.20746f
C1410 VDD.t203 VSS 0.02864f
C1411 VDD.t204 VSS 0.02864f
C1412 VDD.n240 VSS 0.20746f
C1413 VDD.t206 VSS 0.02864f
C1414 VDD.t208 VSS 0.02864f
C1415 VDD.n241 VSS 0.26551f
C1416 VDD.t209 VSS 0.16439f
C1417 VDD.t196 VSS 0.02864f
C1418 VDD.n242 VSS 0.3725f
C1419 VDD.t197 VSS 0.16439f
C1420 VDD.t398 VSS 0.29386f
C1421 VDD.t81 VSS 0.02864f
C1422 VDD.n243 VSS 0.31435f
C1423 VDD.t83 VSS 0.02864f
C1424 VDD.t105 VSS 0.02864f
C1425 VDD.n244 VSS 0.20746f
C1426 VDD.t115 VSS 0.02864f
C1427 VDD.t117 VSS 0.02864f
C1428 VDD.n245 VSS 0.20746f
C1429 VDD.t119 VSS 0.02864f
C1430 VDD.t120 VSS 0.02864f
C1431 VDD.n246 VSS 0.20746f
C1432 VDD.t122 VSS 0.02864f
C1433 VDD.t124 VSS 0.02864f
C1434 VDD.n247 VSS 0.20746f
C1435 VDD.t125 VSS 0.02864f
C1436 VDD.t85 VSS 0.02864f
C1437 VDD.n248 VSS 0.20746f
C1438 VDD.t87 VSS 0.02864f
C1439 VDD.t89 VSS 0.02864f
C1440 VDD.n249 VSS 0.20746f
C1441 VDD.t91 VSS 0.02864f
C1442 VDD.t93 VSS 0.02864f
C1443 VDD.n250 VSS 0.20746f
C1444 VDD.t95 VSS 0.02864f
C1445 VDD.t97 VSS 0.02864f
C1446 VDD.n251 VSS 0.20746f
C1447 VDD.t99 VSS 0.02864f
C1448 VDD.t101 VSS 0.02864f
C1449 VDD.n252 VSS 0.20746f
C1450 VDD.t103 VSS 0.02864f
C1451 VDD.t107 VSS 0.02864f
C1452 VDD.n253 VSS 0.20746f
C1453 VDD.t109 VSS 0.02864f
C1454 VDD.t111 VSS 0.02864f
C1455 VDD.n254 VSS 0.26551f
C1456 VDD.t113 VSS 0.16439f
C1457 VDD.t63 VSS 0.02864f
C1458 VDD.n255 VSS 0.31456f
C1459 VDD.t65 VSS 0.02864f
C1460 VDD.t67 VSS 0.02864f
C1461 VDD.n256 VSS 0.20746f
C1462 VDD.t69 VSS 0.02864f
C1463 VDD.t71 VSS 0.02864f
C1464 VDD.n257 VSS 0.20746f
C1465 VDD.t73 VSS 0.02864f
C1466 VDD.t75 VSS 0.02864f
C1467 VDD.n258 VSS 0.26551f
C1468 VDD.t77 VSS 0.16439f
C1469 VDD.t394 VSS 0.02864f
C1470 VDD.n259 VSS 0.37257f
C1471 VDD.t396 VSS 0.16439f
C1472 VDD.t347 VSS 0.02864f
C1473 VDD.n260 VSS 0.3145f
C1474 VDD.t349 VSS 0.02864f
C1475 VDD.t371 VSS 0.02864f
C1476 VDD.n261 VSS 0.20746f
C1477 VDD.t381 VSS 0.02864f
C1478 VDD.t382 VSS 0.02864f
C1479 VDD.n262 VSS 0.20746f
C1480 VDD.t384 VSS 0.02864f
C1481 VDD.t386 VSS 0.02864f
C1482 VDD.n263 VSS 0.20746f
C1483 VDD.t388 VSS 0.02864f
C1484 VDD.t390 VSS 0.02864f
C1485 VDD.n264 VSS 0.20746f
C1486 VDD.t391 VSS 0.02864f
C1487 VDD.t351 VSS 0.02864f
C1488 VDD.n265 VSS 0.20746f
C1489 VDD.t353 VSS 0.02864f
C1490 VDD.t355 VSS 0.02864f
C1491 VDD.n266 VSS 0.20746f
C1492 VDD.t357 VSS 0.02864f
C1493 VDD.t359 VSS 0.02864f
C1494 VDD.n267 VSS 0.20746f
C1495 VDD.t361 VSS 0.02864f
C1496 VDD.t363 VSS 0.02864f
C1497 VDD.n268 VSS 0.20746f
C1498 VDD.t365 VSS 0.02864f
C1499 VDD.t367 VSS 0.02864f
C1500 VDD.n269 VSS 0.20746f
C1501 VDD.t369 VSS 0.02864f
C1502 VDD.t373 VSS 0.02864f
C1503 VDD.n270 VSS 0.20746f
C1504 VDD.t375 VSS 0.02864f
C1505 VDD.t377 VSS 0.02864f
C1506 VDD.n271 VSS 0.26551f
C1507 VDD.t379 VSS 0.16439f
C1508 VDD.t329 VSS 0.02864f
C1509 VDD.n272 VSS 0.31435f
C1510 VDD.t331 VSS 0.02864f
C1511 VDD.t333 VSS 0.02864f
C1512 VDD.n273 VSS 0.20746f
C1513 VDD.t335 VSS 0.02864f
C1514 VDD.t337 VSS 0.02864f
C1515 VDD.n274 VSS 0.20746f
C1516 VDD.t339 VSS 0.02864f
C1517 VDD.t341 VSS 0.02864f
C1518 VDD.n275 VSS 0.26551f
C1519 VDD.t343 VSS 0.16439f
C1520 VDD.t317 VSS 0.18637f
C1521 VDD.t325 VSS 0.02864f
C1522 VDD.n276 VSS 0.37231f
C1523 VDD.t327 VSS 0.16439f
C1524 VDD.n277 VSS 0.328f
C1525 VDD.t319 VSS 0.29386f
C1526 VDD.t9 VSS 0.02864f
C1527 VDD.n278 VSS 0.31445f
C1528 VDD.t11 VSS 0.02864f
C1529 VDD.t17 VSS 0.02864f
C1530 VDD.n279 VSS 0.20746f
C1531 VDD.t19 VSS 0.02864f
C1532 VDD.t21 VSS 0.02864f
C1533 VDD.n280 VSS 0.20746f
C1534 VDD.t23 VSS 0.02864f
C1535 VDD.t25 VSS 0.02864f
C1536 VDD.n281 VSS 0.20746f
C1537 VDD.t27 VSS 0.02864f
C1538 VDD.t29 VSS 0.02864f
C1539 VDD.n282 VSS 0.20746f
C1540 VDD.t31 VSS 0.02864f
C1541 VDD.t13 VSS 0.02864f
C1542 VDD.n283 VSS 0.26551f
C1543 VDD.t15 VSS 0.16439f
C1544 VDD.t1 VSS 0.29354f
C1545 VDD.t403 VSS 0.02864f
C1546 VDD.n284 VSS 0.31425f
C1547 VDD.t405 VSS 0.02864f
C1548 VDD.t407 VSS 0.02864f
C1549 VDD.n285 VSS 0.20746f
C1550 VDD.t408 VSS 0.02864f
C1551 VDD.t409 VSS 0.02864f
C1552 VDD.n286 VSS 0.26551f
C1553 VDD.t411 VSS 0.16439f
C1554 VDD.n287 VSS 0.39439f
C1555 VDD.t5 VSS 0.02864f
C1556 VDD.n288 VSS 0.37261f
C1557 VDD.t7 VSS 0.16439f
C1558 VDD.t159 VSS 0.18669f
C1559 VDD.t311 VSS 0.18658f
C1560 VDD.t345 VSS 0.18661f
C1561 VDD.t161 VSS 0.45582f
C1562 VDD.t392 VSS 0.02864f
C1563 VDD.n289 VSS 0.37251f
C1564 VDD.t163 VSS 0.16439f
C1565 VDD.t399 VSS 0.29381f
C1566 VDD.t157 VSS 0.18659f
C1567 VDD.t3 VSS 0.29388f
C1568 VDD.t57 VSS 0.18656f
C1569 VDD.t79 VSS 0.18666f
C1570 VDD.t150 VSS 0.02864f
C1571 VDD.n290 VSS 0.37255f
C1572 VDD.t59 VSS 0.16439f
C1573 VDD.t61 VSS 0.45603f
C1574 VDD.t155 VSS 0.29354f
C1575 VDD.n291 VSS 0.16223f
C1576 VDD.t151 VSS 0.02864f
C1577 VDD.n292 VSS 0.37258f
C1578 VDD.t152 VSS 0.16439f
C1579 VDD.t164 VSS 0.02864f
C1580 VDD.n293 VSS 0.31456f
C1581 VDD.t165 VSS 0.02864f
C1582 VDD.t166 VSS 0.02864f
C1583 VDD.n294 VSS 0.20746f
C1584 VDD.t167 VSS 0.02864f
C1585 VDD.t169 VSS 0.02864f
C1586 VDD.n295 VSS 0.26551f
C1587 VDD.t171 VSS 0.16439f
C1588 VDD.t173 VSS 0.02864f
C1589 VDD.n296 VSS 0.31452f
C1590 VDD.t175 VSS 0.02864f
C1591 VDD.t181 VSS 0.02864f
C1592 VDD.n297 VSS 0.20746f
C1593 VDD.t183 VSS 0.02864f
C1594 VDD.t185 VSS 0.02864f
C1595 VDD.n298 VSS 0.20746f
C1596 VDD.t187 VSS 0.02864f
C1597 VDD.t189 VSS 0.02864f
C1598 VDD.n299 VSS 0.20746f
C1599 VDD.t191 VSS 0.02864f
C1600 VDD.t193 VSS 0.02864f
C1601 VDD.n300 VSS 0.20746f
C1602 VDD.t195 VSS 0.02864f
C1603 VDD.t177 VSS 0.02864f
C1604 VDD.n301 VSS 0.26551f
C1605 VDD.t179 VSS 0.16439f
C1606 VDD.t154 VSS 0.29384f
C1607 a_1036_340.t1 VSS 0.25628f
C1608 a_1036_340.t0 VSS 0.1439f
C1609 a_1036_340.t3 VSS 0.16348f
C1610 a_1036_340.t2 VSS 0.16159f
C1611 a_1036_340.n0 VSS 0.44183f
C1612 a_1036_340.t5 VSS 0.16488f
C1613 a_1036_340.t4 VSS 0.16159f
C1614 a_1036_340.n1 VSS 0.54193f
C1615 a_1036_4320.t0 VSS 0.04449f
C1616 a_1036_4320.t6 VSS 0.0178f
C1617 a_1036_4320.t7 VSS 0.0178f
C1618 a_1036_4320.n0 VSS 0.15862f
C1619 a_1036_4320.t8 VSS 0.0178f
C1620 a_1036_4320.t9 VSS 0.0178f
C1621 a_1036_4320.n1 VSS 0.15862f
C1622 a_1036_4320.t2 VSS 0.04449f
C1623 a_1036_4320.t3 VSS 0.04449f
C1624 a_1036_4320.n2 VSS 0.22631f
C1625 a_1036_4320.n3 VSS 0.23032f
C1626 a_1036_4320.t10 VSS 0.0178f
C1627 a_1036_4320.t11 VSS 0.0178f
C1628 a_1036_4320.n4 VSS 0.15862f
C1629 a_1036_4320.t4 VSS 0.04449f
C1630 a_1036_4320.t5 VSS 0.04449f
C1631 a_1036_4320.n5 VSS 0.22631f
C1632 a_1036_4320.n6 VSS 0.27741f
C1633 a_1036_4320.t12 VSS 0.1619f
C1634 a_1036_4320.t13 VSS 0.16003f
C1635 a_1036_4320.n7 VSS 0.36533f
C1636 a_1036_4320.t14 VSS 0.1619f
C1637 a_1036_4320.t15 VSS 0.16003f
C1638 a_1036_4320.n8 VSS 0.12785f
C1639 a_1036_4320.t16 VSS 0.1619f
C1640 a_1036_4320.t17 VSS 0.16003f
C1641 a_1036_4320.n9 VSS 0.12785f
C1642 a_1036_4320.t18 VSS 0.1619f
C1643 a_1036_4320.t19 VSS 0.16003f
C1644 a_1036_4320.n10 VSS 0.12785f
C1645 a_1036_4320.t20 VSS 0.1619f
C1646 a_1036_4320.t21 VSS 0.16003f
C1647 a_1036_4320.n11 VSS 0.12785f
C1648 a_1036_4320.t22 VSS 0.1619f
C1649 a_1036_4320.t23 VSS 0.16003f
C1650 a_1036_4320.n12 VSS 0.12785f
C1651 a_1036_4320.t24 VSS 0.1619f
C1652 a_1036_4320.t25 VSS 0.16003f
C1653 a_1036_4320.n13 VSS 0.12785f
C1654 a_1036_4320.t26 VSS 0.1619f
C1655 a_1036_4320.t27 VSS 0.16003f
C1656 a_1036_4320.n14 VSS 0.12785f
C1657 a_1036_4320.t28 VSS 0.1619f
C1658 a_1036_4320.t29 VSS 0.16003f
C1659 a_1036_4320.n15 VSS 0.12785f
C1660 a_1036_4320.t30 VSS 0.1619f
C1661 a_1036_4320.t31 VSS 0.16003f
C1662 a_1036_4320.n16 VSS 0.12785f
C1663 a_1036_4320.t32 VSS 0.1619f
C1664 a_1036_4320.t33 VSS 0.16003f
C1665 a_1036_4320.n17 VSS 0.23246f
C1666 a_1036_4320.t34 VSS 0.16329f
C1667 a_1036_4320.t35 VSS 0.16003f
C1668 a_1036_4320.n18 VSS 0.30207f
C1669 a_1036_4320.n19 VSS 0.27084f
C1670 a_1036_4320.n20 VSS 0.22631f
C1671 a_1036_4320.t1 VSS 0.04449f
C1672 a_1036_6700.t0 VSS 0.01737f
C1673 a_1036_6700.t10 VSS 0.00695f
C1674 a_1036_6700.t11 VSS 0.00695f
C1675 a_1036_6700.n0 VSS 0.06194f
C1676 a_1036_6700.t2 VSS 0.01737f
C1677 a_1036_6700.t3 VSS 0.01737f
C1678 a_1036_6700.n1 VSS 0.08837f
C1679 a_1036_6700.t12 VSS 0.00695f
C1680 a_1036_6700.t13 VSS 0.00695f
C1681 a_1036_6700.n2 VSS 0.06194f
C1682 a_1036_6700.n3 VSS 0.10276f
C1683 a_1036_6700.t4 VSS 0.01737f
C1684 a_1036_6700.t5 VSS 0.01737f
C1685 a_1036_6700.n4 VSS 0.08837f
C1686 a_1036_6700.t14 VSS 0.00695f
C1687 a_1036_6700.t15 VSS 0.00695f
C1688 a_1036_6700.n5 VSS 0.06194f
C1689 a_1036_6700.n6 VSS 0.08993f
C1690 a_1036_6700.t6 VSS 0.01737f
C1691 a_1036_6700.t7 VSS 0.01737f
C1692 a_1036_6700.n7 VSS 0.08837f
C1693 a_1036_6700.t16 VSS 0.00695f
C1694 a_1036_6700.t17 VSS 0.00695f
C1695 a_1036_6700.n8 VSS 0.06194f
C1696 a_1036_6700.n9 VSS 0.09849f
C1697 a_1036_6700.t8 VSS 0.01737f
C1698 a_1036_6700.t9 VSS 0.01737f
C1699 a_1036_6700.n10 VSS 0.08837f
C1700 a_1036_6700.t18 VSS 0.00695f
C1701 a_1036_6700.t19 VSS 0.00695f
C1702 a_1036_6700.n11 VSS 0.06194f
C1703 a_1036_6700.n12 VSS 0.1126f
C1704 a_1036_6700.t20 VSS 0.09761f
C1705 a_1036_6700.t21 VSS 0.12005f
C1706 a_1036_6700.n13 VSS 0.24725f
C1707 a_1036_6700.t22 VSS 0.09761f
C1708 a_1036_6700.t23 VSS 0.12005f
C1709 a_1036_6700.n14 VSS 0.07569f
C1710 a_1036_6700.n15 VSS 0.10378f
C1711 a_1036_6700.t24 VSS 0.09761f
C1712 a_1036_6700.t25 VSS 0.12005f
C1713 a_1036_6700.n16 VSS 0.08091f
C1714 a_1036_6700.n17 VSS 0.10378f
C1715 a_1036_6700.t26 VSS 0.09761f
C1716 a_1036_6700.t27 VSS 0.12005f
C1717 a_1036_6700.n18 VSS 0.08091f
C1718 a_1036_6700.n19 VSS 0.10378f
C1719 a_1036_6700.t28 VSS 0.09761f
C1720 a_1036_6700.t29 VSS 0.12005f
C1721 a_1036_6700.n20 VSS 0.18835f
C1722 a_1036_6700.n21 VSS 0.10378f
C1723 a_1036_6700.t30 VSS 0.09761f
C1724 a_1036_6700.t31 VSS 0.12005f
C1725 a_1036_6700.n22 VSS 0.37763f
C1726 a_1036_6700.t32 VSS 0.12005f
C1727 a_1036_6700.n23 VSS 0.06094f
C1728 a_1036_6700.t33 VSS 0.12005f
C1729 a_1036_6700.n24 VSS 0.06177f
C1730 a_1036_6700.t34 VSS 0.12005f
C1731 a_1036_6700.n25 VSS 0.06177f
C1732 a_1036_6700.t35 VSS 0.12005f
C1733 a_1036_6700.n26 VSS 0.06177f
C1734 a_1036_6700.t36 VSS 0.12005f
C1735 a_1036_6700.n27 VSS 0.11881f
C1736 a_1036_6700.t37 VSS 0.12052f
C1737 a_1036_6700.n28 VSS 0.555f
C1738 a_1036_6700.n29 VSS 0.37699f
C1739 a_1036_6700.n30 VSS 0.10576f
C1740 a_1036_6700.n31 VSS 0.08837f
C1741 a_1036_6700.t1 VSS 0.01737f
C1742 a_11116_340.t0 VSS 0.19635f
C1743 a_11116_340.t1 VSS 0.11025f
C1744 a_11116_340.t5 VSS 0.11784f
C1745 a_11116_340.t4 VSS 0.13122f
C1746 a_11116_340.n0 VSS 0.74702f
C1747 a_11116_340.t7 VSS 0.18012f
C1748 a_11116_340.t6 VSS 0.14234f
C1749 a_11116_340.t3 VSS 0.27324f
C1750 a_11116_340.n1 VSS 0.6808f
C1751 a_11116_340.t2 VSS 1.31196f
C1752 a_11116_340.n2 VSS 0.51324f
C1753 a_11116_340.n3 VSS 0.3573f
C1754 a_11436_4320.t0 VSS 0.04669f
C1755 a_11436_4320.t2 VSS 0.01868f
C1756 a_11436_4320.t3 VSS 0.01868f
C1757 a_11436_4320.n0 VSS 0.16646f
C1758 a_11436_4320.t4 VSS 0.1699f
C1759 a_11436_4320.t5 VSS 0.16794f
C1760 a_11436_4320.n1 VSS 0.34595f
C1761 a_11436_4320.t6 VSS 0.1699f
C1762 a_11436_4320.t7 VSS 0.16794f
C1763 a_11436_4320.n2 VSS 0.13417f
C1764 a_11436_4320.t8 VSS 0.1699f
C1765 a_11436_4320.t9 VSS 0.16794f
C1766 a_11436_4320.n3 VSS 0.13417f
C1767 a_11436_4320.t10 VSS 0.1699f
C1768 a_11436_4320.t11 VSS 0.16794f
C1769 a_11436_4320.n4 VSS 0.13417f
C1770 a_11436_4320.t12 VSS 0.1699f
C1771 a_11436_4320.t13 VSS 0.16794f
C1772 a_11436_4320.n5 VSS 0.13417f
C1773 a_11436_4320.t14 VSS 0.1699f
C1774 a_11436_4320.t15 VSS 0.16794f
C1775 a_11436_4320.n6 VSS 0.13417f
C1776 a_11436_4320.t16 VSS 0.1699f
C1777 a_11436_4320.t17 VSS 0.16794f
C1778 a_11436_4320.n7 VSS 0.24396f
C1779 a_11436_4320.t18 VSS 0.17136f
C1780 a_11436_4320.t19 VSS 0.16794f
C1781 a_11436_4320.n8 VSS 0.53179f
C1782 a_11436_4320.n9 VSS 0.2375f
C1783 a_11436_4320.t1 VSS 0.04669f
C1784 a_12076_4320.t0 VSS 0.04531f
C1785 a_12076_4320.t15 VSS 0.01812f
C1786 a_12076_4320.t1 VSS 0.01812f
C1787 a_12076_4320.n0 VSS 0.16155f
C1788 a_12076_4320.t11 VSS 0.01812f
C1789 a_12076_4320.t13 VSS 0.01812f
C1790 a_12076_4320.n1 VSS 0.16155f
C1791 a_12076_4320.t10 VSS 0.04531f
C1792 a_12076_4320.t12 VSS 0.04531f
C1793 a_12076_4320.n2 VSS 0.23049f
C1794 a_12076_4320.n3 VSS 0.27585f
C1795 a_12076_4320.t3 VSS 0.01812f
C1796 a_12076_4320.t5 VSS 0.01812f
C1797 a_12076_4320.n4 VSS 0.16155f
C1798 a_12076_4320.t2 VSS 0.04531f
C1799 a_12076_4320.t4 VSS 0.04531f
C1800 a_12076_4320.n5 VSS 0.23049f
C1801 a_12076_4320.n6 VSS 0.23458f
C1802 a_12076_4320.t7 VSS 0.01812f
C1803 a_12076_4320.t9 VSS 0.01812f
C1804 a_12076_4320.n7 VSS 0.16155f
C1805 a_12076_4320.t6 VSS 0.04531f
C1806 a_12076_4320.t8 VSS 0.04531f
C1807 a_12076_4320.n8 VSS 0.23049f
C1808 a_12076_4320.n9 VSS 0.29369f
C1809 a_12076_4320.t16 VSS 0.16489f
C1810 a_12076_4320.t17 VSS 0.16298f
C1811 a_12076_4320.n10 VSS 0.38783f
C1812 a_12076_4320.t18 VSS 0.16489f
C1813 a_12076_4320.t19 VSS 0.16298f
C1814 a_12076_4320.n11 VSS 0.13021f
C1815 a_12076_4320.t20 VSS 0.16489f
C1816 a_12076_4320.t21 VSS 0.16298f
C1817 a_12076_4320.n12 VSS 0.13021f
C1818 a_12076_4320.t22 VSS 0.16489f
C1819 a_12076_4320.t23 VSS 0.16298f
C1820 a_12076_4320.n13 VSS 0.13021f
C1821 a_12076_4320.t24 VSS 0.16489f
C1822 a_12076_4320.t25 VSS 0.16298f
C1823 a_12076_4320.n14 VSS 0.13021f
C1824 a_12076_4320.t26 VSS 0.16489f
C1825 a_12076_4320.t27 VSS 0.16298f
C1826 a_12076_4320.n15 VSS 0.13021f
C1827 a_12076_4320.t28 VSS 0.16489f
C1828 a_12076_4320.t29 VSS 0.16298f
C1829 a_12076_4320.n16 VSS 0.13021f
C1830 a_12076_4320.t30 VSS 0.16489f
C1831 a_12076_4320.t31 VSS 0.16298f
C1832 a_12076_4320.n17 VSS 0.13021f
C1833 a_12076_4320.t32 VSS 0.16489f
C1834 a_12076_4320.t33 VSS 0.16298f
C1835 a_12076_4320.n18 VSS 0.13021f
C1836 a_12076_4320.t34 VSS 0.16489f
C1837 a_12076_4320.t35 VSS 0.16298f
C1838 a_12076_4320.n19 VSS 0.13021f
C1839 a_12076_4320.t36 VSS 0.16489f
C1840 a_12076_4320.t37 VSS 0.16298f
C1841 a_12076_4320.n20 VSS 0.13021f
C1842 a_12076_4320.t38 VSS 0.16489f
C1843 a_12076_4320.t39 VSS 0.16298f
C1844 a_12076_4320.n21 VSS 0.13021f
C1845 a_12076_4320.t40 VSS 0.16489f
C1846 a_12076_4320.t41 VSS 0.16298f
C1847 a_12076_4320.n22 VSS 0.13021f
C1848 a_12076_4320.t42 VSS 0.16489f
C1849 a_12076_4320.t43 VSS 0.16298f
C1850 a_12076_4320.n23 VSS 0.13021f
C1851 a_12076_4320.t44 VSS 0.16489f
C1852 a_12076_4320.t45 VSS 0.16298f
C1853 a_12076_4320.n24 VSS 0.13021f
C1854 a_12076_4320.t46 VSS 0.16489f
C1855 a_12076_4320.t47 VSS 0.16298f
C1856 a_12076_4320.n25 VSS 0.13021f
C1857 a_12076_4320.t48 VSS 0.16489f
C1858 a_12076_4320.t49 VSS 0.16298f
C1859 a_12076_4320.n26 VSS 0.13021f
C1860 a_12076_4320.t50 VSS 0.16489f
C1861 a_12076_4320.t51 VSS 0.16298f
C1862 a_12076_4320.n27 VSS 0.13021f
C1863 a_12076_4320.t52 VSS 0.16489f
C1864 a_12076_4320.t53 VSS 0.16298f
C1865 a_12076_4320.n28 VSS 0.13021f
C1866 a_12076_4320.t54 VSS 0.16489f
C1867 a_12076_4320.t55 VSS 0.16298f
C1868 a_12076_4320.n29 VSS 0.13021f
C1869 a_12076_4320.t56 VSS 0.16489f
C1870 a_12076_4320.t57 VSS 0.16298f
C1871 a_12076_4320.n30 VSS 0.13021f
C1872 a_12076_4320.t58 VSS 0.16489f
C1873 a_12076_4320.t59 VSS 0.16298f
C1874 a_12076_4320.n31 VSS 0.13021f
C1875 a_12076_4320.t60 VSS 0.16489f
C1876 a_12076_4320.t61 VSS 0.16298f
C1877 a_12076_4320.n32 VSS 0.23676f
C1878 a_12076_4320.t62 VSS 0.1663f
C1879 a_12076_4320.t63 VSS 0.16298f
C1880 a_12076_4320.n33 VSS 0.33429f
C1881 a_12076_4320.n34 VSS 0.25689f
C1882 a_12076_4320.n35 VSS 0.23049f
C1883 a_12076_4320.t14 VSS 0.04531f
C1884 a_1292_12000.t0 VSS 0.02223f
C1885 a_1292_12000.t10 VSS 0.00889f
C1886 a_1292_12000.t11 VSS 0.00889f
C1887 a_1292_12000.n0 VSS 0.07927f
C1888 a_1292_12000.t12 VSS 0.00889f
C1889 a_1292_12000.t13 VSS 0.00889f
C1890 a_1292_12000.n1 VSS 0.07927f
C1891 a_1292_12000.t2 VSS 0.02223f
C1892 a_1292_12000.t3 VSS 0.02223f
C1893 a_1292_12000.n2 VSS 0.1131f
C1894 a_1292_12000.n3 VSS 0.13152f
C1895 a_1292_12000.t14 VSS 0.00889f
C1896 a_1292_12000.t15 VSS 0.00889f
C1897 a_1292_12000.n4 VSS 0.07927f
C1898 a_1292_12000.t4 VSS 0.02223f
C1899 a_1292_12000.t5 VSS 0.02223f
C1900 a_1292_12000.n5 VSS 0.1131f
C1901 a_1292_12000.n6 VSS 0.1151f
C1902 a_1292_12000.t16 VSS 0.00889f
C1903 a_1292_12000.t17 VSS 0.00889f
C1904 a_1292_12000.n7 VSS 0.07927f
C1905 a_1292_12000.t6 VSS 0.02223f
C1906 a_1292_12000.t7 VSS 0.02223f
C1907 a_1292_12000.n8 VSS 0.1131f
C1908 a_1292_12000.n9 VSS 0.12605f
C1909 a_1292_12000.t18 VSS 0.00889f
C1910 a_1292_12000.t19 VSS 0.00889f
C1911 a_1292_12000.n10 VSS 0.07927f
C1912 a_1292_12000.t8 VSS 0.02223f
C1913 a_1292_12000.t9 VSS 0.02223f
C1914 a_1292_12000.n11 VSS 0.1131f
C1915 a_1292_12000.n12 VSS 0.14411f
C1916 a_1292_12000.n13 VSS 2.02135f
C1917 a_1292_12000.t20 VSS 0.12492f
C1918 a_1292_12000.t21 VSS 0.15364f
C1919 a_1292_12000.n14 VSS 0.51406f
C1920 a_1292_12000.t22 VSS 0.12492f
C1921 a_1292_12000.t23 VSS 0.15364f
C1922 a_1292_12000.n15 VSS 0.17872f
C1923 a_1292_12000.n16 VSS 0.13282f
C1924 a_1292_12000.t24 VSS 0.12492f
C1925 a_1292_12000.t25 VSS 0.15364f
C1926 a_1292_12000.n17 VSS 0.10354f
C1927 a_1292_12000.n18 VSS 0.13282f
C1928 a_1292_12000.t26 VSS 0.12492f
C1929 a_1292_12000.t27 VSS 0.15364f
C1930 a_1292_12000.n19 VSS 0.10354f
C1931 a_1292_12000.n20 VSS 0.13282f
C1932 a_1292_12000.t28 VSS 0.12492f
C1933 a_1292_12000.t29 VSS 0.15364f
C1934 a_1292_12000.n21 VSS 0.09686f
C1935 a_1292_12000.n22 VSS 0.13282f
C1936 a_1292_12000.t30 VSS 0.12492f
C1937 a_1292_12000.t31 VSS 0.15364f
C1938 a_1292_12000.n23 VSS 0.13517f
C1939 a_1292_12000.t32 VSS 0.15364f
C1940 a_1292_12000.n24 VSS 0.07799f
C1941 a_1292_12000.t33 VSS 0.15364f
C1942 a_1292_12000.n25 VSS 0.07906f
C1943 a_1292_12000.t34 VSS 0.15364f
C1944 a_1292_12000.n26 VSS 0.07906f
C1945 a_1292_12000.t35 VSS 0.15364f
C1946 a_1292_12000.n27 VSS 0.07906f
C1947 a_1292_12000.t36 VSS 0.15364f
C1948 a_1292_12000.n28 VSS 0.15206f
C1949 a_1292_12000.t37 VSS 0.15424f
C1950 a_1292_12000.n29 VSS 1.59257f
C1951 a_1292_12000.n30 VSS 0.13535f
C1952 a_1292_12000.n31 VSS 0.1131f
C1953 a_1292_12000.t1 VSS 0.02223f
C1954 a_14476_1540.t1 VSS 0.02761f
C1955 a_14476_1540.t0 VSS 0.15623f
C1956 a_14476_1540.t6 VSS 0.10045f
C1957 a_14476_1540.t5 VSS 0.09929f
C1958 a_14476_1540.n0 VSS 0.95562f
C1959 a_14476_1540.t4 VSS 0.10131f
C1960 a_14476_1540.t3 VSS 0.09929f
C1961 a_14476_1540.t8 VSS 0.25859f
C1962 a_14476_1540.t7 VSS 0.09929f
C1963 a_14476_1540.n1 VSS 0.43458f
C1964 a_14476_1540.n2 VSS 0.14042f
C1965 a_14476_1540.t2 VSS 0.02761f
C1966 a_14476_340.t0 VSS 0.10789f
C1967 a_14476_340.t1 VSS 0.10789f
C1968 a_15116_1540.t0 VSS 0.00234f
C1969 a_15116_1540.t1 VSS 0.00234f
C1970 a_15116_340.t2 VSS 0.34848f
C1971 a_15116_340.t0 VSS 0.01169f
C1972 a_15116_340.t1 VSS 0.01169f
C1973 a_15116_340.n0 VSS 0.1144f
C1974 a_15116_340.t4 VSS 0.14568f
C1975 a_15116_340.t3 VSS 0.10512f
C1976 a_15116_340.n1 VSS 0.52904f
C1977 a_1516_340.t1 VSS 0.03315f
C1978 a_1516_340.t0 VSS 0.01326f
C1979 a_1516_340.t2 VSS 0.01326f
C1980 a_1516_340.n0 VSS 0.11818f
C1981 a_1516_340.t5 VSS 0.45906f
C1982 a_1516_340.n1 VSS 0.5179f
C1983 a_1516_340.t4 VSS 1.16857f
C1984 a_1516_340.t7 VSS 0.15869f
C1985 a_1516_340.t6 VSS 0.13708f
C1986 a_1516_340.n2 VSS 0.74246f
C1987 a_1516_340.t9 VSS 0.11787f
C1988 a_1516_340.t8 VSS 0.12637f
C1989 a_1516_340.n3 VSS 0.37728f
C1990 a_1516_340.t11 VSS 0.26315f
C1991 a_1516_340.n4 VSS 0.78825f
C1992 a_1516_340.t10 VSS 1.26353f
C1993 a_1516_340.n5 VSS 0.76032f
C1994 a_1516_340.n6 VSS 0.43546f
C1995 a_1516_340.n7 VSS 0.16862f
C1996 a_1516_340.t3 VSS 0.03315f
C1997 a_16236_340.t1 VSS 0.04475f
C1998 a_16236_340.t0 VSS 0.0179f
C1999 a_16236_340.t2 VSS 0.0179f
C2000 a_16236_340.n0 VSS 0.15954f
C2001 a_16236_340.t5 VSS 0.16284f
C2002 a_16236_340.t4 VSS 0.16096f
C2003 a_16236_340.n1 VSS 0.32884f
C2004 a_16236_340.t7 VSS 0.16284f
C2005 a_16236_340.t6 VSS 0.16096f
C2006 a_16236_340.n2 VSS 0.12859f
C2007 a_16236_340.t9 VSS 0.16284f
C2008 a_16236_340.t8 VSS 0.16096f
C2009 a_16236_340.n3 VSS 0.12859f
C2010 a_16236_340.t11 VSS 0.16284f
C2011 a_16236_340.t10 VSS 0.16096f
C2012 a_16236_340.n4 VSS 0.12859f
C2013 a_16236_340.t13 VSS 0.16284f
C2014 a_16236_340.t12 VSS 0.16096f
C2015 a_16236_340.n5 VSS 0.23382f
C2016 a_16236_340.t15 VSS 0.16423f
C2017 a_16236_340.t14 VSS 0.16096f
C2018 a_16236_340.n6 VSS 0.51346f
C2019 a_16236_340.n7 VSS 0.22763f
C2020 a_16236_340.t3 VSS 0.04475f
C2021 a_16876_340.t1 VSS 0.04268f
C2022 a_16876_340.t10 VSS 0.01707f
C2023 a_16876_340.t0 VSS 0.01707f
C2024 a_16876_340.n0 VSS 0.15218f
C2025 a_16876_340.t7 VSS 0.04268f
C2026 a_16876_340.t9 VSS 0.04268f
C2027 a_16876_340.n1 VSS 0.21712f
C2028 a_16876_340.t6 VSS 0.01707f
C2029 a_16876_340.t8 VSS 0.01707f
C2030 a_16876_340.n2 VSS 0.15218f
C2031 a_16876_340.n3 VSS 0.25984f
C2032 a_16876_340.t3 VSS 0.04268f
C2033 a_16876_340.t5 VSS 0.04268f
C2034 a_16876_340.n4 VSS 0.21712f
C2035 a_16876_340.t2 VSS 0.01707f
C2036 a_16876_340.t4 VSS 0.01707f
C2037 a_16876_340.n5 VSS 0.15218f
C2038 a_16876_340.n6 VSS 0.26615f
C2039 a_16876_340.t13 VSS 0.15532f
C2040 a_16876_340.t12 VSS 0.15353f
C2041 a_16876_340.n7 VSS 0.34398f
C2042 a_16876_340.t15 VSS 0.15532f
C2043 a_16876_340.t14 VSS 0.15353f
C2044 a_16876_340.n8 VSS 0.12266f
C2045 a_16876_340.t17 VSS 0.15532f
C2046 a_16876_340.t16 VSS 0.15353f
C2047 a_16876_340.n9 VSS 0.12266f
C2048 a_16876_340.t19 VSS 0.15532f
C2049 a_16876_340.t18 VSS 0.15353f
C2050 a_16876_340.n10 VSS 0.12266f
C2051 a_16876_340.t21 VSS 0.15532f
C2052 a_16876_340.t20 VSS 0.15353f
C2053 a_16876_340.n11 VSS 0.12266f
C2054 a_16876_340.t23 VSS 0.15532f
C2055 a_16876_340.t22 VSS 0.15353f
C2056 a_16876_340.n12 VSS 0.12266f
C2057 a_16876_340.t25 VSS 0.15532f
C2058 a_16876_340.t24 VSS 0.15353f
C2059 a_16876_340.n13 VSS 0.12266f
C2060 a_16876_340.t27 VSS 0.15532f
C2061 a_16876_340.t26 VSS 0.15353f
C2062 a_16876_340.n14 VSS 0.12266f
C2063 a_16876_340.t29 VSS 0.15532f
C2064 a_16876_340.t28 VSS 0.15353f
C2065 a_16876_340.n15 VSS 0.12266f
C2066 a_16876_340.t31 VSS 0.15532f
C2067 a_16876_340.t30 VSS 0.15353f
C2068 a_16876_340.n16 VSS 0.12266f
C2069 a_16876_340.t33 VSS 0.15532f
C2070 a_16876_340.t32 VSS 0.15353f
C2071 a_16876_340.n17 VSS 0.22302f
C2072 a_16876_340.t35 VSS 0.15665f
C2073 a_16876_340.t34 VSS 0.15353f
C2074 a_16876_340.n18 VSS 0.29382f
C2075 a_16876_340.n19 VSS 0.22097f
C2076 a_16876_340.n20 VSS 0.21712f
C2077 a_16876_340.t11 VSS 0.04268f
C2078 a_17836_4320.t0 VSS 0.22264f
C2079 a_17836_4320.t1 VSS 0.12502f
C2080 a_17836_4320.t2 VSS 0.14202f
C2081 a_17836_4320.t3 VSS 0.14038f
C2082 a_17836_4320.n0 VSS 0.3897f
C2083 a_17836_4320.t4 VSS 0.14323f
C2084 a_17836_4320.t5 VSS 0.14038f
C2085 a_17836_4320.n1 VSS 0.4672f
C2086 a_18316_4320.t0 VSS 0.0477f
C2087 a_18316_4320.t1 VSS 0.01908f
C2088 a_18316_4320.t3 VSS 0.01908f
C2089 a_18316_4320.n0 VSS 0.17007f
C2090 a_18316_4320.t4 VSS 0.17358f
C2091 a_18316_4320.t5 VSS 0.17158f
C2092 a_18316_4320.n1 VSS 0.35345f
C2093 a_18316_4320.t6 VSS 0.17358f
C2094 a_18316_4320.t7 VSS 0.17158f
C2095 a_18316_4320.n2 VSS 0.13708f
C2096 a_18316_4320.t8 VSS 0.17358f
C2097 a_18316_4320.t9 VSS 0.17158f
C2098 a_18316_4320.n3 VSS 0.13708f
C2099 a_18316_4320.t10 VSS 0.17358f
C2100 a_18316_4320.t11 VSS 0.17158f
C2101 a_18316_4320.n4 VSS 0.13708f
C2102 a_18316_4320.t12 VSS 0.17358f
C2103 a_18316_4320.t13 VSS 0.17158f
C2104 a_18316_4320.n5 VSS 0.13708f
C2105 a_18316_4320.t14 VSS 0.17358f
C2106 a_18316_4320.t15 VSS 0.17158f
C2107 a_18316_4320.n6 VSS 0.13708f
C2108 a_18316_4320.t16 VSS 0.17358f
C2109 a_18316_4320.t17 VSS 0.17158f
C2110 a_18316_4320.n7 VSS 0.13708f
C2111 a_18316_4320.t18 VSS 0.17358f
C2112 a_18316_4320.t19 VSS 0.17158f
C2113 a_18316_4320.n8 VSS 0.13708f
C2114 a_18316_4320.t20 VSS 0.17358f
C2115 a_18316_4320.t21 VSS 0.17158f
C2116 a_18316_4320.n9 VSS 0.24925f
C2117 a_18316_4320.t22 VSS 0.17507f
C2118 a_18316_4320.t23 VSS 0.17158f
C2119 a_18316_4320.n10 VSS 0.54332f
C2120 a_18316_4320.n11 VSS 0.24265f
C2121 a_18316_4320.t2 VSS 0.0477f
C2122 a_20396_340.t1 VSS 0.22434f
C2123 a_20396_340.t0 VSS 0.12597f
C2124 a_20396_340.t3 VSS 0.14311f
C2125 a_20396_340.t2 VSS 0.14145f
C2126 a_20396_340.n0 VSS 0.38677f
C2127 a_20396_340.t5 VSS 0.14433f
C2128 a_20396_340.t4 VSS 0.14145f
C2129 a_20396_340.n1 VSS 0.47439f
C2130 a_20876_340.t1 VSS 0.04626f
C2131 a_20876_340.t0 VSS 0.0185f
C2132 a_20876_340.t2 VSS 0.0185f
C2133 a_20876_340.n0 VSS 0.16492f
C2134 a_20876_340.t5 VSS 0.16833f
C2135 a_20876_340.t4 VSS 0.16638f
C2136 a_20876_340.n1 VSS 0.33993f
C2137 a_20876_340.t7 VSS 0.16833f
C2138 a_20876_340.t6 VSS 0.16638f
C2139 a_20876_340.n2 VSS 0.13293f
C2140 a_20876_340.t9 VSS 0.16833f
C2141 a_20876_340.t8 VSS 0.16638f
C2142 a_20876_340.n3 VSS 0.13293f
C2143 a_20876_340.t11 VSS 0.16833f
C2144 a_20876_340.t10 VSS 0.16638f
C2145 a_20876_340.n4 VSS 0.13293f
C2146 a_20876_340.t13 VSS 0.16833f
C2147 a_20876_340.t12 VSS 0.16638f
C2148 a_20876_340.n5 VSS 0.13293f
C2149 a_20876_340.t15 VSS 0.16833f
C2150 a_20876_340.t14 VSS 0.16638f
C2151 a_20876_340.n6 VSS 0.13293f
C2152 a_20876_340.t17 VSS 0.16833f
C2153 a_20876_340.t16 VSS 0.16638f
C2154 a_20876_340.n7 VSS 0.2417f
C2155 a_20876_340.t19 VSS 0.16977f
C2156 a_20876_340.t18 VSS 0.16638f
C2157 a_20876_340.n8 VSS 0.53077f
C2158 a_20876_340.n9 VSS 0.2353f
C2159 a_20876_340.t3 VSS 0.04626f
C2160 a_20876_4320.t0 VSS 0.04687f
C2161 a_20876_4320.t2 VSS 0.01875f
C2162 a_20876_4320.t3 VSS 0.01875f
C2163 a_20876_4320.n0 VSS 0.1671f
C2164 a_20876_4320.t4 VSS 0.17055f
C2165 a_20876_4320.t5 VSS 0.16859f
C2166 a_20876_4320.n1 VSS 0.34728f
C2167 a_20876_4320.t6 VSS 0.17055f
C2168 a_20876_4320.t7 VSS 0.16859f
C2169 a_20876_4320.n2 VSS 0.13469f
C2170 a_20876_4320.t8 VSS 0.17055f
C2171 a_20876_4320.t9 VSS 0.16859f
C2172 a_20876_4320.n3 VSS 0.13469f
C2173 a_20876_4320.t10 VSS 0.17055f
C2174 a_20876_4320.t11 VSS 0.16859f
C2175 a_20876_4320.n4 VSS 0.13469f
C2176 a_20876_4320.t12 VSS 0.17055f
C2177 a_20876_4320.t13 VSS 0.16859f
C2178 a_20876_4320.n5 VSS 0.13469f
C2179 a_20876_4320.t14 VSS 0.17055f
C2180 a_20876_4320.t15 VSS 0.16859f
C2181 a_20876_4320.n6 VSS 0.13469f
C2182 a_20876_4320.t16 VSS 0.17055f
C2183 a_20876_4320.t17 VSS 0.16859f
C2184 a_20876_4320.n7 VSS 0.2449f
C2185 a_20876_4320.t18 VSS 0.17202f
C2186 a_20876_4320.t19 VSS 0.16859f
C2187 a_20876_4320.n8 VSS 0.53384f
C2188 a_20876_4320.n9 VSS 0.23841f
C2189 a_20876_4320.t1 VSS 0.04687f
C2190 a_21516_340.t1 VSS 0.04517f
C2191 a_21516_340.t14 VSS 0.01807f
C2192 a_21516_340.t0 VSS 0.01807f
C2193 a_21516_340.n0 VSS 0.16103f
C2194 a_21516_340.t11 VSS 0.04517f
C2195 a_21516_340.t13 VSS 0.04517f
C2196 a_21516_340.n1 VSS 0.22975f
C2197 a_21516_340.t10 VSS 0.01807f
C2198 a_21516_340.t12 VSS 0.01807f
C2199 a_21516_340.n2 VSS 0.16103f
C2200 a_21516_340.n3 VSS 0.27495f
C2201 a_21516_340.t3 VSS 0.04517f
C2202 a_21516_340.t5 VSS 0.04517f
C2203 a_21516_340.n4 VSS 0.22975f
C2204 a_21516_340.t2 VSS 0.01807f
C2205 a_21516_340.t4 VSS 0.01807f
C2206 a_21516_340.n5 VSS 0.16103f
C2207 a_21516_340.n6 VSS 0.23382f
C2208 a_21516_340.t7 VSS 0.04517f
C2209 a_21516_340.t9 VSS 0.04517f
C2210 a_21516_340.n7 VSS 0.22975f
C2211 a_21516_340.t6 VSS 0.01807f
C2212 a_21516_340.t8 VSS 0.01807f
C2213 a_21516_340.n8 VSS 0.16103f
C2214 a_21516_340.n9 VSS 0.29274f
C2215 a_21516_340.t17 VSS 0.16435f
C2216 a_21516_340.t16 VSS 0.16246f
C2217 a_21516_340.n10 VSS 0.38386f
C2218 a_21516_340.t19 VSS 0.16435f
C2219 a_21516_340.t18 VSS 0.16246f
C2220 a_21516_340.n11 VSS 0.12979f
C2221 a_21516_340.t21 VSS 0.16435f
C2222 a_21516_340.t20 VSS 0.16246f
C2223 a_21516_340.n12 VSS 0.12979f
C2224 a_21516_340.t23 VSS 0.16435f
C2225 a_21516_340.t22 VSS 0.16246f
C2226 a_21516_340.n13 VSS 0.12979f
C2227 a_21516_340.t25 VSS 0.16435f
C2228 a_21516_340.t24 VSS 0.16246f
C2229 a_21516_340.n14 VSS 0.12979f
C2230 a_21516_340.t27 VSS 0.16435f
C2231 a_21516_340.t26 VSS 0.16246f
C2232 a_21516_340.n15 VSS 0.12979f
C2233 a_21516_340.t29 VSS 0.16435f
C2234 a_21516_340.t28 VSS 0.16246f
C2235 a_21516_340.n16 VSS 0.12979f
C2236 a_21516_340.t31 VSS 0.16435f
C2237 a_21516_340.t30 VSS 0.16246f
C2238 a_21516_340.n17 VSS 0.12979f
C2239 a_21516_340.t33 VSS 0.16435f
C2240 a_21516_340.t32 VSS 0.16246f
C2241 a_21516_340.n18 VSS 0.12979f
C2242 a_21516_340.t35 VSS 0.16435f
C2243 a_21516_340.t34 VSS 0.16246f
C2244 a_21516_340.n19 VSS 0.12979f
C2245 a_21516_340.t37 VSS 0.16435f
C2246 a_21516_340.t36 VSS 0.16246f
C2247 a_21516_340.n20 VSS 0.12979f
C2248 a_21516_340.t39 VSS 0.16435f
C2249 a_21516_340.t38 VSS 0.16246f
C2250 a_21516_340.n21 VSS 0.12979f
C2251 a_21516_340.t41 VSS 0.16435f
C2252 a_21516_340.t40 VSS 0.16246f
C2253 a_21516_340.n22 VSS 0.12979f
C2254 a_21516_340.t43 VSS 0.16435f
C2255 a_21516_340.t42 VSS 0.16246f
C2256 a_21516_340.n23 VSS 0.12979f
C2257 a_21516_340.t45 VSS 0.16435f
C2258 a_21516_340.t44 VSS 0.16246f
C2259 a_21516_340.n24 VSS 0.12979f
C2260 a_21516_340.t47 VSS 0.16435f
C2261 a_21516_340.t46 VSS 0.16246f
C2262 a_21516_340.n25 VSS 0.12979f
C2263 a_21516_340.t49 VSS 0.16435f
C2264 a_21516_340.t48 VSS 0.16246f
C2265 a_21516_340.n26 VSS 0.12979f
C2266 a_21516_340.t51 VSS 0.16435f
C2267 a_21516_340.t50 VSS 0.16246f
C2268 a_21516_340.n27 VSS 0.12979f
C2269 a_21516_340.t53 VSS 0.16435f
C2270 a_21516_340.t52 VSS 0.16246f
C2271 a_21516_340.n28 VSS 0.12979f
C2272 a_21516_340.t55 VSS 0.16435f
C2273 a_21516_340.t54 VSS 0.16246f
C2274 a_21516_340.n29 VSS 0.12979f
C2275 a_21516_340.t57 VSS 0.16435f
C2276 a_21516_340.t56 VSS 0.16246f
C2277 a_21516_340.n30 VSS 0.12979f
C2278 a_21516_340.t59 VSS 0.16435f
C2279 a_21516_340.t58 VSS 0.16246f
C2280 a_21516_340.n31 VSS 0.12979f
C2281 a_21516_340.t61 VSS 0.16435f
C2282 a_21516_340.t60 VSS 0.16246f
C2283 a_21516_340.n32 VSS 0.23599f
C2284 a_21516_340.t63 VSS 0.16576f
C2285 a_21516_340.t62 VSS 0.16246f
C2286 a_21516_340.n33 VSS 0.33697f
C2287 a_21516_340.n34 VSS 0.25605f
C2288 a_21516_340.n35 VSS 0.22975f
C2289 a_21516_340.t15 VSS 0.04517f
C2290 a_21516_4320.t0 VSS 0.04521f
C2291 a_21516_4320.t15 VSS 0.01808f
C2292 a_21516_4320.t1 VSS 0.01808f
C2293 a_21516_4320.n0 VSS 0.16119f
C2294 a_21516_4320.t11 VSS 0.01808f
C2295 a_21516_4320.t13 VSS 0.01808f
C2296 a_21516_4320.n1 VSS 0.16119f
C2297 a_21516_4320.t10 VSS 0.04521f
C2298 a_21516_4320.t12 VSS 0.04521f
C2299 a_21516_4320.n2 VSS 0.22998f
C2300 a_21516_4320.n3 VSS 0.27523f
C2301 a_21516_4320.t3 VSS 0.01808f
C2302 a_21516_4320.t5 VSS 0.01808f
C2303 a_21516_4320.n4 VSS 0.16119f
C2304 a_21516_4320.t2 VSS 0.04521f
C2305 a_21516_4320.t4 VSS 0.04521f
C2306 a_21516_4320.n5 VSS 0.22998f
C2307 a_21516_4320.n6 VSS 0.23405f
C2308 a_21516_4320.t7 VSS 0.01808f
C2309 a_21516_4320.t9 VSS 0.01808f
C2310 a_21516_4320.n7 VSS 0.16119f
C2311 a_21516_4320.t6 VSS 0.04521f
C2312 a_21516_4320.t8 VSS 0.04521f
C2313 a_21516_4320.n8 VSS 0.22998f
C2314 a_21516_4320.n9 VSS 0.29303f
C2315 a_21516_4320.t16 VSS 0.16452f
C2316 a_21516_4320.t17 VSS 0.16262f
C2317 a_21516_4320.n10 VSS 0.38696f
C2318 a_21516_4320.t18 VSS 0.16452f
C2319 a_21516_4320.t19 VSS 0.16262f
C2320 a_21516_4320.n11 VSS 0.12992f
C2321 a_21516_4320.t20 VSS 0.16452f
C2322 a_21516_4320.t21 VSS 0.16262f
C2323 a_21516_4320.n12 VSS 0.12992f
C2324 a_21516_4320.t22 VSS 0.16452f
C2325 a_21516_4320.t23 VSS 0.16262f
C2326 a_21516_4320.n13 VSS 0.12992f
C2327 a_21516_4320.t24 VSS 0.16452f
C2328 a_21516_4320.t25 VSS 0.16262f
C2329 a_21516_4320.n14 VSS 0.12992f
C2330 a_21516_4320.t26 VSS 0.16452f
C2331 a_21516_4320.t27 VSS 0.16262f
C2332 a_21516_4320.n15 VSS 0.12992f
C2333 a_21516_4320.t28 VSS 0.16452f
C2334 a_21516_4320.t29 VSS 0.16262f
C2335 a_21516_4320.n16 VSS 0.12992f
C2336 a_21516_4320.t30 VSS 0.16452f
C2337 a_21516_4320.t31 VSS 0.16262f
C2338 a_21516_4320.n17 VSS 0.12992f
C2339 a_21516_4320.t32 VSS 0.16452f
C2340 a_21516_4320.t33 VSS 0.16262f
C2341 a_21516_4320.n18 VSS 0.12992f
C2342 a_21516_4320.t34 VSS 0.16452f
C2343 a_21516_4320.t35 VSS 0.16262f
C2344 a_21516_4320.n19 VSS 0.12992f
C2345 a_21516_4320.t36 VSS 0.16452f
C2346 a_21516_4320.t37 VSS 0.16262f
C2347 a_21516_4320.n20 VSS 0.12992f
C2348 a_21516_4320.t38 VSS 0.16452f
C2349 a_21516_4320.t39 VSS 0.16262f
C2350 a_21516_4320.n21 VSS 0.12992f
C2351 a_21516_4320.t40 VSS 0.16452f
C2352 a_21516_4320.t41 VSS 0.16262f
C2353 a_21516_4320.n22 VSS 0.12992f
C2354 a_21516_4320.t42 VSS 0.16452f
C2355 a_21516_4320.t43 VSS 0.16262f
C2356 a_21516_4320.n23 VSS 0.12992f
C2357 a_21516_4320.t44 VSS 0.16452f
C2358 a_21516_4320.t45 VSS 0.16262f
C2359 a_21516_4320.n24 VSS 0.12992f
C2360 a_21516_4320.t46 VSS 0.16452f
C2361 a_21516_4320.t47 VSS 0.16262f
C2362 a_21516_4320.n25 VSS 0.12992f
C2363 a_21516_4320.t48 VSS 0.16452f
C2364 a_21516_4320.t49 VSS 0.16262f
C2365 a_21516_4320.n26 VSS 0.12992f
C2366 a_21516_4320.t50 VSS 0.16452f
C2367 a_21516_4320.t51 VSS 0.16262f
C2368 a_21516_4320.n27 VSS 0.12992f
C2369 a_21516_4320.t52 VSS 0.16452f
C2370 a_21516_4320.t53 VSS 0.16262f
C2371 a_21516_4320.n28 VSS 0.12992f
C2372 a_21516_4320.t54 VSS 0.16452f
C2373 a_21516_4320.t55 VSS 0.16262f
C2374 a_21516_4320.n29 VSS 0.12992f
C2375 a_21516_4320.t56 VSS 0.16452f
C2376 a_21516_4320.t57 VSS 0.16262f
C2377 a_21516_4320.n30 VSS 0.12992f
C2378 a_21516_4320.t58 VSS 0.16452f
C2379 a_21516_4320.t59 VSS 0.16262f
C2380 a_21516_4320.n31 VSS 0.12992f
C2381 a_21516_4320.t60 VSS 0.16452f
C2382 a_21516_4320.t61 VSS 0.16262f
C2383 a_21516_4320.n32 VSS 0.23623f
C2384 a_21516_4320.t62 VSS 0.16593f
C2385 a_21516_4320.t63 VSS 0.16262f
C2386 a_21516_4320.n33 VSS 0.33354f
C2387 a_21516_4320.n34 VSS 0.25631f
C2388 a_21516_4320.n35 VSS 0.22998f
C2389 a_21516_4320.t14 VSS 0.04521f
C2390 a_27276_4320.t0 VSS 0.24402f
C2391 a_27276_4320.t1 VSS 0.13702f
C2392 a_27276_4320.t2 VSS 0.15566f
C2393 a_27276_4320.t3 VSS 0.15386f
C2394 a_27276_4320.n0 VSS 0.42713f
C2395 a_27276_4320.t4 VSS 0.15699f
C2396 a_27276_4320.t5 VSS 0.15386f
C2397 a_27276_4320.n1 VSS 0.51206f
C2398 a_4492_4188.t1 VSS 0.09807f
C2399 a_4492_4188.t0 VSS 0.05507f
C2400 a_4492_4188.t2 VSS 0.58802f
C2401 a_4492_4188.t3 VSS 0.06183f
C2402 a_4492_4188.n0 VSS 1.58197f
C2403 a_4492_4188.t5 VSS 0.06256f
C2404 a_4492_4188.t4 VSS 0.06183f
C2405 a_4492_4188.n1 VSS 0.71333f
C2406 a_4492_4188.t7 VSS 0.06309f
C2407 a_4492_4188.t6 VSS 0.06183f
C2408 a_4492_4188.n2 VSS 0.12922f
C2409 a_4556_4320.t0 VSS 0.22704f
C2410 a_4556_4320.t1 VSS 0.12749f
C2411 a_4556_4320.t2 VSS 0.14483f
C2412 a_4556_4320.t3 VSS 0.14315f
C2413 a_4556_4320.n0 VSS 0.39741f
C2414 a_4556_4320.t4 VSS 0.14607f
C2415 a_4556_4320.t5 VSS 0.14315f
C2416 a_4556_4320.n1 VSS 0.47643f
C2417 a_5036_4320.t0 VSS 0.04635f
C2418 a_5036_4320.t1 VSS 0.01854f
C2419 a_5036_4320.t3 VSS 0.01854f
C2420 a_5036_4320.n0 VSS 0.16525f
C2421 a_5036_4320.t4 VSS 0.16866f
C2422 a_5036_4320.t5 VSS 0.16671f
C2423 a_5036_4320.n1 VSS 0.34343f
C2424 a_5036_4320.t6 VSS 0.16866f
C2425 a_5036_4320.t7 VSS 0.16671f
C2426 a_5036_4320.n2 VSS 0.13319f
C2427 a_5036_4320.t8 VSS 0.16866f
C2428 a_5036_4320.t9 VSS 0.16671f
C2429 a_5036_4320.n3 VSS 0.13319f
C2430 a_5036_4320.t10 VSS 0.16866f
C2431 a_5036_4320.t11 VSS 0.16671f
C2432 a_5036_4320.n4 VSS 0.13319f
C2433 a_5036_4320.t12 VSS 0.16866f
C2434 a_5036_4320.t13 VSS 0.16671f
C2435 a_5036_4320.n5 VSS 0.13319f
C2436 a_5036_4320.t14 VSS 0.16866f
C2437 a_5036_4320.t15 VSS 0.16671f
C2438 a_5036_4320.n6 VSS 0.13319f
C2439 a_5036_4320.t16 VSS 0.16866f
C2440 a_5036_4320.t17 VSS 0.16671f
C2441 a_5036_4320.n7 VSS 0.24218f
C2442 a_5036_4320.t18 VSS 0.17011f
C2443 a_5036_4320.t19 VSS 0.16671f
C2444 a_5036_4320.n8 VSS 0.52792f
C2445 a_5036_4320.n9 VSS 0.23577f
C2446 a_5036_4320.t2 VSS 0.04635f
C2447 a_5676_4320.t0 VSS 0.04532f
C2448 a_5676_4320.t15 VSS 0.01813f
C2449 a_5676_4320.t1 VSS 0.01813f
C2450 a_5676_4320.n0 VSS 0.16157f
C2451 a_5676_4320.t11 VSS 0.01813f
C2452 a_5676_4320.t13 VSS 0.01813f
C2453 a_5676_4320.n1 VSS 0.16157f
C2454 a_5676_4320.t10 VSS 0.04532f
C2455 a_5676_4320.t12 VSS 0.04532f
C2456 a_5676_4320.n2 VSS 0.23052f
C2457 a_5676_4320.n3 VSS 0.27588f
C2458 a_5676_4320.t3 VSS 0.01813f
C2459 a_5676_4320.t5 VSS 0.01813f
C2460 a_5676_4320.n4 VSS 0.16157f
C2461 a_5676_4320.t2 VSS 0.04532f
C2462 a_5676_4320.t4 VSS 0.04532f
C2463 a_5676_4320.n5 VSS 0.23052f
C2464 a_5676_4320.n6 VSS 0.2346f
C2465 a_5676_4320.t7 VSS 0.01813f
C2466 a_5676_4320.t9 VSS 0.01813f
C2467 a_5676_4320.n7 VSS 0.16157f
C2468 a_5676_4320.t6 VSS 0.04532f
C2469 a_5676_4320.t8 VSS 0.04532f
C2470 a_5676_4320.n8 VSS 0.23052f
C2471 a_5676_4320.n9 VSS 0.29373f
C2472 a_5676_4320.t16 VSS 0.16491f
C2473 a_5676_4320.t17 VSS 0.163f
C2474 a_5676_4320.n10 VSS 0.38787f
C2475 a_5676_4320.t18 VSS 0.16491f
C2476 a_5676_4320.t19 VSS 0.163f
C2477 a_5676_4320.n11 VSS 0.13023f
C2478 a_5676_4320.t20 VSS 0.16491f
C2479 a_5676_4320.t21 VSS 0.163f
C2480 a_5676_4320.n12 VSS 0.13023f
C2481 a_5676_4320.t22 VSS 0.16491f
C2482 a_5676_4320.t23 VSS 0.163f
C2483 a_5676_4320.n13 VSS 0.13023f
C2484 a_5676_4320.t24 VSS 0.16491f
C2485 a_5676_4320.t25 VSS 0.163f
C2486 a_5676_4320.n14 VSS 0.13023f
C2487 a_5676_4320.t26 VSS 0.16491f
C2488 a_5676_4320.t27 VSS 0.163f
C2489 a_5676_4320.n15 VSS 0.13023f
C2490 a_5676_4320.t28 VSS 0.16491f
C2491 a_5676_4320.t29 VSS 0.163f
C2492 a_5676_4320.n16 VSS 0.13023f
C2493 a_5676_4320.t30 VSS 0.16491f
C2494 a_5676_4320.t31 VSS 0.163f
C2495 a_5676_4320.n17 VSS 0.13023f
C2496 a_5676_4320.t32 VSS 0.16491f
C2497 a_5676_4320.t33 VSS 0.163f
C2498 a_5676_4320.n18 VSS 0.13023f
C2499 a_5676_4320.t34 VSS 0.16491f
C2500 a_5676_4320.t35 VSS 0.163f
C2501 a_5676_4320.n19 VSS 0.13023f
C2502 a_5676_4320.t36 VSS 0.16491f
C2503 a_5676_4320.t37 VSS 0.163f
C2504 a_5676_4320.n20 VSS 0.13023f
C2505 a_5676_4320.t38 VSS 0.16491f
C2506 a_5676_4320.t39 VSS 0.163f
C2507 a_5676_4320.n21 VSS 0.13023f
C2508 a_5676_4320.t40 VSS 0.16491f
C2509 a_5676_4320.t41 VSS 0.163f
C2510 a_5676_4320.n22 VSS 0.13023f
C2511 a_5676_4320.t42 VSS 0.16491f
C2512 a_5676_4320.t43 VSS 0.163f
C2513 a_5676_4320.n23 VSS 0.13023f
C2514 a_5676_4320.t44 VSS 0.16491f
C2515 a_5676_4320.t45 VSS 0.163f
C2516 a_5676_4320.n24 VSS 0.13023f
C2517 a_5676_4320.t46 VSS 0.16491f
C2518 a_5676_4320.t47 VSS 0.163f
C2519 a_5676_4320.n25 VSS 0.13023f
C2520 a_5676_4320.t48 VSS 0.16491f
C2521 a_5676_4320.t49 VSS 0.163f
C2522 a_5676_4320.n26 VSS 0.13023f
C2523 a_5676_4320.t50 VSS 0.16491f
C2524 a_5676_4320.t51 VSS 0.163f
C2525 a_5676_4320.n27 VSS 0.13023f
C2526 a_5676_4320.t52 VSS 0.16491f
C2527 a_5676_4320.t53 VSS 0.163f
C2528 a_5676_4320.n28 VSS 0.13023f
C2529 a_5676_4320.t54 VSS 0.16491f
C2530 a_5676_4320.t55 VSS 0.163f
C2531 a_5676_4320.n29 VSS 0.13023f
C2532 a_5676_4320.t56 VSS 0.16491f
C2533 a_5676_4320.t57 VSS 0.163f
C2534 a_5676_4320.n30 VSS 0.13023f
C2535 a_5676_4320.t58 VSS 0.16491f
C2536 a_5676_4320.t59 VSS 0.163f
C2537 a_5676_4320.n31 VSS 0.13023f
C2538 a_5676_4320.t60 VSS 0.16491f
C2539 a_5676_4320.t61 VSS 0.163f
C2540 a_5676_4320.n32 VSS 0.23679f
C2541 a_5676_4320.t62 VSS 0.16632f
C2542 a_5676_4320.t63 VSS 0.163f
C2543 a_5676_4320.n33 VSS 0.33433f
C2544 a_5676_4320.n34 VSS 0.25692f
C2545 a_5676_4320.n35 VSS 0.23052f
C2546 a_5676_4320.t14 VSS 0.04532f
C2547 a_7916_1540.t0 VSS 0.00234f
C2548 a_7916_1540.t1 VSS 0.00234f
C2549 a_7916_340.t2 VSS 0.2566f
C2550 a_7916_340.t0 VSS 0.00861f
C2551 a_7916_340.t1 VSS 0.00861f
C2552 a_7916_340.n0 VSS 0.08424f
C2553 a_7916_340.t5 VSS 0.07831f
C2554 a_7916_340.t6 VSS 0.0774f
C2555 a_7916_340.n1 VSS 0.10892f
C2556 a_7916_340.t3 VSS 0.07898f
C2557 a_7916_340.t4 VSS 0.0774f
C2558 a_7916_340.t7 VSS 0.30758f
C2559 a_7916_340.t8 VSS 0.0774f
C2560 a_7916_340.n2 VSS 1.03808f
C2561 a_7916_340.n3 VSS 0.59666f
C2562 a_8556_1540.t1 VSS 0.0299f
C2563 a_8556_1540.t0 VSS 0.15972f
C2564 a_8556_1540.t4 VSS 0.14711f
C2565 a_8556_1540.t3 VSS 0.10755f
C2566 a_8556_1540.n0 VSS 0.5156f
C2567 a_8556_1540.n1 VSS 0.16364f
C2568 a_8556_1540.t2 VSS 0.0299f
C2569 a_8556_340.t0 VSS 0.10822f
C2570 a_8556_340.t1 VSS 0.10822f
C2571 a_9196_340.t1 VSS 0.11711f
C2572 a_9196_340.t0 VSS 0.06576f
C2573 a_9196_340.t2 VSS 0.0747f
C2574 a_9196_340.t3 VSS 0.07384f
C2575 a_9196_340.n0 VSS 0.11206f
C2576 a_9196_340.t4 VSS 0.07534f
C2577 a_9196_340.t5 VSS 0.07384f
C2578 a_9196_340.n1 VSS 1.50399f
C2579 a_9196_340.t6 VSS 0.30752f
C2580 a_9196_340.t7 VSS 0.07384f
C2581 a_9196_340.n2 VSS 1.04887f
C2582 a_972_4188.t1 VSS 0.03288f
C2583 a_972_4188.t0 VSS 0.01315f
C2584 a_972_4188.t2 VSS 0.01315f
C2585 a_972_4188.n0 VSS 0.11722f
C2586 a_972_4188.t14 VSS 0.11964f
C2587 a_972_4188.t15 VSS 0.11826f
C2588 a_972_4188.n1 VSS 2.88503f
C2589 a_972_4188.t4 VSS 0.12067f
C2590 a_972_4188.t5 VSS 0.11826f
C2591 a_972_4188.t6 VSS 0.11964f
C2592 a_972_4188.t7 VSS 0.11826f
C2593 a_972_4188.n2 VSS 0.17179f
C2594 a_972_4188.t8 VSS 0.11964f
C2595 a_972_4188.t9 VSS 0.11826f
C2596 a_972_4188.n3 VSS 0.09448f
C2597 a_972_4188.t10 VSS 0.11964f
C2598 a_972_4188.t11 VSS 0.11826f
C2599 a_972_4188.n4 VSS 0.09448f
C2600 a_972_4188.t12 VSS 0.11964f
C2601 a_972_4188.t13 VSS 0.11826f
C2602 a_972_4188.n5 VSS 0.09448f
C2603 a_972_4188.n6 VSS 3.01359f
C2604 a_972_4188.n7 VSS 0.16725f
C2605 a_972_4188.t3 VSS 0.03288f
C2606 a_972_8460.t0 VSS 0.0435f
C2607 a_972_8460.t1 VSS 0.0174f
C2608 a_972_8460.t3 VSS 0.0174f
C2609 a_972_8460.n0 VSS 0.15509f
C2610 a_972_8460.t21 VSS 0.15829f
C2611 a_972_8460.t20 VSS 0.15646f
C2612 a_972_8460.n1 VSS 3.95816f
C2613 a_972_8460.t5 VSS 0.15965f
C2614 a_972_8460.t4 VSS 0.15646f
C2615 a_972_8460.t7 VSS 0.15829f
C2616 a_972_8460.t6 VSS 0.15646f
C2617 a_972_8460.n2 VSS 0.22729f
C2618 a_972_8460.t9 VSS 0.15829f
C2619 a_972_8460.t8 VSS 0.15646f
C2620 a_972_8460.n3 VSS 0.125f
C2621 a_972_8460.t11 VSS 0.15829f
C2622 a_972_8460.t10 VSS 0.15646f
C2623 a_972_8460.n4 VSS 0.125f
C2624 a_972_8460.t13 VSS 0.15829f
C2625 a_972_8460.t12 VSS 0.15646f
C2626 a_972_8460.n5 VSS 0.125f
C2627 a_972_8460.t15 VSS 0.15829f
C2628 a_972_8460.t14 VSS 0.15646f
C2629 a_972_8460.n6 VSS 0.125f
C2630 a_972_8460.t17 VSS 0.15829f
C2631 a_972_8460.t16 VSS 0.15646f
C2632 a_972_8460.n7 VSS 0.125f
C2633 a_972_8460.t19 VSS 0.15829f
C2634 a_972_8460.t18 VSS 0.15646f
C2635 a_972_8460.n8 VSS 0.125f
C2636 a_972_8460.t23 VSS 0.15965f
C2637 a_972_8460.t22 VSS 0.15646f
C2638 a_972_8460.n9 VSS 3.99133f
C2639 a_972_8460.n10 VSS 0.22127f
C2640 a_972_8460.t2 VSS 0.0435f
C999999 CHOP1 VSS 1f
.ends
