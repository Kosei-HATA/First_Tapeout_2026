* NGSPICE file created from eeg_adc_clk.ext - technology: gf180mcuD

.subckt eeg_adc_clk CHOP1 CIA NCIA CIB NCIB CDA NCDA CDB NCDB VDD VSS
M0 VDD a_7916_340# a_11436_4320# VDD pfet_03v3 ad=1.125p pd=5.9u as=0.65p ps=3.02u w=2.5u l=0.28u
M1 VSS a_16236_340# a_16876_340# VSS nfet_03v3 ad=0.26p pd=1.52u as=0.26p ps=1.52u w=1u l=0.28u
M2 VDD a_20876_4320# a_21516_4320# VDD pfet_03v3 ad=0.65p pd=3.02u as=0.65p ps=3.02u w=2.5u l=0.28u
M3 VDD a_16236_340# a_16876_340# VDD pfet_03v3 ad=0.65p pd=3.02u as=0.65p ps=3.02u w=2.5u l=0.28u
M4 VSS a_5676_4320# NCIB VSS nfet_03v3 ad=0.26p pd=1.52u as=0.26p ps=1.52u w=1u l=0.28u
M5 NCIB a_5676_4320# VDD VDD pfet_03v3 ad=0.65p pd=3.02u as=0.65p ps=3.02u w=2.5u l=0.28u
M6 a_21516_4320# a_20876_4320# VSS VSS nfet_03v3 ad=0.26p pd=1.52u as=0.45p ps=2.9u w=1u l=0.28u
M7 VDD a_20876_4320# a_21516_4320# VDD pfet_03v3 ad=0.65p pd=3.02u as=0.65p ps=3.02u w=2.5u l=0.28u
M8 VSS a_1036_4320# CIB VSS nfet_03v3 ad=0.26p pd=1.52u as=0.26p ps=1.52u w=1u l=0.28u
M9 a_4556_4320# a_4492_4188# VDD VDD pfet_03v3 ad=1.125p pd=5.9u as=1.125p ps=5.9u w=2.5u l=0.28u
M10 VSS a_972_8460# a_1036_6700# VSS nfet_03v3 ad=0.26p pd=1.52u as=0.26p ps=1.52u w=1u l=0.28u
M11 VDD a_1036_6700# NCDB VDD pfet_03v3 ad=2.6p pd=10.52u as=2.6p ps=10.52u w=10u l=0.28u
M12 NCIA a_21516_340# VSS VSS nfet_03v3 ad=0.26p pd=1.52u as=0.26p ps=1.52u w=1u l=0.28u
M13 CDA a_12076_4320# VSS VSS nfet_03v3 ad=0.26p pd=1.52u as=0.26p ps=1.52u w=1u l=0.28u
M14 VDD a_12076_4320# CDA VDD pfet_03v3 ad=0.65p pd=3.02u as=0.65p ps=3.02u w=2.5u l=0.28u
M15 VSS a_1036_4320# CIB VSS nfet_03v3 ad=0.45p pd=2.9u as=0.26p ps=1.52u w=1u l=0.28u
M16 CDB a_21516_4320# VSS VSS nfet_03v3 ad=0.26p pd=1.52u as=0.26p ps=1.52u w=1u l=0.28u
M17 VDD a_21516_4320# CDB VDD pfet_03v3 ad=1.125p pd=5.9u as=0.65p ps=3.02u w=2.5u l=0.28u
M18 a_1036_6700# a_972_8460# VDD VDD pfet_03v3 ad=0.65p pd=3.02u as=1.125p ps=5.9u w=2.5u l=0.28u
M19 VDD a_16876_340# CIA VDD pfet_03v3 ad=0.65p pd=3.02u as=0.65p ps=3.02u w=2.5u l=0.28u
M20 VSS a_21516_340# NCIA VSS nfet_03v3 ad=0.26p pd=1.52u as=0.26p ps=1.52u w=1u l=0.28u
M21 CDB a_21516_4320# VSS VSS nfet_03v3 ad=0.26p pd=1.52u as=0.26p ps=1.52u w=1u l=0.28u
M22 a_5036_4320# a_4556_4320# VSS VSS nfet_03v3 ad=0.26p pd=1.52u as=0.45p ps=2.9u w=1u l=0.28u
M23 VDD a_5036_4320# a_5676_4320# VDD pfet_03v3 ad=0.65p pd=3.02u as=0.65p ps=3.02u w=2.5u l=0.28u
M24 NCIB a_5676_4320# VSS VSS nfet_03v3 ad=0.26p pd=1.52u as=0.26p ps=1.52u w=1u l=0.28u
M25 a_2500_1540# a_1516_340# VDD VDD pfet_03v3 ad=0.45p pd=2.9u as=0.45p ps=2.9u w=1u l=2u
M26 VDD a_5676_4320# NCIB VDD pfet_03v3 ad=0.65p pd=3.02u as=0.65p ps=3.02u w=2.5u l=0.28u
M27 a_21516_4320# a_20876_4320# VDD VDD pfet_03v3 ad=0.65p pd=3.02u as=0.65p ps=3.02u w=2.5u l=0.28u
M28 a_1036_6700# a_972_8460# VSS VSS nfet_03v3 ad=0.26p pd=1.52u as=0.26p ps=1.52u w=1u l=0.28u
M29 NCIA a_21516_340# VDD VDD pfet_03v3 ad=0.65p pd=3.02u as=0.65p ps=3.02u w=2.5u l=0.28u
M30 a_12076_4320# a_11436_4320# VDD VDD pfet_03v3 ad=0.65p pd=3.02u as=0.65p ps=3.02u w=2.5u l=0.28u
M31 NCDA a_1292_12000# VDD VDD pfet_03v3 ad=2.6p pd=10.52u as=2.6p ps=10.52u w=10u l=0.28u
M32 VDD a_972_8460# a_1036_6700# VDD pfet_03v3 ad=0.65p pd=3.02u as=0.65p ps=3.02u w=2.5u l=0.28u
M33 VDD a_972_4188# a_1036_4320# VDD pfet_03v3 ad=0.65p pd=3.02u as=0.65p ps=3.02u w=2.5u l=0.28u
M34 VSS a_11436_4320# a_12076_4320# VSS nfet_03v3 ad=0.26p pd=1.52u as=0.26p ps=1.52u w=1u l=0.28u
M35 CIA a_16876_340# VDD VDD pfet_03v3 ad=0.65p pd=3.02u as=0.65p ps=3.02u w=2.5u l=0.28u
M36 NCIB a_5676_4320# VSS VSS nfet_03v3 ad=0.26p pd=1.52u as=0.26p ps=1.52u w=1u l=0.28u
M37 CDB a_21516_4320# VDD VDD pfet_03v3 ad=0.65p pd=3.02u as=0.65p ps=3.02u w=2.5u l=0.28u
M38 VSS a_20876_4320# a_21516_4320# VSS nfet_03v3 ad=0.45p pd=2.9u as=0.26p ps=1.52u w=1u l=0.28u
M39 VSS a_1036_6700# NCDB VSS nfet_03v3 ad=3.6p pd=16.9u as=2.08p ps=8.52u w=8u l=0.28u
M40 a_1516_340# a_1036_340# VSS VSS nfet_03v3 ad=0.26p pd=1.52u as=0.45p ps=2.9u w=1u l=0.28u
M41 VSS a_21516_4320# CDB VSS nfet_03v3 ad=0.26p pd=1.52u as=0.26p ps=1.52u w=1u l=0.28u
M42 a_14476_1540# a_11116_340# a_14476_340# VSS nfet_03v3 ad=0.9p pd=4.9u as=0.52p ps=2.52u w=2u l=0.28u
M43 a_5676_4320# a_5036_4320# VDD VDD pfet_03v3 ad=0.65p pd=3.02u as=1.125p ps=5.9u w=2.5u l=0.28u
M44 VSS a_1292_12000# NCDA VSS nfet_03v3 ad=2.08p pd=8.52u as=2.08p ps=8.52u w=8u l=0.28u
M45 VSS a_12076_4320# CDA VSS nfet_03v3 ad=0.26p pd=1.52u as=0.26p ps=1.52u w=1u l=0.28u
M46 VSS a_4556_4320# a_5036_4320# VSS nfet_03v3 ad=0.45p pd=2.9u as=0.26p ps=1.52u w=1u l=0.28u
M47 a_7916_1540# a_1516_340# VDD VDD pfet_03v3 ad=1.3p pd=5.52u as=2.25p ps=10.9u w=5u l=0.28u
M48 VDD a_27276_4320# a_972_8460# VDD pfet_03v3 ad=1.125p pd=5.9u as=0.65p ps=3.02u w=2.5u l=0.28u
M49 VDD a_11436_4320# a_12076_4320# VDD pfet_03v3 ad=0.65p pd=3.02u as=0.65p ps=3.02u w=2.5u l=0.28u
M50 a_1036_6700# a_972_8460# VDD VDD pfet_03v3 ad=0.65p pd=3.02u as=0.65p ps=3.02u w=2.5u l=0.28u
M51 a_12076_4320# a_11436_4320# VSS VSS nfet_03v3 ad=0.26p pd=1.52u as=0.45p ps=2.9u w=1u l=0.28u
M52 VSS a_16876_340# CIA VSS nfet_03v3 ad=0.26p pd=1.52u as=0.26p ps=1.52u w=1u l=0.28u
M53 VSS a_5676_4320# NCIB VSS nfet_03v3 ad=0.26p pd=1.52u as=0.26p ps=1.52u w=1u l=0.28u
M54 a_21516_4320# a_20876_4320# VSS VSS nfet_03v3 ad=0.26p pd=1.52u as=0.26p ps=1.52u w=1u l=0.28u
M55 VDD a_21516_4320# CDB VDD pfet_03v3 ad=0.65p pd=3.02u as=0.65p ps=3.02u w=2.5u l=0.28u
M56 NCDA a_1292_12000# VSS VSS nfet_03v3 ad=2.08p pd=8.52u as=2.08p ps=8.52u w=8u l=0.28u
M57 VSS a_972_8460# a_1036_6700# VSS nfet_03v3 ad=0.45p pd=2.9u as=0.26p ps=1.52u w=1u l=0.28u
M58 a_21516_340# a_20876_340# VSS VSS nfet_03v3 ad=0.26p pd=1.52u as=0.26p ps=1.52u w=1u l=0.28u
M59 a_15116_1540# a_11116_340# VDD VDD pfet_03v3 ad=1.3p pd=5.52u as=2.25p ps=10.9u w=5u l=0.28u
M60 VDD a_21516_340# NCIA VDD pfet_03v3 ad=0.65p pd=3.02u as=0.65p ps=3.02u w=2.5u l=0.28u
M61 VDD a_12076_4320# CDA VDD pfet_03v3 ad=0.65p pd=3.02u as=0.65p ps=3.02u w=2.5u l=0.28u
M62 CDA a_12076_4320# VSS VSS nfet_03v3 ad=0.26p pd=1.52u as=0.26p ps=1.52u w=1u l=0.28u
M63 a_12076_4320# a_11436_4320# VSS VSS nfet_03v3 ad=0.26p pd=1.52u as=0.26p ps=1.52u w=1u l=0.28u
M64 VSS a_972_4188# a_1036_4320# VSS nfet_03v3 ad=0.26p pd=1.52u as=0.26p ps=1.52u w=1u l=0.28u
M65 VDD a_12076_4320# CDA VDD pfet_03v3 ad=1.125p pd=5.9u as=0.65p ps=3.02u w=2.5u l=0.28u
M66 CIB a_1036_4320# VDD VDD pfet_03v3 ad=0.65p pd=3.02u as=1.125p ps=5.9u w=2.5u l=0.28u
M67 a_972_8460# a_27276_4320# VDD VDD pfet_03v3 ad=0.65p pd=3.02u as=1.125p ps=5.9u w=2.5u l=0.28u
M68 VDD a_16876_340# CIA VDD pfet_03v3 ad=0.65p pd=3.02u as=0.65p ps=3.02u w=2.5u l=0.28u
M69 a_7916_340# a_6820_1540# a_7916_1540# VDD pfet_03v3 ad=2.25p pd=10.9u as=1.3p ps=5.52u w=5u l=0.28u
M70 a_27276_4320# a_9196_340# VSS VSS nfet_03v3 ad=0.45p pd=2.9u as=0.45p ps=2.9u w=1u l=0.28u
M71 a_5676_4320# a_5036_4320# VSS VSS nfet_03v3 ad=0.26p pd=1.52u as=0.26p ps=1.52u w=1u l=0.28u
M72 VSS a_21516_340# NCIA VSS nfet_03v3 ad=0.26p pd=1.52u as=0.26p ps=1.52u w=1u l=0.28u
M73 VDD a_5036_4320# a_5676_4320# VDD pfet_03v3 ad=1.125p pd=5.9u as=0.65p ps=3.02u w=2.5u l=0.28u
M74 a_17836_4320# a_7916_340# VSS VSS nfet_03v3 ad=0.45p pd=2.9u as=0.45p ps=2.9u w=1u l=0.28u
M75 a_5676_4320# a_5036_4320# VSS VSS nfet_03v3 ad=0.26p pd=1.52u as=0.26p ps=1.52u w=1u l=0.28u
M76 a_16876_340# a_16236_340# VSS VSS nfet_03v3 ad=0.26p pd=1.52u as=0.26p ps=1.52u w=1u l=0.28u
M77 a_21516_340# a_20876_340# VDD VDD pfet_03v3 ad=0.65p pd=3.02u as=0.65p ps=3.02u w=2.5u l=0.28u
M78 NCIA a_21516_340# VDD VDD pfet_03v3 ad=0.65p pd=3.02u as=0.65p ps=3.02u w=2.5u l=0.28u
M79 VSS a_11436_4320# a_12076_4320# VSS nfet_03v3 ad=0.26p pd=1.52u as=0.26p ps=1.52u w=1u l=0.28u
M80 CDA a_12076_4320# VDD VDD pfet_03v3 ad=0.65p pd=3.02u as=1.125p ps=5.9u w=2.5u l=0.28u
M81 a_1036_4320# a_972_4188# VSS VSS nfet_03v3 ad=0.26p pd=1.52u as=0.26p ps=1.52u w=1u l=0.28u
M82 VSS a_11436_4320# a_12076_4320# VSS nfet_03v3 ad=0.45p pd=2.9u as=0.26p ps=1.52u w=1u l=0.28u
M83 NCDB a_1036_6700# VDD VDD pfet_03v3 ad=2.6p pd=10.52u as=2.6p ps=10.52u w=10u l=0.28u
M84 CDB a_21516_4320# VDD VDD pfet_03v3 ad=0.65p pd=3.02u as=0.65p ps=3.02u w=2.5u l=0.28u
M85 VSS a_21516_4320# CDB VSS nfet_03v3 ad=0.26p pd=1.52u as=0.26p ps=1.52u w=1u l=0.28u
M86 VSS a_21516_340# NCIA VSS nfet_03v3 ad=0.26p pd=1.52u as=0.26p ps=1.52u w=1u l=0.28u
M87 a_16236_340# a_14476_1540# VDD VDD pfet_03v3 ad=0.65p pd=3.02u as=1.125p ps=5.9u w=2.5u l=0.28u
M88 NCIA a_21516_340# VDD VDD pfet_03v3 ad=0.65p pd=3.02u as=0.65p ps=3.02u w=2.5u l=0.28u
M89 CIB a_1036_4320# VSS VSS nfet_03v3 ad=0.26p pd=1.52u as=0.26p ps=1.52u w=1u l=0.28u
M90 VDD a_17836_4320# a_18316_4320# VDD pfet_03v3 ad=1.125p pd=5.9u as=0.65p ps=3.02u w=2.5u l=0.28u
M91 VDD a_1036_4320# CIB VDD pfet_03v3 ad=0.65p pd=3.02u as=0.65p ps=3.02u w=2.5u l=0.28u
M92 VSS a_5036_4320# a_5676_4320# VSS nfet_03v3 ad=0.26p pd=1.52u as=0.26p ps=1.52u w=1u l=0.28u
M93 VDD a_20876_340# a_21516_340# VDD pfet_03v3 ad=0.65p pd=3.02u as=0.65p ps=3.02u w=2.5u l=0.28u
M94 NCIA a_21516_340# VSS VSS nfet_03v3 ad=0.26p pd=1.52u as=0.26p ps=1.52u w=1u l=0.28u
M95 VDD a_1036_6700# NCDB VDD pfet_03v3 ad=4.5p pd=20.9u as=2.6p ps=10.52u w=10u l=0.28u
M96 a_9196_340# a_8556_1540# VDD VDD pfet_03v3 ad=1.125p pd=5.9u as=1.125p ps=5.9u w=2.5u l=0.28u
M97 VDD a_5676_4320# NCIB VDD pfet_03v3 ad=0.65p pd=3.02u as=0.65p ps=3.02u w=2.5u l=0.28u
M98 a_4492_4188# a_15116_340# VDD VDD pfet_03v3 ad=1.125p pd=5.9u as=1.125p ps=5.9u w=2.5u l=0.28u
M99 VSS a_14476_1540# a_16236_340# VSS nfet_03v3 ad=0.45p pd=2.9u as=0.26p ps=1.52u w=1u l=0.28u
M100 NCIB a_5676_4320# VDD VDD pfet_03v3 ad=0.65p pd=3.02u as=0.65p ps=3.02u w=2.5u l=0.28u
M101 VDD a_1292_12000# NCDA VDD pfet_03v3 ad=2.6p pd=10.52u as=2.6p ps=10.52u w=10u l=0.28u
M102 CIB a_1036_4320# VDD VDD pfet_03v3 ad=0.65p pd=3.02u as=0.65p ps=3.02u w=2.5u l=0.28u
M103 VSS a_5676_4320# NCIB VSS nfet_03v3 ad=0.26p pd=1.52u as=0.26p ps=1.52u w=1u l=0.28u
M104 NCIB a_5676_4320# VDD VDD pfet_03v3 ad=0.65p pd=3.02u as=0.65p ps=3.02u w=2.5u l=0.28u
M105 a_1292_12000# a_18316_4320# VSS VSS nfet_03v3 ad=0.26p pd=1.52u as=0.26p ps=1.52u w=1u l=0.28u
M106 VDD a_21516_340# NCIA VDD pfet_03v3 ad=0.65p pd=3.02u as=0.65p ps=3.02u w=2.5u l=0.28u
M107 a_16876_340# a_16236_340# VSS VSS nfet_03v3 ad=0.26p pd=1.52u as=0.45p ps=2.9u w=1u l=0.28u
M108 VDD a_12076_4320# CDA VDD pfet_03v3 ad=0.65p pd=3.02u as=0.65p ps=3.02u w=2.5u l=0.28u
M109 CDA a_12076_4320# VSS VSS nfet_03v3 ad=0.26p pd=1.52u as=0.26p ps=1.52u w=1u l=0.28u
M110 VSS a_1036_4320# CIB VSS nfet_03v3 ad=0.26p pd=1.52u as=0.26p ps=1.52u w=1u l=0.28u
M111 CIB a_1036_4320# VDD VDD pfet_03v3 ad=0.65p pd=3.02u as=0.65p ps=3.02u w=2.5u l=0.28u
M112 NCIA a_21516_340# VSS VSS nfet_03v3 ad=0.26p pd=1.52u as=0.45p ps=2.9u w=1u l=0.28u
M113 VDD a_16236_340# a_16876_340# VDD pfet_03v3 ad=0.65p pd=3.02u as=0.65p ps=3.02u w=2.5u l=0.28u
M114 VDD a_12076_4320# CDA VDD pfet_03v3 ad=0.65p pd=3.02u as=0.65p ps=3.02u w=2.5u l=0.28u
M115 CDA a_12076_4320# VSS VSS nfet_03v3 ad=0.26p pd=1.52u as=0.26p ps=1.52u w=1u l=0.28u
M116 VDD a_21516_4320# CDB VDD pfet_03v3 ad=0.65p pd=3.02u as=0.65p ps=3.02u w=2.5u l=0.28u
M117 CDB a_21516_4320# VSS VSS nfet_03v3 ad=0.26p pd=1.52u as=0.26p ps=1.52u w=1u l=0.28u
M118 NCDA a_1292_12000# VDD VDD pfet_03v3 ad=2.6p pd=10.52u as=2.6p ps=10.52u w=10u l=0.28u
M119 NCIB a_5676_4320# VDD VDD pfet_03v3 ad=0.65p pd=3.02u as=0.65p ps=3.02u w=2.5u l=0.28u
M120 a_1036_340# CHOP1 VDD VDD pfet_03v3 ad=1.125p pd=5.9u as=1.125p ps=5.9u w=2.5u l=0.28u
M121 VSS a_21516_340# NCIA VSS nfet_03v3 ad=0.26p pd=1.52u as=0.26p ps=1.52u w=1u l=0.28u
M122 VDD a_5676_4320# NCIB VDD pfet_03v3 ad=0.65p pd=3.02u as=0.65p ps=3.02u w=2.5u l=0.28u
M123 VDD a_1036_6700# NCDB VDD pfet_03v3 ad=2.6p pd=10.52u as=2.6p ps=10.52u w=10u l=0.28u
M124 a_1292_12000# a_18316_4320# VDD VDD pfet_03v3 ad=0.65p pd=3.02u as=0.65p ps=3.02u w=2.5u l=0.28u
M125 NCIB a_5676_4320# VSS VSS nfet_03v3 ad=0.26p pd=1.52u as=0.45p ps=2.9u w=1u l=0.28u
M126 a_2500_1540# a_1516_340# VSS VSS nfet_03v3 ad=0.45p pd=2.9u as=0.45p ps=2.9u w=1u l=4u
M127 VDD a_5676_4320# NCIB VDD pfet_03v3 ad=0.65p pd=3.02u as=0.65p ps=3.02u w=2.5u l=0.28u
M128 VSS a_18316_4320# a_1292_12000# VSS nfet_03v3 ad=0.26p pd=1.52u as=0.26p ps=1.52u w=1u l=0.28u
M129 VDD a_1292_12000# NCDA VDD pfet_03v3 ad=2.6p pd=10.52u as=2.6p ps=10.52u w=10u l=0.28u
M130 VSS a_13380_1540# a_15116_340# VSS nfet_03v3 ad=0.45p pd=2.9u as=0.26p ps=1.52u w=1u l=0.28u
M131 VSS a_18316_4320# a_1292_12000# VSS nfet_03v3 ad=0.26p pd=1.52u as=0.26p ps=1.52u w=1u l=0.28u
M132 NCIA a_21516_340# VDD VDD pfet_03v3 ad=0.65p pd=3.02u as=1.125p ps=5.9u w=2.5u l=0.28u
M133 VSS a_5676_4320# NCIB VSS nfet_03v3 ad=0.26p pd=1.52u as=0.26p ps=1.52u w=1u l=0.28u
M134 a_11436_4320# a_7916_340# VDD VDD pfet_03v3 ad=0.65p pd=3.02u as=1.125p ps=5.9u w=2.5u l=0.28u
M135 VSS a_12076_4320# CDA VSS nfet_03v3 ad=0.26p pd=1.52u as=0.26p ps=1.52u w=1u l=0.28u
M136 a_16876_340# a_16236_340# VDD VDD pfet_03v3 ad=0.65p pd=3.02u as=1.125p ps=5.9u w=2.5u l=0.28u
M137 VDD a_5676_4320# NCIB VDD pfet_03v3 ad=0.65p pd=3.02u as=0.65p ps=3.02u w=2.5u l=0.28u
M138 VSS a_9196_340# a_20876_4320# VSS nfet_03v3 ad=0.45p pd=2.9u as=0.26p ps=1.52u w=1u l=0.28u
M139 a_4492_4188# a_15116_340# VSS VSS nfet_03v3 ad=0.45p pd=2.9u as=0.45p ps=2.9u w=1u l=0.28u
M140 a_21516_4320# a_20876_4320# VDD VDD pfet_03v3 ad=0.65p pd=3.02u as=0.65p ps=3.02u w=2.5u l=0.28u
M141 VSS a_21516_4320# CDB VSS nfet_03v3 ad=0.26p pd=1.52u as=0.26p ps=1.52u w=1u l=0.28u
M142 CDB a_21516_4320# VDD VDD pfet_03v3 ad=0.65p pd=3.02u as=0.65p ps=3.02u w=2.5u l=0.28u
M143 a_16876_340# a_16236_340# VDD VDD pfet_03v3 ad=0.65p pd=3.02u as=0.65p ps=3.02u w=2.5u l=0.28u
M144 VSS a_16876_340# CIA VSS nfet_03v3 ad=0.26p pd=1.52u as=0.26p ps=1.52u w=1u l=0.28u
M145 NCDA a_1292_12000# VDD VDD pfet_03v3 ad=2.6p pd=10.52u as=2.6p ps=10.52u w=10u l=0.28u
M146 CDA a_12076_4320# VDD VDD pfet_03v3 ad=0.65p pd=3.02u as=0.65p ps=3.02u w=2.5u l=0.28u
M147 CIB a_1036_4320# VSS VSS nfet_03v3 ad=0.26p pd=1.52u as=0.26p ps=1.52u w=1u l=0.28u
M148 VDD a_5676_4320# NCIB VDD pfet_03v3 ad=1.125p pd=5.9u as=0.65p ps=3.02u w=2.5u l=0.28u
M149 a_21516_340# a_20876_340# VSS VSS nfet_03v3 ad=0.26p pd=1.52u as=0.26p ps=1.52u w=1u l=0.28u
M150 VSS a_12076_4320# CDA VSS nfet_03v3 ad=0.26p pd=1.52u as=0.26p ps=1.52u w=1u l=0.28u
M151 CDA a_12076_4320# VDD VDD pfet_03v3 ad=0.65p pd=3.02u as=0.65p ps=3.02u w=2.5u l=0.28u
M152 CIA a_16876_340# VSS VSS nfet_03v3 ad=0.26p pd=1.52u as=0.26p ps=1.52u w=1u l=0.28u
M153 VSS a_21516_4320# CDB VSS nfet_03v3 ad=0.26p pd=1.52u as=0.26p ps=1.52u w=1u l=0.28u
M154 CDB a_21516_4320# VDD VDD pfet_03v3 ad=0.65p pd=3.02u as=0.65p ps=3.02u w=2.5u l=0.28u
M155 NCIB a_5676_4320# VSS VSS nfet_03v3 ad=0.26p pd=1.52u as=0.26p ps=1.52u w=1u l=0.28u
M156 VDD a_1036_340# a_1516_340# VDD pfet_03v3 ad=1.125p pd=5.9u as=0.65p ps=3.02u w=2.5u l=0.28u
M157 NCIB a_5676_4320# VDD VDD pfet_03v3 ad=0.65p pd=3.02u as=0.65p ps=3.02u w=2.5u l=0.28u
M158 VDD a_20876_4320# a_21516_4320# VDD pfet_03v3 ad=0.65p pd=3.02u as=0.65p ps=3.02u w=2.5u l=0.28u
M159 a_20876_4320# a_9196_340# VSS VSS nfet_03v3 ad=0.26p pd=1.52u as=0.45p ps=2.9u w=1u l=0.28u
M160 VSS a_1292_12000# NCDA VSS nfet_03v3 ad=2.08p pd=8.52u as=2.08p ps=8.52u w=8u l=0.28u
M161 a_1292_12000# a_18316_4320# VSS VSS nfet_03v3 ad=0.26p pd=1.52u as=0.26p ps=1.52u w=1u l=0.28u
M162 VSS a_5676_4320# NCIB VSS nfet_03v3 ad=0.26p pd=1.52u as=0.26p ps=1.52u w=1u l=0.28u
M163 NCIB a_5676_4320# VDD VDD pfet_03v3 ad=0.65p pd=3.02u as=0.65p ps=3.02u w=2.5u l=0.28u
M164 VDD a_21516_340# NCIA VDD pfet_03v3 ad=0.65p pd=3.02u as=0.65p ps=3.02u w=2.5u l=0.28u
M165 VSS a_21516_340# NCIA VSS nfet_03v3 ad=0.26p pd=1.52u as=0.26p ps=1.52u w=1u l=0.28u
M166 VDD a_12076_4320# CDA VDD pfet_03v3 ad=0.65p pd=3.02u as=0.65p ps=3.02u w=2.5u l=0.28u
M167 CDA a_12076_4320# VSS VSS nfet_03v3 ad=0.26p pd=1.52u as=0.26p ps=1.52u w=1u l=0.28u
M168 a_5380_1540# a_3940_1540# VSS VSS nfet_03v3 ad=0.45p pd=2.9u as=0.45p ps=2.9u w=1u l=4u
M169 VSS a_972_8460# a_1036_6700# VSS nfet_03v3 ad=0.26p pd=1.52u as=0.26p ps=1.52u w=1u l=0.28u
M170 VDD a_21516_340# NCIA VDD pfet_03v3 ad=0.65p pd=3.02u as=0.65p ps=3.02u w=2.5u l=0.28u
M171 VDD a_12076_4320# CDA VDD pfet_03v3 ad=0.65p pd=3.02u as=0.65p ps=3.02u w=2.5u l=0.28u
M172 CDA a_12076_4320# VSS VSS nfet_03v3 ad=0.26p pd=1.52u as=0.26p ps=1.52u w=1u l=0.28u
M173 CIA a_16876_340# VSS VSS nfet_03v3 ad=0.26p pd=1.52u as=0.45p ps=2.9u w=1u l=0.28u
M174 a_6820_1540# a_5380_1540# VDD VDD pfet_03v3 ad=0.45p pd=2.9u as=0.45p ps=2.9u w=1u l=2u
M175 VDD a_21516_4320# CDB VDD pfet_03v3 ad=0.65p pd=3.02u as=0.65p ps=3.02u w=2.5u l=0.28u
M176 CDB a_21516_4320# VSS VSS nfet_03v3 ad=0.26p pd=1.52u as=0.26p ps=1.52u w=1u l=0.28u
M177 VDD a_16876_340# CIA VDD pfet_03v3 ad=0.65p pd=3.02u as=0.65p ps=3.02u w=2.5u l=0.28u
M178 VDD a_12076_4320# CDA VDD pfet_03v3 ad=0.65p pd=3.02u as=0.65p ps=3.02u w=2.5u l=0.28u
M179 VSS a_18316_4320# a_1292_12000# VSS nfet_03v3 ad=0.26p pd=1.52u as=0.26p ps=1.52u w=1u l=0.28u
M180 a_13380_1540# a_11940_1540# VSS VSS nfet_03v3 ad=0.45p pd=2.9u as=0.45p ps=2.9u w=1u l=4u
M181 NCIA a_21516_340# VDD VDD pfet_03v3 ad=0.65p pd=3.02u as=0.65p ps=3.02u w=2.5u l=0.28u
M182 a_1036_4320# a_972_4188# VDD VDD pfet_03v3 ad=0.65p pd=3.02u as=1.125p ps=5.9u w=2.5u l=0.28u
M183 VSS a_7916_340# a_11436_4320# VSS nfet_03v3 ad=0.45p pd=2.9u as=0.26p ps=1.52u w=1u l=0.28u
M184 NCDB a_1036_6700# VSS VSS nfet_03v3 ad=2.08p pd=8.52u as=2.08p ps=8.52u w=8u l=0.28u
M185 NCIA a_21516_340# VDD VDD pfet_03v3 ad=0.65p pd=3.02u as=0.65p ps=3.02u w=2.5u l=0.28u
M186 a_12076_4320# a_11436_4320# VDD VDD pfet_03v3 ad=0.65p pd=3.02u as=0.65p ps=3.02u w=2.5u l=0.28u
M187 VDD a_972_8460# a_1036_6700# VDD pfet_03v3 ad=0.65p pd=3.02u as=0.65p ps=3.02u w=2.5u l=0.28u
M188 VDD a_5676_4320# NCIB VDD pfet_03v3 ad=0.65p pd=3.02u as=0.65p ps=3.02u w=2.5u l=0.28u
M189 VSS a_20876_4320# a_21516_4320# VSS nfet_03v3 ad=0.26p pd=1.52u as=0.26p ps=1.52u w=1u l=0.28u
M190 NCIA a_21516_340# VSS VSS nfet_03v3 ad=0.26p pd=1.52u as=0.26p ps=1.52u w=1u l=0.28u
M191 a_1036_6700# a_972_8460# VSS VSS nfet_03v3 ad=0.26p pd=1.52u as=0.26p ps=1.52u w=1u l=0.28u
M192 VSS a_16236_340# a_16876_340# VSS nfet_03v3 ad=0.26p pd=1.52u as=0.26p ps=1.52u w=1u l=0.28u
M193 VDD a_11116_340# a_14476_1540# VDD pfet_03v3 ad=1.125p pd=5.9u as=0.65p ps=3.02u w=2.5u l=0.28u
M194 NCIB a_5676_4320# VSS VSS nfet_03v3 ad=0.26p pd=1.52u as=0.26p ps=1.52u w=1u l=0.28u
M195 CIA a_16876_340# VDD VDD pfet_03v3 ad=0.65p pd=3.02u as=1.125p ps=5.9u w=2.5u l=0.28u
M196 VSS a_20876_4320# a_21516_4320# VSS nfet_03v3 ad=0.26p pd=1.52u as=0.26p ps=1.52u w=1u l=0.28u
M197 NCIA a_21516_340# VDD VDD pfet_03v3 ad=0.65p pd=3.02u as=0.65p ps=3.02u w=2.5u l=0.28u
M198 CDB a_21516_4320# VDD VDD pfet_03v3 ad=0.65p pd=3.02u as=1.125p ps=5.9u w=2.5u l=0.28u
M199 CDA a_12076_4320# VDD VDD pfet_03v3 ad=0.65p pd=3.02u as=0.65p ps=3.02u w=2.5u l=0.28u
M200 a_4556_4320# a_4492_4188# VSS VSS nfet_03v3 ad=0.45p pd=2.9u as=0.45p ps=2.9u w=1u l=0.28u
M201 VDD a_972_4188# a_1036_4320# VDD pfet_03v3 ad=1.125p pd=5.9u as=0.65p ps=3.02u w=2.5u l=0.28u
M202 a_1036_6700# a_972_8460# VSS VSS nfet_03v3 ad=0.26p pd=1.52u as=0.26p ps=1.52u w=1u l=0.28u
M203 VSS a_12076_4320# CDA VSS nfet_03v3 ad=0.26p pd=1.52u as=0.26p ps=1.52u w=1u l=0.28u
M204 CDA a_12076_4320# VDD VDD pfet_03v3 ad=0.65p pd=3.02u as=0.65p ps=3.02u w=2.5u l=0.28u
M205 NCDB a_1036_6700# VDD VDD pfet_03v3 ad=2.6p pd=10.52u as=2.6p ps=10.52u w=10u l=0.28u
M206 a_20396_340# a_14476_1540# VDD VDD pfet_03v3 ad=1.125p pd=5.9u as=1.125p ps=5.9u w=2.5u l=0.28u
M207 VSS a_21516_4320# CDB VSS nfet_03v3 ad=0.45p pd=2.9u as=0.26p ps=1.52u w=1u l=0.28u
M208 a_7916_340# a_1516_340# VSS VSS nfet_03v3 ad=0.26p pd=1.52u as=0.45p ps=2.9u w=1u l=0.28u
M209 NCDA a_1292_12000# VDD VDD pfet_03v3 ad=2.6p pd=10.52u as=2.6p ps=10.52u w=10u l=0.28u
M210 a_1036_6700# a_972_8460# VDD VDD pfet_03v3 ad=0.65p pd=3.02u as=0.65p ps=3.02u w=2.5u l=0.28u
M211 CIA a_16876_340# VDD VDD pfet_03v3 ad=0.65p pd=3.02u as=0.65p ps=3.02u w=2.5u l=0.28u
M212 a_14476_1540# a_13380_1540# VDD VDD pfet_03v3 ad=0.65p pd=3.02u as=1.125p ps=5.9u w=2.5u l=0.28u
M213 VSS a_5036_4320# a_5676_4320# VSS nfet_03v3 ad=0.26p pd=1.52u as=0.26p ps=1.52u w=1u l=0.28u
M214 VSS a_5676_4320# NCIB VSS nfet_03v3 ad=0.26p pd=1.52u as=0.26p ps=1.52u w=1u l=0.28u
M215 a_5676_4320# a_5036_4320# VDD VDD pfet_03v3 ad=0.65p pd=3.02u as=0.65p ps=3.02u w=2.5u l=0.28u
M216 VDD a_21516_340# NCIA VDD pfet_03v3 ad=0.65p pd=3.02u as=0.65p ps=3.02u w=2.5u l=0.28u
M217 a_21516_4320# a_20876_4320# VSS VSS nfet_03v3 ad=0.26p pd=1.52u as=0.26p ps=1.52u w=1u l=0.28u
M218 a_1036_4320# a_972_4188# VDD VDD pfet_03v3 ad=0.65p pd=3.02u as=0.65p ps=3.02u w=2.5u l=0.28u
M219 VSS a_972_8460# a_1036_6700# VSS nfet_03v3 ad=0.26p pd=1.52u as=0.26p ps=1.52u w=1u l=0.28u
M220 VDD a_21516_340# NCIA VDD pfet_03v3 ad=0.65p pd=3.02u as=0.65p ps=3.02u w=2.5u l=0.28u
M221 a_12076_4320# a_11436_4320# VSS VSS nfet_03v3 ad=0.26p pd=1.52u as=0.26p ps=1.52u w=1u l=0.28u
M222 VDD a_16876_340# CIA VDD pfet_03v3 ad=0.65p pd=3.02u as=0.65p ps=3.02u w=2.5u l=0.28u
M223 VSS a_972_4188# a_1036_4320# VSS nfet_03v3 ad=0.26p pd=1.52u as=0.26p ps=1.52u w=1u l=0.28u
M224 VDD a_1292_12000# NCDA VDD pfet_03v3 ad=2.6p pd=10.52u as=2.6p ps=10.52u w=10u l=0.28u
M225 VDD a_21516_4320# CDB VDD pfet_03v3 ad=0.65p pd=3.02u as=0.65p ps=3.02u w=2.5u l=0.28u
M226 CIA a_16876_340# VSS VSS nfet_03v3 ad=0.26p pd=1.52u as=0.26p ps=1.52u w=1u l=0.28u
M227 VDD a_16876_340# CIA VDD pfet_03v3 ad=0.65p pd=3.02u as=0.65p ps=3.02u w=2.5u l=0.28u
M228 CDB a_21516_4320# VSS VSS nfet_03v3 ad=0.26p pd=1.52u as=0.26p ps=1.52u w=1u l=0.28u
M229 VDD a_21516_4320# CDB VDD pfet_03v3 ad=0.65p pd=3.02u as=0.65p ps=3.02u w=2.5u l=0.28u
M230 a_5676_4320# a_5036_4320# VSS VSS nfet_03v3 ad=0.26p pd=1.52u as=0.45p ps=2.9u w=1u l=0.28u
M231 VSS a_20876_340# a_21516_340# VSS nfet_03v3 ad=0.45p pd=2.9u as=0.26p ps=1.52u w=1u l=0.28u
M232 VDD a_5036_4320# a_5676_4320# VDD pfet_03v3 ad=0.65p pd=3.02u as=0.65p ps=3.02u w=2.5u l=0.28u
M233 VSS a_16876_340# CIA VSS nfet_03v3 ad=0.45p pd=2.9u as=0.26p ps=1.52u w=1u l=0.28u
M234 a_11116_340# a_10020_1540# VDD VDD pfet_03v3 ad=1.125p pd=5.9u as=1.125p ps=5.9u w=2.5u l=0.28u
M235 a_18316_4320# a_17836_4320# VDD VDD pfet_03v3 ad=0.65p pd=3.02u as=1.125p ps=5.9u w=2.5u l=0.28u
M236 VDD a_1516_340# a_8556_1540# VDD pfet_03v3 ad=1.125p pd=5.9u as=0.65p ps=3.02u w=2.5u l=0.28u
M237 a_21516_340# a_20876_340# VDD VDD pfet_03v3 ad=0.65p pd=3.02u as=1.125p ps=5.9u w=2.5u l=0.28u
M238 VSS a_27276_4320# a_972_8460# VSS nfet_03v3 ad=0.45p pd=2.9u as=0.26p ps=1.52u w=1u l=0.28u
M239 VSS a_11436_4320# a_12076_4320# VSS nfet_03v3 ad=0.26p pd=1.52u as=0.26p ps=1.52u w=1u l=0.28u
M240 VDD a_972_8460# a_1036_6700# VDD pfet_03v3 ad=1.125p pd=5.9u as=0.65p ps=3.02u w=2.5u l=0.28u
M241 CDB a_21516_4320# VDD VDD pfet_03v3 ad=0.65p pd=3.02u as=0.65p ps=3.02u w=2.5u l=0.28u
M242 VSS a_1036_340# a_1516_340# VSS nfet_03v3 ad=0.45p pd=2.9u as=0.26p ps=1.52u w=1u l=0.28u
M243 NCIA a_21516_340# VSS VSS nfet_03v3 ad=0.26p pd=1.52u as=0.26p ps=1.52u w=1u l=0.28u
M244 VSS a_21516_4320# CDB VSS nfet_03v3 ad=0.26p pd=1.52u as=0.26p ps=1.52u w=1u l=0.28u
M245 NCIA a_21516_340# VDD VDD pfet_03v3 ad=0.65p pd=3.02u as=0.65p ps=3.02u w=2.5u l=0.28u
M246 CDB a_21516_4320# VDD VDD pfet_03v3 ad=0.65p pd=3.02u as=0.65p ps=3.02u w=2.5u l=0.28u
M247 VDD a_1292_12000# NCDA VDD pfet_03v3 ad=2.6p pd=10.52u as=2.6p ps=10.52u w=10u l=0.28u
M248 VDD a_1036_4320# CIB VDD pfet_03v3 ad=0.65p pd=3.02u as=0.65p ps=3.02u w=2.5u l=0.28u
M249 VSS a_16876_340# CIA VSS nfet_03v3 ad=0.26p pd=1.52u as=0.26p ps=1.52u w=1u l=0.28u
M250 NCIA a_21516_340# VDD VDD pfet_03v3 ad=0.65p pd=3.02u as=0.65p ps=3.02u w=2.5u l=0.28u
M251 CDA a_12076_4320# VDD VDD pfet_03v3 ad=0.65p pd=3.02u as=0.65p ps=3.02u w=2.5u l=0.28u
M252 VSS a_12076_4320# CDA VSS nfet_03v3 ad=0.26p pd=1.52u as=0.26p ps=1.52u w=1u l=0.28u
M253 CIB a_1036_4320# VSS VSS nfet_03v3 ad=0.26p pd=1.52u as=0.45p ps=2.9u w=1u l=0.28u
M254 VSS a_12076_4320# CDA VSS nfet_03v3 ad=0.45p pd=2.9u as=0.26p ps=1.52u w=1u l=0.28u
M255 a_5380_1540# a_3940_1540# VDD VDD pfet_03v3 ad=0.45p pd=2.9u as=0.45p ps=2.9u w=1u l=2u
M256 VDD a_1036_4320# CIB VDD pfet_03v3 ad=0.65p pd=3.02u as=0.65p ps=3.02u w=2.5u l=0.28u
M257 a_8556_1540# a_6820_1540# VDD VDD pfet_03v3 ad=0.65p pd=3.02u as=1.125p ps=5.9u w=2.5u l=0.28u
M258 CDB a_21516_4320# VDD VDD pfet_03v3 ad=0.65p pd=3.02u as=0.65p ps=3.02u w=2.5u l=0.28u
M259 a_21516_340# a_20876_340# VSS VSS nfet_03v3 ad=0.26p pd=1.52u as=0.45p ps=2.9u w=1u l=0.28u
M260 a_972_8460# a_27276_4320# VSS VSS nfet_03v3 ad=0.26p pd=1.52u as=0.45p ps=2.9u w=1u l=0.28u
M261 CIA a_16876_340# VSS VSS nfet_03v3 ad=0.26p pd=1.52u as=0.26p ps=1.52u w=1u l=0.28u
M262 VSS a_5036_4320# a_5676_4320# VSS nfet_03v3 ad=0.45p pd=2.9u as=0.26p ps=1.52u w=1u l=0.28u
M263 a_9196_340# a_8556_1540# VSS VSS nfet_03v3 ad=0.45p pd=2.9u as=0.45p ps=2.9u w=1u l=0.28u
M264 VSS a_20876_340# a_21516_340# VSS nfet_03v3 ad=0.26p pd=1.52u as=0.26p ps=1.52u w=1u l=0.28u
M265 NCIB a_5676_4320# VDD VDD pfet_03v3 ad=0.65p pd=3.02u as=0.65p ps=3.02u w=2.5u l=0.28u
M266 VDD a_18316_4320# a_1292_12000# VDD pfet_03v3 ad=1.125p pd=5.9u as=0.65p ps=3.02u w=2.5u l=0.28u
M267 VDD a_18316_4320# a_1292_12000# VDD pfet_03v3 ad=0.65p pd=3.02u as=0.65p ps=3.02u w=2.5u l=0.28u
M268 VDD a_21516_340# NCIA VDD pfet_03v3 ad=0.65p pd=3.02u as=0.65p ps=3.02u w=2.5u l=0.28u
M269 a_10020_1540# a_1516_340# VSS VSS nfet_03v3 ad=0.45p pd=2.9u as=0.45p ps=2.9u w=1u l=4u
M270 VSS a_21516_340# NCIA VSS nfet_03v3 ad=0.26p pd=1.52u as=0.26p ps=1.52u w=1u l=0.28u
M271 VDD a_20876_340# a_21516_340# VDD pfet_03v3 ad=1.125p pd=5.9u as=0.65p ps=3.02u w=2.5u l=0.28u
M272 CDA a_12076_4320# VSS VSS nfet_03v3 ad=0.26p pd=1.52u as=0.45p ps=2.9u w=1u l=0.28u
M273 VDD a_12076_4320# CDA VDD pfet_03v3 ad=0.65p pd=3.02u as=0.65p ps=3.02u w=2.5u l=0.28u
M274 VDD a_21516_4320# CDB VDD pfet_03v3 ad=0.65p pd=3.02u as=0.65p ps=3.02u w=2.5u l=0.28u
M275 NCDB a_1036_6700# VDD VDD pfet_03v3 ad=2.6p pd=10.52u as=2.6p ps=10.52u w=10u l=0.28u
M276 a_16876_340# a_16236_340# VSS VSS nfet_03v3 ad=0.26p pd=1.52u as=0.26p ps=1.52u w=1u l=0.28u
M277 NCIA a_21516_340# VSS VSS nfet_03v3 ad=0.26p pd=1.52u as=0.26p ps=1.52u w=1u l=0.28u
M278 CDB a_21516_4320# VSS VSS nfet_03v3 ad=0.26p pd=1.52u as=0.26p ps=1.52u w=1u l=0.28u
M279 VDD a_21516_4320# CDB VDD pfet_03v3 ad=0.65p pd=3.02u as=0.65p ps=3.02u w=2.5u l=0.28u
M280 a_1292_12000# a_18316_4320# VDD VDD pfet_03v3 ad=0.65p pd=3.02u as=1.125p ps=5.9u w=2.5u l=0.28u
M281 CIB a_1036_4320# VDD VDD pfet_03v3 ad=0.65p pd=3.02u as=0.65p ps=3.02u w=2.5u l=0.28u
M282 a_20396_340# a_14476_1540# VSS VSS nfet_03v3 ad=0.45p pd=2.9u as=0.45p ps=2.9u w=1u l=0.28u
M283 VDD a_4492_4188# a_972_4188# VDD pfet_03v3 ad=1.125p pd=5.9u as=0.65p ps=3.02u w=2.5u l=0.28u
M284 VSS a_16236_340# a_16876_340# VSS nfet_03v3 ad=0.45p pd=2.9u as=0.26p ps=1.52u w=1u l=0.28u
M285 VDD a_1292_12000# NCDA VDD pfet_03v3 ad=4.5p pd=20.9u as=2.6p ps=10.52u w=10u l=0.28u
M286 VSS a_17836_4320# a_18316_4320# VSS nfet_03v3 ad=0.45p pd=2.9u as=0.26p ps=1.52u w=1u l=0.28u
M287 VSS a_1036_4320# CIB VSS nfet_03v3 ad=0.26p pd=1.52u as=0.26p ps=1.52u w=1u l=0.28u
M288 a_1292_12000# a_18316_4320# VDD VDD pfet_03v3 ad=0.65p pd=3.02u as=0.65p ps=3.02u w=2.5u l=0.28u
M289 a_10020_1540# a_1516_340# VDD VDD pfet_03v3 ad=0.45p pd=2.9u as=0.45p ps=2.9u w=1u l=2u
M290 VSS a_1036_6700# NCDB VSS nfet_03v3 ad=2.08p pd=8.52u as=2.08p ps=8.52u w=8u l=0.28u
M291 a_21516_340# a_20876_340# VDD VDD pfet_03v3 ad=0.65p pd=3.02u as=0.65p ps=3.02u w=2.5u l=0.28u
M292 VSS a_6820_1540# a_7916_340# VSS nfet_03v3 ad=0.45p pd=2.9u as=0.26p ps=1.52u w=1u l=0.28u
M293 NCIB a_5676_4320# VDD VDD pfet_03v3 ad=0.65p pd=3.02u as=0.65p ps=3.02u w=2.5u l=0.28u
M294 a_20876_340# a_20396_340# VSS VSS nfet_03v3 ad=0.26p pd=1.52u as=0.45p ps=2.9u w=1u l=0.28u
M295 a_13380_1540# a_11940_1540# VDD VDD pfet_03v3 ad=0.45p pd=2.9u as=0.45p ps=2.9u w=1u l=2u
M296 VSS a_5676_4320# NCIB VSS nfet_03v3 ad=0.26p pd=1.52u as=0.26p ps=1.52u w=1u l=0.28u
M297 NCIB a_5676_4320# VSS VSS nfet_03v3 ad=0.26p pd=1.52u as=0.26p ps=1.52u w=1u l=0.28u
M298 NCIA a_21516_340# VSS VSS nfet_03v3 ad=0.26p pd=1.52u as=0.26p ps=1.52u w=1u l=0.28u
M299 a_1516_340# a_1036_340# VDD VDD pfet_03v3 ad=0.65p pd=3.02u as=1.125p ps=5.9u w=2.5u l=0.28u
M300 a_8556_340# a_6820_1540# VSS VSS nfet_03v3 ad=0.52p pd=2.52u as=0.9p ps=4.9u w=2u l=0.28u
M301 a_21516_4320# a_20876_4320# VDD VDD pfet_03v3 ad=0.65p pd=3.02u as=1.125p ps=5.9u w=2.5u l=0.28u
M302 VDD a_5676_4320# NCIB VDD pfet_03v3 ad=0.65p pd=3.02u as=0.65p ps=3.02u w=2.5u l=0.28u
M303 CIB a_1036_4320# VSS VSS nfet_03v3 ad=0.26p pd=1.52u as=0.26p ps=1.52u w=1u l=0.28u
M304 VDD a_1036_4320# CIB VDD pfet_03v3 ad=0.65p pd=3.02u as=0.65p ps=3.02u w=2.5u l=0.28u
M305 NCIB a_5676_4320# VSS VSS nfet_03v3 ad=0.26p pd=1.52u as=0.26p ps=1.52u w=1u l=0.28u
M306 NCDB a_1036_6700# VSS VSS nfet_03v3 ad=2.08p pd=8.52u as=2.08p ps=8.52u w=8u l=0.28u
M307 a_972_4188# a_4492_4188# VDD VDD pfet_03v3 ad=0.65p pd=3.02u as=1.125p ps=5.9u w=2.5u l=0.28u
M308 VSS a_21516_340# NCIA VSS nfet_03v3 ad=0.26p pd=1.52u as=0.26p ps=1.52u w=1u l=0.28u
M309 VSS a_12076_4320# CDA VSS nfet_03v3 ad=0.26p pd=1.52u as=0.26p ps=1.52u w=1u l=0.28u
M310 CIB a_1036_4320# VSS VSS nfet_03v3 ad=0.26p pd=1.52u as=0.26p ps=1.52u w=1u l=0.28u
M311 CDA a_12076_4320# VDD VDD pfet_03v3 ad=0.65p pd=3.02u as=0.65p ps=3.02u w=2.5u l=0.28u
M312 VDD a_1036_4320# CIB VDD pfet_03v3 ad=1.125p pd=5.9u as=0.65p ps=3.02u w=2.5u l=0.28u
M313 CDB a_21516_4320# VDD VDD pfet_03v3 ad=0.65p pd=3.02u as=0.65p ps=3.02u w=2.5u l=0.28u
M314 NCDA a_1292_12000# VSS VSS nfet_03v3 ad=2.08p pd=8.52u as=3.6p ps=16.9u w=8u l=0.28u
M315 VSS a_12076_4320# CDA VSS nfet_03v3 ad=0.26p pd=1.52u as=0.26p ps=1.52u w=1u l=0.28u
M316 CDB a_21516_4320# VDD VDD pfet_03v3 ad=0.65p pd=3.02u as=0.65p ps=3.02u w=2.5u l=0.28u
M317 VSS a_21516_4320# CDB VSS nfet_03v3 ad=0.26p pd=1.52u as=0.26p ps=1.52u w=1u l=0.28u
M318 NCIB a_5676_4320# VSS VSS nfet_03v3 ad=0.26p pd=1.52u as=0.26p ps=1.52u w=1u l=0.28u
M319 VSS a_5676_4320# NCIB VSS nfet_03v3 ad=0.26p pd=1.52u as=0.26p ps=1.52u w=1u l=0.28u
M320 a_5036_4320# a_4556_4320# VDD VDD pfet_03v3 ad=0.65p pd=3.02u as=1.125p ps=5.9u w=2.5u l=0.28u
M321 NCIB a_5676_4320# VDD VDD pfet_03v3 ad=0.65p pd=3.02u as=0.65p ps=3.02u w=2.5u l=0.28u
M322 a_1292_12000# a_18316_4320# VSS VSS nfet_03v3 ad=0.26p pd=1.52u as=0.26p ps=1.52u w=1u l=0.28u
M323 a_1036_6700# a_972_8460# VSS VSS nfet_03v3 ad=0.26p pd=1.52u as=0.45p ps=2.9u w=1u l=0.28u
M324 VSS a_5676_4320# NCIB VSS nfet_03v3 ad=0.26p pd=1.52u as=0.26p ps=1.52u w=1u l=0.28u
M325 VDD a_21516_340# NCIA VDD pfet_03v3 ad=0.65p pd=3.02u as=0.65p ps=3.02u w=2.5u l=0.28u
M326 VSS a_21516_340# NCIA VSS nfet_03v3 ad=0.26p pd=1.52u as=0.26p ps=1.52u w=1u l=0.28u
M327 NCDA a_1292_12000# VDD VDD pfet_03v3 ad=2.6p pd=10.52u as=2.6p ps=10.52u w=10u l=0.28u
M328 VDD a_11436_4320# a_12076_4320# VDD pfet_03v3 ad=0.65p pd=3.02u as=0.65p ps=3.02u w=2.5u l=0.28u
M329 a_11436_4320# a_7916_340# VSS VSS nfet_03v3 ad=0.26p pd=1.52u as=0.45p ps=2.9u w=1u l=0.28u
M330 VDD a_16236_340# a_16876_340# VDD pfet_03v3 ad=1.125p pd=5.9u as=0.65p ps=3.02u w=2.5u l=0.28u
M331 VSS a_5676_4320# NCIB VSS nfet_03v3 ad=0.26p pd=1.52u as=0.26p ps=1.52u w=1u l=0.28u
M332 NCIB a_5676_4320# VDD VDD pfet_03v3 ad=0.65p pd=3.02u as=0.65p ps=3.02u w=2.5u l=0.28u
M333 a_21516_4320# a_20876_4320# VSS VSS nfet_03v3 ad=0.26p pd=1.52u as=0.26p ps=1.52u w=1u l=0.28u
M334 NCIA a_21516_340# VSS VSS nfet_03v3 ad=0.26p pd=1.52u as=0.26p ps=1.52u w=1u l=0.28u
M335 VDD a_20876_4320# a_21516_4320# VDD pfet_03v3 ad=1.125p pd=5.9u as=0.65p ps=3.02u w=2.5u l=0.28u
M336 CDB a_21516_4320# VSS VSS nfet_03v3 ad=0.26p pd=1.52u as=0.26p ps=1.52u w=1u l=0.28u
M337 VDD a_21516_4320# CDB VDD pfet_03v3 ad=0.65p pd=3.02u as=0.65p ps=3.02u w=2.5u l=0.28u
M338 VSS a_972_8460# a_1036_6700# VSS nfet_03v3 ad=0.26p pd=1.52u as=0.26p ps=1.52u w=1u l=0.28u
M339 a_972_4188# a_4492_4188# VSS VSS nfet_03v3 ad=0.26p pd=1.52u as=0.45p ps=2.9u w=1u l=0.28u
M340 VDD a_12076_4320# CDA VDD pfet_03v3 ad=0.65p pd=3.02u as=0.65p ps=3.02u w=2.5u l=0.28u
M341 CDA a_12076_4320# VSS VSS nfet_03v3 ad=0.26p pd=1.52u as=0.26p ps=1.52u w=1u l=0.28u
M342 VDD a_4556_4320# a_5036_4320# VDD pfet_03v3 ad=1.125p pd=5.9u as=0.65p ps=3.02u w=2.5u l=0.28u
M343 VSS a_5676_4320# NCIB VSS nfet_03v3 ad=0.45p pd=2.9u as=0.26p ps=1.52u w=1u l=0.28u
M344 CDA a_12076_4320# VSS VSS nfet_03v3 ad=0.26p pd=1.52u as=0.26p ps=1.52u w=1u l=0.28u
M345 CDB a_21516_4320# VSS VSS nfet_03v3 ad=0.26p pd=1.52u as=0.26p ps=1.52u w=1u l=0.28u
M346 a_12076_4320# a_11436_4320# VDD VDD pfet_03v3 ad=0.65p pd=3.02u as=1.125p ps=5.9u w=2.5u l=0.28u
M347 NCIB a_5676_4320# VSS VSS nfet_03v3 ad=0.26p pd=1.52u as=0.26p ps=1.52u w=1u l=0.28u
M348 VDD a_972_8460# a_1036_6700# VDD pfet_03v3 ad=0.65p pd=3.02u as=0.65p ps=3.02u w=2.5u l=0.28u
M349 VDD a_5676_4320# NCIB VDD pfet_03v3 ad=0.65p pd=3.02u as=0.65p ps=3.02u w=2.5u l=0.28u
M350 VSS a_20876_4320# a_21516_4320# VSS nfet_03v3 ad=0.26p pd=1.52u as=0.26p ps=1.52u w=1u l=0.28u
M351 a_21516_340# a_20876_340# VSS VSS nfet_03v3 ad=0.26p pd=1.52u as=0.26p ps=1.52u w=1u l=0.28u
M352 a_21516_4320# a_20876_4320# VDD VDD pfet_03v3 ad=0.65p pd=3.02u as=0.65p ps=3.02u w=2.5u l=0.28u
M353 a_1036_6700# a_972_8460# VSS VSS nfet_03v3 ad=0.26p pd=1.52u as=0.26p ps=1.52u w=1u l=0.28u
M354 NCIB a_5676_4320# VSS VSS nfet_03v3 ad=0.26p pd=1.52u as=0.26p ps=1.52u w=1u l=0.28u
M355 VDD a_1036_6700# NCDB VDD pfet_03v3 ad=2.6p pd=10.52u as=2.6p ps=10.52u w=10u l=0.28u
M356 NCIA a_21516_340# VDD VDD pfet_03v3 ad=0.65p pd=3.02u as=0.65p ps=3.02u w=2.5u l=0.28u
M357 a_12076_4320# a_11436_4320# VDD VDD pfet_03v3 ad=0.65p pd=3.02u as=0.65p ps=3.02u w=2.5u l=0.28u
M358 VSS a_12076_4320# CDA VSS nfet_03v3 ad=0.26p pd=1.52u as=0.26p ps=1.52u w=1u l=0.28u
M359 CDA a_12076_4320# VDD VDD pfet_03v3 ad=0.65p pd=3.02u as=0.65p ps=3.02u w=2.5u l=0.28u
M360 VDD a_972_4188# a_1036_4320# VDD pfet_03v3 ad=0.65p pd=3.02u as=0.65p ps=3.02u w=2.5u l=0.28u
M361 CIA a_16876_340# VDD VDD pfet_03v3 ad=0.65p pd=3.02u as=0.65p ps=3.02u w=2.5u l=0.28u
M362 VSS a_12076_4320# CDA VSS nfet_03v3 ad=0.26p pd=1.52u as=0.26p ps=1.52u w=1u l=0.28u
M363 VSS a_21516_340# NCIA VSS nfet_03v3 ad=0.26p pd=1.52u as=0.26p ps=1.52u w=1u l=0.28u
M364 VSS a_21516_4320# CDB VSS nfet_03v3 ad=0.26p pd=1.52u as=0.26p ps=1.52u w=1u l=0.28u
M365 a_27276_4320# a_9196_340# VDD VDD pfet_03v3 ad=1.125p pd=5.9u as=1.125p ps=5.9u w=2.5u l=0.28u
M366 a_5676_4320# a_5036_4320# VDD VDD pfet_03v3 ad=0.65p pd=3.02u as=0.65p ps=3.02u w=2.5u l=0.28u
M367 CIA a_16876_340# VDD VDD pfet_03v3 ad=0.65p pd=3.02u as=0.65p ps=3.02u w=2.5u l=0.28u
M368 VSS a_12076_4320# CDA VSS nfet_03v3 ad=0.26p pd=1.52u as=0.26p ps=1.52u w=1u l=0.28u
M369 a_17836_4320# a_7916_340# VDD VDD pfet_03v3 ad=1.125p pd=5.9u as=1.125p ps=5.9u w=2.5u l=0.28u
M370 VSS a_20396_340# a_20876_340# VSS nfet_03v3 ad=0.45p pd=2.9u as=0.26p ps=1.52u w=1u l=0.28u
M371 a_5676_4320# a_5036_4320# VDD VDD pfet_03v3 ad=0.65p pd=3.02u as=0.65p ps=3.02u w=2.5u l=0.28u
M372 VDD a_20396_340# a_20876_340# VDD pfet_03v3 ad=1.125p pd=5.9u as=0.65p ps=3.02u w=2.5u l=0.28u
M373 VDD a_21516_340# NCIA VDD pfet_03v3 ad=0.65p pd=3.02u as=0.65p ps=3.02u w=2.5u l=0.28u
M374 VDD a_11436_4320# a_12076_4320# VDD pfet_03v3 ad=0.65p pd=3.02u as=0.65p ps=3.02u w=2.5u l=0.28u
M375 a_1036_6700# a_972_8460# VDD VDD pfet_03v3 ad=0.65p pd=3.02u as=0.65p ps=3.02u w=2.5u l=0.28u
M376 a_1036_4320# a_972_4188# VSS VSS nfet_03v3 ad=0.26p pd=1.52u as=0.45p ps=2.9u w=1u l=0.28u
M377 a_1036_4320# a_972_4188# VDD VDD pfet_03v3 ad=0.65p pd=3.02u as=0.65p ps=3.02u w=2.5u l=0.28u
M378 VDD a_1036_6700# NCDB VDD pfet_03v3 ad=2.6p pd=10.52u as=2.6p ps=10.52u w=10u l=0.28u
M379 a_8556_1540# a_1516_340# a_8556_340# VSS nfet_03v3 ad=0.9p pd=4.9u as=0.52p ps=2.52u w=2u l=0.28u
M380 VDD a_11436_4320# a_12076_4320# VDD pfet_03v3 ad=1.125p pd=5.9u as=0.65p ps=3.02u w=2.5u l=0.28u
M381 a_12076_4320# a_11436_4320# VSS VSS nfet_03v3 ad=0.26p pd=1.52u as=0.26p ps=1.52u w=1u l=0.28u
M382 a_1036_6700# a_972_8460# VDD VDD pfet_03v3 ad=0.65p pd=3.02u as=0.65p ps=3.02u w=2.5u l=0.28u
M383 a_3940_1540# a_2500_1540# VDD VDD pfet_03v3 ad=0.45p pd=2.9u as=0.45p ps=2.9u w=1u l=2u
M384 VSS a_5676_4320# NCIB VSS nfet_03v3 ad=0.26p pd=1.52u as=0.26p ps=1.52u w=1u l=0.28u
M385 VDD a_21516_4320# CDB VDD pfet_03v3 ad=0.65p pd=3.02u as=0.65p ps=3.02u w=2.5u l=0.28u
M386 a_16236_340# a_14476_1540# VSS VSS nfet_03v3 ad=0.26p pd=1.52u as=0.45p ps=2.9u w=1u l=0.28u
M387 NCIA a_21516_340# VSS VSS nfet_03v3 ad=0.26p pd=1.52u as=0.26p ps=1.52u w=1u l=0.28u
M388 VSS a_1292_12000# NCDA VSS nfet_03v3 ad=3.6p pd=16.9u as=2.08p ps=8.52u w=8u l=0.28u
M389 VDD a_21516_340# NCIA VDD pfet_03v3 ad=0.65p pd=3.02u as=0.65p ps=3.02u w=2.5u l=0.28u
M390 CDB a_21516_4320# VSS VSS nfet_03v3 ad=0.26p pd=1.52u as=0.45p ps=2.9u w=1u l=0.28u
M391 VSS a_972_4188# a_1036_4320# VSS nfet_03v3 ad=0.45p pd=2.9u as=0.26p ps=1.52u w=1u l=0.28u
M392 CDA a_12076_4320# VSS VSS nfet_03v3 ad=0.26p pd=1.52u as=0.26p ps=1.52u w=1u l=0.28u
M393 CIB a_1036_4320# VDD VDD pfet_03v3 ad=0.65p pd=3.02u as=0.65p ps=3.02u w=2.5u l=0.28u
M394 a_3940_1540# a_2500_1540# VSS VSS nfet_03v3 ad=0.45p pd=2.9u as=0.45p ps=2.9u w=1u l=4u
M395 VDD a_5036_4320# a_5676_4320# VDD pfet_03v3 ad=0.65p pd=3.02u as=0.65p ps=3.02u w=2.5u l=0.28u
M396 NCDB a_1036_6700# VSS VSS nfet_03v3 ad=2.08p pd=8.52u as=3.6p ps=16.9u w=8u l=0.28u
M397 a_20876_340# a_20396_340# VDD VDD pfet_03v3 ad=0.65p pd=3.02u as=1.125p ps=5.9u w=2.5u l=0.28u
M398 NCDB a_1036_6700# VDD VDD pfet_03v3 ad=2.6p pd=10.52u as=2.6p ps=10.52u w=10u l=0.28u
M399 VDD a_16876_340# CIA VDD pfet_03v3 ad=1.125p pd=5.9u as=0.65p ps=3.02u w=2.5u l=0.28u
M400 CDA a_12076_4320# VSS VSS nfet_03v3 ad=0.26p pd=1.52u as=0.26p ps=1.52u w=1u l=0.28u
M401 NCDA a_1292_12000# VDD VDD pfet_03v3 ad=2.6p pd=10.52u as=4.5p ps=20.9u w=10u l=0.28u
M402 a_11116_340# a_10020_1540# VSS VSS nfet_03v3 ad=0.45p pd=2.9u as=0.45p ps=2.9u w=1u l=0.28u
M403 VDD a_972_8460# a_1036_6700# VDD pfet_03v3 ad=0.65p pd=3.02u as=0.65p ps=3.02u w=2.5u l=0.28u
M404 a_5676_4320# a_5036_4320# VSS VSS nfet_03v3 ad=0.26p pd=1.52u as=0.26p ps=1.52u w=1u l=0.28u
M405 NCIA a_21516_340# VSS VSS nfet_03v3 ad=0.26p pd=1.52u as=0.26p ps=1.52u w=1u l=0.28u
M406 a_15116_340# a_13380_1540# a_15116_1540# VDD pfet_03v3 ad=2.25p pd=10.9u as=1.3p ps=5.52u w=5u l=0.28u
M407 a_11940_1540# a_11116_340# VSS VSS nfet_03v3 ad=0.45p pd=2.9u as=0.45p ps=2.9u w=1u l=4u
M408 VDD a_5676_4320# NCIB VDD pfet_03v3 ad=0.65p pd=3.02u as=0.65p ps=3.02u w=2.5u l=0.28u
M409 a_1292_12000# a_18316_4320# VDD VDD pfet_03v3 ad=0.65p pd=3.02u as=0.65p ps=3.02u w=2.5u l=0.28u
M410 VSS a_1036_6700# NCDB VSS nfet_03v3 ad=2.08p pd=8.52u as=2.08p ps=8.52u w=8u l=0.28u
M411 NCIA a_21516_340# VDD VDD pfet_03v3 ad=0.65p pd=3.02u as=0.65p ps=3.02u w=2.5u l=0.28u
M412 CDA a_12076_4320# VDD VDD pfet_03v3 ad=0.65p pd=3.02u as=0.65p ps=3.02u w=2.5u l=0.28u
M413 a_1036_4320# a_972_4188# VSS VSS nfet_03v3 ad=0.26p pd=1.52u as=0.26p ps=1.52u w=1u l=0.28u
M414 VDD a_1036_4320# CIB VDD pfet_03v3 ad=0.65p pd=3.02u as=0.65p ps=3.02u w=2.5u l=0.28u
M415 a_15116_340# a_11116_340# VSS VSS nfet_03v3 ad=0.26p pd=1.52u as=0.45p ps=2.9u w=1u l=0.28u
M416 VSS a_21516_340# NCIA VSS nfet_03v3 ad=0.26p pd=1.52u as=0.26p ps=1.52u w=1u l=0.28u
M417 CDA a_12076_4320# VDD VDD pfet_03v3 ad=0.65p pd=3.02u as=0.65p ps=3.02u w=2.5u l=0.28u
M418 CIA a_16876_340# VDD VDD pfet_03v3 ad=0.65p pd=3.02u as=0.65p ps=3.02u w=2.5u l=0.28u
M419 VSS a_21516_4320# CDB VSS nfet_03v3 ad=0.26p pd=1.52u as=0.26p ps=1.52u w=1u l=0.28u
M420 CDB a_21516_4320# VDD VDD pfet_03v3 ad=0.65p pd=3.02u as=0.65p ps=3.02u w=2.5u l=0.28u
M421 VSS a_4492_4188# a_972_4188# VSS nfet_03v3 ad=0.45p pd=2.9u as=0.26p ps=1.52u w=1u l=0.28u
M422 VSS a_21516_4320# CDB VSS nfet_03v3 ad=0.26p pd=1.52u as=0.26p ps=1.52u w=1u l=0.28u
M423 a_11940_1540# a_11116_340# VDD VDD pfet_03v3 ad=0.45p pd=2.9u as=0.45p ps=2.9u w=1u l=2u
M424 VSS a_5036_4320# a_5676_4320# VSS nfet_03v3 ad=0.26p pd=1.52u as=0.26p ps=1.52u w=1u l=0.28u
M425 CIA a_16876_340# VSS VSS nfet_03v3 ad=0.26p pd=1.52u as=0.26p ps=1.52u w=1u l=0.28u
M426 VDD a_20876_340# a_21516_340# VDD pfet_03v3 ad=0.65p pd=3.02u as=0.65p ps=3.02u w=2.5u l=0.28u
M427 VDD a_18316_4320# a_1292_12000# VDD pfet_03v3 ad=0.65p pd=3.02u as=0.65p ps=3.02u w=2.5u l=0.28u
M428 NCIB a_5676_4320# VDD VDD pfet_03v3 ad=0.65p pd=3.02u as=1.125p ps=5.9u w=2.5u l=0.28u
M429 NCDA a_1292_12000# VSS VSS nfet_03v3 ad=2.08p pd=8.52u as=2.08p ps=8.52u w=8u l=0.28u
M430 a_18316_4320# a_17836_4320# VSS VSS nfet_03v3 ad=0.26p pd=1.52u as=0.45p ps=2.9u w=1u l=0.28u
M431 VDD a_18316_4320# a_1292_12000# VDD pfet_03v3 ad=0.65p pd=3.02u as=0.65p ps=3.02u w=2.5u l=0.28u
M432 VSS a_20876_340# a_21516_340# VSS nfet_03v3 ad=0.26p pd=1.52u as=0.26p ps=1.52u w=1u l=0.28u
M433 VDD a_20876_340# a_21516_340# VDD pfet_03v3 ad=0.65p pd=3.02u as=0.65p ps=3.02u w=2.5u l=0.28u
M434 a_6820_1540# a_5380_1540# VSS VSS nfet_03v3 ad=0.45p pd=2.9u as=0.45p ps=2.9u w=1u l=4u
M435 VDD a_5676_4320# NCIB VDD pfet_03v3 ad=0.65p pd=3.02u as=0.65p ps=3.02u w=2.5u l=0.28u
M436 VSS a_16876_340# CIA VSS nfet_03v3 ad=0.26p pd=1.52u as=0.26p ps=1.52u w=1u l=0.28u
M437 VDD a_12076_4320# CDA VDD pfet_03v3 ad=0.65p pd=3.02u as=0.65p ps=3.02u w=2.5u l=0.28u
M438 VDD a_21516_4320# CDB VDD pfet_03v3 ad=0.65p pd=3.02u as=0.65p ps=3.02u w=2.5u l=0.28u
M439 VDD a_9196_340# a_20876_4320# VDD pfet_03v3 ad=1.125p pd=5.9u as=0.65p ps=3.02u w=2.5u l=0.28u
M440 CDB a_21516_4320# VSS VSS nfet_03v3 ad=0.26p pd=1.52u as=0.26p ps=1.52u w=1u l=0.28u
M441 VDD a_14476_1540# a_16236_340# VDD pfet_03v3 ad=1.125p pd=5.9u as=0.65p ps=3.02u w=2.5u l=0.28u
M442 VDD a_21516_340# NCIA VDD pfet_03v3 ad=1.125p pd=5.9u as=0.65p ps=3.02u w=2.5u l=0.28u
M443 CDB a_21516_4320# VSS VSS nfet_03v3 ad=0.26p pd=1.52u as=0.26p ps=1.52u w=1u l=0.28u
M444 VSS a_1036_4320# CIB VSS nfet_03v3 ad=0.26p pd=1.52u as=0.26p ps=1.52u w=1u l=0.28u
M445 CIB a_1036_4320# VDD VDD pfet_03v3 ad=0.65p pd=3.02u as=0.65p ps=3.02u w=2.5u l=0.28u
M446 NCIA a_21516_340# VSS VSS nfet_03v3 ad=0.26p pd=1.52u as=0.26p ps=1.52u w=1u l=0.28u
M447 a_14476_340# a_13380_1540# VSS VSS nfet_03v3 ad=0.52p pd=2.52u as=0.9p ps=4.9u w=2u l=0.28u
M448 CDA a_12076_4320# VSS VSS nfet_03v3 ad=0.26p pd=1.52u as=0.26p ps=1.52u w=1u l=0.28u
M449 VDD a_12076_4320# CDA VDD pfet_03v3 ad=0.65p pd=3.02u as=0.65p ps=3.02u w=2.5u l=0.28u
M450 VSS a_1036_4320# CIB VSS nfet_03v3 ad=0.26p pd=1.52u as=0.26p ps=1.52u w=1u l=0.28u
M451 VDD a_21516_4320# CDB VDD pfet_03v3 ad=0.65p pd=3.02u as=0.65p ps=3.02u w=2.5u l=0.28u
M452 CDB a_21516_4320# VSS VSS nfet_03v3 ad=0.26p pd=1.52u as=0.26p ps=1.52u w=1u l=0.28u
M453 a_21516_340# a_20876_340# VDD VDD pfet_03v3 ad=0.65p pd=3.02u as=0.65p ps=3.02u w=2.5u l=0.28u
M454 NCIB a_5676_4320# VDD VDD pfet_03v3 ad=0.65p pd=3.02u as=0.65p ps=3.02u w=2.5u l=0.28u
M455 VSS a_21516_340# NCIA VSS nfet_03v3 ad=0.45p pd=2.9u as=0.26p ps=1.52u w=1u l=0.28u
M456 a_20876_4320# a_9196_340# VDD VDD pfet_03v3 ad=0.65p pd=3.02u as=1.125p ps=5.9u w=2.5u l=0.28u
M457 a_1292_12000# a_18316_4320# VDD VDD pfet_03v3 ad=0.65p pd=3.02u as=0.65p ps=3.02u w=2.5u l=0.28u
M458 NCDB a_1036_6700# VDD VDD pfet_03v3 ad=2.6p pd=10.52u as=2.6p ps=10.52u w=10u l=0.28u
M459 NCIB a_5676_4320# VSS VSS nfet_03v3 ad=0.26p pd=1.52u as=0.26p ps=1.52u w=1u l=0.28u
M460 VDD a_5676_4320# NCIB VDD pfet_03v3 ad=0.65p pd=3.02u as=0.65p ps=3.02u w=2.5u l=0.28u
M461 VSS a_18316_4320# a_1292_12000# VSS nfet_03v3 ad=0.45p pd=2.9u as=0.26p ps=1.52u w=1u l=0.28u
M462 CIA a_16876_340# VSS VSS nfet_03v3 ad=0.26p pd=1.52u as=0.26p ps=1.52u w=1u l=0.28u
M463 CDA a_12076_4320# VDD VDD pfet_03v3 ad=0.65p pd=3.02u as=0.65p ps=3.02u w=2.5u l=0.28u
M464 VSS a_18316_4320# a_1292_12000# VSS nfet_03v3 ad=0.26p pd=1.52u as=0.26p ps=1.52u w=1u l=0.28u
M465 NCIA a_21516_340# VDD VDD pfet_03v3 ad=0.65p pd=3.02u as=0.65p ps=3.02u w=2.5u l=0.28u
M466 VSS a_20876_340# a_21516_340# VSS nfet_03v3 ad=0.26p pd=1.52u as=0.26p ps=1.52u w=1u l=0.28u
M467 CDA a_12076_4320# VDD VDD pfet_03v3 ad=0.65p pd=3.02u as=0.65p ps=3.02u w=2.5u l=0.28u
M468 VSS a_12076_4320# CDA VSS nfet_03v3 ad=0.26p pd=1.52u as=0.26p ps=1.52u w=1u l=0.28u
M469 VSS a_16876_340# CIA VSS nfet_03v3 ad=0.26p pd=1.52u as=0.26p ps=1.52u w=1u l=0.28u
M470 VSS a_21516_4320# CDB VSS nfet_03v3 ad=0.26p pd=1.52u as=0.26p ps=1.52u w=1u l=0.28u
M471 CDB a_21516_4320# VDD VDD pfet_03v3 ad=0.65p pd=3.02u as=0.65p ps=3.02u w=2.5u l=0.28u
M472 VSS a_21516_340# NCIA VSS nfet_03v3 ad=0.26p pd=1.52u as=0.26p ps=1.52u w=1u l=0.28u
M473 a_16876_340# a_16236_340# VDD VDD pfet_03v3 ad=0.65p pd=3.02u as=0.65p ps=3.02u w=2.5u l=0.28u
M474 VDD a_1036_6700# NCDB VDD pfet_03v3 ad=2.6p pd=10.52u as=2.6p ps=10.52u w=10u l=0.28u
M475 VSS a_21516_4320# CDB VSS nfet_03v3 ad=0.26p pd=1.52u as=0.26p ps=1.52u w=1u l=0.28u
M476 CIB a_1036_4320# VSS VSS nfet_03v3 ad=0.26p pd=1.52u as=0.26p ps=1.52u w=1u l=0.28u
M477 VDD a_18316_4320# a_1292_12000# VDD pfet_03v3 ad=0.65p pd=3.02u as=0.65p ps=3.02u w=2.5u l=0.28u
M478 a_1292_12000# a_18316_4320# VSS VSS nfet_03v3 ad=0.26p pd=1.52u as=0.45p ps=2.9u w=1u l=0.28u
M479 a_1036_340# CHOP1 VSS VSS nfet_03v3 ad=0.45p pd=2.9u as=0.45p ps=2.9u w=1u l=0.28u
M480 VDD a_1292_12000# NCDA VDD pfet_03v3 ad=2.6p pd=10.52u as=2.6p ps=10.52u w=10u l=0.28u
M481 NCIA a_21516_340# VSS VSS nfet_03v3 ad=0.26p pd=1.52u as=0.26p ps=1.52u w=1u l=0.28u
M482 a_1292_12000# a_18316_4320# VSS VSS nfet_03v3 ad=0.26p pd=1.52u as=0.26p ps=1.52u w=1u l=0.28u
M483 NCDB a_1036_6700# VDD VDD pfet_03v3 ad=2.6p pd=10.52u as=4.5p ps=20.9u w=10u l=0.28u
M484 VDD a_21516_340# NCIA VDD pfet_03v3 ad=0.65p pd=3.02u as=0.65p ps=3.02u w=2.5u l=0.28u
M485 NCIB a_5676_4320# VSS VSS nfet_03v3 ad=0.26p pd=1.52u as=0.26p ps=1.52u w=1u l=0.28u
.ends
