* NGSPICE file created from adc_flat.ext - technology: gf180mcuD

.subckt adc_flat
X0 m4_200_80# m4_80_680# cap_mim_2f0_m4m5_noshield c_width=98.82999u c_length=98.82999u
C0 m4_200_80# m4_80_680# 17.5289f
C1 m4_200_80# w_80_80# 88.4691f ; **FLOATING
C2 m4_80_680# w_80_80# 18.6282f ; **FLOATING
.ends
