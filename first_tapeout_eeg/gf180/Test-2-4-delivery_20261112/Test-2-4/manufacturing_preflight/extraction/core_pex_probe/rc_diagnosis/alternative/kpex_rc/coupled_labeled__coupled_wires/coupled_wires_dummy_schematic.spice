.subckt coupled_wires VDD VSS
.ends
.end
