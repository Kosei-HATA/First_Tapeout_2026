* NGSPICE file created from inverter_link.ext - technology: gf180mcuD

.subckt inverter_link IN OUT AG2
X0 OUT a_244_68# a_20056_472# w_19914_352# pfet_05v0 ad=0.5368p pd=3.32u as=0.5368p ps=3.32u w=1.22u l=0.5u
X1 a_244_68# IN a_36_68# w_n86_n86# nfet_05v0 ad=0.3608p pd=2.52u as=0.3608p ps=2.52u w=0.82u l=0.6u
X2 a_244_68# IN a_56_472# w_n86_352# pfet_05v0 ad=0.5368p pd=3.32u as=0.5368p ps=3.32u w=1.22u l=0.5u
X3 OUT a_244_68# a_20036_68# w_n86_n86# nfet_05v0 ad=0.3608p pd=2.52u as=0.3608p ps=2.52u w=0.82u l=0.6u
C0 w_n86_352# a_244_68# 0.05633f
C1 w_n86_352# a_56_472# 0.0901f
C2 w_n86_352# a_36_68# 0.0054f
C3 w_n86_352# IN 0.13776f
C4 w_19914_352# a_244_68# 0.15854f
C5 w_19914_352# a_20056_472# 0.09f
C6 w_19914_352# a_20036_68# 0.00614f
C7 w_19914_352# OUT 0.03208f
C8 a_244_68# a_56_472# 0.15445f
C9 a_244_68# a_20056_472# 0.08034f
C10 a_244_68# a_36_68# 0.13836f
C11 a_244_68# a_20036_68# 0.10305f
C12 a_244_68# IN 0.26972f
C13 a_244_68# OUT 0.26601f
C14 a_244_68# AG2 1.44327f
C15 a_56_472# a_36_68# 0.01766f
C16 a_56_472# IN 0.05098f
C17 a_20056_472# a_20036_68# 0.01085f
C18 a_20056_472# OUT 0.13942f
C19 a_36_68# IN 0.05681f
C20 a_20036_68# OUT 0.11686f
C21 AG2 w_n86_n86# 5.3327f
C22 OUT w_n86_n86# 0.10331f
C23 IN w_n86_n86# 0.2304f
C24 a_20036_68# w_n86_n86# 0.22748f
C25 a_36_68# w_n86_n86# 0.22766f
C26 a_20056_472# w_n86_n86# 0.16348f
C27 a_56_472# w_n86_n86# 0.16277f
C28 a_244_68# w_n86_n86# 8.88145f
C29 w_19914_352# w_n86_n86# 0.96348f
C30 w_n86_352# w_n86_n86# 0.96348f
.ends
