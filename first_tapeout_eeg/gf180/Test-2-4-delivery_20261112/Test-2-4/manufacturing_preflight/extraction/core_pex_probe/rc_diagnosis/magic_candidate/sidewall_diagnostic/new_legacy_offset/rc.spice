* NGSPICE file created from adc_flat.ext - technology: gf180mcuD

.subckt adc_flat TOP BOT
X0 TOP.t0 BOT.t0 cap_mim_2f0_m4m5_noshield c_width=98.82999u c_length=98.82999u
R0 TOP.n2 TOP.n1 2.24231
R1 TOP.n3 TOP.n1 4.5005
R2 TOP.n0 TOP.n6 0.00673679
R3 TOP.n5 TOP.n6 2.24231
R4 TOP.n3 TOP.n5 0.0183702
R5 TOP TOP.n4 0.988491
R6 TOP.n4 TOP.n3 0.252957
R7 TOP.n5 TOP.n2 0.0362404
R8 TOP.n2 TOP.n0 0.349335
R9 TOP.n4 TOP.n7 0.105191
R10 TOP.n7 TOP.n1 0.0067
R11 TOP.n7 TOP.n0 0.00145531
R12 TOP.n6 TOP.t0 0.0705747
R13 BOT BOT.t0 3.74784
C0 BOT TOP 17.5289f
C1 TOP w_80_80# 0.2676f
C2 BOT w_80_80# 0.6926f
C3 BOT.t0 w_80_80# 17.9356f
C4 TOP.n0 w_80_80# 0.01114f
C5 TOP.n1 w_80_80# 0.00575f
C6 TOP.n2 w_80_80# 0.2086f
C7 TOP.n3 w_80_80# 0.03199f
C8 TOP.n4 w_80_80# 0.36534f
C9 TOP.n5 w_80_80# 0.00221f
C10 TOP.n6 w_80_80# 3.2916f
C11 TOP.n7 w_80_80# 0.51076f
C12 TOP.t0 w_80_80# 83.7741f
.ends
