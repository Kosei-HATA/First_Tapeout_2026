* NGSPICE file created from inverter_link.ext - technology: gf180mcuD

.subckt inverter_link IN OUT AG1 AG2
X0 OUT.t1 a_244_68.t3 a_20056_472.t0 w_19914_352# pfet_05v0 ad=0.5368p pd=3.32u as=0.5368p ps=3.32u w=1.22u l=0.5u
X1 a_244_68.t0 IN.t0 a_36_68# w_n86_n86# nfet_05v0 ad=0.3608p pd=2.52u as=0.3608p ps=2.52u w=0.82u l=0.6u
X2 a_244_68.t1 IN.t1 a_56_472.t0 w_n86_352# pfet_05v0 ad=0.5368p pd=3.32u as=0.5368p ps=3.32u w=1.22u l=0.5u
X3 OUT.t0 a_244_68.t2 a_20036_68# w_n86_n86# nfet_05v0 ad=0.3608p pd=2.52u as=0.3608p ps=2.52u w=0.82u l=0.6u
R0 a_244_68.t1 a_244_68.n1 4.44003
R1 a_244_68.n1 a_244_68.n0 33.7521
R2 a_244_68.n0 a_244_68.t2 12.3497
R3 a_244_68.n0 a_244_68.t3 17.192
R4 a_244_68.n1 a_244_68.t0 8.53124
R5 OUT OUT.t0 8.53124
R6 OUT OUT.t1 4.44003
R7 IN.n0 IN.n1 0.791333
R8 IN.n0 IN.t0 11.5588
R9 IN.n1 IN.t1 17.192
R10 IN.n1 IN 4.0185
R11 AG2 AG1 23.9405
C0 a_56_472.t0 a_244_68.n1 0.15445f
C1 w_19914_352# OUT 0.03208f
C2 a_244_68.n1 a_20056_472.t0 0.08034f
C3 w_n86_352# a_36_68# 0.0054f
C4 a_56_472.t0 IN 0.05098f
C5 a_20036_68# OUT 0.11686f
C6 w_19914_352# a_20056_472.t0 0.09f
C7 a_244_68.n1 IN 0.26972f
C8 a_244_68.n1 w_19914_352# 0.15854f
C9 a_56_472.t0 w_n86_352# 0.0901f
C10 a_56_472.t0 a_36_68# 0.01766f
C11 a_20036_68# a_20056_472.t0 0.01085f
C12 AG2 a_244_68.n1 1.44327f
C13 a_20036_68# a_244_68.n1 0.10305f
C14 a_244_68.n1 w_n86_352# 0.05633f
C15 a_244_68.n1 a_36_68# 0.13836f
C16 a_20056_472.t0 OUT 0.13942f
C17 a_20036_68# w_19914_352# 0.00614f
C18 w_n86_352# IN 0.13776f
C19 a_36_68# IN 0.05681f
C20 a_244_68.n1 OUT 0.26601f
C21 AG2 w_n86_n86# 2.66635f
C22 AG1 w_n86_n86# 2.66635f
C23 OUT w_n86_n86# 0.06152f
C24 IN w_n86_n86# 0.03185f
C25 a_20036_68# w_n86_n86# 0.22748f
C26 a_36_68# w_n86_n86# 0.22766f
C27 w_19914_352# w_n86_n86# 0.96348f
C28 w_n86_352# w_n86_n86# 0.96348f
C29 IN.n0 w_n86_n86# 0.0299f
C30 IN.n1 w_n86_n86# 0.03369f
C31 IN.t1 w_n86_n86# 0.06984f
C32 IN.t0 w_n86_n86# 0.06511f
C33 OUT.t1 w_n86_n86# 0.02451f
C34 OUT.t0 w_n86_n86# 0.01728f
C35 a_20056_472.t0 w_n86_n86# 0.16348f
C36 a_244_68.t1 w_n86_n86# 0.11439f
C37 a_244_68.t0 w_n86_n86# 0.08063f
C38 a_244_68.t3 w_n86_n86# 0.18619f
C39 a_244_68.t2 w_n86_n86# 0.17869f
C40 a_244_68.n0 w_n86_n86# 3.66851f
C41 a_244_68.n1 w_n86_n86# 4.65303f
C42 a_56_472.t0 w_n86_n86# 0.16277f
.ends
