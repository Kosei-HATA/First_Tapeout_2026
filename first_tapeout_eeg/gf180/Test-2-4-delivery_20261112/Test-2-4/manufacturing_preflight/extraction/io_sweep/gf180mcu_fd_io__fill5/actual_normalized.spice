* NGSPICE file created from gf180mcu_fd_io__fill5.ext - technology: gf180mcuD

.subckt gf180mcu_fd_io__fill5 VDD VSS DVSS DVDD
X0 VDD VSS cap_nmos_06v0 c_width=1.5u c_length=1.5u
X1 VDD VSS cap_nmos_06v0 c_width=1.5u c_length=1.5u
X2 VDD VSS cap_nmos_06v0 c_width=1.5u c_length=1.5u
X3 VDD VSS cap_nmos_06v0 c_width=1.5u c_length=1.5u
X4 VDD VSS cap_nmos_06v0 c_width=1.5u c_length=1.5u
X5 VDD VSS cap_nmos_06v0 c_width=1.5u c_length=1.5u
X6 VDD VSS cap_nmos_06v0 c_width=1.5u c_length=1.5u
X7 VDD VSS cap_nmos_06v0 c_width=1.5u c_length=1.5u
X8 VDD VSS cap_nmos_06v0 c_width=1.5u c_length=1.5u
X9 VDD VSS cap_nmos_06v0 c_width=1.5u c_length=1.5u
X10 VDD VSS cap_nmos_06v0 c_width=1.5u c_length=1.5u
X11 VDD VSS cap_nmos_06v0 c_width=1.5u c_length=1.5u
X12 VDD VSS cap_nmos_06v0 c_width=1.5u c_length=1.5u
X13 VDD VSS cap_nmos_06v0 c_width=1.5u c_length=1.5u
X14 VDD VSS cap_nmos_06v0 c_width=1.5u c_length=1.5u
X15 VDD VSS cap_nmos_06v0 c_width=1.5u c_length=1.5u
X16 VDD VSS cap_nmos_06v0 c_width=1.5u c_length=1.5u
X17 VDD VSS cap_nmos_06v0 c_width=1.5u c_length=1.5u
X18 VDD VSS cap_nmos_06v0 c_width=1.5u c_length=1.5u
X19 VDD VSS cap_nmos_06v0 c_width=1.5u c_length=1.5u
X20 VDD VSS cap_nmos_06v0 c_width=1.5u c_length=1.5u
X21 VDD VSS cap_nmos_06v0 c_width=1.5u c_length=1.5u
X22 VDD VSS cap_nmos_06v0 c_width=1.5u c_length=1.5u
X23 VDD VSS cap_nmos_06v0 c_width=1.5u c_length=1.5u
X24 VDD VSS cap_nmos_06v0 c_width=1.5u c_length=1.5u
X25 VDD VSS cap_nmos_06v0 c_width=1.5u c_length=1.5u
X26 VDD VSS cap_nmos_06v0 c_width=1.5u c_length=1.5u
X27 VDD VSS cap_nmos_06v0 c_width=1.5u c_length=1.5u
X28 VDD VSS cap_nmos_06v0 c_width=1.5u c_length=1.5u
X29 VDD VSS cap_nmos_06v0 c_width=1.5u c_length=1.5u
X30 VDD VSS cap_nmos_06v0 c_width=1.5u c_length=1.5u
X31 VDD VSS cap_nmos_06v0 c_width=1.5u c_length=1.5u
X32 VDD VSS cap_nmos_06v0 c_width=1.5u c_length=1.5u
X33 VDD VSS cap_nmos_06v0 c_width=1.5u c_length=1.5u
X34 VDD VSS cap_nmos_06v0 c_width=1.5u c_length=1.5u
X35 VDD VSS cap_nmos_06v0 c_width=1.5u c_length=1.5u
X36 VDD VSS cap_nmos_06v0 c_width=1.5u c_length=1.5u
X37 VDD VSS cap_nmos_06v0 c_width=1.5u c_length=1.5u
X38 VDD VSS cap_nmos_06v0 c_width=1.5u c_length=1.5u
X39 VDD VSS cap_nmos_06v0 c_width=1.5u c_length=1.5u
X40 VDD VSS cap_nmos_06v0 c_width=1.5u c_length=1.5u
X41 VDD VSS cap_nmos_06v0 c_width=1.5u c_length=1.5u
X42 VDD VSS cap_nmos_06v0 c_width=1.5u c_length=1.5u
X43 VDD VSS cap_nmos_06v0 c_width=1.5u c_length=1.5u
X44 VDD VSS cap_nmos_06v0 c_width=1.5u c_length=1.5u
X45 VDD VSS cap_nmos_06v0 c_width=1.5u c_length=1.5u
X46 VDD VSS cap_nmos_06v0 c_width=1.5u c_length=1.5u
X47 VDD VSS cap_nmos_06v0 c_width=1.5u c_length=1.5u
X48 VDD VSS cap_nmos_06v0 c_width=1.5u c_length=1.5u
X49 VDD VSS cap_nmos_06v0 c_width=1.5u c_length=1.5u
X50 VDD VSS cap_nmos_06v0 c_width=1.5u c_length=1.5u
X51 VDD VSS cap_nmos_06v0 c_width=1.5u c_length=1.5u
X52 VDD VSS cap_nmos_06v0 c_width=1.5u c_length=1.5u
X53 VDD VSS cap_nmos_06v0 c_width=1.5u c_length=1.5u
X54 VDD VSS cap_nmos_06v0 c_width=1.5u c_length=1.5u
X55 VDD VSS cap_nmos_06v0 c_width=1.5u c_length=1.5u
X56 VDD VSS cap_nmos_06v0 c_width=1.5u c_length=1.5u
X57 VDD VSS cap_nmos_06v0 c_width=1.5u c_length=1.5u
X58 VDD VSS cap_nmos_06v0 c_width=1.5u c_length=1.5u
X59 VDD VSS cap_nmos_06v0 c_width=1.5u c_length=1.5u
X60 VDD VSS cap_nmos_06v0 c_width=1.5u c_length=1.5u
X61 VDD VSS cap_nmos_06v0 c_width=1.5u c_length=1.5u
X62 VDD VSS cap_nmos_06v0 c_width=1.5u c_length=1.5u
X63 VDD VSS cap_nmos_06v0 c_width=1.5u c_length=1.5u
X64 VDD VSS cap_nmos_06v0 c_width=1.5u c_length=1.5u
X65 VDD VSS cap_nmos_06v0 c_width=1.5u c_length=1.5u
X66 VDD VSS cap_nmos_06v0 c_width=1.5u c_length=1.5u
X67 VDD VSS cap_nmos_06v0 c_width=1.5u c_length=1.5u
X68 VDD VSS cap_nmos_06v0 c_width=1.5u c_length=1.5u
X69 VDD VSS cap_nmos_06v0 c_width=1.5u c_length=1.5u
.ends
