* GF180MCU-D port of the sky130 chopped-AFE OTA cell library.
* All FETs are 3.3V devices (nfet_03v3/pfet_03v3), VDD=3.3 V, VCM=1.65 V.
* Subckt pin order follows GF180 convention: d g s b.
* Long-L philosophy kept: L=2u in signal/bias paths (min 03v3 L is 0.28u,
* used only in chopper TGs where Ron/charge matter).
*
* afe_ln_gf (2026-09-30): this is the low-noise-study working copy.
* Canonical cells live in gf180_afe_cells.spice (untouched). This file adds
* gf180_fd_ota_core_soft_ln / gf180_fd_ota_chopped_full2_ln: same topology
* with stage-1 pair/load geometry exposed as params (GWS1/GLS1/GNFS1,
* GWL1/GLL1/GNFL1). Defaults reproduce the canonical devices exactly
* (verified: v0 = baseline 1295.0 nV/rtHz @1 kHz, gain 31.96).
* Recommended low-noise config "vb": GWS1=240u GLS1=8u GNFS1=24
* GWL1=96u GLL1=8u GNFL1=8  (0.404 -> 0.254 uVrms in-band).

* ---- transmission gate (chopper switch) ----
* Minimum-L complementary pass gate with half-size charge-cancellation
* dummies, mirroring eeg_tg_lowq. 03v3 min L = 0.28u.
.subckt gf180_tg_lowq A B EN ENB VDD33 VSS
XMN B EN A VSS nfet_03v3 L=0.28u W=1.5u nf=1
XMP B ENB A VDD33 pfet_03v3 L=0.28u W=3u nf=1
XMND B ENB B VSS nfet_03v3 L=0.28u W=0.75u nf=1
XMPD B EN B VDD33 pfet_03v3 L=0.28u W=1.5u nf=1
XMNDA A ENB A VSS nfet_03v3 L=0.28u W=0.75u nf=1
XMPDA A EN A VDD33 pfet_03v3 L=0.28u W=1.5u nf=1
.ends gf180_tg_lowq

.subckt gf180_cmos_chopper_lowq INP INN OUTP OUTN PHI NPHI PHIB NPHIB VDD33 VSS
XSP INP OUTP PHI NPHI VDD33 VSS gf180_tg_lowq
XSN INN OUTN PHI NPHI VDD33 VSS gf180_tg_lowq
XCP INP OUTN PHIB NPHIB VDD33 VSS gf180_tg_lowq
XCN INN OUTP PHIB NPHIB VDD33 VSS gf180_tg_lowq
.ends gf180_cmos_chopper_lowq

* ---- pseudo-resistor: two diode-connected PMOS, floating mid ----
.subckt gf180_pseudo_res A B
XMP1 M M A A pfet_03v3 L=2u W=1u nf=1
XMP2 M M B B pfet_03v3 L=2u W=1u nf=1
.ends gf180_pseudo_res

* ---- stage-1 core with CM softening loads ----
* Sizes: input pair W=60 (gm/id ~ 18-20 at 12 uA/side), loads W=24,
* tail W=24. Same topology as sky130 eeg_fd_ota_core_soft.
.subckt gf180_fd_ota_core_soft INP INN VBP VBN OUTP OUTN VCM_SENSE VCM_REF VDD33 VSS params: RLOAD=20Meg RCM=5Meg
XM1 OUTP INP TAIL VSS nfet_03v3 L=4u W=120u nf=12
XM2 OUTN INN TAIL VSS nfet_03v3 L=4u W=120u nf=12
XM3 OUTP VBP VDD33 VDD33 pfet_03v3 L=4u W=48u nf=4
XM4 OUTN VBP VDD33 VDD33 pfet_03v3 L=4u W=48u nf=4
XM5 TAIL VBN VSS VSS nfet_03v3 L=4u W=48u nf=8
RCM1 OUTP VCM_SENSE {RCM}
RCM2 OUTN VCM_SENSE {RCM}
RLOADP OUTP VCM_REF {RLOAD}
RLOADN OUTN VCM_REF {RLOAD}
.ends gf180_fd_ota_core_soft

* parametrized-geometry variant for low-noise screening (afe_ln)
.subckt gf180_fd_ota_core_soft_ln INP INN VBP VBN OUTP OUTN VCM_SENSE VCM_REF VDD33 VSS params: RLOAD=20Meg RCM=5Meg GWS1=120u GLS1=4u GNFS1=12 GWL1=48u GLL1=4u GNFL1=4
XM1 OUTP INP TAIL VSS nfet_03v3 L={GLS1} W={GWS1} nf={GNFS1}
XM2 OUTN INN TAIL VSS nfet_03v3 L={GLS1} W={GWS1} nf={GNFS1}
XM3 OUTP VBP VDD33 VDD33 pfet_03v3 L={GLL1} W={GWL1} nf={GNFL1}
XM4 OUTN VBP VDD33 VDD33 pfet_03v3 L={GLL1} W={GWL1} nf={GNFL1}
XM5 TAIL VBN VSS VSS nfet_03v3 L=4u W=48u nf=8
RCM1 OUTP VCM_SENSE {RCM}
RCM2 OUTN VCM_SENSE {RCM}
RLOADP OUTP VCM_REF {RLOAD}
RLOADN OUTN VCM_REF {RLOAD}
.ends gf180_fd_ota_core_soft_ln

* ---- constant-gm bias gen (beta multiplier) with pseudo-R kick-start ----
* Branch current target ~10 uA (RSET tuned in bench verify).
.subckt gf180_bias_gen VBN VBNF VBP VDD33 VSS params: RSET=40k RFILT=10Meg CFILT=100p
XMP1 VBN VBP VDD33 VDD33 pfet_03v3 L=4u W=10u nf=2
XMN1 VBN VBN VSS VSS nfet_03v3 L=4u W=10u nf=2
XMP2 VBP VBP VDD33 VDD33 pfet_03v3 L=4u W=10u nf=2
XMN2 VBP VBN SNS2 VSS nfet_03v3 L=4u W=40u nf=8
RSET SNS2 VSS {RSET}
XRSTART VDD33 VBN gf180_pseudo_res
RF VBN VBNF {RFILT}
CF VBNF VSS {CFILT}
.ends gf180_bias_gen

* ---- CMFB error amp, diode-connected PMOS loads ----
.subckt gf180_cmfb_amp_dl2 VCM_SENSE VCM_REF VBN VBP VDD33 VSS params: W9=4u L9=2u W10=12u
XM6 NLEFT VCM_SENSE NTAIL VSS nfet_03v3 L=2u W=2u nf=1
XM7 VBP VCM_REF NTAIL VSS nfet_03v3 L=2u W=2u nf=1
XM8 NLEFT NLEFT VDD33 VDD33 pfet_03v3 L=2u W=2u nf=1
XM9 VBP VBP VDD33 VDD33 pfet_03v3 L={L9} W={W9} nf=1
XM10 NTAIL VBN VSS VSS nfet_03v3 L=2u W={W10} nf=2
.ends gf180_cmfb_amp_dl2

* ---- full OTA: bias gen + input chopper + stage1 + CMFB + mid chopper
*      + stage2 + Miller ----
.subckt gf180_fd_ota_chopped_full2_ln INP INN VCM_REF OUTP OUTN PHII NPHII PHIBI NPHIBI PHIM NPHIM PHIBM NPHIBM VDD33 VSS params: W91=4u L91=2u W92=0.5u L92=2u W10=12u RLOAD=20Meg CC=10p RZ=80k RSET=40k RFILT=10Meg CFILT=100p DVOS=0 GWS1=120u GLS1=4u GNFS1=12 GWL1=48u GLL1=4u GNFL1=4
XBG VBNRAW VBN VBP_BIAS VDD33 VSS gf180_bias_gen RSET={RSET} RFILT={RFILT} CFILT={CFILT}
XCHIN INP INN INP_M INN_M PHII NPHII PHIBI NPHIBI VDD33 VSS gf180_cmos_chopper_lowq
VOS1 INP_M INP_MX {DVOS}
XSTG1 INP_MX INN_M VBP1 VBN N1P N1N VCM1 VCM_REF VDD33 VSS gf180_fd_ota_core_soft_ln RLOAD={RLOAD} GWS1={GWS1} GLS1={GLS1} GNFS1={GNFS1} GWL1={GWL1} GLL1={GLL1} GNFL1={GNFL1}
XCM1 VCM1 VCM_REF VBN VBP1 VDD33 VSS gf180_cmfb_amp_dl2 W9={W91} L9={L91} W10={W10}
XCHMID N1P N1N N2P N2N PHIM NPHIM PHIBM NPHIBM VDD33 VSS gf180_cmos_chopper_lowq
XM21 OUTP N2P VSS VSS nfet_03v3 L=20u W=4u nf=1
XM22 OUTN N2N VSS VSS nfet_03v3 L=20u W=4u nf=1
XM23 OUTP VBP2 VDD33 VDD33 pfet_03v3 L=4u W=12u nf=2
XM24 OUTN VBP2 VDD33 VDD33 pfet_03v3 L=4u W=12u nf=2
RCMO1 OUTP VCM2 5Meg
RCMO2 OUTN VCM2 5Meg
RLOADO1 OUTP VCM_REF {RLOAD}
RLOADO2 OUTN VCM_REF {RLOAD}
XCM2 VCM2 VCM_REF VBN VBP2 VDD33 VSS gf180_cmfb_amp_dl2 W9={W92} L9={L92} W10={W10}
RZP N2P NZP {RZ}
CCP NZP OUTP {CC}
RZN N2N NZN {RZ}
CCN NZN OUTN {CC}
.ends gf180_fd_ota_chopped_full2
