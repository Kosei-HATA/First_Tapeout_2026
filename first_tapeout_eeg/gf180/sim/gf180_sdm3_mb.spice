* gf180_sdm3_mb.spice - 4-bit (15-level) sdm3 variant for fs=512 kHz
* GENERATED by gen_sdm3_mb.py - do not edit by hand.
* All behavioral B-sources are RC-smoothed current-source form
* (target-v)/R into a hold cap, and all floor()/ternary logic is
* replaced by steep sigmoids: ngspice-46 fails to converge on
* discontinuous B-source branches (timestep-too-small at the input
* zero crossing, t=62.5026 ms). Sigmoid offsets put the transition
* between settled integer states, so settled values are exact.
* Requires: gf180_afe_cells.spice (OTA/TG/bias) + gf180_sdm3.spice
* (strongarm, nand2, inv). Loop timing/coefficients identical to sdm3.
* Flash thresholds and DWA/thermometer logic are BEHAVIORAL (ideal
* sources / B-sources) - silicon needs a ladder + DWA RTL.

* ---- 15-level flash: strongarm + SR latch per slice ----
* H_i=1 <=> O2D > theta_i, theta_i=(i-7)*6.25mV; H_i is the latch's NBIT
* terminal (BIT_i=1 <=> O2D<theta_i, same convention as 1-bit sdm3).
.subckt gf180_sdm3_flash15 O2P O2N CMPCK VDD33 VSS H0 H1 H2 H3 H4 H5 H6 H7 H8 H9 H10 H11 H12 H13 H14
* slice 0: theta=-43.75 mV diff
VOFFP0 O2P INPP0 2.187500e-02
VOFFN0 O2N INNN0 -2.187500e-02
XCMP0 INPP0 INNN0 QP0 QN0 CMPCK VDD33 VSS gf180_strongarm
CQP0 QP0 VSS 0.5p
CQN0 QN0 VSS 0.5p
XND10 QP0 H0 BIT0 VDD33 VSS gf180_sdm3_nand2
XND20 QN0 BIT0 H0 VDD33 VSS gf180_sdm3_nand2
* slice 1: theta=-37.50 mV diff
VOFFP1 O2P INPP1 1.875000e-02
VOFFN1 O2N INNN1 -1.875000e-02
XCMP1 INPP1 INNN1 QP1 QN1 CMPCK VDD33 VSS gf180_strongarm
CQP1 QP1 VSS 0.5p
CQN1 QN1 VSS 0.5p
XND11 QP1 H1 BIT1 VDD33 VSS gf180_sdm3_nand2
XND21 QN1 BIT1 H1 VDD33 VSS gf180_sdm3_nand2
* slice 2: theta=-31.25 mV diff
VOFFP2 O2P INPP2 1.562500e-02
VOFFN2 O2N INNN2 -1.562500e-02
XCMP2 INPP2 INNN2 QP2 QN2 CMPCK VDD33 VSS gf180_strongarm
CQP2 QP2 VSS 0.5p
CQN2 QN2 VSS 0.5p
XND12 QP2 H2 BIT2 VDD33 VSS gf180_sdm3_nand2
XND22 QN2 BIT2 H2 VDD33 VSS gf180_sdm3_nand2
* slice 3: theta=-25.00 mV diff
VOFFP3 O2P INPP3 1.250000e-02
VOFFN3 O2N INNN3 -1.250000e-02
XCMP3 INPP3 INNN3 QP3 QN3 CMPCK VDD33 VSS gf180_strongarm
CQP3 QP3 VSS 0.5p
CQN3 QN3 VSS 0.5p
XND13 QP3 H3 BIT3 VDD33 VSS gf180_sdm3_nand2
XND23 QN3 BIT3 H3 VDD33 VSS gf180_sdm3_nand2
* slice 4: theta=-18.75 mV diff
VOFFP4 O2P INPP4 9.375000e-03
VOFFN4 O2N INNN4 -9.375000e-03
XCMP4 INPP4 INNN4 QP4 QN4 CMPCK VDD33 VSS gf180_strongarm
CQP4 QP4 VSS 0.5p
CQN4 QN4 VSS 0.5p
XND14 QP4 H4 BIT4 VDD33 VSS gf180_sdm3_nand2
XND24 QN4 BIT4 H4 VDD33 VSS gf180_sdm3_nand2
* slice 5: theta=-12.50 mV diff
VOFFP5 O2P INPP5 6.250000e-03
VOFFN5 O2N INNN5 -6.250000e-03
XCMP5 INPP5 INNN5 QP5 QN5 CMPCK VDD33 VSS gf180_strongarm
CQP5 QP5 VSS 0.5p
CQN5 QN5 VSS 0.5p
XND15 QP5 H5 BIT5 VDD33 VSS gf180_sdm3_nand2
XND25 QN5 BIT5 H5 VDD33 VSS gf180_sdm3_nand2
* slice 6: theta=-6.25 mV diff
VOFFP6 O2P INPP6 3.125000e-03
VOFFN6 O2N INNN6 -3.125000e-03
XCMP6 INPP6 INNN6 QP6 QN6 CMPCK VDD33 VSS gf180_strongarm
CQP6 QP6 VSS 0.5p
CQN6 QN6 VSS 0.5p
XND16 QP6 H6 BIT6 VDD33 VSS gf180_sdm3_nand2
XND26 QN6 BIT6 H6 VDD33 VSS gf180_sdm3_nand2
* slice 7: theta=+0.00 mV diff
VOFFP7 O2P INPP7 -0.000000e+00
VOFFN7 O2N INNN7 0.000000e+00
XCMP7 INPP7 INNN7 QP7 QN7 CMPCK VDD33 VSS gf180_strongarm
CQP7 QP7 VSS 0.5p
CQN7 QN7 VSS 0.5p
XND17 QP7 H7 BIT7 VDD33 VSS gf180_sdm3_nand2
XND27 QN7 BIT7 H7 VDD33 VSS gf180_sdm3_nand2
* slice 8: theta=+6.25 mV diff
VOFFP8 O2P INPP8 -3.125000e-03
VOFFN8 O2N INNN8 3.125000e-03
XCMP8 INPP8 INNN8 QP8 QN8 CMPCK VDD33 VSS gf180_strongarm
CQP8 QP8 VSS 0.5p
CQN8 QN8 VSS 0.5p
XND18 QP8 H8 BIT8 VDD33 VSS gf180_sdm3_nand2
XND28 QN8 BIT8 H8 VDD33 VSS gf180_sdm3_nand2
* slice 9: theta=+12.50 mV diff
VOFFP9 O2P INPP9 -6.250000e-03
VOFFN9 O2N INNN9 6.250000e-03
XCMP9 INPP9 INNN9 QP9 QN9 CMPCK VDD33 VSS gf180_strongarm
CQP9 QP9 VSS 0.5p
CQN9 QN9 VSS 0.5p
XND19 QP9 H9 BIT9 VDD33 VSS gf180_sdm3_nand2
XND29 QN9 BIT9 H9 VDD33 VSS gf180_sdm3_nand2
* slice 10: theta=+18.75 mV diff
VOFFP10 O2P INPP10 -9.375000e-03
VOFFN10 O2N INNN10 9.375000e-03
XCMP10 INPP10 INNN10 QP10 QN10 CMPCK VDD33 VSS gf180_strongarm
CQP10 QP10 VSS 0.5p
CQN10 QN10 VSS 0.5p
XND110 QP10 H10 BIT10 VDD33 VSS gf180_sdm3_nand2
XND210 QN10 BIT10 H10 VDD33 VSS gf180_sdm3_nand2
* slice 11: theta=+25.00 mV diff
VOFFP11 O2P INPP11 -1.250000e-02
VOFFN11 O2N INNN11 1.250000e-02
XCMP11 INPP11 INNN11 QP11 QN11 CMPCK VDD33 VSS gf180_strongarm
CQP11 QP11 VSS 0.5p
CQN11 QN11 VSS 0.5p
XND111 QP11 H11 BIT11 VDD33 VSS gf180_sdm3_nand2
XND211 QN11 BIT11 H11 VDD33 VSS gf180_sdm3_nand2
* slice 12: theta=+31.25 mV diff
VOFFP12 O2P INPP12 -1.562500e-02
VOFFN12 O2N INNN12 1.562500e-02
XCMP12 INPP12 INNN12 QP12 QN12 CMPCK VDD33 VSS gf180_strongarm
CQP12 QP12 VSS 0.5p
CQN12 QN12 VSS 0.5p
XND112 QP12 H12 BIT12 VDD33 VSS gf180_sdm3_nand2
XND212 QN12 BIT12 H12 VDD33 VSS gf180_sdm3_nand2
* slice 13: theta=+37.50 mV diff
VOFFP13 O2P INPP13 -1.875000e-02
VOFFN13 O2N INNN13 1.875000e-02
XCMP13 INPP13 INNN13 QP13 QN13 CMPCK VDD33 VSS gf180_strongarm
CQP13 QP13 VSS 0.5p
CQN13 QN13 VSS 0.5p
XND113 QP13 H13 BIT13 VDD33 VSS gf180_sdm3_nand2
XND213 QN13 BIT13 H13 VDD33 VSS gf180_sdm3_nand2
* slice 14: theta=+43.75 mV diff
VOFFP14 O2P INPP14 -2.187500e-02
VOFFN14 O2N INNN14 2.187500e-02
XCMP14 INPP14 INNN14 QP14 QN14 CMPCK VDD33 VSS gf180_strongarm
CQP14 QP14 VSS 0.5p
CQN14 QN14 VSS 0.5p
XND114 QP14 H14 BIT14 VDD33 VSS gf180_sdm3_nand2
XND214 QN14 BIT14 H14 VDD33 VSS gf180_sdm3_nand2
.ends gf180_sdm3_flash15

* ---- int1 mb: CS=16p sampled input + 15x1p/side direct DAC, CI=8p ----
* SELP_j/SELN_j: 0/VDD level, unit j P-side left plate -> VP if SELP_j,
* else VN during PH2 (complement on N side: SELN_j=1 -> NP side to VP).
.subckt gf180_sdm3_int1_mb INP_S INN_S VCM_REF VP VN OUTP OUTN PH1 NPH1 PH2 NPH2 VDD33 VSS SP0 SP1 SP2 SP3 SP4 SP5 SP6 SP7 SP8 SP9 SP10 SP11 SP12 SP13 SP14 SN0 SN1 SN2 SN3 SN4 SN5 SN6 SN7 SN8 SN9 SN10 SN11 SN12 SN13 SN14 params: CS=16p CU=1p CI=8p W91=11u L91=2u W92=6u L92=2u W10=12u RSET=25k CC=10p
XOTA INP INN VCM_REF OUTP OUTN VDD33 VSS gf180_fd_ota_full2_nc W91={W91} L91={L91} W92={W92} L92={L92} W10={W10} RSET={RSET} CC={CC}
CSP CSLP CSRP {CS}
CSN CSLN CSRN {CS}
XS1A CSLP INP_S PH1 NPH1 VDD33 VSS gf180_tg_lowq
XS1B CSRP VCM_REF PH1 NPH1 VDD33 VSS gf180_tg_lowq
XS1C CSLN INN_S PH1 NPH1 VDD33 VSS gf180_tg_lowq
XS1D CSRN VCM_REF PH1 NPH1 VDD33 VSS gf180_tg_lowq
XS2A CSLP VCM_REF PH2 NPH2 VDD33 VSS gf180_tg_lowq
XS2B CSRP INP PH2 NPH2 VDD33 VSS gf180_tg_lowq
XS2C CSLN VCM_REF PH2 NPH2 VDD33 VSS gf180_tg_lowq
XS2D CSRN INN PH2 NPH2 VDD33 VSS gf180_tg_lowq
* DAC unit 0 (P side DP0, N side DN0)
CDP0 CDLP0 CDRP0 {CU}
CDN0 CDLN0 CDRN0 {CU}
XDPA0 CDLP0 VCM_REF PH1 NPH1 VDD33 VSS gf180_tg_lowq
XDPB0 CDRP0 VCM_REF PH1 NPH1 VDD33 VSS gf180_tg_lowq
XDNA0 CDLN0 VCM_REF PH1 NPH1 VDD33 VSS gf180_tg_lowq
XDNB0 CDRN0 VCM_REF PH1 NPH1 VDD33 VSS gf180_tg_lowq
XDP20 CDRP0 INP PH2 NPH2 VDD33 VSS gf180_tg_lowq
XDN20 CDRN0 INN PH2 NPH2 VDD33 VSS gf180_tg_lowq
BGPP0 GPP0 VSS I=(v(GPP0)-v(PH2)*v(SP0)/v(VDD33))/1k
BGPN0 GPN0 VSS I=(v(GPN0)-v(PH2)*(v(VDD33)-v(SP0))/v(VDD33))/1k
BGNP0 GNP0 VSS I=(v(GNP0)-v(PH2)*v(SN0)/v(VDD33))/1k
BGNN0 GNN0 VSS I=(v(GNN0)-v(PH2)*(v(VDD33)-v(SN0))/v(VDD33))/1k
BNOPP0 NGPP0 0 V=v(VDD33)-v(GPP0)
BNOPN0 NGPN0 0 V=v(VDD33)-v(GPN0)
BNONP0 NGNP0 0 V=v(VDD33)-v(GNP0)
BNONN0 NGNN0 0 V=v(VDD33)-v(GNN0)
CGPP0 GPP0 VSS 2p
CGPN0 GPN0 VSS 2p
CGNP0 GNP0 VSS 2p
CGNN0 GNN0 VSS 2p
CNGPP0 NGPP0 VSS 0.2p
CNGPN0 NGPN0 VSS 0.2p
CNGNP0 NGNP0 VSS 0.2p
CNGNN0 NGNN0 VSS 0.2p
XPVP0 CDLP0 VP GPP0 NGPP0 VDD33 VSS gf180_tg_lowq
XPVN0 CDLP0 VN GPN0 NGPN0 VDD33 VSS gf180_tg_lowq
XNVP0 CDLN0 VP GNP0 NGNP0 VDD33 VSS gf180_tg_lowq
XNVN0 CDLN0 VN GNN0 NGNN0 VDD33 VSS gf180_tg_lowq
* DAC unit 1 (P side DP1, N side DN1)
CDP1 CDLP1 CDRP1 {CU}
CDN1 CDLN1 CDRN1 {CU}
XDPA1 CDLP1 VCM_REF PH1 NPH1 VDD33 VSS gf180_tg_lowq
XDPB1 CDRP1 VCM_REF PH1 NPH1 VDD33 VSS gf180_tg_lowq
XDNA1 CDLN1 VCM_REF PH1 NPH1 VDD33 VSS gf180_tg_lowq
XDNB1 CDRN1 VCM_REF PH1 NPH1 VDD33 VSS gf180_tg_lowq
XDP21 CDRP1 INP PH2 NPH2 VDD33 VSS gf180_tg_lowq
XDN21 CDRN1 INN PH2 NPH2 VDD33 VSS gf180_tg_lowq
BGPP1 GPP1 VSS I=(v(GPP1)-v(PH2)*v(SP1)/v(VDD33))/1k
BGPN1 GPN1 VSS I=(v(GPN1)-v(PH2)*(v(VDD33)-v(SP1))/v(VDD33))/1k
BGNP1 GNP1 VSS I=(v(GNP1)-v(PH2)*v(SN1)/v(VDD33))/1k
BGNN1 GNN1 VSS I=(v(GNN1)-v(PH2)*(v(VDD33)-v(SN1))/v(VDD33))/1k
BNOPP1 NGPP1 0 V=v(VDD33)-v(GPP1)
BNOPN1 NGPN1 0 V=v(VDD33)-v(GPN1)
BNONP1 NGNP1 0 V=v(VDD33)-v(GNP1)
BNONN1 NGNN1 0 V=v(VDD33)-v(GNN1)
CGPP1 GPP1 VSS 2p
CGPN1 GPN1 VSS 2p
CGNP1 GNP1 VSS 2p
CGNN1 GNN1 VSS 2p
CNGPP1 NGPP1 VSS 0.2p
CNGPN1 NGPN1 VSS 0.2p
CNGNP1 NGNP1 VSS 0.2p
CNGNN1 NGNN1 VSS 0.2p
XPVP1 CDLP1 VP GPP1 NGPP1 VDD33 VSS gf180_tg_lowq
XPVN1 CDLP1 VN GPN1 NGPN1 VDD33 VSS gf180_tg_lowq
XNVP1 CDLN1 VP GNP1 NGNP1 VDD33 VSS gf180_tg_lowq
XNVN1 CDLN1 VN GNN1 NGNN1 VDD33 VSS gf180_tg_lowq
* DAC unit 2 (P side DP2, N side DN2)
CDP2 CDLP2 CDRP2 {CU}
CDN2 CDLN2 CDRN2 {CU}
XDPA2 CDLP2 VCM_REF PH1 NPH1 VDD33 VSS gf180_tg_lowq
XDPB2 CDRP2 VCM_REF PH1 NPH1 VDD33 VSS gf180_tg_lowq
XDNA2 CDLN2 VCM_REF PH1 NPH1 VDD33 VSS gf180_tg_lowq
XDNB2 CDRN2 VCM_REF PH1 NPH1 VDD33 VSS gf180_tg_lowq
XDP22 CDRP2 INP PH2 NPH2 VDD33 VSS gf180_tg_lowq
XDN22 CDRN2 INN PH2 NPH2 VDD33 VSS gf180_tg_lowq
BGPP2 GPP2 VSS I=(v(GPP2)-v(PH2)*v(SP2)/v(VDD33))/1k
BGPN2 GPN2 VSS I=(v(GPN2)-v(PH2)*(v(VDD33)-v(SP2))/v(VDD33))/1k
BGNP2 GNP2 VSS I=(v(GNP2)-v(PH2)*v(SN2)/v(VDD33))/1k
BGNN2 GNN2 VSS I=(v(GNN2)-v(PH2)*(v(VDD33)-v(SN2))/v(VDD33))/1k
BNOPP2 NGPP2 0 V=v(VDD33)-v(GPP2)
BNOPN2 NGPN2 0 V=v(VDD33)-v(GPN2)
BNONP2 NGNP2 0 V=v(VDD33)-v(GNP2)
BNONN2 NGNN2 0 V=v(VDD33)-v(GNN2)
CGPP2 GPP2 VSS 2p
CGPN2 GPN2 VSS 2p
CGNP2 GNP2 VSS 2p
CGNN2 GNN2 VSS 2p
CNGPP2 NGPP2 VSS 0.2p
CNGPN2 NGPN2 VSS 0.2p
CNGNP2 NGNP2 VSS 0.2p
CNGNN2 NGNN2 VSS 0.2p
XPVP2 CDLP2 VP GPP2 NGPP2 VDD33 VSS gf180_tg_lowq
XPVN2 CDLP2 VN GPN2 NGPN2 VDD33 VSS gf180_tg_lowq
XNVP2 CDLN2 VP GNP2 NGNP2 VDD33 VSS gf180_tg_lowq
XNVN2 CDLN2 VN GNN2 NGNN2 VDD33 VSS gf180_tg_lowq
* DAC unit 3 (P side DP3, N side DN3)
CDP3 CDLP3 CDRP3 {CU}
CDN3 CDLN3 CDRN3 {CU}
XDPA3 CDLP3 VCM_REF PH1 NPH1 VDD33 VSS gf180_tg_lowq
XDPB3 CDRP3 VCM_REF PH1 NPH1 VDD33 VSS gf180_tg_lowq
XDNA3 CDLN3 VCM_REF PH1 NPH1 VDD33 VSS gf180_tg_lowq
XDNB3 CDRN3 VCM_REF PH1 NPH1 VDD33 VSS gf180_tg_lowq
XDP23 CDRP3 INP PH2 NPH2 VDD33 VSS gf180_tg_lowq
XDN23 CDRN3 INN PH2 NPH2 VDD33 VSS gf180_tg_lowq
BGPP3 GPP3 VSS I=(v(GPP3)-v(PH2)*v(SP3)/v(VDD33))/1k
BGPN3 GPN3 VSS I=(v(GPN3)-v(PH2)*(v(VDD33)-v(SP3))/v(VDD33))/1k
BGNP3 GNP3 VSS I=(v(GNP3)-v(PH2)*v(SN3)/v(VDD33))/1k
BGNN3 GNN3 VSS I=(v(GNN3)-v(PH2)*(v(VDD33)-v(SN3))/v(VDD33))/1k
BNOPP3 NGPP3 0 V=v(VDD33)-v(GPP3)
BNOPN3 NGPN3 0 V=v(VDD33)-v(GPN3)
BNONP3 NGNP3 0 V=v(VDD33)-v(GNP3)
BNONN3 NGNN3 0 V=v(VDD33)-v(GNN3)
CGPP3 GPP3 VSS 2p
CGPN3 GPN3 VSS 2p
CGNP3 GNP3 VSS 2p
CGNN3 GNN3 VSS 2p
CNGPP3 NGPP3 VSS 0.2p
CNGPN3 NGPN3 VSS 0.2p
CNGNP3 NGNP3 VSS 0.2p
CNGNN3 NGNN3 VSS 0.2p
XPVP3 CDLP3 VP GPP3 NGPP3 VDD33 VSS gf180_tg_lowq
XPVN3 CDLP3 VN GPN3 NGPN3 VDD33 VSS gf180_tg_lowq
XNVP3 CDLN3 VP GNP3 NGNP3 VDD33 VSS gf180_tg_lowq
XNVN3 CDLN3 VN GNN3 NGNN3 VDD33 VSS gf180_tg_lowq
* DAC unit 4 (P side DP4, N side DN4)
CDP4 CDLP4 CDRP4 {CU}
CDN4 CDLN4 CDRN4 {CU}
XDPA4 CDLP4 VCM_REF PH1 NPH1 VDD33 VSS gf180_tg_lowq
XDPB4 CDRP4 VCM_REF PH1 NPH1 VDD33 VSS gf180_tg_lowq
XDNA4 CDLN4 VCM_REF PH1 NPH1 VDD33 VSS gf180_tg_lowq
XDNB4 CDRN4 VCM_REF PH1 NPH1 VDD33 VSS gf180_tg_lowq
XDP24 CDRP4 INP PH2 NPH2 VDD33 VSS gf180_tg_lowq
XDN24 CDRN4 INN PH2 NPH2 VDD33 VSS gf180_tg_lowq
BGPP4 GPP4 VSS I=(v(GPP4)-v(PH2)*v(SP4)/v(VDD33))/1k
BGPN4 GPN4 VSS I=(v(GPN4)-v(PH2)*(v(VDD33)-v(SP4))/v(VDD33))/1k
BGNP4 GNP4 VSS I=(v(GNP4)-v(PH2)*v(SN4)/v(VDD33))/1k
BGNN4 GNN4 VSS I=(v(GNN4)-v(PH2)*(v(VDD33)-v(SN4))/v(VDD33))/1k
BNOPP4 NGPP4 0 V=v(VDD33)-v(GPP4)
BNOPN4 NGPN4 0 V=v(VDD33)-v(GPN4)
BNONP4 NGNP4 0 V=v(VDD33)-v(GNP4)
BNONN4 NGNN4 0 V=v(VDD33)-v(GNN4)
CGPP4 GPP4 VSS 2p
CGPN4 GPN4 VSS 2p
CGNP4 GNP4 VSS 2p
CGNN4 GNN4 VSS 2p
CNGPP4 NGPP4 VSS 0.2p
CNGPN4 NGPN4 VSS 0.2p
CNGNP4 NGNP4 VSS 0.2p
CNGNN4 NGNN4 VSS 0.2p
XPVP4 CDLP4 VP GPP4 NGPP4 VDD33 VSS gf180_tg_lowq
XPVN4 CDLP4 VN GPN4 NGPN4 VDD33 VSS gf180_tg_lowq
XNVP4 CDLN4 VP GNP4 NGNP4 VDD33 VSS gf180_tg_lowq
XNVN4 CDLN4 VN GNN4 NGNN4 VDD33 VSS gf180_tg_lowq
* DAC unit 5 (P side DP5, N side DN5)
CDP5 CDLP5 CDRP5 {CU}
CDN5 CDLN5 CDRN5 {CU}
XDPA5 CDLP5 VCM_REF PH1 NPH1 VDD33 VSS gf180_tg_lowq
XDPB5 CDRP5 VCM_REF PH1 NPH1 VDD33 VSS gf180_tg_lowq
XDNA5 CDLN5 VCM_REF PH1 NPH1 VDD33 VSS gf180_tg_lowq
XDNB5 CDRN5 VCM_REF PH1 NPH1 VDD33 VSS gf180_tg_lowq
XDP25 CDRP5 INP PH2 NPH2 VDD33 VSS gf180_tg_lowq
XDN25 CDRN5 INN PH2 NPH2 VDD33 VSS gf180_tg_lowq
BGPP5 GPP5 VSS I=(v(GPP5)-v(PH2)*v(SP5)/v(VDD33))/1k
BGPN5 GPN5 VSS I=(v(GPN5)-v(PH2)*(v(VDD33)-v(SP5))/v(VDD33))/1k
BGNP5 GNP5 VSS I=(v(GNP5)-v(PH2)*v(SN5)/v(VDD33))/1k
BGNN5 GNN5 VSS I=(v(GNN5)-v(PH2)*(v(VDD33)-v(SN5))/v(VDD33))/1k
BNOPP5 NGPP5 0 V=v(VDD33)-v(GPP5)
BNOPN5 NGPN5 0 V=v(VDD33)-v(GPN5)
BNONP5 NGNP5 0 V=v(VDD33)-v(GNP5)
BNONN5 NGNN5 0 V=v(VDD33)-v(GNN5)
CGPP5 GPP5 VSS 2p
CGPN5 GPN5 VSS 2p
CGNP5 GNP5 VSS 2p
CGNN5 GNN5 VSS 2p
CNGPP5 NGPP5 VSS 0.2p
CNGPN5 NGPN5 VSS 0.2p
CNGNP5 NGNP5 VSS 0.2p
CNGNN5 NGNN5 VSS 0.2p
XPVP5 CDLP5 VP GPP5 NGPP5 VDD33 VSS gf180_tg_lowq
XPVN5 CDLP5 VN GPN5 NGPN5 VDD33 VSS gf180_tg_lowq
XNVP5 CDLN5 VP GNP5 NGNP5 VDD33 VSS gf180_tg_lowq
XNVN5 CDLN5 VN GNN5 NGNN5 VDD33 VSS gf180_tg_lowq
* DAC unit 6 (P side DP6, N side DN6)
CDP6 CDLP6 CDRP6 {CU}
CDN6 CDLN6 CDRN6 {CU}
XDPA6 CDLP6 VCM_REF PH1 NPH1 VDD33 VSS gf180_tg_lowq
XDPB6 CDRP6 VCM_REF PH1 NPH1 VDD33 VSS gf180_tg_lowq
XDNA6 CDLN6 VCM_REF PH1 NPH1 VDD33 VSS gf180_tg_lowq
XDNB6 CDRN6 VCM_REF PH1 NPH1 VDD33 VSS gf180_tg_lowq
XDP26 CDRP6 INP PH2 NPH2 VDD33 VSS gf180_tg_lowq
XDN26 CDRN6 INN PH2 NPH2 VDD33 VSS gf180_tg_lowq
BGPP6 GPP6 VSS I=(v(GPP6)-v(PH2)*v(SP6)/v(VDD33))/1k
BGPN6 GPN6 VSS I=(v(GPN6)-v(PH2)*(v(VDD33)-v(SP6))/v(VDD33))/1k
BGNP6 GNP6 VSS I=(v(GNP6)-v(PH2)*v(SN6)/v(VDD33))/1k
BGNN6 GNN6 VSS I=(v(GNN6)-v(PH2)*(v(VDD33)-v(SN6))/v(VDD33))/1k
BNOPP6 NGPP6 0 V=v(VDD33)-v(GPP6)
BNOPN6 NGPN6 0 V=v(VDD33)-v(GPN6)
BNONP6 NGNP6 0 V=v(VDD33)-v(GNP6)
BNONN6 NGNN6 0 V=v(VDD33)-v(GNN6)
CGPP6 GPP6 VSS 2p
CGPN6 GPN6 VSS 2p
CGNP6 GNP6 VSS 2p
CGNN6 GNN6 VSS 2p
CNGPP6 NGPP6 VSS 0.2p
CNGPN6 NGPN6 VSS 0.2p
CNGNP6 NGNP6 VSS 0.2p
CNGNN6 NGNN6 VSS 0.2p
XPVP6 CDLP6 VP GPP6 NGPP6 VDD33 VSS gf180_tg_lowq
XPVN6 CDLP6 VN GPN6 NGPN6 VDD33 VSS gf180_tg_lowq
XNVP6 CDLN6 VP GNP6 NGNP6 VDD33 VSS gf180_tg_lowq
XNVN6 CDLN6 VN GNN6 NGNN6 VDD33 VSS gf180_tg_lowq
* DAC unit 7 (P side DP7, N side DN7)
CDP7 CDLP7 CDRP7 {CU}
CDN7 CDLN7 CDRN7 {CU}
XDPA7 CDLP7 VCM_REF PH1 NPH1 VDD33 VSS gf180_tg_lowq
XDPB7 CDRP7 VCM_REF PH1 NPH1 VDD33 VSS gf180_tg_lowq
XDNA7 CDLN7 VCM_REF PH1 NPH1 VDD33 VSS gf180_tg_lowq
XDNB7 CDRN7 VCM_REF PH1 NPH1 VDD33 VSS gf180_tg_lowq
XDP27 CDRP7 INP PH2 NPH2 VDD33 VSS gf180_tg_lowq
XDN27 CDRN7 INN PH2 NPH2 VDD33 VSS gf180_tg_lowq
BGPP7 GPP7 VSS I=(v(GPP7)-v(PH2)*v(SP7)/v(VDD33))/1k
BGPN7 GPN7 VSS I=(v(GPN7)-v(PH2)*(v(VDD33)-v(SP7))/v(VDD33))/1k
BGNP7 GNP7 VSS I=(v(GNP7)-v(PH2)*v(SN7)/v(VDD33))/1k
BGNN7 GNN7 VSS I=(v(GNN7)-v(PH2)*(v(VDD33)-v(SN7))/v(VDD33))/1k
BNOPP7 NGPP7 0 V=v(VDD33)-v(GPP7)
BNOPN7 NGPN7 0 V=v(VDD33)-v(GPN7)
BNONP7 NGNP7 0 V=v(VDD33)-v(GNP7)
BNONN7 NGNN7 0 V=v(VDD33)-v(GNN7)
CGPP7 GPP7 VSS 2p
CGPN7 GPN7 VSS 2p
CGNP7 GNP7 VSS 2p
CGNN7 GNN7 VSS 2p
CNGPP7 NGPP7 VSS 0.2p
CNGPN7 NGPN7 VSS 0.2p
CNGNP7 NGNP7 VSS 0.2p
CNGNN7 NGNN7 VSS 0.2p
XPVP7 CDLP7 VP GPP7 NGPP7 VDD33 VSS gf180_tg_lowq
XPVN7 CDLP7 VN GPN7 NGPN7 VDD33 VSS gf180_tg_lowq
XNVP7 CDLN7 VP GNP7 NGNP7 VDD33 VSS gf180_tg_lowq
XNVN7 CDLN7 VN GNN7 NGNN7 VDD33 VSS gf180_tg_lowq
* DAC unit 8 (P side DP8, N side DN8)
CDP8 CDLP8 CDRP8 {CU}
CDN8 CDLN8 CDRN8 {CU}
XDPA8 CDLP8 VCM_REF PH1 NPH1 VDD33 VSS gf180_tg_lowq
XDPB8 CDRP8 VCM_REF PH1 NPH1 VDD33 VSS gf180_tg_lowq
XDNA8 CDLN8 VCM_REF PH1 NPH1 VDD33 VSS gf180_tg_lowq
XDNB8 CDRN8 VCM_REF PH1 NPH1 VDD33 VSS gf180_tg_lowq
XDP28 CDRP8 INP PH2 NPH2 VDD33 VSS gf180_tg_lowq
XDN28 CDRN8 INN PH2 NPH2 VDD33 VSS gf180_tg_lowq
BGPP8 GPP8 VSS I=(v(GPP8)-v(PH2)*v(SP8)/v(VDD33))/1k
BGPN8 GPN8 VSS I=(v(GPN8)-v(PH2)*(v(VDD33)-v(SP8))/v(VDD33))/1k
BGNP8 GNP8 VSS I=(v(GNP8)-v(PH2)*v(SN8)/v(VDD33))/1k
BGNN8 GNN8 VSS I=(v(GNN8)-v(PH2)*(v(VDD33)-v(SN8))/v(VDD33))/1k
BNOPP8 NGPP8 0 V=v(VDD33)-v(GPP8)
BNOPN8 NGPN8 0 V=v(VDD33)-v(GPN8)
BNONP8 NGNP8 0 V=v(VDD33)-v(GNP8)
BNONN8 NGNN8 0 V=v(VDD33)-v(GNN8)
CGPP8 GPP8 VSS 2p
CGPN8 GPN8 VSS 2p
CGNP8 GNP8 VSS 2p
CGNN8 GNN8 VSS 2p
CNGPP8 NGPP8 VSS 0.2p
CNGPN8 NGPN8 VSS 0.2p
CNGNP8 NGNP8 VSS 0.2p
CNGNN8 NGNN8 VSS 0.2p
XPVP8 CDLP8 VP GPP8 NGPP8 VDD33 VSS gf180_tg_lowq
XPVN8 CDLP8 VN GPN8 NGPN8 VDD33 VSS gf180_tg_lowq
XNVP8 CDLN8 VP GNP8 NGNP8 VDD33 VSS gf180_tg_lowq
XNVN8 CDLN8 VN GNN8 NGNN8 VDD33 VSS gf180_tg_lowq
* DAC unit 9 (P side DP9, N side DN9)
CDP9 CDLP9 CDRP9 {CU}
CDN9 CDLN9 CDRN9 {CU}
XDPA9 CDLP9 VCM_REF PH1 NPH1 VDD33 VSS gf180_tg_lowq
XDPB9 CDRP9 VCM_REF PH1 NPH1 VDD33 VSS gf180_tg_lowq
XDNA9 CDLN9 VCM_REF PH1 NPH1 VDD33 VSS gf180_tg_lowq
XDNB9 CDRN9 VCM_REF PH1 NPH1 VDD33 VSS gf180_tg_lowq
XDP29 CDRP9 INP PH2 NPH2 VDD33 VSS gf180_tg_lowq
XDN29 CDRN9 INN PH2 NPH2 VDD33 VSS gf180_tg_lowq
BGPP9 GPP9 VSS I=(v(GPP9)-v(PH2)*v(SP9)/v(VDD33))/1k
BGPN9 GPN9 VSS I=(v(GPN9)-v(PH2)*(v(VDD33)-v(SP9))/v(VDD33))/1k
BGNP9 GNP9 VSS I=(v(GNP9)-v(PH2)*v(SN9)/v(VDD33))/1k
BGNN9 GNN9 VSS I=(v(GNN9)-v(PH2)*(v(VDD33)-v(SN9))/v(VDD33))/1k
BNOPP9 NGPP9 0 V=v(VDD33)-v(GPP9)
BNOPN9 NGPN9 0 V=v(VDD33)-v(GPN9)
BNONP9 NGNP9 0 V=v(VDD33)-v(GNP9)
BNONN9 NGNN9 0 V=v(VDD33)-v(GNN9)
CGPP9 GPP9 VSS 2p
CGPN9 GPN9 VSS 2p
CGNP9 GNP9 VSS 2p
CGNN9 GNN9 VSS 2p
CNGPP9 NGPP9 VSS 0.2p
CNGPN9 NGPN9 VSS 0.2p
CNGNP9 NGNP9 VSS 0.2p
CNGNN9 NGNN9 VSS 0.2p
XPVP9 CDLP9 VP GPP9 NGPP9 VDD33 VSS gf180_tg_lowq
XPVN9 CDLP9 VN GPN9 NGPN9 VDD33 VSS gf180_tg_lowq
XNVP9 CDLN9 VP GNP9 NGNP9 VDD33 VSS gf180_tg_lowq
XNVN9 CDLN9 VN GNN9 NGNN9 VDD33 VSS gf180_tg_lowq
* DAC unit 10 (P side DP10, N side DN10)
CDP10 CDLP10 CDRP10 {CU}
CDN10 CDLN10 CDRN10 {CU}
XDPA10 CDLP10 VCM_REF PH1 NPH1 VDD33 VSS gf180_tg_lowq
XDPB10 CDRP10 VCM_REF PH1 NPH1 VDD33 VSS gf180_tg_lowq
XDNA10 CDLN10 VCM_REF PH1 NPH1 VDD33 VSS gf180_tg_lowq
XDNB10 CDRN10 VCM_REF PH1 NPH1 VDD33 VSS gf180_tg_lowq
XDP210 CDRP10 INP PH2 NPH2 VDD33 VSS gf180_tg_lowq
XDN210 CDRN10 INN PH2 NPH2 VDD33 VSS gf180_tg_lowq
BGPP10 GPP10 VSS I=(v(GPP10)-v(PH2)*v(SP10)/v(VDD33))/1k
BGPN10 GPN10 VSS I=(v(GPN10)-v(PH2)*(v(VDD33)-v(SP10))/v(VDD33))/1k
BGNP10 GNP10 VSS I=(v(GNP10)-v(PH2)*v(SN10)/v(VDD33))/1k
BGNN10 GNN10 VSS I=(v(GNN10)-v(PH2)*(v(VDD33)-v(SN10))/v(VDD33))/1k
BNOPP10 NGPP10 0 V=v(VDD33)-v(GPP10)
BNOPN10 NGPN10 0 V=v(VDD33)-v(GPN10)
BNONP10 NGNP10 0 V=v(VDD33)-v(GNP10)
BNONN10 NGNN10 0 V=v(VDD33)-v(GNN10)
CGPP10 GPP10 VSS 2p
CGPN10 GPN10 VSS 2p
CGNP10 GNP10 VSS 2p
CGNN10 GNN10 VSS 2p
CNGPP10 NGPP10 VSS 0.2p
CNGPN10 NGPN10 VSS 0.2p
CNGNP10 NGNP10 VSS 0.2p
CNGNN10 NGNN10 VSS 0.2p
XPVP10 CDLP10 VP GPP10 NGPP10 VDD33 VSS gf180_tg_lowq
XPVN10 CDLP10 VN GPN10 NGPN10 VDD33 VSS gf180_tg_lowq
XNVP10 CDLN10 VP GNP10 NGNP10 VDD33 VSS gf180_tg_lowq
XNVN10 CDLN10 VN GNN10 NGNN10 VDD33 VSS gf180_tg_lowq
* DAC unit 11 (P side DP11, N side DN11)
CDP11 CDLP11 CDRP11 {CU}
CDN11 CDLN11 CDRN11 {CU}
XDPA11 CDLP11 VCM_REF PH1 NPH1 VDD33 VSS gf180_tg_lowq
XDPB11 CDRP11 VCM_REF PH1 NPH1 VDD33 VSS gf180_tg_lowq
XDNA11 CDLN11 VCM_REF PH1 NPH1 VDD33 VSS gf180_tg_lowq
XDNB11 CDRN11 VCM_REF PH1 NPH1 VDD33 VSS gf180_tg_lowq
XDP211 CDRP11 INP PH2 NPH2 VDD33 VSS gf180_tg_lowq
XDN211 CDRN11 INN PH2 NPH2 VDD33 VSS gf180_tg_lowq
BGPP11 GPP11 VSS I=(v(GPP11)-v(PH2)*v(SP11)/v(VDD33))/1k
BGPN11 GPN11 VSS I=(v(GPN11)-v(PH2)*(v(VDD33)-v(SP11))/v(VDD33))/1k
BGNP11 GNP11 VSS I=(v(GNP11)-v(PH2)*v(SN11)/v(VDD33))/1k
BGNN11 GNN11 VSS I=(v(GNN11)-v(PH2)*(v(VDD33)-v(SN11))/v(VDD33))/1k
BNOPP11 NGPP11 0 V=v(VDD33)-v(GPP11)
BNOPN11 NGPN11 0 V=v(VDD33)-v(GPN11)
BNONP11 NGNP11 0 V=v(VDD33)-v(GNP11)
BNONN11 NGNN11 0 V=v(VDD33)-v(GNN11)
CGPP11 GPP11 VSS 2p
CGPN11 GPN11 VSS 2p
CGNP11 GNP11 VSS 2p
CGNN11 GNN11 VSS 2p
CNGPP11 NGPP11 VSS 0.2p
CNGPN11 NGPN11 VSS 0.2p
CNGNP11 NGNP11 VSS 0.2p
CNGNN11 NGNN11 VSS 0.2p
XPVP11 CDLP11 VP GPP11 NGPP11 VDD33 VSS gf180_tg_lowq
XPVN11 CDLP11 VN GPN11 NGPN11 VDD33 VSS gf180_tg_lowq
XNVP11 CDLN11 VP GNP11 NGNP11 VDD33 VSS gf180_tg_lowq
XNVN11 CDLN11 VN GNN11 NGNN11 VDD33 VSS gf180_tg_lowq
* DAC unit 12 (P side DP12, N side DN12)
CDP12 CDLP12 CDRP12 {CU}
CDN12 CDLN12 CDRN12 {CU}
XDPA12 CDLP12 VCM_REF PH1 NPH1 VDD33 VSS gf180_tg_lowq
XDPB12 CDRP12 VCM_REF PH1 NPH1 VDD33 VSS gf180_tg_lowq
XDNA12 CDLN12 VCM_REF PH1 NPH1 VDD33 VSS gf180_tg_lowq
XDNB12 CDRN12 VCM_REF PH1 NPH1 VDD33 VSS gf180_tg_lowq
XDP212 CDRP12 INP PH2 NPH2 VDD33 VSS gf180_tg_lowq
XDN212 CDRN12 INN PH2 NPH2 VDD33 VSS gf180_tg_lowq
BGPP12 GPP12 VSS I=(v(GPP12)-v(PH2)*v(SP12)/v(VDD33))/1k
BGPN12 GPN12 VSS I=(v(GPN12)-v(PH2)*(v(VDD33)-v(SP12))/v(VDD33))/1k
BGNP12 GNP12 VSS I=(v(GNP12)-v(PH2)*v(SN12)/v(VDD33))/1k
BGNN12 GNN12 VSS I=(v(GNN12)-v(PH2)*(v(VDD33)-v(SN12))/v(VDD33))/1k
BNOPP12 NGPP12 0 V=v(VDD33)-v(GPP12)
BNOPN12 NGPN12 0 V=v(VDD33)-v(GPN12)
BNONP12 NGNP12 0 V=v(VDD33)-v(GNP12)
BNONN12 NGNN12 0 V=v(VDD33)-v(GNN12)
CGPP12 GPP12 VSS 2p
CGPN12 GPN12 VSS 2p
CGNP12 GNP12 VSS 2p
CGNN12 GNN12 VSS 2p
CNGPP12 NGPP12 VSS 0.2p
CNGPN12 NGPN12 VSS 0.2p
CNGNP12 NGNP12 VSS 0.2p
CNGNN12 NGNN12 VSS 0.2p
XPVP12 CDLP12 VP GPP12 NGPP12 VDD33 VSS gf180_tg_lowq
XPVN12 CDLP12 VN GPN12 NGPN12 VDD33 VSS gf180_tg_lowq
XNVP12 CDLN12 VP GNP12 NGNP12 VDD33 VSS gf180_tg_lowq
XNVN12 CDLN12 VN GNN12 NGNN12 VDD33 VSS gf180_tg_lowq
* DAC unit 13 (P side DP13, N side DN13)
CDP13 CDLP13 CDRP13 {CU}
CDN13 CDLN13 CDRN13 {CU}
XDPA13 CDLP13 VCM_REF PH1 NPH1 VDD33 VSS gf180_tg_lowq
XDPB13 CDRP13 VCM_REF PH1 NPH1 VDD33 VSS gf180_tg_lowq
XDNA13 CDLN13 VCM_REF PH1 NPH1 VDD33 VSS gf180_tg_lowq
XDNB13 CDRN13 VCM_REF PH1 NPH1 VDD33 VSS gf180_tg_lowq
XDP213 CDRP13 INP PH2 NPH2 VDD33 VSS gf180_tg_lowq
XDN213 CDRN13 INN PH2 NPH2 VDD33 VSS gf180_tg_lowq
BGPP13 GPP13 VSS I=(v(GPP13)-v(PH2)*v(SP13)/v(VDD33))/1k
BGPN13 GPN13 VSS I=(v(GPN13)-v(PH2)*(v(VDD33)-v(SP13))/v(VDD33))/1k
BGNP13 GNP13 VSS I=(v(GNP13)-v(PH2)*v(SN13)/v(VDD33))/1k
BGNN13 GNN13 VSS I=(v(GNN13)-v(PH2)*(v(VDD33)-v(SN13))/v(VDD33))/1k
BNOPP13 NGPP13 0 V=v(VDD33)-v(GPP13)
BNOPN13 NGPN13 0 V=v(VDD33)-v(GPN13)
BNONP13 NGNP13 0 V=v(VDD33)-v(GNP13)
BNONN13 NGNN13 0 V=v(VDD33)-v(GNN13)
CGPP13 GPP13 VSS 2p
CGPN13 GPN13 VSS 2p
CGNP13 GNP13 VSS 2p
CGNN13 GNN13 VSS 2p
CNGPP13 NGPP13 VSS 0.2p
CNGPN13 NGPN13 VSS 0.2p
CNGNP13 NGNP13 VSS 0.2p
CNGNN13 NGNN13 VSS 0.2p
XPVP13 CDLP13 VP GPP13 NGPP13 VDD33 VSS gf180_tg_lowq
XPVN13 CDLP13 VN GPN13 NGPN13 VDD33 VSS gf180_tg_lowq
XNVP13 CDLN13 VP GNP13 NGNP13 VDD33 VSS gf180_tg_lowq
XNVN13 CDLN13 VN GNN13 NGNN13 VDD33 VSS gf180_tg_lowq
* DAC unit 14 (P side DP14, N side DN14)
CDP14 CDLP14 CDRP14 {CU}
CDN14 CDLN14 CDRN14 {CU}
XDPA14 CDLP14 VCM_REF PH1 NPH1 VDD33 VSS gf180_tg_lowq
XDPB14 CDRP14 VCM_REF PH1 NPH1 VDD33 VSS gf180_tg_lowq
XDNA14 CDLN14 VCM_REF PH1 NPH1 VDD33 VSS gf180_tg_lowq
XDNB14 CDRN14 VCM_REF PH1 NPH1 VDD33 VSS gf180_tg_lowq
XDP214 CDRP14 INP PH2 NPH2 VDD33 VSS gf180_tg_lowq
XDN214 CDRN14 INN PH2 NPH2 VDD33 VSS gf180_tg_lowq
BGPP14 GPP14 VSS I=(v(GPP14)-v(PH2)*v(SP14)/v(VDD33))/1k
BGPN14 GPN14 VSS I=(v(GPN14)-v(PH2)*(v(VDD33)-v(SP14))/v(VDD33))/1k
BGNP14 GNP14 VSS I=(v(GNP14)-v(PH2)*v(SN14)/v(VDD33))/1k
BGNN14 GNN14 VSS I=(v(GNN14)-v(PH2)*(v(VDD33)-v(SN14))/v(VDD33))/1k
BNOPP14 NGPP14 0 V=v(VDD33)-v(GPP14)
BNOPN14 NGPN14 0 V=v(VDD33)-v(GPN14)
BNONP14 NGNP14 0 V=v(VDD33)-v(GNP14)
BNONN14 NGNN14 0 V=v(VDD33)-v(GNN14)
CGPP14 GPP14 VSS 2p
CGPN14 GPN14 VSS 2p
CGNP14 GNP14 VSS 2p
CGNN14 GNN14 VSS 2p
CNGPP14 NGPP14 VSS 0.2p
CNGPN14 NGPN14 VSS 0.2p
CNGNP14 NGNP14 VSS 0.2p
CNGNN14 NGNN14 VSS 0.2p
XPVP14 CDLP14 VP GPP14 NGPP14 VDD33 VSS gf180_tg_lowq
XPVN14 CDLP14 VN GPN14 NGPN14 VDD33 VSS gf180_tg_lowq
XNVP14 CDLN14 VP GNP14 NGNP14 VDD33 VSS gf180_tg_lowq
XNVN14 CDLN14 VN GNN14 NGNN14 VDD33 VSS gf180_tg_lowq
CIP OUTN INP {CI}
CIN OUTP INN {CI}
RBIASP INP VCM_REF 10G
RBIASN INN VCM_REF 10G
.ends gf180_sdm3_int1_mb

* ---- int2 mb: CS=2p, CI=4p, 15x0.25p/side DAC (S2P/S2N selects, PH1 int)
* int2 integrates during PH1 with the REGISTERED code (applied via S2*).
.subckt gf180_sdm3_int2_mb INP_S INN_S VCM_REF VP VN OUTP OUTN PH1 NPH1 PH2 NPH2 VDD33 VSS S2P0 S2P1 S2P2 S2P3 S2P4 S2P5 S2P6 S2P7 S2P8 S2P9 S2P10 S2P11 S2P12 S2P13 S2P14 S2N0 S2N1 S2N2 S2N3 S2N4 S2N5 S2N6 S2N7 S2N8 S2N9 S2N10 S2N11 S2N12 S2N13 S2N14 params: CS=2p CU=0.25p CI=4p W91=11u L91=2u W92=6u L92=2u W10=12u RSET=25k CC=10p
XOTA INP INN VCM_REF OUTP OUTN VDD33 VSS gf180_fd_ota_full2_nc W91={W91} L91={L91} W92={W92} L92={L92} W10={W10} RSET={RSET} CC={CC}
CSP CSLP CSRP {CS}
CSN CSLN CSRN {CS}
XS1A CSLP INP_S PH1 NPH1 VDD33 VSS gf180_tg_lowq
XS1B CSRP VCM_REF PH1 NPH1 VDD33 VSS gf180_tg_lowq
XS1C CSLN INN_S PH1 NPH1 VDD33 VSS gf180_tg_lowq
XS1D CSRN VCM_REF PH1 NPH1 VDD33 VSS gf180_tg_lowq
XS2A CSLP VCM_REF PH2 NPH2 VDD33 VSS gf180_tg_lowq
XS2B CSRP INP PH2 NPH2 VDD33 VSS gf180_tg_lowq
XS2C CSLN VCM_REF PH2 NPH2 VDD33 VSS gf180_tg_lowq
XS2D CSRN INN PH2 NPH2 VDD33 VSS gf180_tg_lowq
* DAC unit 0
CDP0 CDLP0 CDRP0 {CU}
CDN0 CDLN0 CDRN0 {CU}
XDP10 CDRP0 VCM_REF PH1 NPH1 VDD33 VSS gf180_tg_lowq
XDP20 CDRP0 INP PH2 NPH2 VDD33 VSS gf180_tg_lowq
XDN10 CDRN0 VCM_REF PH1 NPH1 VDD33 VSS gf180_tg_lowq
XDN20 CDRN0 INN PH2 NPH2 VDD33 VSS gf180_tg_lowq
BGPP0 GPP0 VSS I=(v(GPP0)-v(PH2)*v(S2P0)/v(VDD33))/1k
BGPN0 GPN0 VSS I=(v(GPN0)-v(PH2)*(v(VDD33)-v(S2P0))/v(VDD33))/1k
BGNP0 GNP0 VSS I=(v(GNP0)-v(PH2)*v(S2N0)/v(VDD33))/1k
BGNN0 GNN0 VSS I=(v(GNN0)-v(PH2)*(v(VDD33)-v(S2N0))/v(VDD33))/1k
BNOPP0 NGPP0 0 V=v(VDD33)-v(GPP0)
BNOPN0 NGPN0 0 V=v(VDD33)-v(GPN0)
BNONP0 NGNP0 0 V=v(VDD33)-v(GNP0)
BNONN0 NGNN0 0 V=v(VDD33)-v(GNN0)
CGPP0 GPP0 VSS 2p
CGPN0 GPN0 VSS 2p
CGNP0 GNP0 VSS 2p
CGNN0 GNN0 VSS 2p
CNGPP0 NGPP0 VSS 0.2p
CNGPN0 NGPN0 VSS 0.2p
CNGNP0 NGNP0 VSS 0.2p
CNGNN0 NGNN0 VSS 0.2p
XPVP0 CDLP0 VP GPP0 NGPP0 VDD33 VSS gf180_tg_lowq
XPVN0 CDLP0 VN GPN0 NGPN0 VDD33 VSS gf180_tg_lowq
XNVP0 CDLN0 VP GNP0 NGNP0 VDD33 VSS gf180_tg_lowq
XNVN0 CDLN0 VN GNN0 NGNN0 VDD33 VSS gf180_tg_lowq
XDPC0 CDLP0 VCM_REF PH1 NPH1 VDD33 VSS gf180_tg_lowq
XDNC0 CDLN0 VCM_REF PH1 NPH1 VDD33 VSS gf180_tg_lowq
* DAC unit 1
CDP1 CDLP1 CDRP1 {CU}
CDN1 CDLN1 CDRN1 {CU}
XDP11 CDRP1 VCM_REF PH1 NPH1 VDD33 VSS gf180_tg_lowq
XDP21 CDRP1 INP PH2 NPH2 VDD33 VSS gf180_tg_lowq
XDN11 CDRN1 VCM_REF PH1 NPH1 VDD33 VSS gf180_tg_lowq
XDN21 CDRN1 INN PH2 NPH2 VDD33 VSS gf180_tg_lowq
BGPP1 GPP1 VSS I=(v(GPP1)-v(PH2)*v(S2P1)/v(VDD33))/1k
BGPN1 GPN1 VSS I=(v(GPN1)-v(PH2)*(v(VDD33)-v(S2P1))/v(VDD33))/1k
BGNP1 GNP1 VSS I=(v(GNP1)-v(PH2)*v(S2N1)/v(VDD33))/1k
BGNN1 GNN1 VSS I=(v(GNN1)-v(PH2)*(v(VDD33)-v(S2N1))/v(VDD33))/1k
BNOPP1 NGPP1 0 V=v(VDD33)-v(GPP1)
BNOPN1 NGPN1 0 V=v(VDD33)-v(GPN1)
BNONP1 NGNP1 0 V=v(VDD33)-v(GNP1)
BNONN1 NGNN1 0 V=v(VDD33)-v(GNN1)
CGPP1 GPP1 VSS 2p
CGPN1 GPN1 VSS 2p
CGNP1 GNP1 VSS 2p
CGNN1 GNN1 VSS 2p
CNGPP1 NGPP1 VSS 0.2p
CNGPN1 NGPN1 VSS 0.2p
CNGNP1 NGNP1 VSS 0.2p
CNGNN1 NGNN1 VSS 0.2p
XPVP1 CDLP1 VP GPP1 NGPP1 VDD33 VSS gf180_tg_lowq
XPVN1 CDLP1 VN GPN1 NGPN1 VDD33 VSS gf180_tg_lowq
XNVP1 CDLN1 VP GNP1 NGNP1 VDD33 VSS gf180_tg_lowq
XNVN1 CDLN1 VN GNN1 NGNN1 VDD33 VSS gf180_tg_lowq
XDPC1 CDLP1 VCM_REF PH1 NPH1 VDD33 VSS gf180_tg_lowq
XDNC1 CDLN1 VCM_REF PH1 NPH1 VDD33 VSS gf180_tg_lowq
* DAC unit 2
CDP2 CDLP2 CDRP2 {CU}
CDN2 CDLN2 CDRN2 {CU}
XDP12 CDRP2 VCM_REF PH1 NPH1 VDD33 VSS gf180_tg_lowq
XDP22 CDRP2 INP PH2 NPH2 VDD33 VSS gf180_tg_lowq
XDN12 CDRN2 VCM_REF PH1 NPH1 VDD33 VSS gf180_tg_lowq
XDN22 CDRN2 INN PH2 NPH2 VDD33 VSS gf180_tg_lowq
BGPP2 GPP2 VSS I=(v(GPP2)-v(PH2)*v(S2P2)/v(VDD33))/1k
BGPN2 GPN2 VSS I=(v(GPN2)-v(PH2)*(v(VDD33)-v(S2P2))/v(VDD33))/1k
BGNP2 GNP2 VSS I=(v(GNP2)-v(PH2)*v(S2N2)/v(VDD33))/1k
BGNN2 GNN2 VSS I=(v(GNN2)-v(PH2)*(v(VDD33)-v(S2N2))/v(VDD33))/1k
BNOPP2 NGPP2 0 V=v(VDD33)-v(GPP2)
BNOPN2 NGPN2 0 V=v(VDD33)-v(GPN2)
BNONP2 NGNP2 0 V=v(VDD33)-v(GNP2)
BNONN2 NGNN2 0 V=v(VDD33)-v(GNN2)
CGPP2 GPP2 VSS 2p
CGPN2 GPN2 VSS 2p
CGNP2 GNP2 VSS 2p
CGNN2 GNN2 VSS 2p
CNGPP2 NGPP2 VSS 0.2p
CNGPN2 NGPN2 VSS 0.2p
CNGNP2 NGNP2 VSS 0.2p
CNGNN2 NGNN2 VSS 0.2p
XPVP2 CDLP2 VP GPP2 NGPP2 VDD33 VSS gf180_tg_lowq
XPVN2 CDLP2 VN GPN2 NGPN2 VDD33 VSS gf180_tg_lowq
XNVP2 CDLN2 VP GNP2 NGNP2 VDD33 VSS gf180_tg_lowq
XNVN2 CDLN2 VN GNN2 NGNN2 VDD33 VSS gf180_tg_lowq
XDPC2 CDLP2 VCM_REF PH1 NPH1 VDD33 VSS gf180_tg_lowq
XDNC2 CDLN2 VCM_REF PH1 NPH1 VDD33 VSS gf180_tg_lowq
* DAC unit 3
CDP3 CDLP3 CDRP3 {CU}
CDN3 CDLN3 CDRN3 {CU}
XDP13 CDRP3 VCM_REF PH1 NPH1 VDD33 VSS gf180_tg_lowq
XDP23 CDRP3 INP PH2 NPH2 VDD33 VSS gf180_tg_lowq
XDN13 CDRN3 VCM_REF PH1 NPH1 VDD33 VSS gf180_tg_lowq
XDN23 CDRN3 INN PH2 NPH2 VDD33 VSS gf180_tg_lowq
BGPP3 GPP3 VSS I=(v(GPP3)-v(PH2)*v(S2P3)/v(VDD33))/1k
BGPN3 GPN3 VSS I=(v(GPN3)-v(PH2)*(v(VDD33)-v(S2P3))/v(VDD33))/1k
BGNP3 GNP3 VSS I=(v(GNP3)-v(PH2)*v(S2N3)/v(VDD33))/1k
BGNN3 GNN3 VSS I=(v(GNN3)-v(PH2)*(v(VDD33)-v(S2N3))/v(VDD33))/1k
BNOPP3 NGPP3 0 V=v(VDD33)-v(GPP3)
BNOPN3 NGPN3 0 V=v(VDD33)-v(GPN3)
BNONP3 NGNP3 0 V=v(VDD33)-v(GNP3)
BNONN3 NGNN3 0 V=v(VDD33)-v(GNN3)
CGPP3 GPP3 VSS 2p
CGPN3 GPN3 VSS 2p
CGNP3 GNP3 VSS 2p
CGNN3 GNN3 VSS 2p
CNGPP3 NGPP3 VSS 0.2p
CNGPN3 NGPN3 VSS 0.2p
CNGNP3 NGNP3 VSS 0.2p
CNGNN3 NGNN3 VSS 0.2p
XPVP3 CDLP3 VP GPP3 NGPP3 VDD33 VSS gf180_tg_lowq
XPVN3 CDLP3 VN GPN3 NGPN3 VDD33 VSS gf180_tg_lowq
XNVP3 CDLN3 VP GNP3 NGNP3 VDD33 VSS gf180_tg_lowq
XNVN3 CDLN3 VN GNN3 NGNN3 VDD33 VSS gf180_tg_lowq
XDPC3 CDLP3 VCM_REF PH1 NPH1 VDD33 VSS gf180_tg_lowq
XDNC3 CDLN3 VCM_REF PH1 NPH1 VDD33 VSS gf180_tg_lowq
* DAC unit 4
CDP4 CDLP4 CDRP4 {CU}
CDN4 CDLN4 CDRN4 {CU}
XDP14 CDRP4 VCM_REF PH1 NPH1 VDD33 VSS gf180_tg_lowq
XDP24 CDRP4 INP PH2 NPH2 VDD33 VSS gf180_tg_lowq
XDN14 CDRN4 VCM_REF PH1 NPH1 VDD33 VSS gf180_tg_lowq
XDN24 CDRN4 INN PH2 NPH2 VDD33 VSS gf180_tg_lowq
BGPP4 GPP4 VSS I=(v(GPP4)-v(PH2)*v(S2P4)/v(VDD33))/1k
BGPN4 GPN4 VSS I=(v(GPN4)-v(PH2)*(v(VDD33)-v(S2P4))/v(VDD33))/1k
BGNP4 GNP4 VSS I=(v(GNP4)-v(PH2)*v(S2N4)/v(VDD33))/1k
BGNN4 GNN4 VSS I=(v(GNN4)-v(PH2)*(v(VDD33)-v(S2N4))/v(VDD33))/1k
BNOPP4 NGPP4 0 V=v(VDD33)-v(GPP4)
BNOPN4 NGPN4 0 V=v(VDD33)-v(GPN4)
BNONP4 NGNP4 0 V=v(VDD33)-v(GNP4)
BNONN4 NGNN4 0 V=v(VDD33)-v(GNN4)
CGPP4 GPP4 VSS 2p
CGPN4 GPN4 VSS 2p
CGNP4 GNP4 VSS 2p
CGNN4 GNN4 VSS 2p
CNGPP4 NGPP4 VSS 0.2p
CNGPN4 NGPN4 VSS 0.2p
CNGNP4 NGNP4 VSS 0.2p
CNGNN4 NGNN4 VSS 0.2p
XPVP4 CDLP4 VP GPP4 NGPP4 VDD33 VSS gf180_tg_lowq
XPVN4 CDLP4 VN GPN4 NGPN4 VDD33 VSS gf180_tg_lowq
XNVP4 CDLN4 VP GNP4 NGNP4 VDD33 VSS gf180_tg_lowq
XNVN4 CDLN4 VN GNN4 NGNN4 VDD33 VSS gf180_tg_lowq
XDPC4 CDLP4 VCM_REF PH1 NPH1 VDD33 VSS gf180_tg_lowq
XDNC4 CDLN4 VCM_REF PH1 NPH1 VDD33 VSS gf180_tg_lowq
* DAC unit 5
CDP5 CDLP5 CDRP5 {CU}
CDN5 CDLN5 CDRN5 {CU}
XDP15 CDRP5 VCM_REF PH1 NPH1 VDD33 VSS gf180_tg_lowq
XDP25 CDRP5 INP PH2 NPH2 VDD33 VSS gf180_tg_lowq
XDN15 CDRN5 VCM_REF PH1 NPH1 VDD33 VSS gf180_tg_lowq
XDN25 CDRN5 INN PH2 NPH2 VDD33 VSS gf180_tg_lowq
BGPP5 GPP5 VSS I=(v(GPP5)-v(PH2)*v(S2P5)/v(VDD33))/1k
BGPN5 GPN5 VSS I=(v(GPN5)-v(PH2)*(v(VDD33)-v(S2P5))/v(VDD33))/1k
BGNP5 GNP5 VSS I=(v(GNP5)-v(PH2)*v(S2N5)/v(VDD33))/1k
BGNN5 GNN5 VSS I=(v(GNN5)-v(PH2)*(v(VDD33)-v(S2N5))/v(VDD33))/1k
BNOPP5 NGPP5 0 V=v(VDD33)-v(GPP5)
BNOPN5 NGPN5 0 V=v(VDD33)-v(GPN5)
BNONP5 NGNP5 0 V=v(VDD33)-v(GNP5)
BNONN5 NGNN5 0 V=v(VDD33)-v(GNN5)
CGPP5 GPP5 VSS 2p
CGPN5 GPN5 VSS 2p
CGNP5 GNP5 VSS 2p
CGNN5 GNN5 VSS 2p
CNGPP5 NGPP5 VSS 0.2p
CNGPN5 NGPN5 VSS 0.2p
CNGNP5 NGNP5 VSS 0.2p
CNGNN5 NGNN5 VSS 0.2p
XPVP5 CDLP5 VP GPP5 NGPP5 VDD33 VSS gf180_tg_lowq
XPVN5 CDLP5 VN GPN5 NGPN5 VDD33 VSS gf180_tg_lowq
XNVP5 CDLN5 VP GNP5 NGNP5 VDD33 VSS gf180_tg_lowq
XNVN5 CDLN5 VN GNN5 NGNN5 VDD33 VSS gf180_tg_lowq
XDPC5 CDLP5 VCM_REF PH1 NPH1 VDD33 VSS gf180_tg_lowq
XDNC5 CDLN5 VCM_REF PH1 NPH1 VDD33 VSS gf180_tg_lowq
* DAC unit 6
CDP6 CDLP6 CDRP6 {CU}
CDN6 CDLN6 CDRN6 {CU}
XDP16 CDRP6 VCM_REF PH1 NPH1 VDD33 VSS gf180_tg_lowq
XDP26 CDRP6 INP PH2 NPH2 VDD33 VSS gf180_tg_lowq
XDN16 CDRN6 VCM_REF PH1 NPH1 VDD33 VSS gf180_tg_lowq
XDN26 CDRN6 INN PH2 NPH2 VDD33 VSS gf180_tg_lowq
BGPP6 GPP6 VSS I=(v(GPP6)-v(PH2)*v(S2P6)/v(VDD33))/1k
BGPN6 GPN6 VSS I=(v(GPN6)-v(PH2)*(v(VDD33)-v(S2P6))/v(VDD33))/1k
BGNP6 GNP6 VSS I=(v(GNP6)-v(PH2)*v(S2N6)/v(VDD33))/1k
BGNN6 GNN6 VSS I=(v(GNN6)-v(PH2)*(v(VDD33)-v(S2N6))/v(VDD33))/1k
BNOPP6 NGPP6 0 V=v(VDD33)-v(GPP6)
BNOPN6 NGPN6 0 V=v(VDD33)-v(GPN6)
BNONP6 NGNP6 0 V=v(VDD33)-v(GNP6)
BNONN6 NGNN6 0 V=v(VDD33)-v(GNN6)
CGPP6 GPP6 VSS 2p
CGPN6 GPN6 VSS 2p
CGNP6 GNP6 VSS 2p
CGNN6 GNN6 VSS 2p
CNGPP6 NGPP6 VSS 0.2p
CNGPN6 NGPN6 VSS 0.2p
CNGNP6 NGNP6 VSS 0.2p
CNGNN6 NGNN6 VSS 0.2p
XPVP6 CDLP6 VP GPP6 NGPP6 VDD33 VSS gf180_tg_lowq
XPVN6 CDLP6 VN GPN6 NGPN6 VDD33 VSS gf180_tg_lowq
XNVP6 CDLN6 VP GNP6 NGNP6 VDD33 VSS gf180_tg_lowq
XNVN6 CDLN6 VN GNN6 NGNN6 VDD33 VSS gf180_tg_lowq
XDPC6 CDLP6 VCM_REF PH1 NPH1 VDD33 VSS gf180_tg_lowq
XDNC6 CDLN6 VCM_REF PH1 NPH1 VDD33 VSS gf180_tg_lowq
* DAC unit 7
CDP7 CDLP7 CDRP7 {CU}
CDN7 CDLN7 CDRN7 {CU}
XDP17 CDRP7 VCM_REF PH1 NPH1 VDD33 VSS gf180_tg_lowq
XDP27 CDRP7 INP PH2 NPH2 VDD33 VSS gf180_tg_lowq
XDN17 CDRN7 VCM_REF PH1 NPH1 VDD33 VSS gf180_tg_lowq
XDN27 CDRN7 INN PH2 NPH2 VDD33 VSS gf180_tg_lowq
BGPP7 GPP7 VSS I=(v(GPP7)-v(PH2)*v(S2P7)/v(VDD33))/1k
BGPN7 GPN7 VSS I=(v(GPN7)-v(PH2)*(v(VDD33)-v(S2P7))/v(VDD33))/1k
BGNP7 GNP7 VSS I=(v(GNP7)-v(PH2)*v(S2N7)/v(VDD33))/1k
BGNN7 GNN7 VSS I=(v(GNN7)-v(PH2)*(v(VDD33)-v(S2N7))/v(VDD33))/1k
BNOPP7 NGPP7 0 V=v(VDD33)-v(GPP7)
BNOPN7 NGPN7 0 V=v(VDD33)-v(GPN7)
BNONP7 NGNP7 0 V=v(VDD33)-v(GNP7)
BNONN7 NGNN7 0 V=v(VDD33)-v(GNN7)
CGPP7 GPP7 VSS 2p
CGPN7 GPN7 VSS 2p
CGNP7 GNP7 VSS 2p
CGNN7 GNN7 VSS 2p
CNGPP7 NGPP7 VSS 0.2p
CNGPN7 NGPN7 VSS 0.2p
CNGNP7 NGNP7 VSS 0.2p
CNGNN7 NGNN7 VSS 0.2p
XPVP7 CDLP7 VP GPP7 NGPP7 VDD33 VSS gf180_tg_lowq
XPVN7 CDLP7 VN GPN7 NGPN7 VDD33 VSS gf180_tg_lowq
XNVP7 CDLN7 VP GNP7 NGNP7 VDD33 VSS gf180_tg_lowq
XNVN7 CDLN7 VN GNN7 NGNN7 VDD33 VSS gf180_tg_lowq
XDPC7 CDLP7 VCM_REF PH1 NPH1 VDD33 VSS gf180_tg_lowq
XDNC7 CDLN7 VCM_REF PH1 NPH1 VDD33 VSS gf180_tg_lowq
* DAC unit 8
CDP8 CDLP8 CDRP8 {CU}
CDN8 CDLN8 CDRN8 {CU}
XDP18 CDRP8 VCM_REF PH1 NPH1 VDD33 VSS gf180_tg_lowq
XDP28 CDRP8 INP PH2 NPH2 VDD33 VSS gf180_tg_lowq
XDN18 CDRN8 VCM_REF PH1 NPH1 VDD33 VSS gf180_tg_lowq
XDN28 CDRN8 INN PH2 NPH2 VDD33 VSS gf180_tg_lowq
BGPP8 GPP8 VSS I=(v(GPP8)-v(PH2)*v(S2P8)/v(VDD33))/1k
BGPN8 GPN8 VSS I=(v(GPN8)-v(PH2)*(v(VDD33)-v(S2P8))/v(VDD33))/1k
BGNP8 GNP8 VSS I=(v(GNP8)-v(PH2)*v(S2N8)/v(VDD33))/1k
BGNN8 GNN8 VSS I=(v(GNN8)-v(PH2)*(v(VDD33)-v(S2N8))/v(VDD33))/1k
BNOPP8 NGPP8 0 V=v(VDD33)-v(GPP8)
BNOPN8 NGPN8 0 V=v(VDD33)-v(GPN8)
BNONP8 NGNP8 0 V=v(VDD33)-v(GNP8)
BNONN8 NGNN8 0 V=v(VDD33)-v(GNN8)
CGPP8 GPP8 VSS 2p
CGPN8 GPN8 VSS 2p
CGNP8 GNP8 VSS 2p
CGNN8 GNN8 VSS 2p
CNGPP8 NGPP8 VSS 0.2p
CNGPN8 NGPN8 VSS 0.2p
CNGNP8 NGNP8 VSS 0.2p
CNGNN8 NGNN8 VSS 0.2p
XPVP8 CDLP8 VP GPP8 NGPP8 VDD33 VSS gf180_tg_lowq
XPVN8 CDLP8 VN GPN8 NGPN8 VDD33 VSS gf180_tg_lowq
XNVP8 CDLN8 VP GNP8 NGNP8 VDD33 VSS gf180_tg_lowq
XNVN8 CDLN8 VN GNN8 NGNN8 VDD33 VSS gf180_tg_lowq
XDPC8 CDLP8 VCM_REF PH1 NPH1 VDD33 VSS gf180_tg_lowq
XDNC8 CDLN8 VCM_REF PH1 NPH1 VDD33 VSS gf180_tg_lowq
* DAC unit 9
CDP9 CDLP9 CDRP9 {CU}
CDN9 CDLN9 CDRN9 {CU}
XDP19 CDRP9 VCM_REF PH1 NPH1 VDD33 VSS gf180_tg_lowq
XDP29 CDRP9 INP PH2 NPH2 VDD33 VSS gf180_tg_lowq
XDN19 CDRN9 VCM_REF PH1 NPH1 VDD33 VSS gf180_tg_lowq
XDN29 CDRN9 INN PH2 NPH2 VDD33 VSS gf180_tg_lowq
BGPP9 GPP9 VSS I=(v(GPP9)-v(PH2)*v(S2P9)/v(VDD33))/1k
BGPN9 GPN9 VSS I=(v(GPN9)-v(PH2)*(v(VDD33)-v(S2P9))/v(VDD33))/1k
BGNP9 GNP9 VSS I=(v(GNP9)-v(PH2)*v(S2N9)/v(VDD33))/1k
BGNN9 GNN9 VSS I=(v(GNN9)-v(PH2)*(v(VDD33)-v(S2N9))/v(VDD33))/1k
BNOPP9 NGPP9 0 V=v(VDD33)-v(GPP9)
BNOPN9 NGPN9 0 V=v(VDD33)-v(GPN9)
BNONP9 NGNP9 0 V=v(VDD33)-v(GNP9)
BNONN9 NGNN9 0 V=v(VDD33)-v(GNN9)
CGPP9 GPP9 VSS 2p
CGPN9 GPN9 VSS 2p
CGNP9 GNP9 VSS 2p
CGNN9 GNN9 VSS 2p
CNGPP9 NGPP9 VSS 0.2p
CNGPN9 NGPN9 VSS 0.2p
CNGNP9 NGNP9 VSS 0.2p
CNGNN9 NGNN9 VSS 0.2p
XPVP9 CDLP9 VP GPP9 NGPP9 VDD33 VSS gf180_tg_lowq
XPVN9 CDLP9 VN GPN9 NGPN9 VDD33 VSS gf180_tg_lowq
XNVP9 CDLN9 VP GNP9 NGNP9 VDD33 VSS gf180_tg_lowq
XNVN9 CDLN9 VN GNN9 NGNN9 VDD33 VSS gf180_tg_lowq
XDPC9 CDLP9 VCM_REF PH1 NPH1 VDD33 VSS gf180_tg_lowq
XDNC9 CDLN9 VCM_REF PH1 NPH1 VDD33 VSS gf180_tg_lowq
* DAC unit 10
CDP10 CDLP10 CDRP10 {CU}
CDN10 CDLN10 CDRN10 {CU}
XDP110 CDRP10 VCM_REF PH1 NPH1 VDD33 VSS gf180_tg_lowq
XDP210 CDRP10 INP PH2 NPH2 VDD33 VSS gf180_tg_lowq
XDN110 CDRN10 VCM_REF PH1 NPH1 VDD33 VSS gf180_tg_lowq
XDN210 CDRN10 INN PH2 NPH2 VDD33 VSS gf180_tg_lowq
BGPP10 GPP10 VSS I=(v(GPP10)-v(PH2)*v(S2P10)/v(VDD33))/1k
BGPN10 GPN10 VSS I=(v(GPN10)-v(PH2)*(v(VDD33)-v(S2P10))/v(VDD33))/1k
BGNP10 GNP10 VSS I=(v(GNP10)-v(PH2)*v(S2N10)/v(VDD33))/1k
BGNN10 GNN10 VSS I=(v(GNN10)-v(PH2)*(v(VDD33)-v(S2N10))/v(VDD33))/1k
BNOPP10 NGPP10 0 V=v(VDD33)-v(GPP10)
BNOPN10 NGPN10 0 V=v(VDD33)-v(GPN10)
BNONP10 NGNP10 0 V=v(VDD33)-v(GNP10)
BNONN10 NGNN10 0 V=v(VDD33)-v(GNN10)
CGPP10 GPP10 VSS 2p
CGPN10 GPN10 VSS 2p
CGNP10 GNP10 VSS 2p
CGNN10 GNN10 VSS 2p
CNGPP10 NGPP10 VSS 0.2p
CNGPN10 NGPN10 VSS 0.2p
CNGNP10 NGNP10 VSS 0.2p
CNGNN10 NGNN10 VSS 0.2p
XPVP10 CDLP10 VP GPP10 NGPP10 VDD33 VSS gf180_tg_lowq
XPVN10 CDLP10 VN GPN10 NGPN10 VDD33 VSS gf180_tg_lowq
XNVP10 CDLN10 VP GNP10 NGNP10 VDD33 VSS gf180_tg_lowq
XNVN10 CDLN10 VN GNN10 NGNN10 VDD33 VSS gf180_tg_lowq
XDPC10 CDLP10 VCM_REF PH1 NPH1 VDD33 VSS gf180_tg_lowq
XDNC10 CDLN10 VCM_REF PH1 NPH1 VDD33 VSS gf180_tg_lowq
* DAC unit 11
CDP11 CDLP11 CDRP11 {CU}
CDN11 CDLN11 CDRN11 {CU}
XDP111 CDRP11 VCM_REF PH1 NPH1 VDD33 VSS gf180_tg_lowq
XDP211 CDRP11 INP PH2 NPH2 VDD33 VSS gf180_tg_lowq
XDN111 CDRN11 VCM_REF PH1 NPH1 VDD33 VSS gf180_tg_lowq
XDN211 CDRN11 INN PH2 NPH2 VDD33 VSS gf180_tg_lowq
BGPP11 GPP11 VSS I=(v(GPP11)-v(PH2)*v(S2P11)/v(VDD33))/1k
BGPN11 GPN11 VSS I=(v(GPN11)-v(PH2)*(v(VDD33)-v(S2P11))/v(VDD33))/1k
BGNP11 GNP11 VSS I=(v(GNP11)-v(PH2)*v(S2N11)/v(VDD33))/1k
BGNN11 GNN11 VSS I=(v(GNN11)-v(PH2)*(v(VDD33)-v(S2N11))/v(VDD33))/1k
BNOPP11 NGPP11 0 V=v(VDD33)-v(GPP11)
BNOPN11 NGPN11 0 V=v(VDD33)-v(GPN11)
BNONP11 NGNP11 0 V=v(VDD33)-v(GNP11)
BNONN11 NGNN11 0 V=v(VDD33)-v(GNN11)
CGPP11 GPP11 VSS 2p
CGPN11 GPN11 VSS 2p
CGNP11 GNP11 VSS 2p
CGNN11 GNN11 VSS 2p
CNGPP11 NGPP11 VSS 0.2p
CNGPN11 NGPN11 VSS 0.2p
CNGNP11 NGNP11 VSS 0.2p
CNGNN11 NGNN11 VSS 0.2p
XPVP11 CDLP11 VP GPP11 NGPP11 VDD33 VSS gf180_tg_lowq
XPVN11 CDLP11 VN GPN11 NGPN11 VDD33 VSS gf180_tg_lowq
XNVP11 CDLN11 VP GNP11 NGNP11 VDD33 VSS gf180_tg_lowq
XNVN11 CDLN11 VN GNN11 NGNN11 VDD33 VSS gf180_tg_lowq
XDPC11 CDLP11 VCM_REF PH1 NPH1 VDD33 VSS gf180_tg_lowq
XDNC11 CDLN11 VCM_REF PH1 NPH1 VDD33 VSS gf180_tg_lowq
* DAC unit 12
CDP12 CDLP12 CDRP12 {CU}
CDN12 CDLN12 CDRN12 {CU}
XDP112 CDRP12 VCM_REF PH1 NPH1 VDD33 VSS gf180_tg_lowq
XDP212 CDRP12 INP PH2 NPH2 VDD33 VSS gf180_tg_lowq
XDN112 CDRN12 VCM_REF PH1 NPH1 VDD33 VSS gf180_tg_lowq
XDN212 CDRN12 INN PH2 NPH2 VDD33 VSS gf180_tg_lowq
BGPP12 GPP12 VSS I=(v(GPP12)-v(PH2)*v(S2P12)/v(VDD33))/1k
BGPN12 GPN12 VSS I=(v(GPN12)-v(PH2)*(v(VDD33)-v(S2P12))/v(VDD33))/1k
BGNP12 GNP12 VSS I=(v(GNP12)-v(PH2)*v(S2N12)/v(VDD33))/1k
BGNN12 GNN12 VSS I=(v(GNN12)-v(PH2)*(v(VDD33)-v(S2N12))/v(VDD33))/1k
BNOPP12 NGPP12 0 V=v(VDD33)-v(GPP12)
BNOPN12 NGPN12 0 V=v(VDD33)-v(GPN12)
BNONP12 NGNP12 0 V=v(VDD33)-v(GNP12)
BNONN12 NGNN12 0 V=v(VDD33)-v(GNN12)
CGPP12 GPP12 VSS 2p
CGPN12 GPN12 VSS 2p
CGNP12 GNP12 VSS 2p
CGNN12 GNN12 VSS 2p
CNGPP12 NGPP12 VSS 0.2p
CNGPN12 NGPN12 VSS 0.2p
CNGNP12 NGNP12 VSS 0.2p
CNGNN12 NGNN12 VSS 0.2p
XPVP12 CDLP12 VP GPP12 NGPP12 VDD33 VSS gf180_tg_lowq
XPVN12 CDLP12 VN GPN12 NGPN12 VDD33 VSS gf180_tg_lowq
XNVP12 CDLN12 VP GNP12 NGNP12 VDD33 VSS gf180_tg_lowq
XNVN12 CDLN12 VN GNN12 NGNN12 VDD33 VSS gf180_tg_lowq
XDPC12 CDLP12 VCM_REF PH1 NPH1 VDD33 VSS gf180_tg_lowq
XDNC12 CDLN12 VCM_REF PH1 NPH1 VDD33 VSS gf180_tg_lowq
* DAC unit 13
CDP13 CDLP13 CDRP13 {CU}
CDN13 CDLN13 CDRN13 {CU}
XDP113 CDRP13 VCM_REF PH1 NPH1 VDD33 VSS gf180_tg_lowq
XDP213 CDRP13 INP PH2 NPH2 VDD33 VSS gf180_tg_lowq
XDN113 CDRN13 VCM_REF PH1 NPH1 VDD33 VSS gf180_tg_lowq
XDN213 CDRN13 INN PH2 NPH2 VDD33 VSS gf180_tg_lowq
BGPP13 GPP13 VSS I=(v(GPP13)-v(PH2)*v(S2P13)/v(VDD33))/1k
BGPN13 GPN13 VSS I=(v(GPN13)-v(PH2)*(v(VDD33)-v(S2P13))/v(VDD33))/1k
BGNP13 GNP13 VSS I=(v(GNP13)-v(PH2)*v(S2N13)/v(VDD33))/1k
BGNN13 GNN13 VSS I=(v(GNN13)-v(PH2)*(v(VDD33)-v(S2N13))/v(VDD33))/1k
BNOPP13 NGPP13 0 V=v(VDD33)-v(GPP13)
BNOPN13 NGPN13 0 V=v(VDD33)-v(GPN13)
BNONP13 NGNP13 0 V=v(VDD33)-v(GNP13)
BNONN13 NGNN13 0 V=v(VDD33)-v(GNN13)
CGPP13 GPP13 VSS 2p
CGPN13 GPN13 VSS 2p
CGNP13 GNP13 VSS 2p
CGNN13 GNN13 VSS 2p
CNGPP13 NGPP13 VSS 0.2p
CNGPN13 NGPN13 VSS 0.2p
CNGNP13 NGNP13 VSS 0.2p
CNGNN13 NGNN13 VSS 0.2p
XPVP13 CDLP13 VP GPP13 NGPP13 VDD33 VSS gf180_tg_lowq
XPVN13 CDLP13 VN GPN13 NGPN13 VDD33 VSS gf180_tg_lowq
XNVP13 CDLN13 VP GNP13 NGNP13 VDD33 VSS gf180_tg_lowq
XNVN13 CDLN13 VN GNN13 NGNN13 VDD33 VSS gf180_tg_lowq
XDPC13 CDLP13 VCM_REF PH1 NPH1 VDD33 VSS gf180_tg_lowq
XDNC13 CDLN13 VCM_REF PH1 NPH1 VDD33 VSS gf180_tg_lowq
* DAC unit 14
CDP14 CDLP14 CDRP14 {CU}
CDN14 CDLN14 CDRN14 {CU}
XDP114 CDRP14 VCM_REF PH1 NPH1 VDD33 VSS gf180_tg_lowq
XDP214 CDRP14 INP PH2 NPH2 VDD33 VSS gf180_tg_lowq
XDN114 CDRN14 VCM_REF PH1 NPH1 VDD33 VSS gf180_tg_lowq
XDN214 CDRN14 INN PH2 NPH2 VDD33 VSS gf180_tg_lowq
BGPP14 GPP14 VSS I=(v(GPP14)-v(PH2)*v(S2P14)/v(VDD33))/1k
BGPN14 GPN14 VSS I=(v(GPN14)-v(PH2)*(v(VDD33)-v(S2P14))/v(VDD33))/1k
BGNP14 GNP14 VSS I=(v(GNP14)-v(PH2)*v(S2N14)/v(VDD33))/1k
BGNN14 GNN14 VSS I=(v(GNN14)-v(PH2)*(v(VDD33)-v(S2N14))/v(VDD33))/1k
BNOPP14 NGPP14 0 V=v(VDD33)-v(GPP14)
BNOPN14 NGPN14 0 V=v(VDD33)-v(GPN14)
BNONP14 NGNP14 0 V=v(VDD33)-v(GNP14)
BNONN14 NGNN14 0 V=v(VDD33)-v(GNN14)
CGPP14 GPP14 VSS 2p
CGPN14 GPN14 VSS 2p
CGNP14 GNP14 VSS 2p
CGNN14 GNN14 VSS 2p
CNGPP14 NGPP14 VSS 0.2p
CNGPN14 NGPN14 VSS 0.2p
CNGNP14 NGNP14 VSS 0.2p
CNGNN14 NGNN14 VSS 0.2p
XPVP14 CDLP14 VP GPP14 NGPP14 VDD33 VSS gf180_tg_lowq
XPVN14 CDLP14 VN GPN14 NGPN14 VDD33 VSS gf180_tg_lowq
XNVP14 CDLN14 VP GNP14 NGNP14 VDD33 VSS gf180_tg_lowq
XNVN14 CDLN14 VN GNN14 NGNN14 VDD33 VSS gf180_tg_lowq
XDPC14 CDLP14 VCM_REF PH1 NPH1 VDD33 VSS gf180_tg_lowq
XDNC14 CDLN14 VCM_REF PH1 NPH1 VDD33 VSS gf180_tg_lowq
CIP OUTN INP {CI}
CIN OUTP INN {CI}
RBIASP INP VCM_REF 10G
RBIASN INN VCM_REF 10G
.ends gf180_sdm3_int2_mb

* ---- modulator top: sdm3 timing, 4-bit flash + behavioral DWA ----
* Nodes: TH0..TH14 = thermometer lines (H_i). External PUP clock (narrow
* pulse at PH1 rising edge) advances the DWA master register.
.subckt gf180_sdm3_mod_mb VINP VINN VCM_REF VP VN PH1 NPH1 PH2 NPH2 CMPCK PUP VDD33 VSS TH0 TH1 TH2 TH3 TH4 TH5 TH6 TH7 TH8 TH9 TH10 TH11 TH12 TH13 TH14 params: RSET=25k CC=10p
XINT1 VINN VINP VCM_REF VP VN O1P O1N PH1 NPH1 PH2 NPH2 VDD33 VSS SEL0 SEL1 SEL2 SEL3 SEL4 SEL5 SEL6 SEL7 SEL8 SEL9 SEL10 SEL11 SEL12 SEL13 SEL14 SELN0 SELN1 SELN2 SELN3 SELN4 SELN5 SELN6 SELN7 SELN8 SELN9 SELN10 SELN11 SELN12 SELN13 SELN14 gf180_sdm3_int1_mb RSET={RSET} CC={CC}
* int2 with swapped clock pins (samples PH2 / integrates PH1)
XINT2 O1N O1P VCM_REF VP VN O2P O2N PH2 NPH2 PH1 NPH1 VDD33 VSS SEL20 SEL21 SEL22 SEL23 SEL24 SEL25 SEL26 SEL27 SEL28 SEL29 SEL210 SEL211 SEL212 SEL213 SEL214 SEL2N0 SEL2N1 SEL2N2 SEL2N3 SEL2N4 SEL2N5 SEL2N6 SEL2N7 SEL2N8 SEL2N9 SEL2N10 SEL2N11 SEL2N12 SEL2N13 SEL2N14 gf180_sdm3_int2_mb RSET={RSET} CC={CC}
XFLASH O2P O2N CMPCK VDD33 VSS TH0 TH1 TH2 TH3 TH4 TH5 TH6 TH7 TH8 TH9 TH10 TH11 TH12 TH13 TH14 gf180_sdm3_flash15
* thermometer count as voltage (1 V per count), RC-filtered (tau ~4 ns)
RTHF0 TH0 THF0 2k
CTHF0 THF0 VSS 2p
RTHF1 TH1 THF1 2k
CTHF1 THF1 VSS 2p
RTHF2 TH2 THF2 2k
CTHF2 THF2 VSS 2p
RTHF3 TH3 THF3 2k
CTHF3 THF3 VSS 2p
RTHF4 TH4 THF4 2k
CTHF4 THF4 VSS 2p
RTHF5 TH5 THF5 2k
CTHF5 THF5 VSS 2p
RTHF6 TH6 THF6 2k
CTHF6 THF6 VSS 2p
RTHF7 TH7 THF7 2k
CTHF7 THF7 VSS 2p
RTHF8 TH8 THF8 2k
CTHF8 THF8 VSS 2p
RTHF9 TH9 THF9 2k
CTHF9 THF9 VSS 2p
RTHF10 TH10 THF10 2k
CTHF10 THF10 VSS 2p
RTHF11 TH11 THF11 2k
CTHF11 THF11 VSS 2p
RTHF12 TH12 THF12 2k
CTHF12 THF12 VSS 2p
RTHF13 TH13 THF13 2k
CTHF13 THF13 VSS 2p
RTHF14 TH14 THF14 2k
CTHF14 THF14 VSS 2p
BCSUM CSUM 0 V=(v(THF0)+v(THF1)+v(THF2)+v(THF3)+v(THF4)+v(THF5)+v(THF6)+v(THF7)+v(THF8)+v(THF9)+v(THF10)+v(THF11)+v(THF12)+v(THF13)+v(THF14))/v(VDD33)
* DWA pointer: master samples mod(p_slave - c + 15) during PUP,
* slave tracks master during PH2. p[n+1]=(p[n]-c[n]) mod 15.
* wrap via steep sigmoid of PNEXT (exact at settled integer states)
BNEXT PNEXT 0 V=v(PTRS)-v(CSUM)+15
BNEXTM PNEXTM 0 V=v(PNEXT)-15/(1+exp((14.5-v(PNEXT))/0.05))
* B-source current sample/hold with sigmoid clock gating
(idsw SW broke transient OP; discontinuous gating breaks tran conv)
BSHM PTRM VSS I=(v(PTRM)-v(PNEXTM))/1k/(1+exp((2.2-v(PUP))/0.05))
CPTRM PTRM VSS 10p
RPTRM PTRM VSS 1T
BSHS PTRS VSS I=(v(PTRS)-v(PTRM))/1k/(1+exp((2.2-v(PH2))/0.05))
CPTRS PTRS VSS 10p
RPTRS PTRS VSS 1T
*
* int1 unit selects (DWA): P-side unit j -> VP if rot(j-p) < 15-c.
* rot via sigmoid wrap of (j-p); sigmoid select; RC-smoothed (tau ~2 ns)
BSEL0 SEL0 VSS I=(v(SEL0)-v(VDD33)/(1+exp(((0-v(PTRS))+15/(1+exp((0-v(PTRS)+0.5)/0.05))+0.5-(15-v(CSUM)))/0.15)))/1k
BSELN0 SELN0 VSS I=(v(SELN0)-(v(VDD33)-v(SEL0)))/1k
BSEL1 SEL1 VSS I=(v(SEL1)-v(VDD33)/(1+exp(((1-v(PTRS))+15/(1+exp((1-v(PTRS)+0.5)/0.05))+0.5-(15-v(CSUM)))/0.15)))/1k
BSELN1 SELN1 VSS I=(v(SELN1)-(v(VDD33)-v(SEL1)))/1k
BSEL2 SEL2 VSS I=(v(SEL2)-v(VDD33)/(1+exp(((2-v(PTRS))+15/(1+exp((2-v(PTRS)+0.5)/0.05))+0.5-(15-v(CSUM)))/0.15)))/1k
BSELN2 SELN2 VSS I=(v(SELN2)-(v(VDD33)-v(SEL2)))/1k
BSEL3 SEL3 VSS I=(v(SEL3)-v(VDD33)/(1+exp(((3-v(PTRS))+15/(1+exp((3-v(PTRS)+0.5)/0.05))+0.5-(15-v(CSUM)))/0.15)))/1k
BSELN3 SELN3 VSS I=(v(SELN3)-(v(VDD33)-v(SEL3)))/1k
BSEL4 SEL4 VSS I=(v(SEL4)-v(VDD33)/(1+exp(((4-v(PTRS))+15/(1+exp((4-v(PTRS)+0.5)/0.05))+0.5-(15-v(CSUM)))/0.15)))/1k
BSELN4 SELN4 VSS I=(v(SELN4)-(v(VDD33)-v(SEL4)))/1k
BSEL5 SEL5 VSS I=(v(SEL5)-v(VDD33)/(1+exp(((5-v(PTRS))+15/(1+exp((5-v(PTRS)+0.5)/0.05))+0.5-(15-v(CSUM)))/0.15)))/1k
BSELN5 SELN5 VSS I=(v(SELN5)-(v(VDD33)-v(SEL5)))/1k
BSEL6 SEL6 VSS I=(v(SEL6)-v(VDD33)/(1+exp(((6-v(PTRS))+15/(1+exp((6-v(PTRS)+0.5)/0.05))+0.5-(15-v(CSUM)))/0.15)))/1k
BSELN6 SELN6 VSS I=(v(SELN6)-(v(VDD33)-v(SEL6)))/1k
BSEL7 SEL7 VSS I=(v(SEL7)-v(VDD33)/(1+exp(((7-v(PTRS))+15/(1+exp((7-v(PTRS)+0.5)/0.05))+0.5-(15-v(CSUM)))/0.15)))/1k
BSELN7 SELN7 VSS I=(v(SELN7)-(v(VDD33)-v(SEL7)))/1k
BSEL8 SEL8 VSS I=(v(SEL8)-v(VDD33)/(1+exp(((8-v(PTRS))+15/(1+exp((8-v(PTRS)+0.5)/0.05))+0.5-(15-v(CSUM)))/0.15)))/1k
BSELN8 SELN8 VSS I=(v(SELN8)-(v(VDD33)-v(SEL8)))/1k
BSEL9 SEL9 VSS I=(v(SEL9)-v(VDD33)/(1+exp(((9-v(PTRS))+15/(1+exp((9-v(PTRS)+0.5)/0.05))+0.5-(15-v(CSUM)))/0.15)))/1k
BSELN9 SELN9 VSS I=(v(SELN9)-(v(VDD33)-v(SEL9)))/1k
BSEL10 SEL10 VSS I=(v(SEL10)-v(VDD33)/(1+exp(((10-v(PTRS))+15/(1+exp((10-v(PTRS)+0.5)/0.05))+0.5-(15-v(CSUM)))/0.15)))/1k
BSELN10 SELN10 VSS I=(v(SELN10)-(v(VDD33)-v(SEL10)))/1k
BSEL11 SEL11 VSS I=(v(SEL11)-v(VDD33)/(1+exp(((11-v(PTRS))+15/(1+exp((11-v(PTRS)+0.5)/0.05))+0.5-(15-v(CSUM)))/0.15)))/1k
BSELN11 SELN11 VSS I=(v(SELN11)-(v(VDD33)-v(SEL11)))/1k
BSEL12 SEL12 VSS I=(v(SEL12)-v(VDD33)/(1+exp(((12-v(PTRS))+15/(1+exp((12-v(PTRS)+0.5)/0.05))+0.5-(15-v(CSUM)))/0.15)))/1k
BSELN12 SELN12 VSS I=(v(SELN12)-(v(VDD33)-v(SEL12)))/1k
BSEL13 SEL13 VSS I=(v(SEL13)-v(VDD33)/(1+exp(((13-v(PTRS))+15/(1+exp((13-v(PTRS)+0.5)/0.05))+0.5-(15-v(CSUM)))/0.15)))/1k
BSELN13 SELN13 VSS I=(v(SELN13)-(v(VDD33)-v(SEL13)))/1k
BSEL14 SEL14 VSS I=(v(SEL14)-v(VDD33)/(1+exp(((14-v(PTRS))+15/(1+exp((14-v(PTRS)+0.5)/0.05))+0.5-(15-v(CSUM)))/0.15)))/1k
BSELN14 SELN14 VSS I=(v(SELN14)-(v(VDD33)-v(SEL14)))/1k
* int2 code register: tracks CSUM during PH2, holds through PH1
* (smoothed B-source sample/hold; idsw SW broke transient OP)
BC2R C2R VSS I=(v(C2R)-v(CSUM))/1k/(1+exp((2.0-v(PH2))/0.05))
CC2R C2R VSS 0.5p
RC2R C2R VSS 1G
* int2 unit selects (straight thermometer from registered code)
BSEL20 SEL20 VSS I=(v(SEL20)-v(VDD33)/(1+exp((0+0.5-(15-v(C2R)))/0.15)))/1k
BSEL2N0 SEL2N0 VSS I=(v(SEL2N0)-(v(VDD33)-v(SEL20)))/1k
BSEL21 SEL21 VSS I=(v(SEL21)-v(VDD33)/(1+exp((1+0.5-(15-v(C2R)))/0.15)))/1k
BSEL2N1 SEL2N1 VSS I=(v(SEL2N1)-(v(VDD33)-v(SEL21)))/1k
BSEL22 SEL22 VSS I=(v(SEL22)-v(VDD33)/(1+exp((2+0.5-(15-v(C2R)))/0.15)))/1k
BSEL2N2 SEL2N2 VSS I=(v(SEL2N2)-(v(VDD33)-v(SEL22)))/1k
BSEL23 SEL23 VSS I=(v(SEL23)-v(VDD33)/(1+exp((3+0.5-(15-v(C2R)))/0.15)))/1k
BSEL2N3 SEL2N3 VSS I=(v(SEL2N3)-(v(VDD33)-v(SEL23)))/1k
BSEL24 SEL24 VSS I=(v(SEL24)-v(VDD33)/(1+exp((4+0.5-(15-v(C2R)))/0.15)))/1k
BSEL2N4 SEL2N4 VSS I=(v(SEL2N4)-(v(VDD33)-v(SEL24)))/1k
BSEL25 SEL25 VSS I=(v(SEL25)-v(VDD33)/(1+exp((5+0.5-(15-v(C2R)))/0.15)))/1k
BSEL2N5 SEL2N5 VSS I=(v(SEL2N5)-(v(VDD33)-v(SEL25)))/1k
BSEL26 SEL26 VSS I=(v(SEL26)-v(VDD33)/(1+exp((6+0.5-(15-v(C2R)))/0.15)))/1k
BSEL2N6 SEL2N6 VSS I=(v(SEL2N6)-(v(VDD33)-v(SEL26)))/1k
BSEL27 SEL27 VSS I=(v(SEL27)-v(VDD33)/(1+exp((7+0.5-(15-v(C2R)))/0.15)))/1k
BSEL2N7 SEL2N7 VSS I=(v(SEL2N7)-(v(VDD33)-v(SEL27)))/1k
BSEL28 SEL28 VSS I=(v(SEL28)-v(VDD33)/(1+exp((8+0.5-(15-v(C2R)))/0.15)))/1k
BSEL2N8 SEL2N8 VSS I=(v(SEL2N8)-(v(VDD33)-v(SEL28)))/1k
BSEL29 SEL29 VSS I=(v(SEL29)-v(VDD33)/(1+exp((9+0.5-(15-v(C2R)))/0.15)))/1k
BSEL2N9 SEL2N9 VSS I=(v(SEL2N9)-(v(VDD33)-v(SEL29)))/1k
BSEL210 SEL210 VSS I=(v(SEL210)-v(VDD33)/(1+exp((10+0.5-(15-v(C2R)))/0.15)))/1k
BSEL2N10 SEL2N10 VSS I=(v(SEL2N10)-(v(VDD33)-v(SEL210)))/1k
BSEL211 SEL211 VSS I=(v(SEL211)-v(VDD33)/(1+exp((11+0.5-(15-v(C2R)))/0.15)))/1k
BSEL2N11 SEL2N11 VSS I=(v(SEL2N11)-(v(VDD33)-v(SEL211)))/1k
BSEL212 SEL212 VSS I=(v(SEL212)-v(VDD33)/(1+exp((12+0.5-(15-v(C2R)))/0.15)))/1k
BSEL2N12 SEL2N12 VSS I=(v(SEL2N12)-(v(VDD33)-v(SEL212)))/1k
BSEL213 SEL213 VSS I=(v(SEL213)-v(VDD33)/(1+exp((13+0.5-(15-v(C2R)))/0.15)))/1k
BSEL2N13 SEL2N13 VSS I=(v(SEL2N13)-(v(VDD33)-v(SEL213)))/1k
BSEL214 SEL214 VSS I=(v(SEL214)-v(VDD33)/(1+exp((14+0.5-(15-v(C2R)))/0.15)))/1k
BSEL2N14 SEL2N14 VSS I=(v(SEL2N14)-(v(VDD33)-v(SEL214)))/1k
CSEL0 SEL0 VSS 2p
CSELN0 SELN0 VSS 2p
CSEL20 SEL20 VSS 2p
CSEL2N0 SEL2N0 VSS 2p
CSEL1 SEL1 VSS 2p
CSELN1 SELN1 VSS 2p
CSEL21 SEL21 VSS 2p
CSEL2N1 SEL2N1 VSS 2p
CSEL2 SEL2 VSS 2p
CSELN2 SELN2 VSS 2p
CSEL22 SEL22 VSS 2p
CSEL2N2 SEL2N2 VSS 2p
CSEL3 SEL3 VSS 2p
CSELN3 SELN3 VSS 2p
CSEL23 SEL23 VSS 2p
CSEL2N3 SEL2N3 VSS 2p
CSEL4 SEL4 VSS 2p
CSELN4 SELN4 VSS 2p
CSEL24 SEL24 VSS 2p
CSEL2N4 SEL2N4 VSS 2p
CSEL5 SEL5 VSS 2p
CSELN5 SELN5 VSS 2p
CSEL25 SEL25 VSS 2p
CSEL2N5 SEL2N5 VSS 2p
CSEL6 SEL6 VSS 2p
CSELN6 SELN6 VSS 2p
CSEL26 SEL26 VSS 2p
CSEL2N6 SEL2N6 VSS 2p
CSEL7 SEL7 VSS 2p
CSELN7 SELN7 VSS 2p
CSEL27 SEL27 VSS 2p
CSEL2N7 SEL2N7 VSS 2p
CSEL8 SEL8 VSS 2p
CSELN8 SELN8 VSS 2p
CSEL28 SEL28 VSS 2p
CSEL2N8 SEL2N8 VSS 2p
CSEL9 SEL9 VSS 2p
CSELN9 SELN9 VSS 2p
CSEL29 SEL29 VSS 2p
CSEL2N9 SEL2N9 VSS 2p
CSEL10 SEL10 VSS 2p
CSELN10 SELN10 VSS 2p
CSEL210 SEL210 VSS 2p
CSEL2N10 SEL2N10 VSS 2p
CSEL11 SEL11 VSS 2p
CSELN11 SELN11 VSS 2p
CSEL211 SEL211 VSS 2p
CSEL2N11 SEL2N11 VSS 2p
CSEL12 SEL12 VSS 2p
CSELN12 SELN12 VSS 2p
CSEL212 SEL212 VSS 2p
CSEL2N12 SEL2N12 VSS 2p
CSEL13 SEL13 VSS 2p
CSELN13 SELN13 VSS 2p
CSEL213 SEL213 VSS 2p
CSEL2N13 SEL2N13 VSS 2p
CSEL14 SEL14 VSS 2p
CSELN14 SELN14 VSS 2p
CSEL214 SEL214 VSS 2p
CSEL2N14 SEL2N14 VSS 2p
CCSUM CSUM VSS 0.5p
CPNEXT PNEXT VSS 0.2p
CPNEXTM PNEXTM VSS 0.2p
.ends gf180_sdm3_mod_mb
