* gf180_sdm3_mb5_nodwa.spice - 5-bit STRAIGHT-THERMOMETER (no DWA) (31-level) sdm3 variant for fs=512 kHz
* GENERATED by gen_sdm3_mb_nodwa.py - do not edit by hand.
* All behavioral B-sources are RC-smoothed current-source form
* (target-v)/R into a hold cap: ngspice-46 fails to converge on
* discontinuous B-source voltage branches (timestep-too-small at
* the input zero crossing, t=62.5026 ms). tau ~2 ns everywhere.
* Requires: gf180_afe_cells.spice (OTA/TG/bias) + gf180_sdm3.spice
* (strongarm, nand2, inv). Loop timing/coefficients identical to sdm3.
* Flash thresholds and DWA/thermometer logic are BEHAVIORAL (ideal
* sources / B-sources) - silicon needs a ladder + DWA RTL.

* ---- 31-level flash: strongarm + SR latch per slice ----
* H_i=1 <=> O2D > theta_i, theta_i=(i-15)*3.125mV; H_i is the latch's NBIT
* terminal (BIT_i=1 <=> O2D<theta_i, same convention as 1-bit sdm3).
.subckt gf180_sdm3_flash31 O2P O2N CMPCK VDD33 VSS H0 H1 H2 H3 H4 H5 H6 H7 H8 H9 H10 H11 H12 H13 H14 H15 H16 H17 H18 H19 H20 H21 H22 H23 H24 H25 H26 H27 H28 H29 H30
* slice 0: theta=-46.88 mV diff
VOFFP0 O2P INPP0 2.343750e-02
VOFFN0 O2N INNN0 -2.343750e-02
XCMP0 INPP0 INNN0 QP0 QN0 CMPCK VDD33 VSS gf180_strongarm
CQP0 QP0 VSS 0.5p
CQN0 QN0 VSS 0.5p
XND10 QP0 H0 BIT0 VDD33 VSS gf180_sdm3_nand2
XND20 QN0 BIT0 H0 VDD33 VSS gf180_sdm3_nand2
* slice 1: theta=-43.75 mV diff
VOFFP1 O2P INPP1 2.187500e-02
VOFFN1 O2N INNN1 -2.187500e-02
XCMP1 INPP1 INNN1 QP1 QN1 CMPCK VDD33 VSS gf180_strongarm
CQP1 QP1 VSS 0.5p
CQN1 QN1 VSS 0.5p
XND11 QP1 H1 BIT1 VDD33 VSS gf180_sdm3_nand2
XND21 QN1 BIT1 H1 VDD33 VSS gf180_sdm3_nand2
* slice 2: theta=-40.62 mV diff
VOFFP2 O2P INPP2 2.031250e-02
VOFFN2 O2N INNN2 -2.031250e-02
XCMP2 INPP2 INNN2 QP2 QN2 CMPCK VDD33 VSS gf180_strongarm
CQP2 QP2 VSS 0.5p
CQN2 QN2 VSS 0.5p
XND12 QP2 H2 BIT2 VDD33 VSS gf180_sdm3_nand2
XND22 QN2 BIT2 H2 VDD33 VSS gf180_sdm3_nand2
* slice 3: theta=-37.50 mV diff
VOFFP3 O2P INPP3 1.875000e-02
VOFFN3 O2N INNN3 -1.875000e-02
XCMP3 INPP3 INNN3 QP3 QN3 CMPCK VDD33 VSS gf180_strongarm
CQP3 QP3 VSS 0.5p
CQN3 QN3 VSS 0.5p
XND13 QP3 H3 BIT3 VDD33 VSS gf180_sdm3_nand2
XND23 QN3 BIT3 H3 VDD33 VSS gf180_sdm3_nand2
* slice 4: theta=-34.38 mV diff
VOFFP4 O2P INPP4 1.718750e-02
VOFFN4 O2N INNN4 -1.718750e-02
XCMP4 INPP4 INNN4 QP4 QN4 CMPCK VDD33 VSS gf180_strongarm
CQP4 QP4 VSS 0.5p
CQN4 QN4 VSS 0.5p
XND14 QP4 H4 BIT4 VDD33 VSS gf180_sdm3_nand2
XND24 QN4 BIT4 H4 VDD33 VSS gf180_sdm3_nand2
* slice 5: theta=-31.25 mV diff
VOFFP5 O2P INPP5 1.562500e-02
VOFFN5 O2N INNN5 -1.562500e-02
XCMP5 INPP5 INNN5 QP5 QN5 CMPCK VDD33 VSS gf180_strongarm
CQP5 QP5 VSS 0.5p
CQN5 QN5 VSS 0.5p
XND15 QP5 H5 BIT5 VDD33 VSS gf180_sdm3_nand2
XND25 QN5 BIT5 H5 VDD33 VSS gf180_sdm3_nand2
* slice 6: theta=-28.12 mV diff
VOFFP6 O2P INPP6 1.406250e-02
VOFFN6 O2N INNN6 -1.406250e-02
XCMP6 INPP6 INNN6 QP6 QN6 CMPCK VDD33 VSS gf180_strongarm
CQP6 QP6 VSS 0.5p
CQN6 QN6 VSS 0.5p
XND16 QP6 H6 BIT6 VDD33 VSS gf180_sdm3_nand2
XND26 QN6 BIT6 H6 VDD33 VSS gf180_sdm3_nand2
* slice 7: theta=-25.00 mV diff
VOFFP7 O2P INPP7 1.250000e-02
VOFFN7 O2N INNN7 -1.250000e-02
XCMP7 INPP7 INNN7 QP7 QN7 CMPCK VDD33 VSS gf180_strongarm
CQP7 QP7 VSS 0.5p
CQN7 QN7 VSS 0.5p
XND17 QP7 H7 BIT7 VDD33 VSS gf180_sdm3_nand2
XND27 QN7 BIT7 H7 VDD33 VSS gf180_sdm3_nand2
* slice 8: theta=-21.88 mV diff
VOFFP8 O2P INPP8 1.093750e-02
VOFFN8 O2N INNN8 -1.093750e-02
XCMP8 INPP8 INNN8 QP8 QN8 CMPCK VDD33 VSS gf180_strongarm
CQP8 QP8 VSS 0.5p
CQN8 QN8 VSS 0.5p
XND18 QP8 H8 BIT8 VDD33 VSS gf180_sdm3_nand2
XND28 QN8 BIT8 H8 VDD33 VSS gf180_sdm3_nand2
* slice 9: theta=-18.75 mV diff
VOFFP9 O2P INPP9 9.375000e-03
VOFFN9 O2N INNN9 -9.375000e-03
XCMP9 INPP9 INNN9 QP9 QN9 CMPCK VDD33 VSS gf180_strongarm
CQP9 QP9 VSS 0.5p
CQN9 QN9 VSS 0.5p
XND19 QP9 H9 BIT9 VDD33 VSS gf180_sdm3_nand2
XND29 QN9 BIT9 H9 VDD33 VSS gf180_sdm3_nand2
* slice 10: theta=-15.62 mV diff
VOFFP10 O2P INPP10 7.812500e-03
VOFFN10 O2N INNN10 -7.812500e-03
XCMP10 INPP10 INNN10 QP10 QN10 CMPCK VDD33 VSS gf180_strongarm
CQP10 QP10 VSS 0.5p
CQN10 QN10 VSS 0.5p
XND110 QP10 H10 BIT10 VDD33 VSS gf180_sdm3_nand2
XND210 QN10 BIT10 H10 VDD33 VSS gf180_sdm3_nand2
* slice 11: theta=-12.50 mV diff
VOFFP11 O2P INPP11 6.250000e-03
VOFFN11 O2N INNN11 -6.250000e-03
XCMP11 INPP11 INNN11 QP11 QN11 CMPCK VDD33 VSS gf180_strongarm
CQP11 QP11 VSS 0.5p
CQN11 QN11 VSS 0.5p
XND111 QP11 H11 BIT11 VDD33 VSS gf180_sdm3_nand2
XND211 QN11 BIT11 H11 VDD33 VSS gf180_sdm3_nand2
* slice 12: theta=-9.38 mV diff
VOFFP12 O2P INPP12 4.687500e-03
VOFFN12 O2N INNN12 -4.687500e-03
XCMP12 INPP12 INNN12 QP12 QN12 CMPCK VDD33 VSS gf180_strongarm
CQP12 QP12 VSS 0.5p
CQN12 QN12 VSS 0.5p
XND112 QP12 H12 BIT12 VDD33 VSS gf180_sdm3_nand2
XND212 QN12 BIT12 H12 VDD33 VSS gf180_sdm3_nand2
* slice 13: theta=-6.25 mV diff
VOFFP13 O2P INPP13 3.125000e-03
VOFFN13 O2N INNN13 -3.125000e-03
XCMP13 INPP13 INNN13 QP13 QN13 CMPCK VDD33 VSS gf180_strongarm
CQP13 QP13 VSS 0.5p
CQN13 QN13 VSS 0.5p
XND113 QP13 H13 BIT13 VDD33 VSS gf180_sdm3_nand2
XND213 QN13 BIT13 H13 VDD33 VSS gf180_sdm3_nand2
* slice 14: theta=-3.12 mV diff
VOFFP14 O2P INPP14 1.562500e-03
VOFFN14 O2N INNN14 -1.562500e-03
XCMP14 INPP14 INNN14 QP14 QN14 CMPCK VDD33 VSS gf180_strongarm
CQP14 QP14 VSS 0.5p
CQN14 QN14 VSS 0.5p
XND114 QP14 H14 BIT14 VDD33 VSS gf180_sdm3_nand2
XND214 QN14 BIT14 H14 VDD33 VSS gf180_sdm3_nand2
* slice 15: theta=+0.00 mV diff
VOFFP15 O2P INPP15 -0.000000e+00
VOFFN15 O2N INNN15 0.000000e+00
XCMP15 INPP15 INNN15 QP15 QN15 CMPCK VDD33 VSS gf180_strongarm
CQP15 QP15 VSS 0.5p
CQN15 QN15 VSS 0.5p
XND115 QP15 H15 BIT15 VDD33 VSS gf180_sdm3_nand2
XND215 QN15 BIT15 H15 VDD33 VSS gf180_sdm3_nand2
* slice 16: theta=+3.12 mV diff
VOFFP16 O2P INPP16 -1.562500e-03
VOFFN16 O2N INNN16 1.562500e-03
XCMP16 INPP16 INNN16 QP16 QN16 CMPCK VDD33 VSS gf180_strongarm
CQP16 QP16 VSS 0.5p
CQN16 QN16 VSS 0.5p
XND116 QP16 H16 BIT16 VDD33 VSS gf180_sdm3_nand2
XND216 QN16 BIT16 H16 VDD33 VSS gf180_sdm3_nand2
* slice 17: theta=+6.25 mV diff
VOFFP17 O2P INPP17 -3.125000e-03
VOFFN17 O2N INNN17 3.125000e-03
XCMP17 INPP17 INNN17 QP17 QN17 CMPCK VDD33 VSS gf180_strongarm
CQP17 QP17 VSS 0.5p
CQN17 QN17 VSS 0.5p
XND117 QP17 H17 BIT17 VDD33 VSS gf180_sdm3_nand2
XND217 QN17 BIT17 H17 VDD33 VSS gf180_sdm3_nand2
* slice 18: theta=+9.38 mV diff
VOFFP18 O2P INPP18 -4.687500e-03
VOFFN18 O2N INNN18 4.687500e-03
XCMP18 INPP18 INNN18 QP18 QN18 CMPCK VDD33 VSS gf180_strongarm
CQP18 QP18 VSS 0.5p
CQN18 QN18 VSS 0.5p
XND118 QP18 H18 BIT18 VDD33 VSS gf180_sdm3_nand2
XND218 QN18 BIT18 H18 VDD33 VSS gf180_sdm3_nand2
* slice 19: theta=+12.50 mV diff
VOFFP19 O2P INPP19 -6.250000e-03
VOFFN19 O2N INNN19 6.250000e-03
XCMP19 INPP19 INNN19 QP19 QN19 CMPCK VDD33 VSS gf180_strongarm
CQP19 QP19 VSS 0.5p
CQN19 QN19 VSS 0.5p
XND119 QP19 H19 BIT19 VDD33 VSS gf180_sdm3_nand2
XND219 QN19 BIT19 H19 VDD33 VSS gf180_sdm3_nand2
* slice 20: theta=+15.62 mV diff
VOFFP20 O2P INPP20 -7.812500e-03
VOFFN20 O2N INNN20 7.812500e-03
XCMP20 INPP20 INNN20 QP20 QN20 CMPCK VDD33 VSS gf180_strongarm
CQP20 QP20 VSS 0.5p
CQN20 QN20 VSS 0.5p
XND120 QP20 H20 BIT20 VDD33 VSS gf180_sdm3_nand2
XND220 QN20 BIT20 H20 VDD33 VSS gf180_sdm3_nand2
* slice 21: theta=+18.75 mV diff
VOFFP21 O2P INPP21 -9.375000e-03
VOFFN21 O2N INNN21 9.375000e-03
XCMP21 INPP21 INNN21 QP21 QN21 CMPCK VDD33 VSS gf180_strongarm
CQP21 QP21 VSS 0.5p
CQN21 QN21 VSS 0.5p
XND121 QP21 H21 BIT21 VDD33 VSS gf180_sdm3_nand2
XND221 QN21 BIT21 H21 VDD33 VSS gf180_sdm3_nand2
* slice 22: theta=+21.88 mV diff
VOFFP22 O2P INPP22 -1.093750e-02
VOFFN22 O2N INNN22 1.093750e-02
XCMP22 INPP22 INNN22 QP22 QN22 CMPCK VDD33 VSS gf180_strongarm
CQP22 QP22 VSS 0.5p
CQN22 QN22 VSS 0.5p
XND122 QP22 H22 BIT22 VDD33 VSS gf180_sdm3_nand2
XND222 QN22 BIT22 H22 VDD33 VSS gf180_sdm3_nand2
* slice 23: theta=+25.00 mV diff
VOFFP23 O2P INPP23 -1.250000e-02
VOFFN23 O2N INNN23 1.250000e-02
XCMP23 INPP23 INNN23 QP23 QN23 CMPCK VDD33 VSS gf180_strongarm
CQP23 QP23 VSS 0.5p
CQN23 QN23 VSS 0.5p
XND123 QP23 H23 BIT23 VDD33 VSS gf180_sdm3_nand2
XND223 QN23 BIT23 H23 VDD33 VSS gf180_sdm3_nand2
* slice 24: theta=+28.12 mV diff
VOFFP24 O2P INPP24 -1.406250e-02
VOFFN24 O2N INNN24 1.406250e-02
XCMP24 INPP24 INNN24 QP24 QN24 CMPCK VDD33 VSS gf180_strongarm
CQP24 QP24 VSS 0.5p
CQN24 QN24 VSS 0.5p
XND124 QP24 H24 BIT24 VDD33 VSS gf180_sdm3_nand2
XND224 QN24 BIT24 H24 VDD33 VSS gf180_sdm3_nand2
* slice 25: theta=+31.25 mV diff
VOFFP25 O2P INPP25 -1.562500e-02
VOFFN25 O2N INNN25 1.562500e-02
XCMP25 INPP25 INNN25 QP25 QN25 CMPCK VDD33 VSS gf180_strongarm
CQP25 QP25 VSS 0.5p
CQN25 QN25 VSS 0.5p
XND125 QP25 H25 BIT25 VDD33 VSS gf180_sdm3_nand2
XND225 QN25 BIT25 H25 VDD33 VSS gf180_sdm3_nand2
* slice 26: theta=+34.38 mV diff
VOFFP26 O2P INPP26 -1.718750e-02
VOFFN26 O2N INNN26 1.718750e-02
XCMP26 INPP26 INNN26 QP26 QN26 CMPCK VDD33 VSS gf180_strongarm
CQP26 QP26 VSS 0.5p
CQN26 QN26 VSS 0.5p
XND126 QP26 H26 BIT26 VDD33 VSS gf180_sdm3_nand2
XND226 QN26 BIT26 H26 VDD33 VSS gf180_sdm3_nand2
* slice 27: theta=+37.50 mV diff
VOFFP27 O2P INPP27 -1.875000e-02
VOFFN27 O2N INNN27 1.875000e-02
XCMP27 INPP27 INNN27 QP27 QN27 CMPCK VDD33 VSS gf180_strongarm
CQP27 QP27 VSS 0.5p
CQN27 QN27 VSS 0.5p
XND127 QP27 H27 BIT27 VDD33 VSS gf180_sdm3_nand2
XND227 QN27 BIT27 H27 VDD33 VSS gf180_sdm3_nand2
* slice 28: theta=+40.62 mV diff
VOFFP28 O2P INPP28 -2.031250e-02
VOFFN28 O2N INNN28 2.031250e-02
XCMP28 INPP28 INNN28 QP28 QN28 CMPCK VDD33 VSS gf180_strongarm
CQP28 QP28 VSS 0.5p
CQN28 QN28 VSS 0.5p
XND128 QP28 H28 BIT28 VDD33 VSS gf180_sdm3_nand2
XND228 QN28 BIT28 H28 VDD33 VSS gf180_sdm3_nand2
* slice 29: theta=+43.75 mV diff
VOFFP29 O2P INPP29 -2.187500e-02
VOFFN29 O2N INNN29 2.187500e-02
XCMP29 INPP29 INNN29 QP29 QN29 CMPCK VDD33 VSS gf180_strongarm
CQP29 QP29 VSS 0.5p
CQN29 QN29 VSS 0.5p
XND129 QP29 H29 BIT29 VDD33 VSS gf180_sdm3_nand2
XND229 QN29 BIT29 H29 VDD33 VSS gf180_sdm3_nand2
* slice 30: theta=+46.88 mV diff
VOFFP30 O2P INPP30 -2.343750e-02
VOFFN30 O2N INNN30 2.343750e-02
XCMP30 INPP30 INNN30 QP30 QN30 CMPCK VDD33 VSS gf180_strongarm
CQP30 QP30 VSS 0.5p
CQN30 QN30 VSS 0.5p
XND130 QP30 H30 BIT30 VDD33 VSS gf180_sdm3_nand2
XND230 QN30 BIT30 H30 VDD33 VSS gf180_sdm3_nand2
.ends gf180_sdm3_flash31

* ---- int1 mb: CS=16p sampled input + 31x0.5p/side direct DAC, CI=8p ----
* SELP_j/SELN_j: 0/VDD level, unit j P-side left plate -> VP if SELP_j,
* else VN during PH2 (complement on N side: SELN_j=1 -> NP side to VP).
.subckt gf180_sdm3_int1_mb INP_S INN_S VCM_REF VP VN OUTP OUTN PH1 NPH1 PH2 NPH2 VDD33 VSS SP0 SP1 SP2 SP3 SP4 SP5 SP6 SP7 SP8 SP9 SP10 SP11 SP12 SP13 SP14 SP15 SP16 SP17 SP18 SP19 SP20 SP21 SP22 SP23 SP24 SP25 SP26 SP27 SP28 SP29 SP30 SN0 SN1 SN2 SN3 SN4 SN5 SN6 SN7 SN8 SN9 SN10 SN11 SN12 SN13 SN14 SN15 SN16 SN17 SN18 SN19 SN20 SN21 SN22 SN23 SN24 SN25 SN26 SN27 SN28 SN29 SN30 params: CS=16p CU=0.5p CI=8p W91=11u L91=2u W92=6u L92=2u W10=12u RSET=25k CC=10p
XOTA INP INN VCM_REF OUTP OUTN VDD33 VSS gf180_fd_ota_full2_nc W91={W91} L91={L91} W92={W92} L92={L92} W10={W10} RSET={RSET} CC={CC}
CSP CSLP CSRP {CS}
CSN CSLN CSRN {CS}
XS1A CSLP INP_S PH1 NPH1 VDD33 VSS gf180_tg_lowq
XS1B CSRP VCM_REF PH1 NPH1 VDD33 VSS gf180_tg_lowq
XS1C CSLN INN_S PH1 NPH1 VDD33 VSS gf180_tg_lowq
XS1D CSRN VCM_REF PH1 NPH1 VDD33 VSS gf180_tg_lowq
XS2A CSLP VCM_REF PH2 NPH2 VDD33 VSS gf180_tg_lowq
XS2B CSRP INP PH2 NPH2 VDD33 VSS gf180_tg_lowq
XS2C CSLN VCM_REF PH2 NPH2 VDD33 VSS gf180_tg_lowq
XS2D CSRN INN PH2 NPH2 VDD33 VSS gf180_tg_lowq
* DAC unit 0 (P side DP0, N side DN0)
CDP0 CDLP0 CDRP0 {CU}
CDN0 CDLN0 CDRN0 {CU}
XDPA0 CDLP0 VCM_REF PH1 NPH1 VDD33 VSS gf180_tg_lowq
XDPB0 CDRP0 VCM_REF PH1 NPH1 VDD33 VSS gf180_tg_lowq
XDNA0 CDLN0 VCM_REF PH1 NPH1 VDD33 VSS gf180_tg_lowq
XDNB0 CDRN0 VCM_REF PH1 NPH1 VDD33 VSS gf180_tg_lowq
XDP20 CDRP0 INP PH2 NPH2 VDD33 VSS gf180_tg_lowq
XDN20 CDRN0 INN PH2 NPH2 VDD33 VSS gf180_tg_lowq
BGPP0 GPP0 VSS I=(v(GPP0)-v(PH2)*v(SP0)/v(VDD33))/1k
BGPN0 GPN0 VSS I=(v(GPN0)-v(PH2)*(v(VDD33)-v(SP0))/v(VDD33))/1k
BGNP0 GNP0 VSS I=(v(GNP0)-v(PH2)*v(SN0)/v(VDD33))/1k
BGNN0 GNN0 VSS I=(v(GNN0)-v(PH2)*(v(VDD33)-v(SN0))/v(VDD33))/1k
BNOPP0 NGPP0 0 V=v(VDD33)-v(GPP0)
BNOPN0 NGPN0 0 V=v(VDD33)-v(GPN0)
BNONP0 NGNP0 0 V=v(VDD33)-v(GNP0)
BNONN0 NGNN0 0 V=v(VDD33)-v(GNN0)
CGPP0 GPP0 VSS 2p
CGPN0 GPN0 VSS 2p
CGNP0 GNP0 VSS 2p
CGNN0 GNN0 VSS 2p
CNGPP0 NGPP0 VSS 0.2p
CNGPN0 NGPN0 VSS 0.2p
CNGNP0 NGNP0 VSS 0.2p
CNGNN0 NGNN0 VSS 0.2p
XPVP0 CDLP0 VP GPP0 NGPP0 VDD33 VSS gf180_tg_lowq
XPVN0 CDLP0 VN GPN0 NGPN0 VDD33 VSS gf180_tg_lowq
XNVP0 CDLN0 VP GNP0 NGNP0 VDD33 VSS gf180_tg_lowq
XNVN0 CDLN0 VN GNN0 NGNN0 VDD33 VSS gf180_tg_lowq
* DAC unit 1 (P side DP1, N side DN1)
CDP1 CDLP1 CDRP1 {CU}
CDN1 CDLN1 CDRN1 {CU}
XDPA1 CDLP1 VCM_REF PH1 NPH1 VDD33 VSS gf180_tg_lowq
XDPB1 CDRP1 VCM_REF PH1 NPH1 VDD33 VSS gf180_tg_lowq
XDNA1 CDLN1 VCM_REF PH1 NPH1 VDD33 VSS gf180_tg_lowq
XDNB1 CDRN1 VCM_REF PH1 NPH1 VDD33 VSS gf180_tg_lowq
XDP21 CDRP1 INP PH2 NPH2 VDD33 VSS gf180_tg_lowq
XDN21 CDRN1 INN PH2 NPH2 VDD33 VSS gf180_tg_lowq
BGPP1 GPP1 VSS I=(v(GPP1)-v(PH2)*v(SP1)/v(VDD33))/1k
BGPN1 GPN1 VSS I=(v(GPN1)-v(PH2)*(v(VDD33)-v(SP1))/v(VDD33))/1k
BGNP1 GNP1 VSS I=(v(GNP1)-v(PH2)*v(SN1)/v(VDD33))/1k
BGNN1 GNN1 VSS I=(v(GNN1)-v(PH2)*(v(VDD33)-v(SN1))/v(VDD33))/1k
BNOPP1 NGPP1 0 V=v(VDD33)-v(GPP1)
BNOPN1 NGPN1 0 V=v(VDD33)-v(GPN1)
BNONP1 NGNP1 0 V=v(VDD33)-v(GNP1)
BNONN1 NGNN1 0 V=v(VDD33)-v(GNN1)
CGPP1 GPP1 VSS 2p
CGPN1 GPN1 VSS 2p
CGNP1 GNP1 VSS 2p
CGNN1 GNN1 VSS 2p
CNGPP1 NGPP1 VSS 0.2p
CNGPN1 NGPN1 VSS 0.2p
CNGNP1 NGNP1 VSS 0.2p
CNGNN1 NGNN1 VSS 0.2p
XPVP1 CDLP1 VP GPP1 NGPP1 VDD33 VSS gf180_tg_lowq
XPVN1 CDLP1 VN GPN1 NGPN1 VDD33 VSS gf180_tg_lowq
XNVP1 CDLN1 VP GNP1 NGNP1 VDD33 VSS gf180_tg_lowq
XNVN1 CDLN1 VN GNN1 NGNN1 VDD33 VSS gf180_tg_lowq
* DAC unit 2 (P side DP2, N side DN2)
CDP2 CDLP2 CDRP2 {CU}
CDN2 CDLN2 CDRN2 {CU}
XDPA2 CDLP2 VCM_REF PH1 NPH1 VDD33 VSS gf180_tg_lowq
XDPB2 CDRP2 VCM_REF PH1 NPH1 VDD33 VSS gf180_tg_lowq
XDNA2 CDLN2 VCM_REF PH1 NPH1 VDD33 VSS gf180_tg_lowq
XDNB2 CDRN2 VCM_REF PH1 NPH1 VDD33 VSS gf180_tg_lowq
XDP22 CDRP2 INP PH2 NPH2 VDD33 VSS gf180_tg_lowq
XDN22 CDRN2 INN PH2 NPH2 VDD33 VSS gf180_tg_lowq
BGPP2 GPP2 VSS I=(v(GPP2)-v(PH2)*v(SP2)/v(VDD33))/1k
BGPN2 GPN2 VSS I=(v(GPN2)-v(PH2)*(v(VDD33)-v(SP2))/v(VDD33))/1k
BGNP2 GNP2 VSS I=(v(GNP2)-v(PH2)*v(SN2)/v(VDD33))/1k
BGNN2 GNN2 VSS I=(v(GNN2)-v(PH2)*(v(VDD33)-v(SN2))/v(VDD33))/1k
BNOPP2 NGPP2 0 V=v(VDD33)-v(GPP2)
BNOPN2 NGPN2 0 V=v(VDD33)-v(GPN2)
BNONP2 NGNP2 0 V=v(VDD33)-v(GNP2)
BNONN2 NGNN2 0 V=v(VDD33)-v(GNN2)
CGPP2 GPP2 VSS 2p
CGPN2 GPN2 VSS 2p
CGNP2 GNP2 VSS 2p
CGNN2 GNN2 VSS 2p
CNGPP2 NGPP2 VSS 0.2p
CNGPN2 NGPN2 VSS 0.2p
CNGNP2 NGNP2 VSS 0.2p
CNGNN2 NGNN2 VSS 0.2p
XPVP2 CDLP2 VP GPP2 NGPP2 VDD33 VSS gf180_tg_lowq
XPVN2 CDLP2 VN GPN2 NGPN2 VDD33 VSS gf180_tg_lowq
XNVP2 CDLN2 VP GNP2 NGNP2 VDD33 VSS gf180_tg_lowq
XNVN2 CDLN2 VN GNN2 NGNN2 VDD33 VSS gf180_tg_lowq
* DAC unit 3 (P side DP3, N side DN3)
CDP3 CDLP3 CDRP3 {CU}
CDN3 CDLN3 CDRN3 {CU}
XDPA3 CDLP3 VCM_REF PH1 NPH1 VDD33 VSS gf180_tg_lowq
XDPB3 CDRP3 VCM_REF PH1 NPH1 VDD33 VSS gf180_tg_lowq
XDNA3 CDLN3 VCM_REF PH1 NPH1 VDD33 VSS gf180_tg_lowq
XDNB3 CDRN3 VCM_REF PH1 NPH1 VDD33 VSS gf180_tg_lowq
XDP23 CDRP3 INP PH2 NPH2 VDD33 VSS gf180_tg_lowq
XDN23 CDRN3 INN PH2 NPH2 VDD33 VSS gf180_tg_lowq
BGPP3 GPP3 VSS I=(v(GPP3)-v(PH2)*v(SP3)/v(VDD33))/1k
BGPN3 GPN3 VSS I=(v(GPN3)-v(PH2)*(v(VDD33)-v(SP3))/v(VDD33))/1k
BGNP3 GNP3 VSS I=(v(GNP3)-v(PH2)*v(SN3)/v(VDD33))/1k
BGNN3 GNN3 VSS I=(v(GNN3)-v(PH2)*(v(VDD33)-v(SN3))/v(VDD33))/1k
BNOPP3 NGPP3 0 V=v(VDD33)-v(GPP3)
BNOPN3 NGPN3 0 V=v(VDD33)-v(GPN3)
BNONP3 NGNP3 0 V=v(VDD33)-v(GNP3)
BNONN3 NGNN3 0 V=v(VDD33)-v(GNN3)
CGPP3 GPP3 VSS 2p
CGPN3 GPN3 VSS 2p
CGNP3 GNP3 VSS 2p
CGNN3 GNN3 VSS 2p
CNGPP3 NGPP3 VSS 0.2p
CNGPN3 NGPN3 VSS 0.2p
CNGNP3 NGNP3 VSS 0.2p
CNGNN3 NGNN3 VSS 0.2p
XPVP3 CDLP3 VP GPP3 NGPP3 VDD33 VSS gf180_tg_lowq
XPVN3 CDLP3 VN GPN3 NGPN3 VDD33 VSS gf180_tg_lowq
XNVP3 CDLN3 VP GNP3 NGNP3 VDD33 VSS gf180_tg_lowq
XNVN3 CDLN3 VN GNN3 NGNN3 VDD33 VSS gf180_tg_lowq
* DAC unit 4 (P side DP4, N side DN4)
CDP4 CDLP4 CDRP4 {CU}
CDN4 CDLN4 CDRN4 {CU}
XDPA4 CDLP4 VCM_REF PH1 NPH1 VDD33 VSS gf180_tg_lowq
XDPB4 CDRP4 VCM_REF PH1 NPH1 VDD33 VSS gf180_tg_lowq
XDNA4 CDLN4 VCM_REF PH1 NPH1 VDD33 VSS gf180_tg_lowq
XDNB4 CDRN4 VCM_REF PH1 NPH1 VDD33 VSS gf180_tg_lowq
XDP24 CDRP4 INP PH2 NPH2 VDD33 VSS gf180_tg_lowq
XDN24 CDRN4 INN PH2 NPH2 VDD33 VSS gf180_tg_lowq
BGPP4 GPP4 VSS I=(v(GPP4)-v(PH2)*v(SP4)/v(VDD33))/1k
BGPN4 GPN4 VSS I=(v(GPN4)-v(PH2)*(v(VDD33)-v(SP4))/v(VDD33))/1k
BGNP4 GNP4 VSS I=(v(GNP4)-v(PH2)*v(SN4)/v(VDD33))/1k
BGNN4 GNN4 VSS I=(v(GNN4)-v(PH2)*(v(VDD33)-v(SN4))/v(VDD33))/1k
BNOPP4 NGPP4 0 V=v(VDD33)-v(GPP4)
BNOPN4 NGPN4 0 V=v(VDD33)-v(GPN4)
BNONP4 NGNP4 0 V=v(VDD33)-v(GNP4)
BNONN4 NGNN4 0 V=v(VDD33)-v(GNN4)
CGPP4 GPP4 VSS 2p
CGPN4 GPN4 VSS 2p
CGNP4 GNP4 VSS 2p
CGNN4 GNN4 VSS 2p
CNGPP4 NGPP4 VSS 0.2p
CNGPN4 NGPN4 VSS 0.2p
CNGNP4 NGNP4 VSS 0.2p
CNGNN4 NGNN4 VSS 0.2p
XPVP4 CDLP4 VP GPP4 NGPP4 VDD33 VSS gf180_tg_lowq
XPVN4 CDLP4 VN GPN4 NGPN4 VDD33 VSS gf180_tg_lowq
XNVP4 CDLN4 VP GNP4 NGNP4 VDD33 VSS gf180_tg_lowq
XNVN4 CDLN4 VN GNN4 NGNN4 VDD33 VSS gf180_tg_lowq
* DAC unit 5 (P side DP5, N side DN5)
CDP5 CDLP5 CDRP5 {CU}
CDN5 CDLN5 CDRN5 {CU}
XDPA5 CDLP5 VCM_REF PH1 NPH1 VDD33 VSS gf180_tg_lowq
XDPB5 CDRP5 VCM_REF PH1 NPH1 VDD33 VSS gf180_tg_lowq
XDNA5 CDLN5 VCM_REF PH1 NPH1 VDD33 VSS gf180_tg_lowq
XDNB5 CDRN5 VCM_REF PH1 NPH1 VDD33 VSS gf180_tg_lowq
XDP25 CDRP5 INP PH2 NPH2 VDD33 VSS gf180_tg_lowq
XDN25 CDRN5 INN PH2 NPH2 VDD33 VSS gf180_tg_lowq
BGPP5 GPP5 VSS I=(v(GPP5)-v(PH2)*v(SP5)/v(VDD33))/1k
BGPN5 GPN5 VSS I=(v(GPN5)-v(PH2)*(v(VDD33)-v(SP5))/v(VDD33))/1k
BGNP5 GNP5 VSS I=(v(GNP5)-v(PH2)*v(SN5)/v(VDD33))/1k
BGNN5 GNN5 VSS I=(v(GNN5)-v(PH2)*(v(VDD33)-v(SN5))/v(VDD33))/1k
BNOPP5 NGPP5 0 V=v(VDD33)-v(GPP5)
BNOPN5 NGPN5 0 V=v(VDD33)-v(GPN5)
BNONP5 NGNP5 0 V=v(VDD33)-v(GNP5)
BNONN5 NGNN5 0 V=v(VDD33)-v(GNN5)
CGPP5 GPP5 VSS 2p
CGPN5 GPN5 VSS 2p
CGNP5 GNP5 VSS 2p
CGNN5 GNN5 VSS 2p
CNGPP5 NGPP5 VSS 0.2p
CNGPN5 NGPN5 VSS 0.2p
CNGNP5 NGNP5 VSS 0.2p
CNGNN5 NGNN5 VSS 0.2p
XPVP5 CDLP5 VP GPP5 NGPP5 VDD33 VSS gf180_tg_lowq
XPVN5 CDLP5 VN GPN5 NGPN5 VDD33 VSS gf180_tg_lowq
XNVP5 CDLN5 VP GNP5 NGNP5 VDD33 VSS gf180_tg_lowq
XNVN5 CDLN5 VN GNN5 NGNN5 VDD33 VSS gf180_tg_lowq
* DAC unit 6 (P side DP6, N side DN6)
CDP6 CDLP6 CDRP6 {CU}
CDN6 CDLN6 CDRN6 {CU}
XDPA6 CDLP6 VCM_REF PH1 NPH1 VDD33 VSS gf180_tg_lowq
XDPB6 CDRP6 VCM_REF PH1 NPH1 VDD33 VSS gf180_tg_lowq
XDNA6 CDLN6 VCM_REF PH1 NPH1 VDD33 VSS gf180_tg_lowq
XDNB6 CDRN6 VCM_REF PH1 NPH1 VDD33 VSS gf180_tg_lowq
XDP26 CDRP6 INP PH2 NPH2 VDD33 VSS gf180_tg_lowq
XDN26 CDRN6 INN PH2 NPH2 VDD33 VSS gf180_tg_lowq
BGPP6 GPP6 VSS I=(v(GPP6)-v(PH2)*v(SP6)/v(VDD33))/1k
BGPN6 GPN6 VSS I=(v(GPN6)-v(PH2)*(v(VDD33)-v(SP6))/v(VDD33))/1k
BGNP6 GNP6 VSS I=(v(GNP6)-v(PH2)*v(SN6)/v(VDD33))/1k
BGNN6 GNN6 VSS I=(v(GNN6)-v(PH2)*(v(VDD33)-v(SN6))/v(VDD33))/1k
BNOPP6 NGPP6 0 V=v(VDD33)-v(GPP6)
BNOPN6 NGPN6 0 V=v(VDD33)-v(GPN6)
BNONP6 NGNP6 0 V=v(VDD33)-v(GNP6)
BNONN6 NGNN6 0 V=v(VDD33)-v(GNN6)
CGPP6 GPP6 VSS 2p
CGPN6 GPN6 VSS 2p
CGNP6 GNP6 VSS 2p
CGNN6 GNN6 VSS 2p
CNGPP6 NGPP6 VSS 0.2p
CNGPN6 NGPN6 VSS 0.2p
CNGNP6 NGNP6 VSS 0.2p
CNGNN6 NGNN6 VSS 0.2p
XPVP6 CDLP6 VP GPP6 NGPP6 VDD33 VSS gf180_tg_lowq
XPVN6 CDLP6 VN GPN6 NGPN6 VDD33 VSS gf180_tg_lowq
XNVP6 CDLN6 VP GNP6 NGNP6 VDD33 VSS gf180_tg_lowq
XNVN6 CDLN6 VN GNN6 NGNN6 VDD33 VSS gf180_tg_lowq
* DAC unit 7 (P side DP7, N side DN7)
CDP7 CDLP7 CDRP7 {CU}
CDN7 CDLN7 CDRN7 {CU}
XDPA7 CDLP7 VCM_REF PH1 NPH1 VDD33 VSS gf180_tg_lowq
XDPB7 CDRP7 VCM_REF PH1 NPH1 VDD33 VSS gf180_tg_lowq
XDNA7 CDLN7 VCM_REF PH1 NPH1 VDD33 VSS gf180_tg_lowq
XDNB7 CDRN7 VCM_REF PH1 NPH1 VDD33 VSS gf180_tg_lowq
XDP27 CDRP7 INP PH2 NPH2 VDD33 VSS gf180_tg_lowq
XDN27 CDRN7 INN PH2 NPH2 VDD33 VSS gf180_tg_lowq
BGPP7 GPP7 VSS I=(v(GPP7)-v(PH2)*v(SP7)/v(VDD33))/1k
BGPN7 GPN7 VSS I=(v(GPN7)-v(PH2)*(v(VDD33)-v(SP7))/v(VDD33))/1k
BGNP7 GNP7 VSS I=(v(GNP7)-v(PH2)*v(SN7)/v(VDD33))/1k
BGNN7 GNN7 VSS I=(v(GNN7)-v(PH2)*(v(VDD33)-v(SN7))/v(VDD33))/1k
BNOPP7 NGPP7 0 V=v(VDD33)-v(GPP7)
BNOPN7 NGPN7 0 V=v(VDD33)-v(GPN7)
BNONP7 NGNP7 0 V=v(VDD33)-v(GNP7)
BNONN7 NGNN7 0 V=v(VDD33)-v(GNN7)
CGPP7 GPP7 VSS 2p
CGPN7 GPN7 VSS 2p
CGNP7 GNP7 VSS 2p
CGNN7 GNN7 VSS 2p
CNGPP7 NGPP7 VSS 0.2p
CNGPN7 NGPN7 VSS 0.2p
CNGNP7 NGNP7 VSS 0.2p
CNGNN7 NGNN7 VSS 0.2p
XPVP7 CDLP7 VP GPP7 NGPP7 VDD33 VSS gf180_tg_lowq
XPVN7 CDLP7 VN GPN7 NGPN7 VDD33 VSS gf180_tg_lowq
XNVP7 CDLN7 VP GNP7 NGNP7 VDD33 VSS gf180_tg_lowq
XNVN7 CDLN7 VN GNN7 NGNN7 VDD33 VSS gf180_tg_lowq
* DAC unit 8 (P side DP8, N side DN8)
CDP8 CDLP8 CDRP8 {CU}
CDN8 CDLN8 CDRN8 {CU}
XDPA8 CDLP8 VCM_REF PH1 NPH1 VDD33 VSS gf180_tg_lowq
XDPB8 CDRP8 VCM_REF PH1 NPH1 VDD33 VSS gf180_tg_lowq
XDNA8 CDLN8 VCM_REF PH1 NPH1 VDD33 VSS gf180_tg_lowq
XDNB8 CDRN8 VCM_REF PH1 NPH1 VDD33 VSS gf180_tg_lowq
XDP28 CDRP8 INP PH2 NPH2 VDD33 VSS gf180_tg_lowq
XDN28 CDRN8 INN PH2 NPH2 VDD33 VSS gf180_tg_lowq
BGPP8 GPP8 VSS I=(v(GPP8)-v(PH2)*v(SP8)/v(VDD33))/1k
BGPN8 GPN8 VSS I=(v(GPN8)-v(PH2)*(v(VDD33)-v(SP8))/v(VDD33))/1k
BGNP8 GNP8 VSS I=(v(GNP8)-v(PH2)*v(SN8)/v(VDD33))/1k
BGNN8 GNN8 VSS I=(v(GNN8)-v(PH2)*(v(VDD33)-v(SN8))/v(VDD33))/1k
BNOPP8 NGPP8 0 V=v(VDD33)-v(GPP8)
BNOPN8 NGPN8 0 V=v(VDD33)-v(GPN8)
BNONP8 NGNP8 0 V=v(VDD33)-v(GNP8)
BNONN8 NGNN8 0 V=v(VDD33)-v(GNN8)
CGPP8 GPP8 VSS 2p
CGPN8 GPN8 VSS 2p
CGNP8 GNP8 VSS 2p
CGNN8 GNN8 VSS 2p
CNGPP8 NGPP8 VSS 0.2p
CNGPN8 NGPN8 VSS 0.2p
CNGNP8 NGNP8 VSS 0.2p
CNGNN8 NGNN8 VSS 0.2p
XPVP8 CDLP8 VP GPP8 NGPP8 VDD33 VSS gf180_tg_lowq
XPVN8 CDLP8 VN GPN8 NGPN8 VDD33 VSS gf180_tg_lowq
XNVP8 CDLN8 VP GNP8 NGNP8 VDD33 VSS gf180_tg_lowq
XNVN8 CDLN8 VN GNN8 NGNN8 VDD33 VSS gf180_tg_lowq
* DAC unit 9 (P side DP9, N side DN9)
CDP9 CDLP9 CDRP9 {CU}
CDN9 CDLN9 CDRN9 {CU}
XDPA9 CDLP9 VCM_REF PH1 NPH1 VDD33 VSS gf180_tg_lowq
XDPB9 CDRP9 VCM_REF PH1 NPH1 VDD33 VSS gf180_tg_lowq
XDNA9 CDLN9 VCM_REF PH1 NPH1 VDD33 VSS gf180_tg_lowq
XDNB9 CDRN9 VCM_REF PH1 NPH1 VDD33 VSS gf180_tg_lowq
XDP29 CDRP9 INP PH2 NPH2 VDD33 VSS gf180_tg_lowq
XDN29 CDRN9 INN PH2 NPH2 VDD33 VSS gf180_tg_lowq
BGPP9 GPP9 VSS I=(v(GPP9)-v(PH2)*v(SP9)/v(VDD33))/1k
BGPN9 GPN9 VSS I=(v(GPN9)-v(PH2)*(v(VDD33)-v(SP9))/v(VDD33))/1k
BGNP9 GNP9 VSS I=(v(GNP9)-v(PH2)*v(SN9)/v(VDD33))/1k
BGNN9 GNN9 VSS I=(v(GNN9)-v(PH2)*(v(VDD33)-v(SN9))/v(VDD33))/1k
BNOPP9 NGPP9 0 V=v(VDD33)-v(GPP9)
BNOPN9 NGPN9 0 V=v(VDD33)-v(GPN9)
BNONP9 NGNP9 0 V=v(VDD33)-v(GNP9)
BNONN9 NGNN9 0 V=v(VDD33)-v(GNN9)
CGPP9 GPP9 VSS 2p
CGPN9 GPN9 VSS 2p
CGNP9 GNP9 VSS 2p
CGNN9 GNN9 VSS 2p
CNGPP9 NGPP9 VSS 0.2p
CNGPN9 NGPN9 VSS 0.2p
CNGNP9 NGNP9 VSS 0.2p
CNGNN9 NGNN9 VSS 0.2p
XPVP9 CDLP9 VP GPP9 NGPP9 VDD33 VSS gf180_tg_lowq
XPVN9 CDLP9 VN GPN9 NGPN9 VDD33 VSS gf180_tg_lowq
XNVP9 CDLN9 VP GNP9 NGNP9 VDD33 VSS gf180_tg_lowq
XNVN9 CDLN9 VN GNN9 NGNN9 VDD33 VSS gf180_tg_lowq
* DAC unit 10 (P side DP10, N side DN10)
CDP10 CDLP10 CDRP10 {CU}
CDN10 CDLN10 CDRN10 {CU}
XDPA10 CDLP10 VCM_REF PH1 NPH1 VDD33 VSS gf180_tg_lowq
XDPB10 CDRP10 VCM_REF PH1 NPH1 VDD33 VSS gf180_tg_lowq
XDNA10 CDLN10 VCM_REF PH1 NPH1 VDD33 VSS gf180_tg_lowq
XDNB10 CDRN10 VCM_REF PH1 NPH1 VDD33 VSS gf180_tg_lowq
XDP210 CDRP10 INP PH2 NPH2 VDD33 VSS gf180_tg_lowq
XDN210 CDRN10 INN PH2 NPH2 VDD33 VSS gf180_tg_lowq
BGPP10 GPP10 VSS I=(v(GPP10)-v(PH2)*v(SP10)/v(VDD33))/1k
BGPN10 GPN10 VSS I=(v(GPN10)-v(PH2)*(v(VDD33)-v(SP10))/v(VDD33))/1k
BGNP10 GNP10 VSS I=(v(GNP10)-v(PH2)*v(SN10)/v(VDD33))/1k
BGNN10 GNN10 VSS I=(v(GNN10)-v(PH2)*(v(VDD33)-v(SN10))/v(VDD33))/1k
BNOPP10 NGPP10 0 V=v(VDD33)-v(GPP10)
BNOPN10 NGPN10 0 V=v(VDD33)-v(GPN10)
BNONP10 NGNP10 0 V=v(VDD33)-v(GNP10)
BNONN10 NGNN10 0 V=v(VDD33)-v(GNN10)
CGPP10 GPP10 VSS 2p
CGPN10 GPN10 VSS 2p
CGNP10 GNP10 VSS 2p
CGNN10 GNN10 VSS 2p
CNGPP10 NGPP10 VSS 0.2p
CNGPN10 NGPN10 VSS 0.2p
CNGNP10 NGNP10 VSS 0.2p
CNGNN10 NGNN10 VSS 0.2p
XPVP10 CDLP10 VP GPP10 NGPP10 VDD33 VSS gf180_tg_lowq
XPVN10 CDLP10 VN GPN10 NGPN10 VDD33 VSS gf180_tg_lowq
XNVP10 CDLN10 VP GNP10 NGNP10 VDD33 VSS gf180_tg_lowq
XNVN10 CDLN10 VN GNN10 NGNN10 VDD33 VSS gf180_tg_lowq
* DAC unit 11 (P side DP11, N side DN11)
CDP11 CDLP11 CDRP11 {CU}
CDN11 CDLN11 CDRN11 {CU}
XDPA11 CDLP11 VCM_REF PH1 NPH1 VDD33 VSS gf180_tg_lowq
XDPB11 CDRP11 VCM_REF PH1 NPH1 VDD33 VSS gf180_tg_lowq
XDNA11 CDLN11 VCM_REF PH1 NPH1 VDD33 VSS gf180_tg_lowq
XDNB11 CDRN11 VCM_REF PH1 NPH1 VDD33 VSS gf180_tg_lowq
XDP211 CDRP11 INP PH2 NPH2 VDD33 VSS gf180_tg_lowq
XDN211 CDRN11 INN PH2 NPH2 VDD33 VSS gf180_tg_lowq
BGPP11 GPP11 VSS I=(v(GPP11)-v(PH2)*v(SP11)/v(VDD33))/1k
BGPN11 GPN11 VSS I=(v(GPN11)-v(PH2)*(v(VDD33)-v(SP11))/v(VDD33))/1k
BGNP11 GNP11 VSS I=(v(GNP11)-v(PH2)*v(SN11)/v(VDD33))/1k
BGNN11 GNN11 VSS I=(v(GNN11)-v(PH2)*(v(VDD33)-v(SN11))/v(VDD33))/1k
BNOPP11 NGPP11 0 V=v(VDD33)-v(GPP11)
BNOPN11 NGPN11 0 V=v(VDD33)-v(GPN11)
BNONP11 NGNP11 0 V=v(VDD33)-v(GNP11)
BNONN11 NGNN11 0 V=v(VDD33)-v(GNN11)
CGPP11 GPP11 VSS 2p
CGPN11 GPN11 VSS 2p
CGNP11 GNP11 VSS 2p
CGNN11 GNN11 VSS 2p
CNGPP11 NGPP11 VSS 0.2p
CNGPN11 NGPN11 VSS 0.2p
CNGNP11 NGNP11 VSS 0.2p
CNGNN11 NGNN11 VSS 0.2p
XPVP11 CDLP11 VP GPP11 NGPP11 VDD33 VSS gf180_tg_lowq
XPVN11 CDLP11 VN GPN11 NGPN11 VDD33 VSS gf180_tg_lowq
XNVP11 CDLN11 VP GNP11 NGNP11 VDD33 VSS gf180_tg_lowq
XNVN11 CDLN11 VN GNN11 NGNN11 VDD33 VSS gf180_tg_lowq
* DAC unit 12 (P side DP12, N side DN12)
CDP12 CDLP12 CDRP12 {CU}
CDN12 CDLN12 CDRN12 {CU}
XDPA12 CDLP12 VCM_REF PH1 NPH1 VDD33 VSS gf180_tg_lowq
XDPB12 CDRP12 VCM_REF PH1 NPH1 VDD33 VSS gf180_tg_lowq
XDNA12 CDLN12 VCM_REF PH1 NPH1 VDD33 VSS gf180_tg_lowq
XDNB12 CDRN12 VCM_REF PH1 NPH1 VDD33 VSS gf180_tg_lowq
XDP212 CDRP12 INP PH2 NPH2 VDD33 VSS gf180_tg_lowq
XDN212 CDRN12 INN PH2 NPH2 VDD33 VSS gf180_tg_lowq
BGPP12 GPP12 VSS I=(v(GPP12)-v(PH2)*v(SP12)/v(VDD33))/1k
BGPN12 GPN12 VSS I=(v(GPN12)-v(PH2)*(v(VDD33)-v(SP12))/v(VDD33))/1k
BGNP12 GNP12 VSS I=(v(GNP12)-v(PH2)*v(SN12)/v(VDD33))/1k
BGNN12 GNN12 VSS I=(v(GNN12)-v(PH2)*(v(VDD33)-v(SN12))/v(VDD33))/1k
BNOPP12 NGPP12 0 V=v(VDD33)-v(GPP12)
BNOPN12 NGPN12 0 V=v(VDD33)-v(GPN12)
BNONP12 NGNP12 0 V=v(VDD33)-v(GNP12)
BNONN12 NGNN12 0 V=v(VDD33)-v(GNN12)
CGPP12 GPP12 VSS 2p
CGPN12 GPN12 VSS 2p
CGNP12 GNP12 VSS 2p
CGNN12 GNN12 VSS 2p
CNGPP12 NGPP12 VSS 0.2p
CNGPN12 NGPN12 VSS 0.2p
CNGNP12 NGNP12 VSS 0.2p
CNGNN12 NGNN12 VSS 0.2p
XPVP12 CDLP12 VP GPP12 NGPP12 VDD33 VSS gf180_tg_lowq
XPVN12 CDLP12 VN GPN12 NGPN12 VDD33 VSS gf180_tg_lowq
XNVP12 CDLN12 VP GNP12 NGNP12 VDD33 VSS gf180_tg_lowq
XNVN12 CDLN12 VN GNN12 NGNN12 VDD33 VSS gf180_tg_lowq
* DAC unit 13 (P side DP13, N side DN13)
CDP13 CDLP13 CDRP13 {CU}
CDN13 CDLN13 CDRN13 {CU}
XDPA13 CDLP13 VCM_REF PH1 NPH1 VDD33 VSS gf180_tg_lowq
XDPB13 CDRP13 VCM_REF PH1 NPH1 VDD33 VSS gf180_tg_lowq
XDNA13 CDLN13 VCM_REF PH1 NPH1 VDD33 VSS gf180_tg_lowq
XDNB13 CDRN13 VCM_REF PH1 NPH1 VDD33 VSS gf180_tg_lowq
XDP213 CDRP13 INP PH2 NPH2 VDD33 VSS gf180_tg_lowq
XDN213 CDRN13 INN PH2 NPH2 VDD33 VSS gf180_tg_lowq
BGPP13 GPP13 VSS I=(v(GPP13)-v(PH2)*v(SP13)/v(VDD33))/1k
BGPN13 GPN13 VSS I=(v(GPN13)-v(PH2)*(v(VDD33)-v(SP13))/v(VDD33))/1k
BGNP13 GNP13 VSS I=(v(GNP13)-v(PH2)*v(SN13)/v(VDD33))/1k
BGNN13 GNN13 VSS I=(v(GNN13)-v(PH2)*(v(VDD33)-v(SN13))/v(VDD33))/1k
BNOPP13 NGPP13 0 V=v(VDD33)-v(GPP13)
BNOPN13 NGPN13 0 V=v(VDD33)-v(GPN13)
BNONP13 NGNP13 0 V=v(VDD33)-v(GNP13)
BNONN13 NGNN13 0 V=v(VDD33)-v(GNN13)
CGPP13 GPP13 VSS 2p
CGPN13 GPN13 VSS 2p
CGNP13 GNP13 VSS 2p
CGNN13 GNN13 VSS 2p
CNGPP13 NGPP13 VSS 0.2p
CNGPN13 NGPN13 VSS 0.2p
CNGNP13 NGNP13 VSS 0.2p
CNGNN13 NGNN13 VSS 0.2p
XPVP13 CDLP13 VP GPP13 NGPP13 VDD33 VSS gf180_tg_lowq
XPVN13 CDLP13 VN GPN13 NGPN13 VDD33 VSS gf180_tg_lowq
XNVP13 CDLN13 VP GNP13 NGNP13 VDD33 VSS gf180_tg_lowq
XNVN13 CDLN13 VN GNN13 NGNN13 VDD33 VSS gf180_tg_lowq
* DAC unit 14 (P side DP14, N side DN14)
CDP14 CDLP14 CDRP14 {CU}
CDN14 CDLN14 CDRN14 {CU}
XDPA14 CDLP14 VCM_REF PH1 NPH1 VDD33 VSS gf180_tg_lowq
XDPB14 CDRP14 VCM_REF PH1 NPH1 VDD33 VSS gf180_tg_lowq
XDNA14 CDLN14 VCM_REF PH1 NPH1 VDD33 VSS gf180_tg_lowq
XDNB14 CDRN14 VCM_REF PH1 NPH1 VDD33 VSS gf180_tg_lowq
XDP214 CDRP14 INP PH2 NPH2 VDD33 VSS gf180_tg_lowq
XDN214 CDRN14 INN PH2 NPH2 VDD33 VSS gf180_tg_lowq
BGPP14 GPP14 VSS I=(v(GPP14)-v(PH2)*v(SP14)/v(VDD33))/1k
BGPN14 GPN14 VSS I=(v(GPN14)-v(PH2)*(v(VDD33)-v(SP14))/v(VDD33))/1k
BGNP14 GNP14 VSS I=(v(GNP14)-v(PH2)*v(SN14)/v(VDD33))/1k
BGNN14 GNN14 VSS I=(v(GNN14)-v(PH2)*(v(VDD33)-v(SN14))/v(VDD33))/1k
BNOPP14 NGPP14 0 V=v(VDD33)-v(GPP14)
BNOPN14 NGPN14 0 V=v(VDD33)-v(GPN14)
BNONP14 NGNP14 0 V=v(VDD33)-v(GNP14)
BNONN14 NGNN14 0 V=v(VDD33)-v(GNN14)
CGPP14 GPP14 VSS 2p
CGPN14 GPN14 VSS 2p
CGNP14 GNP14 VSS 2p
CGNN14 GNN14 VSS 2p
CNGPP14 NGPP14 VSS 0.2p
CNGPN14 NGPN14 VSS 0.2p
CNGNP14 NGNP14 VSS 0.2p
CNGNN14 NGNN14 VSS 0.2p
XPVP14 CDLP14 VP GPP14 NGPP14 VDD33 VSS gf180_tg_lowq
XPVN14 CDLP14 VN GPN14 NGPN14 VDD33 VSS gf180_tg_lowq
XNVP14 CDLN14 VP GNP14 NGNP14 VDD33 VSS gf180_tg_lowq
XNVN14 CDLN14 VN GNN14 NGNN14 VDD33 VSS gf180_tg_lowq
* DAC unit 15 (P side DP15, N side DN15)
CDP15 CDLP15 CDRP15 {CU}
CDN15 CDLN15 CDRN15 {CU}
XDPA15 CDLP15 VCM_REF PH1 NPH1 VDD33 VSS gf180_tg_lowq
XDPB15 CDRP15 VCM_REF PH1 NPH1 VDD33 VSS gf180_tg_lowq
XDNA15 CDLN15 VCM_REF PH1 NPH1 VDD33 VSS gf180_tg_lowq
XDNB15 CDRN15 VCM_REF PH1 NPH1 VDD33 VSS gf180_tg_lowq
XDP215 CDRP15 INP PH2 NPH2 VDD33 VSS gf180_tg_lowq
XDN215 CDRN15 INN PH2 NPH2 VDD33 VSS gf180_tg_lowq
BGPP15 GPP15 VSS I=(v(GPP15)-v(PH2)*v(SP15)/v(VDD33))/1k
BGPN15 GPN15 VSS I=(v(GPN15)-v(PH2)*(v(VDD33)-v(SP15))/v(VDD33))/1k
BGNP15 GNP15 VSS I=(v(GNP15)-v(PH2)*v(SN15)/v(VDD33))/1k
BGNN15 GNN15 VSS I=(v(GNN15)-v(PH2)*(v(VDD33)-v(SN15))/v(VDD33))/1k
BNOPP15 NGPP15 0 V=v(VDD33)-v(GPP15)
BNOPN15 NGPN15 0 V=v(VDD33)-v(GPN15)
BNONP15 NGNP15 0 V=v(VDD33)-v(GNP15)
BNONN15 NGNN15 0 V=v(VDD33)-v(GNN15)
CGPP15 GPP15 VSS 2p
CGPN15 GPN15 VSS 2p
CGNP15 GNP15 VSS 2p
CGNN15 GNN15 VSS 2p
CNGPP15 NGPP15 VSS 0.2p
CNGPN15 NGPN15 VSS 0.2p
CNGNP15 NGNP15 VSS 0.2p
CNGNN15 NGNN15 VSS 0.2p
XPVP15 CDLP15 VP GPP15 NGPP15 VDD33 VSS gf180_tg_lowq
XPVN15 CDLP15 VN GPN15 NGPN15 VDD33 VSS gf180_tg_lowq
XNVP15 CDLN15 VP GNP15 NGNP15 VDD33 VSS gf180_tg_lowq
XNVN15 CDLN15 VN GNN15 NGNN15 VDD33 VSS gf180_tg_lowq
* DAC unit 16 (P side DP16, N side DN16)
CDP16 CDLP16 CDRP16 {CU}
CDN16 CDLN16 CDRN16 {CU}
XDPA16 CDLP16 VCM_REF PH1 NPH1 VDD33 VSS gf180_tg_lowq
XDPB16 CDRP16 VCM_REF PH1 NPH1 VDD33 VSS gf180_tg_lowq
XDNA16 CDLN16 VCM_REF PH1 NPH1 VDD33 VSS gf180_tg_lowq
XDNB16 CDRN16 VCM_REF PH1 NPH1 VDD33 VSS gf180_tg_lowq
XDP216 CDRP16 INP PH2 NPH2 VDD33 VSS gf180_tg_lowq
XDN216 CDRN16 INN PH2 NPH2 VDD33 VSS gf180_tg_lowq
BGPP16 GPP16 VSS I=(v(GPP16)-v(PH2)*v(SP16)/v(VDD33))/1k
BGPN16 GPN16 VSS I=(v(GPN16)-v(PH2)*(v(VDD33)-v(SP16))/v(VDD33))/1k
BGNP16 GNP16 VSS I=(v(GNP16)-v(PH2)*v(SN16)/v(VDD33))/1k
BGNN16 GNN16 VSS I=(v(GNN16)-v(PH2)*(v(VDD33)-v(SN16))/v(VDD33))/1k
BNOPP16 NGPP16 0 V=v(VDD33)-v(GPP16)
BNOPN16 NGPN16 0 V=v(VDD33)-v(GPN16)
BNONP16 NGNP16 0 V=v(VDD33)-v(GNP16)
BNONN16 NGNN16 0 V=v(VDD33)-v(GNN16)
CGPP16 GPP16 VSS 2p
CGPN16 GPN16 VSS 2p
CGNP16 GNP16 VSS 2p
CGNN16 GNN16 VSS 2p
CNGPP16 NGPP16 VSS 0.2p
CNGPN16 NGPN16 VSS 0.2p
CNGNP16 NGNP16 VSS 0.2p
CNGNN16 NGNN16 VSS 0.2p
XPVP16 CDLP16 VP GPP16 NGPP16 VDD33 VSS gf180_tg_lowq
XPVN16 CDLP16 VN GPN16 NGPN16 VDD33 VSS gf180_tg_lowq
XNVP16 CDLN16 VP GNP16 NGNP16 VDD33 VSS gf180_tg_lowq
XNVN16 CDLN16 VN GNN16 NGNN16 VDD33 VSS gf180_tg_lowq
* DAC unit 17 (P side DP17, N side DN17)
CDP17 CDLP17 CDRP17 {CU}
CDN17 CDLN17 CDRN17 {CU}
XDPA17 CDLP17 VCM_REF PH1 NPH1 VDD33 VSS gf180_tg_lowq
XDPB17 CDRP17 VCM_REF PH1 NPH1 VDD33 VSS gf180_tg_lowq
XDNA17 CDLN17 VCM_REF PH1 NPH1 VDD33 VSS gf180_tg_lowq
XDNB17 CDRN17 VCM_REF PH1 NPH1 VDD33 VSS gf180_tg_lowq
XDP217 CDRP17 INP PH2 NPH2 VDD33 VSS gf180_tg_lowq
XDN217 CDRN17 INN PH2 NPH2 VDD33 VSS gf180_tg_lowq
BGPP17 GPP17 VSS I=(v(GPP17)-v(PH2)*v(SP17)/v(VDD33))/1k
BGPN17 GPN17 VSS I=(v(GPN17)-v(PH2)*(v(VDD33)-v(SP17))/v(VDD33))/1k
BGNP17 GNP17 VSS I=(v(GNP17)-v(PH2)*v(SN17)/v(VDD33))/1k
BGNN17 GNN17 VSS I=(v(GNN17)-v(PH2)*(v(VDD33)-v(SN17))/v(VDD33))/1k
BNOPP17 NGPP17 0 V=v(VDD33)-v(GPP17)
BNOPN17 NGPN17 0 V=v(VDD33)-v(GPN17)
BNONP17 NGNP17 0 V=v(VDD33)-v(GNP17)
BNONN17 NGNN17 0 V=v(VDD33)-v(GNN17)
CGPP17 GPP17 VSS 2p
CGPN17 GPN17 VSS 2p
CGNP17 GNP17 VSS 2p
CGNN17 GNN17 VSS 2p
CNGPP17 NGPP17 VSS 0.2p
CNGPN17 NGPN17 VSS 0.2p
CNGNP17 NGNP17 VSS 0.2p
CNGNN17 NGNN17 VSS 0.2p
XPVP17 CDLP17 VP GPP17 NGPP17 VDD33 VSS gf180_tg_lowq
XPVN17 CDLP17 VN GPN17 NGPN17 VDD33 VSS gf180_tg_lowq
XNVP17 CDLN17 VP GNP17 NGNP17 VDD33 VSS gf180_tg_lowq
XNVN17 CDLN17 VN GNN17 NGNN17 VDD33 VSS gf180_tg_lowq
* DAC unit 18 (P side DP18, N side DN18)
CDP18 CDLP18 CDRP18 {CU}
CDN18 CDLN18 CDRN18 {CU}
XDPA18 CDLP18 VCM_REF PH1 NPH1 VDD33 VSS gf180_tg_lowq
XDPB18 CDRP18 VCM_REF PH1 NPH1 VDD33 VSS gf180_tg_lowq
XDNA18 CDLN18 VCM_REF PH1 NPH1 VDD33 VSS gf180_tg_lowq
XDNB18 CDRN18 VCM_REF PH1 NPH1 VDD33 VSS gf180_tg_lowq
XDP218 CDRP18 INP PH2 NPH2 VDD33 VSS gf180_tg_lowq
XDN218 CDRN18 INN PH2 NPH2 VDD33 VSS gf180_tg_lowq
BGPP18 GPP18 VSS I=(v(GPP18)-v(PH2)*v(SP18)/v(VDD33))/1k
BGPN18 GPN18 VSS I=(v(GPN18)-v(PH2)*(v(VDD33)-v(SP18))/v(VDD33))/1k
BGNP18 GNP18 VSS I=(v(GNP18)-v(PH2)*v(SN18)/v(VDD33))/1k
BGNN18 GNN18 VSS I=(v(GNN18)-v(PH2)*(v(VDD33)-v(SN18))/v(VDD33))/1k
BNOPP18 NGPP18 0 V=v(VDD33)-v(GPP18)
BNOPN18 NGPN18 0 V=v(VDD33)-v(GPN18)
BNONP18 NGNP18 0 V=v(VDD33)-v(GNP18)
BNONN18 NGNN18 0 V=v(VDD33)-v(GNN18)
CGPP18 GPP18 VSS 2p
CGPN18 GPN18 VSS 2p
CGNP18 GNP18 VSS 2p
CGNN18 GNN18 VSS 2p
CNGPP18 NGPP18 VSS 0.2p
CNGPN18 NGPN18 VSS 0.2p
CNGNP18 NGNP18 VSS 0.2p
CNGNN18 NGNN18 VSS 0.2p
XPVP18 CDLP18 VP GPP18 NGPP18 VDD33 VSS gf180_tg_lowq
XPVN18 CDLP18 VN GPN18 NGPN18 VDD33 VSS gf180_tg_lowq
XNVP18 CDLN18 VP GNP18 NGNP18 VDD33 VSS gf180_tg_lowq
XNVN18 CDLN18 VN GNN18 NGNN18 VDD33 VSS gf180_tg_lowq
* DAC unit 19 (P side DP19, N side DN19)
CDP19 CDLP19 CDRP19 {CU}
CDN19 CDLN19 CDRN19 {CU}
XDPA19 CDLP19 VCM_REF PH1 NPH1 VDD33 VSS gf180_tg_lowq
XDPB19 CDRP19 VCM_REF PH1 NPH1 VDD33 VSS gf180_tg_lowq
XDNA19 CDLN19 VCM_REF PH1 NPH1 VDD33 VSS gf180_tg_lowq
XDNB19 CDRN19 VCM_REF PH1 NPH1 VDD33 VSS gf180_tg_lowq
XDP219 CDRP19 INP PH2 NPH2 VDD33 VSS gf180_tg_lowq
XDN219 CDRN19 INN PH2 NPH2 VDD33 VSS gf180_tg_lowq
BGPP19 GPP19 VSS I=(v(GPP19)-v(PH2)*v(SP19)/v(VDD33))/1k
BGPN19 GPN19 VSS I=(v(GPN19)-v(PH2)*(v(VDD33)-v(SP19))/v(VDD33))/1k
BGNP19 GNP19 VSS I=(v(GNP19)-v(PH2)*v(SN19)/v(VDD33))/1k
BGNN19 GNN19 VSS I=(v(GNN19)-v(PH2)*(v(VDD33)-v(SN19))/v(VDD33))/1k
BNOPP19 NGPP19 0 V=v(VDD33)-v(GPP19)
BNOPN19 NGPN19 0 V=v(VDD33)-v(GPN19)
BNONP19 NGNP19 0 V=v(VDD33)-v(GNP19)
BNONN19 NGNN19 0 V=v(VDD33)-v(GNN19)
CGPP19 GPP19 VSS 2p
CGPN19 GPN19 VSS 2p
CGNP19 GNP19 VSS 2p
CGNN19 GNN19 VSS 2p
CNGPP19 NGPP19 VSS 0.2p
CNGPN19 NGPN19 VSS 0.2p
CNGNP19 NGNP19 VSS 0.2p
CNGNN19 NGNN19 VSS 0.2p
XPVP19 CDLP19 VP GPP19 NGPP19 VDD33 VSS gf180_tg_lowq
XPVN19 CDLP19 VN GPN19 NGPN19 VDD33 VSS gf180_tg_lowq
XNVP19 CDLN19 VP GNP19 NGNP19 VDD33 VSS gf180_tg_lowq
XNVN19 CDLN19 VN GNN19 NGNN19 VDD33 VSS gf180_tg_lowq
* DAC unit 20 (P side DP20, N side DN20)
CDP20 CDLP20 CDRP20 {CU}
CDN20 CDLN20 CDRN20 {CU}
XDPA20 CDLP20 VCM_REF PH1 NPH1 VDD33 VSS gf180_tg_lowq
XDPB20 CDRP20 VCM_REF PH1 NPH1 VDD33 VSS gf180_tg_lowq
XDNA20 CDLN20 VCM_REF PH1 NPH1 VDD33 VSS gf180_tg_lowq
XDNB20 CDRN20 VCM_REF PH1 NPH1 VDD33 VSS gf180_tg_lowq
XDP220 CDRP20 INP PH2 NPH2 VDD33 VSS gf180_tg_lowq
XDN220 CDRN20 INN PH2 NPH2 VDD33 VSS gf180_tg_lowq
BGPP20 GPP20 VSS I=(v(GPP20)-v(PH2)*v(SP20)/v(VDD33))/1k
BGPN20 GPN20 VSS I=(v(GPN20)-v(PH2)*(v(VDD33)-v(SP20))/v(VDD33))/1k
BGNP20 GNP20 VSS I=(v(GNP20)-v(PH2)*v(SN20)/v(VDD33))/1k
BGNN20 GNN20 VSS I=(v(GNN20)-v(PH2)*(v(VDD33)-v(SN20))/v(VDD33))/1k
BNOPP20 NGPP20 0 V=v(VDD33)-v(GPP20)
BNOPN20 NGPN20 0 V=v(VDD33)-v(GPN20)
BNONP20 NGNP20 0 V=v(VDD33)-v(GNP20)
BNONN20 NGNN20 0 V=v(VDD33)-v(GNN20)
CGPP20 GPP20 VSS 2p
CGPN20 GPN20 VSS 2p
CGNP20 GNP20 VSS 2p
CGNN20 GNN20 VSS 2p
CNGPP20 NGPP20 VSS 0.2p
CNGPN20 NGPN20 VSS 0.2p
CNGNP20 NGNP20 VSS 0.2p
CNGNN20 NGNN20 VSS 0.2p
XPVP20 CDLP20 VP GPP20 NGPP20 VDD33 VSS gf180_tg_lowq
XPVN20 CDLP20 VN GPN20 NGPN20 VDD33 VSS gf180_tg_lowq
XNVP20 CDLN20 VP GNP20 NGNP20 VDD33 VSS gf180_tg_lowq
XNVN20 CDLN20 VN GNN20 NGNN20 VDD33 VSS gf180_tg_lowq
* DAC unit 21 (P side DP21, N side DN21)
CDP21 CDLP21 CDRP21 {CU}
CDN21 CDLN21 CDRN21 {CU}
XDPA21 CDLP21 VCM_REF PH1 NPH1 VDD33 VSS gf180_tg_lowq
XDPB21 CDRP21 VCM_REF PH1 NPH1 VDD33 VSS gf180_tg_lowq
XDNA21 CDLN21 VCM_REF PH1 NPH1 VDD33 VSS gf180_tg_lowq
XDNB21 CDRN21 VCM_REF PH1 NPH1 VDD33 VSS gf180_tg_lowq
XDP221 CDRP21 INP PH2 NPH2 VDD33 VSS gf180_tg_lowq
XDN221 CDRN21 INN PH2 NPH2 VDD33 VSS gf180_tg_lowq
BGPP21 GPP21 VSS I=(v(GPP21)-v(PH2)*v(SP21)/v(VDD33))/1k
BGPN21 GPN21 VSS I=(v(GPN21)-v(PH2)*(v(VDD33)-v(SP21))/v(VDD33))/1k
BGNP21 GNP21 VSS I=(v(GNP21)-v(PH2)*v(SN21)/v(VDD33))/1k
BGNN21 GNN21 VSS I=(v(GNN21)-v(PH2)*(v(VDD33)-v(SN21))/v(VDD33))/1k
BNOPP21 NGPP21 0 V=v(VDD33)-v(GPP21)
BNOPN21 NGPN21 0 V=v(VDD33)-v(GPN21)
BNONP21 NGNP21 0 V=v(VDD33)-v(GNP21)
BNONN21 NGNN21 0 V=v(VDD33)-v(GNN21)
CGPP21 GPP21 VSS 2p
CGPN21 GPN21 VSS 2p
CGNP21 GNP21 VSS 2p
CGNN21 GNN21 VSS 2p
CNGPP21 NGPP21 VSS 0.2p
CNGPN21 NGPN21 VSS 0.2p
CNGNP21 NGNP21 VSS 0.2p
CNGNN21 NGNN21 VSS 0.2p
XPVP21 CDLP21 VP GPP21 NGPP21 VDD33 VSS gf180_tg_lowq
XPVN21 CDLP21 VN GPN21 NGPN21 VDD33 VSS gf180_tg_lowq
XNVP21 CDLN21 VP GNP21 NGNP21 VDD33 VSS gf180_tg_lowq
XNVN21 CDLN21 VN GNN21 NGNN21 VDD33 VSS gf180_tg_lowq
* DAC unit 22 (P side DP22, N side DN22)
CDP22 CDLP22 CDRP22 {CU}
CDN22 CDLN22 CDRN22 {CU}
XDPA22 CDLP22 VCM_REF PH1 NPH1 VDD33 VSS gf180_tg_lowq
XDPB22 CDRP22 VCM_REF PH1 NPH1 VDD33 VSS gf180_tg_lowq
XDNA22 CDLN22 VCM_REF PH1 NPH1 VDD33 VSS gf180_tg_lowq
XDNB22 CDRN22 VCM_REF PH1 NPH1 VDD33 VSS gf180_tg_lowq
XDP222 CDRP22 INP PH2 NPH2 VDD33 VSS gf180_tg_lowq
XDN222 CDRN22 INN PH2 NPH2 VDD33 VSS gf180_tg_lowq
BGPP22 GPP22 VSS I=(v(GPP22)-v(PH2)*v(SP22)/v(VDD33))/1k
BGPN22 GPN22 VSS I=(v(GPN22)-v(PH2)*(v(VDD33)-v(SP22))/v(VDD33))/1k
BGNP22 GNP22 VSS I=(v(GNP22)-v(PH2)*v(SN22)/v(VDD33))/1k
BGNN22 GNN22 VSS I=(v(GNN22)-v(PH2)*(v(VDD33)-v(SN22))/v(VDD33))/1k
BNOPP22 NGPP22 0 V=v(VDD33)-v(GPP22)
BNOPN22 NGPN22 0 V=v(VDD33)-v(GPN22)
BNONP22 NGNP22 0 V=v(VDD33)-v(GNP22)
BNONN22 NGNN22 0 V=v(VDD33)-v(GNN22)
CGPP22 GPP22 VSS 2p
CGPN22 GPN22 VSS 2p
CGNP22 GNP22 VSS 2p
CGNN22 GNN22 VSS 2p
CNGPP22 NGPP22 VSS 0.2p
CNGPN22 NGPN22 VSS 0.2p
CNGNP22 NGNP22 VSS 0.2p
CNGNN22 NGNN22 VSS 0.2p
XPVP22 CDLP22 VP GPP22 NGPP22 VDD33 VSS gf180_tg_lowq
XPVN22 CDLP22 VN GPN22 NGPN22 VDD33 VSS gf180_tg_lowq
XNVP22 CDLN22 VP GNP22 NGNP22 VDD33 VSS gf180_tg_lowq
XNVN22 CDLN22 VN GNN22 NGNN22 VDD33 VSS gf180_tg_lowq
* DAC unit 23 (P side DP23, N side DN23)
CDP23 CDLP23 CDRP23 {CU}
CDN23 CDLN23 CDRN23 {CU}
XDPA23 CDLP23 VCM_REF PH1 NPH1 VDD33 VSS gf180_tg_lowq
XDPB23 CDRP23 VCM_REF PH1 NPH1 VDD33 VSS gf180_tg_lowq
XDNA23 CDLN23 VCM_REF PH1 NPH1 VDD33 VSS gf180_tg_lowq
XDNB23 CDRN23 VCM_REF PH1 NPH1 VDD33 VSS gf180_tg_lowq
XDP223 CDRP23 INP PH2 NPH2 VDD33 VSS gf180_tg_lowq
XDN223 CDRN23 INN PH2 NPH2 VDD33 VSS gf180_tg_lowq
BGPP23 GPP23 VSS I=(v(GPP23)-v(PH2)*v(SP23)/v(VDD33))/1k
BGPN23 GPN23 VSS I=(v(GPN23)-v(PH2)*(v(VDD33)-v(SP23))/v(VDD33))/1k
BGNP23 GNP23 VSS I=(v(GNP23)-v(PH2)*v(SN23)/v(VDD33))/1k
BGNN23 GNN23 VSS I=(v(GNN23)-v(PH2)*(v(VDD33)-v(SN23))/v(VDD33))/1k
BNOPP23 NGPP23 0 V=v(VDD33)-v(GPP23)
BNOPN23 NGPN23 0 V=v(VDD33)-v(GPN23)
BNONP23 NGNP23 0 V=v(VDD33)-v(GNP23)
BNONN23 NGNN23 0 V=v(VDD33)-v(GNN23)
CGPP23 GPP23 VSS 2p
CGPN23 GPN23 VSS 2p
CGNP23 GNP23 VSS 2p
CGNN23 GNN23 VSS 2p
CNGPP23 NGPP23 VSS 0.2p
CNGPN23 NGPN23 VSS 0.2p
CNGNP23 NGNP23 VSS 0.2p
CNGNN23 NGNN23 VSS 0.2p
XPVP23 CDLP23 VP GPP23 NGPP23 VDD33 VSS gf180_tg_lowq
XPVN23 CDLP23 VN GPN23 NGPN23 VDD33 VSS gf180_tg_lowq
XNVP23 CDLN23 VP GNP23 NGNP23 VDD33 VSS gf180_tg_lowq
XNVN23 CDLN23 VN GNN23 NGNN23 VDD33 VSS gf180_tg_lowq
* DAC unit 24 (P side DP24, N side DN24)
CDP24 CDLP24 CDRP24 {CU}
CDN24 CDLN24 CDRN24 {CU}
XDPA24 CDLP24 VCM_REF PH1 NPH1 VDD33 VSS gf180_tg_lowq
XDPB24 CDRP24 VCM_REF PH1 NPH1 VDD33 VSS gf180_tg_lowq
XDNA24 CDLN24 VCM_REF PH1 NPH1 VDD33 VSS gf180_tg_lowq
XDNB24 CDRN24 VCM_REF PH1 NPH1 VDD33 VSS gf180_tg_lowq
XDP224 CDRP24 INP PH2 NPH2 VDD33 VSS gf180_tg_lowq
XDN224 CDRN24 INN PH2 NPH2 VDD33 VSS gf180_tg_lowq
BGPP24 GPP24 VSS I=(v(GPP24)-v(PH2)*v(SP24)/v(VDD33))/1k
BGPN24 GPN24 VSS I=(v(GPN24)-v(PH2)*(v(VDD33)-v(SP24))/v(VDD33))/1k
BGNP24 GNP24 VSS I=(v(GNP24)-v(PH2)*v(SN24)/v(VDD33))/1k
BGNN24 GNN24 VSS I=(v(GNN24)-v(PH2)*(v(VDD33)-v(SN24))/v(VDD33))/1k
BNOPP24 NGPP24 0 V=v(VDD33)-v(GPP24)
BNOPN24 NGPN24 0 V=v(VDD33)-v(GPN24)
BNONP24 NGNP24 0 V=v(VDD33)-v(GNP24)
BNONN24 NGNN24 0 V=v(VDD33)-v(GNN24)
CGPP24 GPP24 VSS 2p
CGPN24 GPN24 VSS 2p
CGNP24 GNP24 VSS 2p
CGNN24 GNN24 VSS 2p
CNGPP24 NGPP24 VSS 0.2p
CNGPN24 NGPN24 VSS 0.2p
CNGNP24 NGNP24 VSS 0.2p
CNGNN24 NGNN24 VSS 0.2p
XPVP24 CDLP24 VP GPP24 NGPP24 VDD33 VSS gf180_tg_lowq
XPVN24 CDLP24 VN GPN24 NGPN24 VDD33 VSS gf180_tg_lowq
XNVP24 CDLN24 VP GNP24 NGNP24 VDD33 VSS gf180_tg_lowq
XNVN24 CDLN24 VN GNN24 NGNN24 VDD33 VSS gf180_tg_lowq
* DAC unit 25 (P side DP25, N side DN25)
CDP25 CDLP25 CDRP25 {CU}
CDN25 CDLN25 CDRN25 {CU}
XDPA25 CDLP25 VCM_REF PH1 NPH1 VDD33 VSS gf180_tg_lowq
XDPB25 CDRP25 VCM_REF PH1 NPH1 VDD33 VSS gf180_tg_lowq
XDNA25 CDLN25 VCM_REF PH1 NPH1 VDD33 VSS gf180_tg_lowq
XDNB25 CDRN25 VCM_REF PH1 NPH1 VDD33 VSS gf180_tg_lowq
XDP225 CDRP25 INP PH2 NPH2 VDD33 VSS gf180_tg_lowq
XDN225 CDRN25 INN PH2 NPH2 VDD33 VSS gf180_tg_lowq
BGPP25 GPP25 VSS I=(v(GPP25)-v(PH2)*v(SP25)/v(VDD33))/1k
BGPN25 GPN25 VSS I=(v(GPN25)-v(PH2)*(v(VDD33)-v(SP25))/v(VDD33))/1k
BGNP25 GNP25 VSS I=(v(GNP25)-v(PH2)*v(SN25)/v(VDD33))/1k
BGNN25 GNN25 VSS I=(v(GNN25)-v(PH2)*(v(VDD33)-v(SN25))/v(VDD33))/1k
BNOPP25 NGPP25 0 V=v(VDD33)-v(GPP25)
BNOPN25 NGPN25 0 V=v(VDD33)-v(GPN25)
BNONP25 NGNP25 0 V=v(VDD33)-v(GNP25)
BNONN25 NGNN25 0 V=v(VDD33)-v(GNN25)
CGPP25 GPP25 VSS 2p
CGPN25 GPN25 VSS 2p
CGNP25 GNP25 VSS 2p
CGNN25 GNN25 VSS 2p
CNGPP25 NGPP25 VSS 0.2p
CNGPN25 NGPN25 VSS 0.2p
CNGNP25 NGNP25 VSS 0.2p
CNGNN25 NGNN25 VSS 0.2p
XPVP25 CDLP25 VP GPP25 NGPP25 VDD33 VSS gf180_tg_lowq
XPVN25 CDLP25 VN GPN25 NGPN25 VDD33 VSS gf180_tg_lowq
XNVP25 CDLN25 VP GNP25 NGNP25 VDD33 VSS gf180_tg_lowq
XNVN25 CDLN25 VN GNN25 NGNN25 VDD33 VSS gf180_tg_lowq
* DAC unit 26 (P side DP26, N side DN26)
CDP26 CDLP26 CDRP26 {CU}
CDN26 CDLN26 CDRN26 {CU}
XDPA26 CDLP26 VCM_REF PH1 NPH1 VDD33 VSS gf180_tg_lowq
XDPB26 CDRP26 VCM_REF PH1 NPH1 VDD33 VSS gf180_tg_lowq
XDNA26 CDLN26 VCM_REF PH1 NPH1 VDD33 VSS gf180_tg_lowq
XDNB26 CDRN26 VCM_REF PH1 NPH1 VDD33 VSS gf180_tg_lowq
XDP226 CDRP26 INP PH2 NPH2 VDD33 VSS gf180_tg_lowq
XDN226 CDRN26 INN PH2 NPH2 VDD33 VSS gf180_tg_lowq
BGPP26 GPP26 VSS I=(v(GPP26)-v(PH2)*v(SP26)/v(VDD33))/1k
BGPN26 GPN26 VSS I=(v(GPN26)-v(PH2)*(v(VDD33)-v(SP26))/v(VDD33))/1k
BGNP26 GNP26 VSS I=(v(GNP26)-v(PH2)*v(SN26)/v(VDD33))/1k
BGNN26 GNN26 VSS I=(v(GNN26)-v(PH2)*(v(VDD33)-v(SN26))/v(VDD33))/1k
BNOPP26 NGPP26 0 V=v(VDD33)-v(GPP26)
BNOPN26 NGPN26 0 V=v(VDD33)-v(GPN26)
BNONP26 NGNP26 0 V=v(VDD33)-v(GNP26)
BNONN26 NGNN26 0 V=v(VDD33)-v(GNN26)
CGPP26 GPP26 VSS 2p
CGPN26 GPN26 VSS 2p
CGNP26 GNP26 VSS 2p
CGNN26 GNN26 VSS 2p
CNGPP26 NGPP26 VSS 0.2p
CNGPN26 NGPN26 VSS 0.2p
CNGNP26 NGNP26 VSS 0.2p
CNGNN26 NGNN26 VSS 0.2p
XPVP26 CDLP26 VP GPP26 NGPP26 VDD33 VSS gf180_tg_lowq
XPVN26 CDLP26 VN GPN26 NGPN26 VDD33 VSS gf180_tg_lowq
XNVP26 CDLN26 VP GNP26 NGNP26 VDD33 VSS gf180_tg_lowq
XNVN26 CDLN26 VN GNN26 NGNN26 VDD33 VSS gf180_tg_lowq
* DAC unit 27 (P side DP27, N side DN27)
CDP27 CDLP27 CDRP27 {CU}
CDN27 CDLN27 CDRN27 {CU}
XDPA27 CDLP27 VCM_REF PH1 NPH1 VDD33 VSS gf180_tg_lowq
XDPB27 CDRP27 VCM_REF PH1 NPH1 VDD33 VSS gf180_tg_lowq
XDNA27 CDLN27 VCM_REF PH1 NPH1 VDD33 VSS gf180_tg_lowq
XDNB27 CDRN27 VCM_REF PH1 NPH1 VDD33 VSS gf180_tg_lowq
XDP227 CDRP27 INP PH2 NPH2 VDD33 VSS gf180_tg_lowq
XDN227 CDRN27 INN PH2 NPH2 VDD33 VSS gf180_tg_lowq
BGPP27 GPP27 VSS I=(v(GPP27)-v(PH2)*v(SP27)/v(VDD33))/1k
BGPN27 GPN27 VSS I=(v(GPN27)-v(PH2)*(v(VDD33)-v(SP27))/v(VDD33))/1k
BGNP27 GNP27 VSS I=(v(GNP27)-v(PH2)*v(SN27)/v(VDD33))/1k
BGNN27 GNN27 VSS I=(v(GNN27)-v(PH2)*(v(VDD33)-v(SN27))/v(VDD33))/1k
BNOPP27 NGPP27 0 V=v(VDD33)-v(GPP27)
BNOPN27 NGPN27 0 V=v(VDD33)-v(GPN27)
BNONP27 NGNP27 0 V=v(VDD33)-v(GNP27)
BNONN27 NGNN27 0 V=v(VDD33)-v(GNN27)
CGPP27 GPP27 VSS 2p
CGPN27 GPN27 VSS 2p
CGNP27 GNP27 VSS 2p
CGNN27 GNN27 VSS 2p
CNGPP27 NGPP27 VSS 0.2p
CNGPN27 NGPN27 VSS 0.2p
CNGNP27 NGNP27 VSS 0.2p
CNGNN27 NGNN27 VSS 0.2p
XPVP27 CDLP27 VP GPP27 NGPP27 VDD33 VSS gf180_tg_lowq
XPVN27 CDLP27 VN GPN27 NGPN27 VDD33 VSS gf180_tg_lowq
XNVP27 CDLN27 VP GNP27 NGNP27 VDD33 VSS gf180_tg_lowq
XNVN27 CDLN27 VN GNN27 NGNN27 VDD33 VSS gf180_tg_lowq
* DAC unit 28 (P side DP28, N side DN28)
CDP28 CDLP28 CDRP28 {CU}
CDN28 CDLN28 CDRN28 {CU}
XDPA28 CDLP28 VCM_REF PH1 NPH1 VDD33 VSS gf180_tg_lowq
XDPB28 CDRP28 VCM_REF PH1 NPH1 VDD33 VSS gf180_tg_lowq
XDNA28 CDLN28 VCM_REF PH1 NPH1 VDD33 VSS gf180_tg_lowq
XDNB28 CDRN28 VCM_REF PH1 NPH1 VDD33 VSS gf180_tg_lowq
XDP228 CDRP28 INP PH2 NPH2 VDD33 VSS gf180_tg_lowq
XDN228 CDRN28 INN PH2 NPH2 VDD33 VSS gf180_tg_lowq
BGPP28 GPP28 VSS I=(v(GPP28)-v(PH2)*v(SP28)/v(VDD33))/1k
BGPN28 GPN28 VSS I=(v(GPN28)-v(PH2)*(v(VDD33)-v(SP28))/v(VDD33))/1k
BGNP28 GNP28 VSS I=(v(GNP28)-v(PH2)*v(SN28)/v(VDD33))/1k
BGNN28 GNN28 VSS I=(v(GNN28)-v(PH2)*(v(VDD33)-v(SN28))/v(VDD33))/1k
BNOPP28 NGPP28 0 V=v(VDD33)-v(GPP28)
BNOPN28 NGPN28 0 V=v(VDD33)-v(GPN28)
BNONP28 NGNP28 0 V=v(VDD33)-v(GNP28)
BNONN28 NGNN28 0 V=v(VDD33)-v(GNN28)
CGPP28 GPP28 VSS 2p
CGPN28 GPN28 VSS 2p
CGNP28 GNP28 VSS 2p
CGNN28 GNN28 VSS 2p
CNGPP28 NGPP28 VSS 0.2p
CNGPN28 NGPN28 VSS 0.2p
CNGNP28 NGNP28 VSS 0.2p
CNGNN28 NGNN28 VSS 0.2p
XPVP28 CDLP28 VP GPP28 NGPP28 VDD33 VSS gf180_tg_lowq
XPVN28 CDLP28 VN GPN28 NGPN28 VDD33 VSS gf180_tg_lowq
XNVP28 CDLN28 VP GNP28 NGNP28 VDD33 VSS gf180_tg_lowq
XNVN28 CDLN28 VN GNN28 NGNN28 VDD33 VSS gf180_tg_lowq
* DAC unit 29 (P side DP29, N side DN29)
CDP29 CDLP29 CDRP29 {CU}
CDN29 CDLN29 CDRN29 {CU}
XDPA29 CDLP29 VCM_REF PH1 NPH1 VDD33 VSS gf180_tg_lowq
XDPB29 CDRP29 VCM_REF PH1 NPH1 VDD33 VSS gf180_tg_lowq
XDNA29 CDLN29 VCM_REF PH1 NPH1 VDD33 VSS gf180_tg_lowq
XDNB29 CDRN29 VCM_REF PH1 NPH1 VDD33 VSS gf180_tg_lowq
XDP229 CDRP29 INP PH2 NPH2 VDD33 VSS gf180_tg_lowq
XDN229 CDRN29 INN PH2 NPH2 VDD33 VSS gf180_tg_lowq
BGPP29 GPP29 VSS I=(v(GPP29)-v(PH2)*v(SP29)/v(VDD33))/1k
BGPN29 GPN29 VSS I=(v(GPN29)-v(PH2)*(v(VDD33)-v(SP29))/v(VDD33))/1k
BGNP29 GNP29 VSS I=(v(GNP29)-v(PH2)*v(SN29)/v(VDD33))/1k
BGNN29 GNN29 VSS I=(v(GNN29)-v(PH2)*(v(VDD33)-v(SN29))/v(VDD33))/1k
BNOPP29 NGPP29 0 V=v(VDD33)-v(GPP29)
BNOPN29 NGPN29 0 V=v(VDD33)-v(GPN29)
BNONP29 NGNP29 0 V=v(VDD33)-v(GNP29)
BNONN29 NGNN29 0 V=v(VDD33)-v(GNN29)
CGPP29 GPP29 VSS 2p
CGPN29 GPN29 VSS 2p
CGNP29 GNP29 VSS 2p
CGNN29 GNN29 VSS 2p
CNGPP29 NGPP29 VSS 0.2p
CNGPN29 NGPN29 VSS 0.2p
CNGNP29 NGNP29 VSS 0.2p
CNGNN29 NGNN29 VSS 0.2p
XPVP29 CDLP29 VP GPP29 NGPP29 VDD33 VSS gf180_tg_lowq
XPVN29 CDLP29 VN GPN29 NGPN29 VDD33 VSS gf180_tg_lowq
XNVP29 CDLN29 VP GNP29 NGNP29 VDD33 VSS gf180_tg_lowq
XNVN29 CDLN29 VN GNN29 NGNN29 VDD33 VSS gf180_tg_lowq
* DAC unit 30 (P side DP30, N side DN30)
CDP30 CDLP30 CDRP30 {CU}
CDN30 CDLN30 CDRN30 {CU}
XDPA30 CDLP30 VCM_REF PH1 NPH1 VDD33 VSS gf180_tg_lowq
XDPB30 CDRP30 VCM_REF PH1 NPH1 VDD33 VSS gf180_tg_lowq
XDNA30 CDLN30 VCM_REF PH1 NPH1 VDD33 VSS gf180_tg_lowq
XDNB30 CDRN30 VCM_REF PH1 NPH1 VDD33 VSS gf180_tg_lowq
XDP230 CDRP30 INP PH2 NPH2 VDD33 VSS gf180_tg_lowq
XDN230 CDRN30 INN PH2 NPH2 VDD33 VSS gf180_tg_lowq
BGPP30 GPP30 VSS I=(v(GPP30)-v(PH2)*v(SP30)/v(VDD33))/1k
BGPN30 GPN30 VSS I=(v(GPN30)-v(PH2)*(v(VDD33)-v(SP30))/v(VDD33))/1k
BGNP30 GNP30 VSS I=(v(GNP30)-v(PH2)*v(SN30)/v(VDD33))/1k
BGNN30 GNN30 VSS I=(v(GNN30)-v(PH2)*(v(VDD33)-v(SN30))/v(VDD33))/1k
BNOPP30 NGPP30 0 V=v(VDD33)-v(GPP30)
BNOPN30 NGPN30 0 V=v(VDD33)-v(GPN30)
BNONP30 NGNP30 0 V=v(VDD33)-v(GNP30)
BNONN30 NGNN30 0 V=v(VDD33)-v(GNN30)
CGPP30 GPP30 VSS 2p
CGPN30 GPN30 VSS 2p
CGNP30 GNP30 VSS 2p
CGNN30 GNN30 VSS 2p
CNGPP30 NGPP30 VSS 0.2p
CNGPN30 NGPN30 VSS 0.2p
CNGNP30 NGNP30 VSS 0.2p
CNGNN30 NGNN30 VSS 0.2p
XPVP30 CDLP30 VP GPP30 NGPP30 VDD33 VSS gf180_tg_lowq
XPVN30 CDLP30 VN GPN30 NGPN30 VDD33 VSS gf180_tg_lowq
XNVP30 CDLN30 VP GNP30 NGNP30 VDD33 VSS gf180_tg_lowq
XNVN30 CDLN30 VN GNN30 NGNN30 VDD33 VSS gf180_tg_lowq
CIP OUTN INP {CI}
CIN OUTP INN {CI}
RBIASP INP VCM_REF 10G
RBIASN INN VCM_REF 10G
.ends gf180_sdm3_int1_mb

* ---- int2 mb: CS=2p, CI=4p, 31x0.125p/side DAC (S2P/S2N selects, PH1 int)
* int2 integrates during PH1 with the REGISTERED code (applied via S2*).
.subckt gf180_sdm3_int2_mb INP_S INN_S VCM_REF VP VN OUTP OUTN PH1 NPH1 PH2 NPH2 VDD33 VSS S2P0 S2P1 S2P2 S2P3 S2P4 S2P5 S2P6 S2P7 S2P8 S2P9 S2P10 S2P11 S2P12 S2P13 S2P14 S2P15 S2P16 S2P17 S2P18 S2P19 S2P20 S2P21 S2P22 S2P23 S2P24 S2P25 S2P26 S2P27 S2P28 S2P29 S2P30 S2N0 S2N1 S2N2 S2N3 S2N4 S2N5 S2N6 S2N7 S2N8 S2N9 S2N10 S2N11 S2N12 S2N13 S2N14 S2N15 S2N16 S2N17 S2N18 S2N19 S2N20 S2N21 S2N22 S2N23 S2N24 S2N25 S2N26 S2N27 S2N28 S2N29 S2N30 params: CS=2p CU=0.125p CI=4p W91=11u L91=2u W92=6u L92=2u W10=12u RSET=25k CC=10p
XOTA INP INN VCM_REF OUTP OUTN VDD33 VSS gf180_fd_ota_full2_nc W91={W91} L91={L91} W92={W92} L92={L92} W10={W10} RSET={RSET} CC={CC}
CSP CSLP CSRP {CS}
CSN CSLN CSRN {CS}
XS1A CSLP INP_S PH1 NPH1 VDD33 VSS gf180_tg_lowq
XS1B CSRP VCM_REF PH1 NPH1 VDD33 VSS gf180_tg_lowq
XS1C CSLN INN_S PH1 NPH1 VDD33 VSS gf180_tg_lowq
XS1D CSRN VCM_REF PH1 NPH1 VDD33 VSS gf180_tg_lowq
XS2A CSLP VCM_REF PH2 NPH2 VDD33 VSS gf180_tg_lowq
XS2B CSRP INP PH2 NPH2 VDD33 VSS gf180_tg_lowq
XS2C CSLN VCM_REF PH2 NPH2 VDD33 VSS gf180_tg_lowq
XS2D CSRN INN PH2 NPH2 VDD33 VSS gf180_tg_lowq
* DAC unit 0
CDP0 CDLP0 CDRP0 {CU}
CDN0 CDLN0 CDRN0 {CU}
XDP10 CDRP0 VCM_REF PH1 NPH1 VDD33 VSS gf180_tg_lowq
XDP20 CDRP0 INP PH2 NPH2 VDD33 VSS gf180_tg_lowq
XDN10 CDRN0 VCM_REF PH1 NPH1 VDD33 VSS gf180_tg_lowq
XDN20 CDRN0 INN PH2 NPH2 VDD33 VSS gf180_tg_lowq
BGPP0 GPP0 VSS I=(v(GPP0)-v(PH2)*v(S2P0)/v(VDD33))/1k
BGPN0 GPN0 VSS I=(v(GPN0)-v(PH2)*(v(VDD33)-v(S2P0))/v(VDD33))/1k
BGNP0 GNP0 VSS I=(v(GNP0)-v(PH2)*v(S2N0)/v(VDD33))/1k
BGNN0 GNN0 VSS I=(v(GNN0)-v(PH2)*(v(VDD33)-v(S2N0))/v(VDD33))/1k
BNOPP0 NGPP0 0 V=v(VDD33)-v(GPP0)
BNOPN0 NGPN0 0 V=v(VDD33)-v(GPN0)
BNONP0 NGNP0 0 V=v(VDD33)-v(GNP0)
BNONN0 NGNN0 0 V=v(VDD33)-v(GNN0)
CGPP0 GPP0 VSS 2p
CGPN0 GPN0 VSS 2p
CGNP0 GNP0 VSS 2p
CGNN0 GNN0 VSS 2p
CNGPP0 NGPP0 VSS 0.2p
CNGPN0 NGPN0 VSS 0.2p
CNGNP0 NGNP0 VSS 0.2p
CNGNN0 NGNN0 VSS 0.2p
XPVP0 CDLP0 VP GPP0 NGPP0 VDD33 VSS gf180_tg_lowq
XPVN0 CDLP0 VN GPN0 NGPN0 VDD33 VSS gf180_tg_lowq
XNVP0 CDLN0 VP GNP0 NGNP0 VDD33 VSS gf180_tg_lowq
XNVN0 CDLN0 VN GNN0 NGNN0 VDD33 VSS gf180_tg_lowq
XDPC0 CDLP0 VCM_REF PH1 NPH1 VDD33 VSS gf180_tg_lowq
XDNC0 CDLN0 VCM_REF PH1 NPH1 VDD33 VSS gf180_tg_lowq
* DAC unit 1
CDP1 CDLP1 CDRP1 {CU}
CDN1 CDLN1 CDRN1 {CU}
XDP11 CDRP1 VCM_REF PH1 NPH1 VDD33 VSS gf180_tg_lowq
XDP21 CDRP1 INP PH2 NPH2 VDD33 VSS gf180_tg_lowq
XDN11 CDRN1 VCM_REF PH1 NPH1 VDD33 VSS gf180_tg_lowq
XDN21 CDRN1 INN PH2 NPH2 VDD33 VSS gf180_tg_lowq
BGPP1 GPP1 VSS I=(v(GPP1)-v(PH2)*v(S2P1)/v(VDD33))/1k
BGPN1 GPN1 VSS I=(v(GPN1)-v(PH2)*(v(VDD33)-v(S2P1))/v(VDD33))/1k
BGNP1 GNP1 VSS I=(v(GNP1)-v(PH2)*v(S2N1)/v(VDD33))/1k
BGNN1 GNN1 VSS I=(v(GNN1)-v(PH2)*(v(VDD33)-v(S2N1))/v(VDD33))/1k
BNOPP1 NGPP1 0 V=v(VDD33)-v(GPP1)
BNOPN1 NGPN1 0 V=v(VDD33)-v(GPN1)
BNONP1 NGNP1 0 V=v(VDD33)-v(GNP1)
BNONN1 NGNN1 0 V=v(VDD33)-v(GNN1)
CGPP1 GPP1 VSS 2p
CGPN1 GPN1 VSS 2p
CGNP1 GNP1 VSS 2p
CGNN1 GNN1 VSS 2p
CNGPP1 NGPP1 VSS 0.2p
CNGPN1 NGPN1 VSS 0.2p
CNGNP1 NGNP1 VSS 0.2p
CNGNN1 NGNN1 VSS 0.2p
XPVP1 CDLP1 VP GPP1 NGPP1 VDD33 VSS gf180_tg_lowq
XPVN1 CDLP1 VN GPN1 NGPN1 VDD33 VSS gf180_tg_lowq
XNVP1 CDLN1 VP GNP1 NGNP1 VDD33 VSS gf180_tg_lowq
XNVN1 CDLN1 VN GNN1 NGNN1 VDD33 VSS gf180_tg_lowq
XDPC1 CDLP1 VCM_REF PH1 NPH1 VDD33 VSS gf180_tg_lowq
XDNC1 CDLN1 VCM_REF PH1 NPH1 VDD33 VSS gf180_tg_lowq
* DAC unit 2
CDP2 CDLP2 CDRP2 {CU}
CDN2 CDLN2 CDRN2 {CU}
XDP12 CDRP2 VCM_REF PH1 NPH1 VDD33 VSS gf180_tg_lowq
XDP22 CDRP2 INP PH2 NPH2 VDD33 VSS gf180_tg_lowq
XDN12 CDRN2 VCM_REF PH1 NPH1 VDD33 VSS gf180_tg_lowq
XDN22 CDRN2 INN PH2 NPH2 VDD33 VSS gf180_tg_lowq
BGPP2 GPP2 VSS I=(v(GPP2)-v(PH2)*v(S2P2)/v(VDD33))/1k
BGPN2 GPN2 VSS I=(v(GPN2)-v(PH2)*(v(VDD33)-v(S2P2))/v(VDD33))/1k
BGNP2 GNP2 VSS I=(v(GNP2)-v(PH2)*v(S2N2)/v(VDD33))/1k
BGNN2 GNN2 VSS I=(v(GNN2)-v(PH2)*(v(VDD33)-v(S2N2))/v(VDD33))/1k
BNOPP2 NGPP2 0 V=v(VDD33)-v(GPP2)
BNOPN2 NGPN2 0 V=v(VDD33)-v(GPN2)
BNONP2 NGNP2 0 V=v(VDD33)-v(GNP2)
BNONN2 NGNN2 0 V=v(VDD33)-v(GNN2)
CGPP2 GPP2 VSS 2p
CGPN2 GPN2 VSS 2p
CGNP2 GNP2 VSS 2p
CGNN2 GNN2 VSS 2p
CNGPP2 NGPP2 VSS 0.2p
CNGPN2 NGPN2 VSS 0.2p
CNGNP2 NGNP2 VSS 0.2p
CNGNN2 NGNN2 VSS 0.2p
XPVP2 CDLP2 VP GPP2 NGPP2 VDD33 VSS gf180_tg_lowq
XPVN2 CDLP2 VN GPN2 NGPN2 VDD33 VSS gf180_tg_lowq
XNVP2 CDLN2 VP GNP2 NGNP2 VDD33 VSS gf180_tg_lowq
XNVN2 CDLN2 VN GNN2 NGNN2 VDD33 VSS gf180_tg_lowq
XDPC2 CDLP2 VCM_REF PH1 NPH1 VDD33 VSS gf180_tg_lowq
XDNC2 CDLN2 VCM_REF PH1 NPH1 VDD33 VSS gf180_tg_lowq
* DAC unit 3
CDP3 CDLP3 CDRP3 {CU}
CDN3 CDLN3 CDRN3 {CU}
XDP13 CDRP3 VCM_REF PH1 NPH1 VDD33 VSS gf180_tg_lowq
XDP23 CDRP3 INP PH2 NPH2 VDD33 VSS gf180_tg_lowq
XDN13 CDRN3 VCM_REF PH1 NPH1 VDD33 VSS gf180_tg_lowq
XDN23 CDRN3 INN PH2 NPH2 VDD33 VSS gf180_tg_lowq
BGPP3 GPP3 VSS I=(v(GPP3)-v(PH2)*v(S2P3)/v(VDD33))/1k
BGPN3 GPN3 VSS I=(v(GPN3)-v(PH2)*(v(VDD33)-v(S2P3))/v(VDD33))/1k
BGNP3 GNP3 VSS I=(v(GNP3)-v(PH2)*v(S2N3)/v(VDD33))/1k
BGNN3 GNN3 VSS I=(v(GNN3)-v(PH2)*(v(VDD33)-v(S2N3))/v(VDD33))/1k
BNOPP3 NGPP3 0 V=v(VDD33)-v(GPP3)
BNOPN3 NGPN3 0 V=v(VDD33)-v(GPN3)
BNONP3 NGNP3 0 V=v(VDD33)-v(GNP3)
BNONN3 NGNN3 0 V=v(VDD33)-v(GNN3)
CGPP3 GPP3 VSS 2p
CGPN3 GPN3 VSS 2p
CGNP3 GNP3 VSS 2p
CGNN3 GNN3 VSS 2p
CNGPP3 NGPP3 VSS 0.2p
CNGPN3 NGPN3 VSS 0.2p
CNGNP3 NGNP3 VSS 0.2p
CNGNN3 NGNN3 VSS 0.2p
XPVP3 CDLP3 VP GPP3 NGPP3 VDD33 VSS gf180_tg_lowq
XPVN3 CDLP3 VN GPN3 NGPN3 VDD33 VSS gf180_tg_lowq
XNVP3 CDLN3 VP GNP3 NGNP3 VDD33 VSS gf180_tg_lowq
XNVN3 CDLN3 VN GNN3 NGNN3 VDD33 VSS gf180_tg_lowq
XDPC3 CDLP3 VCM_REF PH1 NPH1 VDD33 VSS gf180_tg_lowq
XDNC3 CDLN3 VCM_REF PH1 NPH1 VDD33 VSS gf180_tg_lowq
* DAC unit 4
CDP4 CDLP4 CDRP4 {CU}
CDN4 CDLN4 CDRN4 {CU}
XDP14 CDRP4 VCM_REF PH1 NPH1 VDD33 VSS gf180_tg_lowq
XDP24 CDRP4 INP PH2 NPH2 VDD33 VSS gf180_tg_lowq
XDN14 CDRN4 VCM_REF PH1 NPH1 VDD33 VSS gf180_tg_lowq
XDN24 CDRN4 INN PH2 NPH2 VDD33 VSS gf180_tg_lowq
BGPP4 GPP4 VSS I=(v(GPP4)-v(PH2)*v(S2P4)/v(VDD33))/1k
BGPN4 GPN4 VSS I=(v(GPN4)-v(PH2)*(v(VDD33)-v(S2P4))/v(VDD33))/1k
BGNP4 GNP4 VSS I=(v(GNP4)-v(PH2)*v(S2N4)/v(VDD33))/1k
BGNN4 GNN4 VSS I=(v(GNN4)-v(PH2)*(v(VDD33)-v(S2N4))/v(VDD33))/1k
BNOPP4 NGPP4 0 V=v(VDD33)-v(GPP4)
BNOPN4 NGPN4 0 V=v(VDD33)-v(GPN4)
BNONP4 NGNP4 0 V=v(VDD33)-v(GNP4)
BNONN4 NGNN4 0 V=v(VDD33)-v(GNN4)
CGPP4 GPP4 VSS 2p
CGPN4 GPN4 VSS 2p
CGNP4 GNP4 VSS 2p
CGNN4 GNN4 VSS 2p
CNGPP4 NGPP4 VSS 0.2p
CNGPN4 NGPN4 VSS 0.2p
CNGNP4 NGNP4 VSS 0.2p
CNGNN4 NGNN4 VSS 0.2p
XPVP4 CDLP4 VP GPP4 NGPP4 VDD33 VSS gf180_tg_lowq
XPVN4 CDLP4 VN GPN4 NGPN4 VDD33 VSS gf180_tg_lowq
XNVP4 CDLN4 VP GNP4 NGNP4 VDD33 VSS gf180_tg_lowq
XNVN4 CDLN4 VN GNN4 NGNN4 VDD33 VSS gf180_tg_lowq
XDPC4 CDLP4 VCM_REF PH1 NPH1 VDD33 VSS gf180_tg_lowq
XDNC4 CDLN4 VCM_REF PH1 NPH1 VDD33 VSS gf180_tg_lowq
* DAC unit 5
CDP5 CDLP5 CDRP5 {CU}
CDN5 CDLN5 CDRN5 {CU}
XDP15 CDRP5 VCM_REF PH1 NPH1 VDD33 VSS gf180_tg_lowq
XDP25 CDRP5 INP PH2 NPH2 VDD33 VSS gf180_tg_lowq
XDN15 CDRN5 VCM_REF PH1 NPH1 VDD33 VSS gf180_tg_lowq
XDN25 CDRN5 INN PH2 NPH2 VDD33 VSS gf180_tg_lowq
BGPP5 GPP5 VSS I=(v(GPP5)-v(PH2)*v(S2P5)/v(VDD33))/1k
BGPN5 GPN5 VSS I=(v(GPN5)-v(PH2)*(v(VDD33)-v(S2P5))/v(VDD33))/1k
BGNP5 GNP5 VSS I=(v(GNP5)-v(PH2)*v(S2N5)/v(VDD33))/1k
BGNN5 GNN5 VSS I=(v(GNN5)-v(PH2)*(v(VDD33)-v(S2N5))/v(VDD33))/1k
BNOPP5 NGPP5 0 V=v(VDD33)-v(GPP5)
BNOPN5 NGPN5 0 V=v(VDD33)-v(GPN5)
BNONP5 NGNP5 0 V=v(VDD33)-v(GNP5)
BNONN5 NGNN5 0 V=v(VDD33)-v(GNN5)
CGPP5 GPP5 VSS 2p
CGPN5 GPN5 VSS 2p
CGNP5 GNP5 VSS 2p
CGNN5 GNN5 VSS 2p
CNGPP5 NGPP5 VSS 0.2p
CNGPN5 NGPN5 VSS 0.2p
CNGNP5 NGNP5 VSS 0.2p
CNGNN5 NGNN5 VSS 0.2p
XPVP5 CDLP5 VP GPP5 NGPP5 VDD33 VSS gf180_tg_lowq
XPVN5 CDLP5 VN GPN5 NGPN5 VDD33 VSS gf180_tg_lowq
XNVP5 CDLN5 VP GNP5 NGNP5 VDD33 VSS gf180_tg_lowq
XNVN5 CDLN5 VN GNN5 NGNN5 VDD33 VSS gf180_tg_lowq
XDPC5 CDLP5 VCM_REF PH1 NPH1 VDD33 VSS gf180_tg_lowq
XDNC5 CDLN5 VCM_REF PH1 NPH1 VDD33 VSS gf180_tg_lowq
* DAC unit 6
CDP6 CDLP6 CDRP6 {CU}
CDN6 CDLN6 CDRN6 {CU}
XDP16 CDRP6 VCM_REF PH1 NPH1 VDD33 VSS gf180_tg_lowq
XDP26 CDRP6 INP PH2 NPH2 VDD33 VSS gf180_tg_lowq
XDN16 CDRN6 VCM_REF PH1 NPH1 VDD33 VSS gf180_tg_lowq
XDN26 CDRN6 INN PH2 NPH2 VDD33 VSS gf180_tg_lowq
BGPP6 GPP6 VSS I=(v(GPP6)-v(PH2)*v(S2P6)/v(VDD33))/1k
BGPN6 GPN6 VSS I=(v(GPN6)-v(PH2)*(v(VDD33)-v(S2P6))/v(VDD33))/1k
BGNP6 GNP6 VSS I=(v(GNP6)-v(PH2)*v(S2N6)/v(VDD33))/1k
BGNN6 GNN6 VSS I=(v(GNN6)-v(PH2)*(v(VDD33)-v(S2N6))/v(VDD33))/1k
BNOPP6 NGPP6 0 V=v(VDD33)-v(GPP6)
BNOPN6 NGPN6 0 V=v(VDD33)-v(GPN6)
BNONP6 NGNP6 0 V=v(VDD33)-v(GNP6)
BNONN6 NGNN6 0 V=v(VDD33)-v(GNN6)
CGPP6 GPP6 VSS 2p
CGPN6 GPN6 VSS 2p
CGNP6 GNP6 VSS 2p
CGNN6 GNN6 VSS 2p
CNGPP6 NGPP6 VSS 0.2p
CNGPN6 NGPN6 VSS 0.2p
CNGNP6 NGNP6 VSS 0.2p
CNGNN6 NGNN6 VSS 0.2p
XPVP6 CDLP6 VP GPP6 NGPP6 VDD33 VSS gf180_tg_lowq
XPVN6 CDLP6 VN GPN6 NGPN6 VDD33 VSS gf180_tg_lowq
XNVP6 CDLN6 VP GNP6 NGNP6 VDD33 VSS gf180_tg_lowq
XNVN6 CDLN6 VN GNN6 NGNN6 VDD33 VSS gf180_tg_lowq
XDPC6 CDLP6 VCM_REF PH1 NPH1 VDD33 VSS gf180_tg_lowq
XDNC6 CDLN6 VCM_REF PH1 NPH1 VDD33 VSS gf180_tg_lowq
* DAC unit 7
CDP7 CDLP7 CDRP7 {CU}
CDN7 CDLN7 CDRN7 {CU}
XDP17 CDRP7 VCM_REF PH1 NPH1 VDD33 VSS gf180_tg_lowq
XDP27 CDRP7 INP PH2 NPH2 VDD33 VSS gf180_tg_lowq
XDN17 CDRN7 VCM_REF PH1 NPH1 VDD33 VSS gf180_tg_lowq
XDN27 CDRN7 INN PH2 NPH2 VDD33 VSS gf180_tg_lowq
BGPP7 GPP7 VSS I=(v(GPP7)-v(PH2)*v(S2P7)/v(VDD33))/1k
BGPN7 GPN7 VSS I=(v(GPN7)-v(PH2)*(v(VDD33)-v(S2P7))/v(VDD33))/1k
BGNP7 GNP7 VSS I=(v(GNP7)-v(PH2)*v(S2N7)/v(VDD33))/1k
BGNN7 GNN7 VSS I=(v(GNN7)-v(PH2)*(v(VDD33)-v(S2N7))/v(VDD33))/1k
BNOPP7 NGPP7 0 V=v(VDD33)-v(GPP7)
BNOPN7 NGPN7 0 V=v(VDD33)-v(GPN7)
BNONP7 NGNP7 0 V=v(VDD33)-v(GNP7)
BNONN7 NGNN7 0 V=v(VDD33)-v(GNN7)
CGPP7 GPP7 VSS 2p
CGPN7 GPN7 VSS 2p
CGNP7 GNP7 VSS 2p
CGNN7 GNN7 VSS 2p
CNGPP7 NGPP7 VSS 0.2p
CNGPN7 NGPN7 VSS 0.2p
CNGNP7 NGNP7 VSS 0.2p
CNGNN7 NGNN7 VSS 0.2p
XPVP7 CDLP7 VP GPP7 NGPP7 VDD33 VSS gf180_tg_lowq
XPVN7 CDLP7 VN GPN7 NGPN7 VDD33 VSS gf180_tg_lowq
XNVP7 CDLN7 VP GNP7 NGNP7 VDD33 VSS gf180_tg_lowq
XNVN7 CDLN7 VN GNN7 NGNN7 VDD33 VSS gf180_tg_lowq
XDPC7 CDLP7 VCM_REF PH1 NPH1 VDD33 VSS gf180_tg_lowq
XDNC7 CDLN7 VCM_REF PH1 NPH1 VDD33 VSS gf180_tg_lowq
* DAC unit 8
CDP8 CDLP8 CDRP8 {CU}
CDN8 CDLN8 CDRN8 {CU}
XDP18 CDRP8 VCM_REF PH1 NPH1 VDD33 VSS gf180_tg_lowq
XDP28 CDRP8 INP PH2 NPH2 VDD33 VSS gf180_tg_lowq
XDN18 CDRN8 VCM_REF PH1 NPH1 VDD33 VSS gf180_tg_lowq
XDN28 CDRN8 INN PH2 NPH2 VDD33 VSS gf180_tg_lowq
BGPP8 GPP8 VSS I=(v(GPP8)-v(PH2)*v(S2P8)/v(VDD33))/1k
BGPN8 GPN8 VSS I=(v(GPN8)-v(PH2)*(v(VDD33)-v(S2P8))/v(VDD33))/1k
BGNP8 GNP8 VSS I=(v(GNP8)-v(PH2)*v(S2N8)/v(VDD33))/1k
BGNN8 GNN8 VSS I=(v(GNN8)-v(PH2)*(v(VDD33)-v(S2N8))/v(VDD33))/1k
BNOPP8 NGPP8 0 V=v(VDD33)-v(GPP8)
BNOPN8 NGPN8 0 V=v(VDD33)-v(GPN8)
BNONP8 NGNP8 0 V=v(VDD33)-v(GNP8)
BNONN8 NGNN8 0 V=v(VDD33)-v(GNN8)
CGPP8 GPP8 VSS 2p
CGPN8 GPN8 VSS 2p
CGNP8 GNP8 VSS 2p
CGNN8 GNN8 VSS 2p
CNGPP8 NGPP8 VSS 0.2p
CNGPN8 NGPN8 VSS 0.2p
CNGNP8 NGNP8 VSS 0.2p
CNGNN8 NGNN8 VSS 0.2p
XPVP8 CDLP8 VP GPP8 NGPP8 VDD33 VSS gf180_tg_lowq
XPVN8 CDLP8 VN GPN8 NGPN8 VDD33 VSS gf180_tg_lowq
XNVP8 CDLN8 VP GNP8 NGNP8 VDD33 VSS gf180_tg_lowq
XNVN8 CDLN8 VN GNN8 NGNN8 VDD33 VSS gf180_tg_lowq
XDPC8 CDLP8 VCM_REF PH1 NPH1 VDD33 VSS gf180_tg_lowq
XDNC8 CDLN8 VCM_REF PH1 NPH1 VDD33 VSS gf180_tg_lowq
* DAC unit 9
CDP9 CDLP9 CDRP9 {CU}
CDN9 CDLN9 CDRN9 {CU}
XDP19 CDRP9 VCM_REF PH1 NPH1 VDD33 VSS gf180_tg_lowq
XDP29 CDRP9 INP PH2 NPH2 VDD33 VSS gf180_tg_lowq
XDN19 CDRN9 VCM_REF PH1 NPH1 VDD33 VSS gf180_tg_lowq
XDN29 CDRN9 INN PH2 NPH2 VDD33 VSS gf180_tg_lowq
BGPP9 GPP9 VSS I=(v(GPP9)-v(PH2)*v(S2P9)/v(VDD33))/1k
BGPN9 GPN9 VSS I=(v(GPN9)-v(PH2)*(v(VDD33)-v(S2P9))/v(VDD33))/1k
BGNP9 GNP9 VSS I=(v(GNP9)-v(PH2)*v(S2N9)/v(VDD33))/1k
BGNN9 GNN9 VSS I=(v(GNN9)-v(PH2)*(v(VDD33)-v(S2N9))/v(VDD33))/1k
BNOPP9 NGPP9 0 V=v(VDD33)-v(GPP9)
BNOPN9 NGPN9 0 V=v(VDD33)-v(GPN9)
BNONP9 NGNP9 0 V=v(VDD33)-v(GNP9)
BNONN9 NGNN9 0 V=v(VDD33)-v(GNN9)
CGPP9 GPP9 VSS 2p
CGPN9 GPN9 VSS 2p
CGNP9 GNP9 VSS 2p
CGNN9 GNN9 VSS 2p
CNGPP9 NGPP9 VSS 0.2p
CNGPN9 NGPN9 VSS 0.2p
CNGNP9 NGNP9 VSS 0.2p
CNGNN9 NGNN9 VSS 0.2p
XPVP9 CDLP9 VP GPP9 NGPP9 VDD33 VSS gf180_tg_lowq
XPVN9 CDLP9 VN GPN9 NGPN9 VDD33 VSS gf180_tg_lowq
XNVP9 CDLN9 VP GNP9 NGNP9 VDD33 VSS gf180_tg_lowq
XNVN9 CDLN9 VN GNN9 NGNN9 VDD33 VSS gf180_tg_lowq
XDPC9 CDLP9 VCM_REF PH1 NPH1 VDD33 VSS gf180_tg_lowq
XDNC9 CDLN9 VCM_REF PH1 NPH1 VDD33 VSS gf180_tg_lowq
* DAC unit 10
CDP10 CDLP10 CDRP10 {CU}
CDN10 CDLN10 CDRN10 {CU}
XDP110 CDRP10 VCM_REF PH1 NPH1 VDD33 VSS gf180_tg_lowq
XDP210 CDRP10 INP PH2 NPH2 VDD33 VSS gf180_tg_lowq
XDN110 CDRN10 VCM_REF PH1 NPH1 VDD33 VSS gf180_tg_lowq
XDN210 CDRN10 INN PH2 NPH2 VDD33 VSS gf180_tg_lowq
BGPP10 GPP10 VSS I=(v(GPP10)-v(PH2)*v(S2P10)/v(VDD33))/1k
BGPN10 GPN10 VSS I=(v(GPN10)-v(PH2)*(v(VDD33)-v(S2P10))/v(VDD33))/1k
BGNP10 GNP10 VSS I=(v(GNP10)-v(PH2)*v(S2N10)/v(VDD33))/1k
BGNN10 GNN10 VSS I=(v(GNN10)-v(PH2)*(v(VDD33)-v(S2N10))/v(VDD33))/1k
BNOPP10 NGPP10 0 V=v(VDD33)-v(GPP10)
BNOPN10 NGPN10 0 V=v(VDD33)-v(GPN10)
BNONP10 NGNP10 0 V=v(VDD33)-v(GNP10)
BNONN10 NGNN10 0 V=v(VDD33)-v(GNN10)
CGPP10 GPP10 VSS 2p
CGPN10 GPN10 VSS 2p
CGNP10 GNP10 VSS 2p
CGNN10 GNN10 VSS 2p
CNGPP10 NGPP10 VSS 0.2p
CNGPN10 NGPN10 VSS 0.2p
CNGNP10 NGNP10 VSS 0.2p
CNGNN10 NGNN10 VSS 0.2p
XPVP10 CDLP10 VP GPP10 NGPP10 VDD33 VSS gf180_tg_lowq
XPVN10 CDLP10 VN GPN10 NGPN10 VDD33 VSS gf180_tg_lowq
XNVP10 CDLN10 VP GNP10 NGNP10 VDD33 VSS gf180_tg_lowq
XNVN10 CDLN10 VN GNN10 NGNN10 VDD33 VSS gf180_tg_lowq
XDPC10 CDLP10 VCM_REF PH1 NPH1 VDD33 VSS gf180_tg_lowq
XDNC10 CDLN10 VCM_REF PH1 NPH1 VDD33 VSS gf180_tg_lowq
* DAC unit 11
CDP11 CDLP11 CDRP11 {CU}
CDN11 CDLN11 CDRN11 {CU}
XDP111 CDRP11 VCM_REF PH1 NPH1 VDD33 VSS gf180_tg_lowq
XDP211 CDRP11 INP PH2 NPH2 VDD33 VSS gf180_tg_lowq
XDN111 CDRN11 VCM_REF PH1 NPH1 VDD33 VSS gf180_tg_lowq
XDN211 CDRN11 INN PH2 NPH2 VDD33 VSS gf180_tg_lowq
BGPP11 GPP11 VSS I=(v(GPP11)-v(PH2)*v(S2P11)/v(VDD33))/1k
BGPN11 GPN11 VSS I=(v(GPN11)-v(PH2)*(v(VDD33)-v(S2P11))/v(VDD33))/1k
BGNP11 GNP11 VSS I=(v(GNP11)-v(PH2)*v(S2N11)/v(VDD33))/1k
BGNN11 GNN11 VSS I=(v(GNN11)-v(PH2)*(v(VDD33)-v(S2N11))/v(VDD33))/1k
BNOPP11 NGPP11 0 V=v(VDD33)-v(GPP11)
BNOPN11 NGPN11 0 V=v(VDD33)-v(GPN11)
BNONP11 NGNP11 0 V=v(VDD33)-v(GNP11)
BNONN11 NGNN11 0 V=v(VDD33)-v(GNN11)
CGPP11 GPP11 VSS 2p
CGPN11 GPN11 VSS 2p
CGNP11 GNP11 VSS 2p
CGNN11 GNN11 VSS 2p
CNGPP11 NGPP11 VSS 0.2p
CNGPN11 NGPN11 VSS 0.2p
CNGNP11 NGNP11 VSS 0.2p
CNGNN11 NGNN11 VSS 0.2p
XPVP11 CDLP11 VP GPP11 NGPP11 VDD33 VSS gf180_tg_lowq
XPVN11 CDLP11 VN GPN11 NGPN11 VDD33 VSS gf180_tg_lowq
XNVP11 CDLN11 VP GNP11 NGNP11 VDD33 VSS gf180_tg_lowq
XNVN11 CDLN11 VN GNN11 NGNN11 VDD33 VSS gf180_tg_lowq
XDPC11 CDLP11 VCM_REF PH1 NPH1 VDD33 VSS gf180_tg_lowq
XDNC11 CDLN11 VCM_REF PH1 NPH1 VDD33 VSS gf180_tg_lowq
* DAC unit 12
CDP12 CDLP12 CDRP12 {CU}
CDN12 CDLN12 CDRN12 {CU}
XDP112 CDRP12 VCM_REF PH1 NPH1 VDD33 VSS gf180_tg_lowq
XDP212 CDRP12 INP PH2 NPH2 VDD33 VSS gf180_tg_lowq
XDN112 CDRN12 VCM_REF PH1 NPH1 VDD33 VSS gf180_tg_lowq
XDN212 CDRN12 INN PH2 NPH2 VDD33 VSS gf180_tg_lowq
BGPP12 GPP12 VSS I=(v(GPP12)-v(PH2)*v(S2P12)/v(VDD33))/1k
BGPN12 GPN12 VSS I=(v(GPN12)-v(PH2)*(v(VDD33)-v(S2P12))/v(VDD33))/1k
BGNP12 GNP12 VSS I=(v(GNP12)-v(PH2)*v(S2N12)/v(VDD33))/1k
BGNN12 GNN12 VSS I=(v(GNN12)-v(PH2)*(v(VDD33)-v(S2N12))/v(VDD33))/1k
BNOPP12 NGPP12 0 V=v(VDD33)-v(GPP12)
BNOPN12 NGPN12 0 V=v(VDD33)-v(GPN12)
BNONP12 NGNP12 0 V=v(VDD33)-v(GNP12)
BNONN12 NGNN12 0 V=v(VDD33)-v(GNN12)
CGPP12 GPP12 VSS 2p
CGPN12 GPN12 VSS 2p
CGNP12 GNP12 VSS 2p
CGNN12 GNN12 VSS 2p
CNGPP12 NGPP12 VSS 0.2p
CNGPN12 NGPN12 VSS 0.2p
CNGNP12 NGNP12 VSS 0.2p
CNGNN12 NGNN12 VSS 0.2p
XPVP12 CDLP12 VP GPP12 NGPP12 VDD33 VSS gf180_tg_lowq
XPVN12 CDLP12 VN GPN12 NGPN12 VDD33 VSS gf180_tg_lowq
XNVP12 CDLN12 VP GNP12 NGNP12 VDD33 VSS gf180_tg_lowq
XNVN12 CDLN12 VN GNN12 NGNN12 VDD33 VSS gf180_tg_lowq
XDPC12 CDLP12 VCM_REF PH1 NPH1 VDD33 VSS gf180_tg_lowq
XDNC12 CDLN12 VCM_REF PH1 NPH1 VDD33 VSS gf180_tg_lowq
* DAC unit 13
CDP13 CDLP13 CDRP13 {CU}
CDN13 CDLN13 CDRN13 {CU}
XDP113 CDRP13 VCM_REF PH1 NPH1 VDD33 VSS gf180_tg_lowq
XDP213 CDRP13 INP PH2 NPH2 VDD33 VSS gf180_tg_lowq
XDN113 CDRN13 VCM_REF PH1 NPH1 VDD33 VSS gf180_tg_lowq
XDN213 CDRN13 INN PH2 NPH2 VDD33 VSS gf180_tg_lowq
BGPP13 GPP13 VSS I=(v(GPP13)-v(PH2)*v(S2P13)/v(VDD33))/1k
BGPN13 GPN13 VSS I=(v(GPN13)-v(PH2)*(v(VDD33)-v(S2P13))/v(VDD33))/1k
BGNP13 GNP13 VSS I=(v(GNP13)-v(PH2)*v(S2N13)/v(VDD33))/1k
BGNN13 GNN13 VSS I=(v(GNN13)-v(PH2)*(v(VDD33)-v(S2N13))/v(VDD33))/1k
BNOPP13 NGPP13 0 V=v(VDD33)-v(GPP13)
BNOPN13 NGPN13 0 V=v(VDD33)-v(GPN13)
BNONP13 NGNP13 0 V=v(VDD33)-v(GNP13)
BNONN13 NGNN13 0 V=v(VDD33)-v(GNN13)
CGPP13 GPP13 VSS 2p
CGPN13 GPN13 VSS 2p
CGNP13 GNP13 VSS 2p
CGNN13 GNN13 VSS 2p
CNGPP13 NGPP13 VSS 0.2p
CNGPN13 NGPN13 VSS 0.2p
CNGNP13 NGNP13 VSS 0.2p
CNGNN13 NGNN13 VSS 0.2p
XPVP13 CDLP13 VP GPP13 NGPP13 VDD33 VSS gf180_tg_lowq
XPVN13 CDLP13 VN GPN13 NGPN13 VDD33 VSS gf180_tg_lowq
XNVP13 CDLN13 VP GNP13 NGNP13 VDD33 VSS gf180_tg_lowq
XNVN13 CDLN13 VN GNN13 NGNN13 VDD33 VSS gf180_tg_lowq
XDPC13 CDLP13 VCM_REF PH1 NPH1 VDD33 VSS gf180_tg_lowq
XDNC13 CDLN13 VCM_REF PH1 NPH1 VDD33 VSS gf180_tg_lowq
* DAC unit 14
CDP14 CDLP14 CDRP14 {CU}
CDN14 CDLN14 CDRN14 {CU}
XDP114 CDRP14 VCM_REF PH1 NPH1 VDD33 VSS gf180_tg_lowq
XDP214 CDRP14 INP PH2 NPH2 VDD33 VSS gf180_tg_lowq
XDN114 CDRN14 VCM_REF PH1 NPH1 VDD33 VSS gf180_tg_lowq
XDN214 CDRN14 INN PH2 NPH2 VDD33 VSS gf180_tg_lowq
BGPP14 GPP14 VSS I=(v(GPP14)-v(PH2)*v(S2P14)/v(VDD33))/1k
BGPN14 GPN14 VSS I=(v(GPN14)-v(PH2)*(v(VDD33)-v(S2P14))/v(VDD33))/1k
BGNP14 GNP14 VSS I=(v(GNP14)-v(PH2)*v(S2N14)/v(VDD33))/1k
BGNN14 GNN14 VSS I=(v(GNN14)-v(PH2)*(v(VDD33)-v(S2N14))/v(VDD33))/1k
BNOPP14 NGPP14 0 V=v(VDD33)-v(GPP14)
BNOPN14 NGPN14 0 V=v(VDD33)-v(GPN14)
BNONP14 NGNP14 0 V=v(VDD33)-v(GNP14)
BNONN14 NGNN14 0 V=v(VDD33)-v(GNN14)
CGPP14 GPP14 VSS 2p
CGPN14 GPN14 VSS 2p
CGNP14 GNP14 VSS 2p
CGNN14 GNN14 VSS 2p
CNGPP14 NGPP14 VSS 0.2p
CNGPN14 NGPN14 VSS 0.2p
CNGNP14 NGNP14 VSS 0.2p
CNGNN14 NGNN14 VSS 0.2p
XPVP14 CDLP14 VP GPP14 NGPP14 VDD33 VSS gf180_tg_lowq
XPVN14 CDLP14 VN GPN14 NGPN14 VDD33 VSS gf180_tg_lowq
XNVP14 CDLN14 VP GNP14 NGNP14 VDD33 VSS gf180_tg_lowq
XNVN14 CDLN14 VN GNN14 NGNN14 VDD33 VSS gf180_tg_lowq
XDPC14 CDLP14 VCM_REF PH1 NPH1 VDD33 VSS gf180_tg_lowq
XDNC14 CDLN14 VCM_REF PH1 NPH1 VDD33 VSS gf180_tg_lowq
* DAC unit 15
CDP15 CDLP15 CDRP15 {CU}
CDN15 CDLN15 CDRN15 {CU}
XDP115 CDRP15 VCM_REF PH1 NPH1 VDD33 VSS gf180_tg_lowq
XDP215 CDRP15 INP PH2 NPH2 VDD33 VSS gf180_tg_lowq
XDN115 CDRN15 VCM_REF PH1 NPH1 VDD33 VSS gf180_tg_lowq
XDN215 CDRN15 INN PH2 NPH2 VDD33 VSS gf180_tg_lowq
BGPP15 GPP15 VSS I=(v(GPP15)-v(PH2)*v(S2P15)/v(VDD33))/1k
BGPN15 GPN15 VSS I=(v(GPN15)-v(PH2)*(v(VDD33)-v(S2P15))/v(VDD33))/1k
BGNP15 GNP15 VSS I=(v(GNP15)-v(PH2)*v(S2N15)/v(VDD33))/1k
BGNN15 GNN15 VSS I=(v(GNN15)-v(PH2)*(v(VDD33)-v(S2N15))/v(VDD33))/1k
BNOPP15 NGPP15 0 V=v(VDD33)-v(GPP15)
BNOPN15 NGPN15 0 V=v(VDD33)-v(GPN15)
BNONP15 NGNP15 0 V=v(VDD33)-v(GNP15)
BNONN15 NGNN15 0 V=v(VDD33)-v(GNN15)
CGPP15 GPP15 VSS 2p
CGPN15 GPN15 VSS 2p
CGNP15 GNP15 VSS 2p
CGNN15 GNN15 VSS 2p
CNGPP15 NGPP15 VSS 0.2p
CNGPN15 NGPN15 VSS 0.2p
CNGNP15 NGNP15 VSS 0.2p
CNGNN15 NGNN15 VSS 0.2p
XPVP15 CDLP15 VP GPP15 NGPP15 VDD33 VSS gf180_tg_lowq
XPVN15 CDLP15 VN GPN15 NGPN15 VDD33 VSS gf180_tg_lowq
XNVP15 CDLN15 VP GNP15 NGNP15 VDD33 VSS gf180_tg_lowq
XNVN15 CDLN15 VN GNN15 NGNN15 VDD33 VSS gf180_tg_lowq
XDPC15 CDLP15 VCM_REF PH1 NPH1 VDD33 VSS gf180_tg_lowq
XDNC15 CDLN15 VCM_REF PH1 NPH1 VDD33 VSS gf180_tg_lowq
* DAC unit 16
CDP16 CDLP16 CDRP16 {CU}
CDN16 CDLN16 CDRN16 {CU}
XDP116 CDRP16 VCM_REF PH1 NPH1 VDD33 VSS gf180_tg_lowq
XDP216 CDRP16 INP PH2 NPH2 VDD33 VSS gf180_tg_lowq
XDN116 CDRN16 VCM_REF PH1 NPH1 VDD33 VSS gf180_tg_lowq
XDN216 CDRN16 INN PH2 NPH2 VDD33 VSS gf180_tg_lowq
BGPP16 GPP16 VSS I=(v(GPP16)-v(PH2)*v(S2P16)/v(VDD33))/1k
BGPN16 GPN16 VSS I=(v(GPN16)-v(PH2)*(v(VDD33)-v(S2P16))/v(VDD33))/1k
BGNP16 GNP16 VSS I=(v(GNP16)-v(PH2)*v(S2N16)/v(VDD33))/1k
BGNN16 GNN16 VSS I=(v(GNN16)-v(PH2)*(v(VDD33)-v(S2N16))/v(VDD33))/1k
BNOPP16 NGPP16 0 V=v(VDD33)-v(GPP16)
BNOPN16 NGPN16 0 V=v(VDD33)-v(GPN16)
BNONP16 NGNP16 0 V=v(VDD33)-v(GNP16)
BNONN16 NGNN16 0 V=v(VDD33)-v(GNN16)
CGPP16 GPP16 VSS 2p
CGPN16 GPN16 VSS 2p
CGNP16 GNP16 VSS 2p
CGNN16 GNN16 VSS 2p
CNGPP16 NGPP16 VSS 0.2p
CNGPN16 NGPN16 VSS 0.2p
CNGNP16 NGNP16 VSS 0.2p
CNGNN16 NGNN16 VSS 0.2p
XPVP16 CDLP16 VP GPP16 NGPP16 VDD33 VSS gf180_tg_lowq
XPVN16 CDLP16 VN GPN16 NGPN16 VDD33 VSS gf180_tg_lowq
XNVP16 CDLN16 VP GNP16 NGNP16 VDD33 VSS gf180_tg_lowq
XNVN16 CDLN16 VN GNN16 NGNN16 VDD33 VSS gf180_tg_lowq
XDPC16 CDLP16 VCM_REF PH1 NPH1 VDD33 VSS gf180_tg_lowq
XDNC16 CDLN16 VCM_REF PH1 NPH1 VDD33 VSS gf180_tg_lowq
* DAC unit 17
CDP17 CDLP17 CDRP17 {CU}
CDN17 CDLN17 CDRN17 {CU}
XDP117 CDRP17 VCM_REF PH1 NPH1 VDD33 VSS gf180_tg_lowq
XDP217 CDRP17 INP PH2 NPH2 VDD33 VSS gf180_tg_lowq
XDN117 CDRN17 VCM_REF PH1 NPH1 VDD33 VSS gf180_tg_lowq
XDN217 CDRN17 INN PH2 NPH2 VDD33 VSS gf180_tg_lowq
BGPP17 GPP17 VSS I=(v(GPP17)-v(PH2)*v(S2P17)/v(VDD33))/1k
BGPN17 GPN17 VSS I=(v(GPN17)-v(PH2)*(v(VDD33)-v(S2P17))/v(VDD33))/1k
BGNP17 GNP17 VSS I=(v(GNP17)-v(PH2)*v(S2N17)/v(VDD33))/1k
BGNN17 GNN17 VSS I=(v(GNN17)-v(PH2)*(v(VDD33)-v(S2N17))/v(VDD33))/1k
BNOPP17 NGPP17 0 V=v(VDD33)-v(GPP17)
BNOPN17 NGPN17 0 V=v(VDD33)-v(GPN17)
BNONP17 NGNP17 0 V=v(VDD33)-v(GNP17)
BNONN17 NGNN17 0 V=v(VDD33)-v(GNN17)
CGPP17 GPP17 VSS 2p
CGPN17 GPN17 VSS 2p
CGNP17 GNP17 VSS 2p
CGNN17 GNN17 VSS 2p
CNGPP17 NGPP17 VSS 0.2p
CNGPN17 NGPN17 VSS 0.2p
CNGNP17 NGNP17 VSS 0.2p
CNGNN17 NGNN17 VSS 0.2p
XPVP17 CDLP17 VP GPP17 NGPP17 VDD33 VSS gf180_tg_lowq
XPVN17 CDLP17 VN GPN17 NGPN17 VDD33 VSS gf180_tg_lowq
XNVP17 CDLN17 VP GNP17 NGNP17 VDD33 VSS gf180_tg_lowq
XNVN17 CDLN17 VN GNN17 NGNN17 VDD33 VSS gf180_tg_lowq
XDPC17 CDLP17 VCM_REF PH1 NPH1 VDD33 VSS gf180_tg_lowq
XDNC17 CDLN17 VCM_REF PH1 NPH1 VDD33 VSS gf180_tg_lowq
* DAC unit 18
CDP18 CDLP18 CDRP18 {CU}
CDN18 CDLN18 CDRN18 {CU}
XDP118 CDRP18 VCM_REF PH1 NPH1 VDD33 VSS gf180_tg_lowq
XDP218 CDRP18 INP PH2 NPH2 VDD33 VSS gf180_tg_lowq
XDN118 CDRN18 VCM_REF PH1 NPH1 VDD33 VSS gf180_tg_lowq
XDN218 CDRN18 INN PH2 NPH2 VDD33 VSS gf180_tg_lowq
BGPP18 GPP18 VSS I=(v(GPP18)-v(PH2)*v(S2P18)/v(VDD33))/1k
BGPN18 GPN18 VSS I=(v(GPN18)-v(PH2)*(v(VDD33)-v(S2P18))/v(VDD33))/1k
BGNP18 GNP18 VSS I=(v(GNP18)-v(PH2)*v(S2N18)/v(VDD33))/1k
BGNN18 GNN18 VSS I=(v(GNN18)-v(PH2)*(v(VDD33)-v(S2N18))/v(VDD33))/1k
BNOPP18 NGPP18 0 V=v(VDD33)-v(GPP18)
BNOPN18 NGPN18 0 V=v(VDD33)-v(GPN18)
BNONP18 NGNP18 0 V=v(VDD33)-v(GNP18)
BNONN18 NGNN18 0 V=v(VDD33)-v(GNN18)
CGPP18 GPP18 VSS 2p
CGPN18 GPN18 VSS 2p
CGNP18 GNP18 VSS 2p
CGNN18 GNN18 VSS 2p
CNGPP18 NGPP18 VSS 0.2p
CNGPN18 NGPN18 VSS 0.2p
CNGNP18 NGNP18 VSS 0.2p
CNGNN18 NGNN18 VSS 0.2p
XPVP18 CDLP18 VP GPP18 NGPP18 VDD33 VSS gf180_tg_lowq
XPVN18 CDLP18 VN GPN18 NGPN18 VDD33 VSS gf180_tg_lowq
XNVP18 CDLN18 VP GNP18 NGNP18 VDD33 VSS gf180_tg_lowq
XNVN18 CDLN18 VN GNN18 NGNN18 VDD33 VSS gf180_tg_lowq
XDPC18 CDLP18 VCM_REF PH1 NPH1 VDD33 VSS gf180_tg_lowq
XDNC18 CDLN18 VCM_REF PH1 NPH1 VDD33 VSS gf180_tg_lowq
* DAC unit 19
CDP19 CDLP19 CDRP19 {CU}
CDN19 CDLN19 CDRN19 {CU}
XDP119 CDRP19 VCM_REF PH1 NPH1 VDD33 VSS gf180_tg_lowq
XDP219 CDRP19 INP PH2 NPH2 VDD33 VSS gf180_tg_lowq
XDN119 CDRN19 VCM_REF PH1 NPH1 VDD33 VSS gf180_tg_lowq
XDN219 CDRN19 INN PH2 NPH2 VDD33 VSS gf180_tg_lowq
BGPP19 GPP19 VSS I=(v(GPP19)-v(PH2)*v(S2P19)/v(VDD33))/1k
BGPN19 GPN19 VSS I=(v(GPN19)-v(PH2)*(v(VDD33)-v(S2P19))/v(VDD33))/1k
BGNP19 GNP19 VSS I=(v(GNP19)-v(PH2)*v(S2N19)/v(VDD33))/1k
BGNN19 GNN19 VSS I=(v(GNN19)-v(PH2)*(v(VDD33)-v(S2N19))/v(VDD33))/1k
BNOPP19 NGPP19 0 V=v(VDD33)-v(GPP19)
BNOPN19 NGPN19 0 V=v(VDD33)-v(GPN19)
BNONP19 NGNP19 0 V=v(VDD33)-v(GNP19)
BNONN19 NGNN19 0 V=v(VDD33)-v(GNN19)
CGPP19 GPP19 VSS 2p
CGPN19 GPN19 VSS 2p
CGNP19 GNP19 VSS 2p
CGNN19 GNN19 VSS 2p
CNGPP19 NGPP19 VSS 0.2p
CNGPN19 NGPN19 VSS 0.2p
CNGNP19 NGNP19 VSS 0.2p
CNGNN19 NGNN19 VSS 0.2p
XPVP19 CDLP19 VP GPP19 NGPP19 VDD33 VSS gf180_tg_lowq
XPVN19 CDLP19 VN GPN19 NGPN19 VDD33 VSS gf180_tg_lowq
XNVP19 CDLN19 VP GNP19 NGNP19 VDD33 VSS gf180_tg_lowq
XNVN19 CDLN19 VN GNN19 NGNN19 VDD33 VSS gf180_tg_lowq
XDPC19 CDLP19 VCM_REF PH1 NPH1 VDD33 VSS gf180_tg_lowq
XDNC19 CDLN19 VCM_REF PH1 NPH1 VDD33 VSS gf180_tg_lowq
* DAC unit 20
CDP20 CDLP20 CDRP20 {CU}
CDN20 CDLN20 CDRN20 {CU}
XDP120 CDRP20 VCM_REF PH1 NPH1 VDD33 VSS gf180_tg_lowq
XDP220 CDRP20 INP PH2 NPH2 VDD33 VSS gf180_tg_lowq
XDN120 CDRN20 VCM_REF PH1 NPH1 VDD33 VSS gf180_tg_lowq
XDN220 CDRN20 INN PH2 NPH2 VDD33 VSS gf180_tg_lowq
BGPP20 GPP20 VSS I=(v(GPP20)-v(PH2)*v(S2P20)/v(VDD33))/1k
BGPN20 GPN20 VSS I=(v(GPN20)-v(PH2)*(v(VDD33)-v(S2P20))/v(VDD33))/1k
BGNP20 GNP20 VSS I=(v(GNP20)-v(PH2)*v(S2N20)/v(VDD33))/1k
BGNN20 GNN20 VSS I=(v(GNN20)-v(PH2)*(v(VDD33)-v(S2N20))/v(VDD33))/1k
BNOPP20 NGPP20 0 V=v(VDD33)-v(GPP20)
BNOPN20 NGPN20 0 V=v(VDD33)-v(GPN20)
BNONP20 NGNP20 0 V=v(VDD33)-v(GNP20)
BNONN20 NGNN20 0 V=v(VDD33)-v(GNN20)
CGPP20 GPP20 VSS 2p
CGPN20 GPN20 VSS 2p
CGNP20 GNP20 VSS 2p
CGNN20 GNN20 VSS 2p
CNGPP20 NGPP20 VSS 0.2p
CNGPN20 NGPN20 VSS 0.2p
CNGNP20 NGNP20 VSS 0.2p
CNGNN20 NGNN20 VSS 0.2p
XPVP20 CDLP20 VP GPP20 NGPP20 VDD33 VSS gf180_tg_lowq
XPVN20 CDLP20 VN GPN20 NGPN20 VDD33 VSS gf180_tg_lowq
XNVP20 CDLN20 VP GNP20 NGNP20 VDD33 VSS gf180_tg_lowq
XNVN20 CDLN20 VN GNN20 NGNN20 VDD33 VSS gf180_tg_lowq
XDPC20 CDLP20 VCM_REF PH1 NPH1 VDD33 VSS gf180_tg_lowq
XDNC20 CDLN20 VCM_REF PH1 NPH1 VDD33 VSS gf180_tg_lowq
* DAC unit 21
CDP21 CDLP21 CDRP21 {CU}
CDN21 CDLN21 CDRN21 {CU}
XDP121 CDRP21 VCM_REF PH1 NPH1 VDD33 VSS gf180_tg_lowq
XDP221 CDRP21 INP PH2 NPH2 VDD33 VSS gf180_tg_lowq
XDN121 CDRN21 VCM_REF PH1 NPH1 VDD33 VSS gf180_tg_lowq
XDN221 CDRN21 INN PH2 NPH2 VDD33 VSS gf180_tg_lowq
BGPP21 GPP21 VSS I=(v(GPP21)-v(PH2)*v(S2P21)/v(VDD33))/1k
BGPN21 GPN21 VSS I=(v(GPN21)-v(PH2)*(v(VDD33)-v(S2P21))/v(VDD33))/1k
BGNP21 GNP21 VSS I=(v(GNP21)-v(PH2)*v(S2N21)/v(VDD33))/1k
BGNN21 GNN21 VSS I=(v(GNN21)-v(PH2)*(v(VDD33)-v(S2N21))/v(VDD33))/1k
BNOPP21 NGPP21 0 V=v(VDD33)-v(GPP21)
BNOPN21 NGPN21 0 V=v(VDD33)-v(GPN21)
BNONP21 NGNP21 0 V=v(VDD33)-v(GNP21)
BNONN21 NGNN21 0 V=v(VDD33)-v(GNN21)
CGPP21 GPP21 VSS 2p
CGPN21 GPN21 VSS 2p
CGNP21 GNP21 VSS 2p
CGNN21 GNN21 VSS 2p
CNGPP21 NGPP21 VSS 0.2p
CNGPN21 NGPN21 VSS 0.2p
CNGNP21 NGNP21 VSS 0.2p
CNGNN21 NGNN21 VSS 0.2p
XPVP21 CDLP21 VP GPP21 NGPP21 VDD33 VSS gf180_tg_lowq
XPVN21 CDLP21 VN GPN21 NGPN21 VDD33 VSS gf180_tg_lowq
XNVP21 CDLN21 VP GNP21 NGNP21 VDD33 VSS gf180_tg_lowq
XNVN21 CDLN21 VN GNN21 NGNN21 VDD33 VSS gf180_tg_lowq
XDPC21 CDLP21 VCM_REF PH1 NPH1 VDD33 VSS gf180_tg_lowq
XDNC21 CDLN21 VCM_REF PH1 NPH1 VDD33 VSS gf180_tg_lowq
* DAC unit 22
CDP22 CDLP22 CDRP22 {CU}
CDN22 CDLN22 CDRN22 {CU}
XDP122 CDRP22 VCM_REF PH1 NPH1 VDD33 VSS gf180_tg_lowq
XDP222 CDRP22 INP PH2 NPH2 VDD33 VSS gf180_tg_lowq
XDN122 CDRN22 VCM_REF PH1 NPH1 VDD33 VSS gf180_tg_lowq
XDN222 CDRN22 INN PH2 NPH2 VDD33 VSS gf180_tg_lowq
BGPP22 GPP22 VSS I=(v(GPP22)-v(PH2)*v(S2P22)/v(VDD33))/1k
BGPN22 GPN22 VSS I=(v(GPN22)-v(PH2)*(v(VDD33)-v(S2P22))/v(VDD33))/1k
BGNP22 GNP22 VSS I=(v(GNP22)-v(PH2)*v(S2N22)/v(VDD33))/1k
BGNN22 GNN22 VSS I=(v(GNN22)-v(PH2)*(v(VDD33)-v(S2N22))/v(VDD33))/1k
BNOPP22 NGPP22 0 V=v(VDD33)-v(GPP22)
BNOPN22 NGPN22 0 V=v(VDD33)-v(GPN22)
BNONP22 NGNP22 0 V=v(VDD33)-v(GNP22)
BNONN22 NGNN22 0 V=v(VDD33)-v(GNN22)
CGPP22 GPP22 VSS 2p
CGPN22 GPN22 VSS 2p
CGNP22 GNP22 VSS 2p
CGNN22 GNN22 VSS 2p
CNGPP22 NGPP22 VSS 0.2p
CNGPN22 NGPN22 VSS 0.2p
CNGNP22 NGNP22 VSS 0.2p
CNGNN22 NGNN22 VSS 0.2p
XPVP22 CDLP22 VP GPP22 NGPP22 VDD33 VSS gf180_tg_lowq
XPVN22 CDLP22 VN GPN22 NGPN22 VDD33 VSS gf180_tg_lowq
XNVP22 CDLN22 VP GNP22 NGNP22 VDD33 VSS gf180_tg_lowq
XNVN22 CDLN22 VN GNN22 NGNN22 VDD33 VSS gf180_tg_lowq
XDPC22 CDLP22 VCM_REF PH1 NPH1 VDD33 VSS gf180_tg_lowq
XDNC22 CDLN22 VCM_REF PH1 NPH1 VDD33 VSS gf180_tg_lowq
* DAC unit 23
CDP23 CDLP23 CDRP23 {CU}
CDN23 CDLN23 CDRN23 {CU}
XDP123 CDRP23 VCM_REF PH1 NPH1 VDD33 VSS gf180_tg_lowq
XDP223 CDRP23 INP PH2 NPH2 VDD33 VSS gf180_tg_lowq
XDN123 CDRN23 VCM_REF PH1 NPH1 VDD33 VSS gf180_tg_lowq
XDN223 CDRN23 INN PH2 NPH2 VDD33 VSS gf180_tg_lowq
BGPP23 GPP23 VSS I=(v(GPP23)-v(PH2)*v(S2P23)/v(VDD33))/1k
BGPN23 GPN23 VSS I=(v(GPN23)-v(PH2)*(v(VDD33)-v(S2P23))/v(VDD33))/1k
BGNP23 GNP23 VSS I=(v(GNP23)-v(PH2)*v(S2N23)/v(VDD33))/1k
BGNN23 GNN23 VSS I=(v(GNN23)-v(PH2)*(v(VDD33)-v(S2N23))/v(VDD33))/1k
BNOPP23 NGPP23 0 V=v(VDD33)-v(GPP23)
BNOPN23 NGPN23 0 V=v(VDD33)-v(GPN23)
BNONP23 NGNP23 0 V=v(VDD33)-v(GNP23)
BNONN23 NGNN23 0 V=v(VDD33)-v(GNN23)
CGPP23 GPP23 VSS 2p
CGPN23 GPN23 VSS 2p
CGNP23 GNP23 VSS 2p
CGNN23 GNN23 VSS 2p
CNGPP23 NGPP23 VSS 0.2p
CNGPN23 NGPN23 VSS 0.2p
CNGNP23 NGNP23 VSS 0.2p
CNGNN23 NGNN23 VSS 0.2p
XPVP23 CDLP23 VP GPP23 NGPP23 VDD33 VSS gf180_tg_lowq
XPVN23 CDLP23 VN GPN23 NGPN23 VDD33 VSS gf180_tg_lowq
XNVP23 CDLN23 VP GNP23 NGNP23 VDD33 VSS gf180_tg_lowq
XNVN23 CDLN23 VN GNN23 NGNN23 VDD33 VSS gf180_tg_lowq
XDPC23 CDLP23 VCM_REF PH1 NPH1 VDD33 VSS gf180_tg_lowq
XDNC23 CDLN23 VCM_REF PH1 NPH1 VDD33 VSS gf180_tg_lowq
* DAC unit 24
CDP24 CDLP24 CDRP24 {CU}
CDN24 CDLN24 CDRN24 {CU}
XDP124 CDRP24 VCM_REF PH1 NPH1 VDD33 VSS gf180_tg_lowq
XDP224 CDRP24 INP PH2 NPH2 VDD33 VSS gf180_tg_lowq
XDN124 CDRN24 VCM_REF PH1 NPH1 VDD33 VSS gf180_tg_lowq
XDN224 CDRN24 INN PH2 NPH2 VDD33 VSS gf180_tg_lowq
BGPP24 GPP24 VSS I=(v(GPP24)-v(PH2)*v(S2P24)/v(VDD33))/1k
BGPN24 GPN24 VSS I=(v(GPN24)-v(PH2)*(v(VDD33)-v(S2P24))/v(VDD33))/1k
BGNP24 GNP24 VSS I=(v(GNP24)-v(PH2)*v(S2N24)/v(VDD33))/1k
BGNN24 GNN24 VSS I=(v(GNN24)-v(PH2)*(v(VDD33)-v(S2N24))/v(VDD33))/1k
BNOPP24 NGPP24 0 V=v(VDD33)-v(GPP24)
BNOPN24 NGPN24 0 V=v(VDD33)-v(GPN24)
BNONP24 NGNP24 0 V=v(VDD33)-v(GNP24)
BNONN24 NGNN24 0 V=v(VDD33)-v(GNN24)
CGPP24 GPP24 VSS 2p
CGPN24 GPN24 VSS 2p
CGNP24 GNP24 VSS 2p
CGNN24 GNN24 VSS 2p
CNGPP24 NGPP24 VSS 0.2p
CNGPN24 NGPN24 VSS 0.2p
CNGNP24 NGNP24 VSS 0.2p
CNGNN24 NGNN24 VSS 0.2p
XPVP24 CDLP24 VP GPP24 NGPP24 VDD33 VSS gf180_tg_lowq
XPVN24 CDLP24 VN GPN24 NGPN24 VDD33 VSS gf180_tg_lowq
XNVP24 CDLN24 VP GNP24 NGNP24 VDD33 VSS gf180_tg_lowq
XNVN24 CDLN24 VN GNN24 NGNN24 VDD33 VSS gf180_tg_lowq
XDPC24 CDLP24 VCM_REF PH1 NPH1 VDD33 VSS gf180_tg_lowq
XDNC24 CDLN24 VCM_REF PH1 NPH1 VDD33 VSS gf180_tg_lowq
* DAC unit 25
CDP25 CDLP25 CDRP25 {CU}
CDN25 CDLN25 CDRN25 {CU}
XDP125 CDRP25 VCM_REF PH1 NPH1 VDD33 VSS gf180_tg_lowq
XDP225 CDRP25 INP PH2 NPH2 VDD33 VSS gf180_tg_lowq
XDN125 CDRN25 VCM_REF PH1 NPH1 VDD33 VSS gf180_tg_lowq
XDN225 CDRN25 INN PH2 NPH2 VDD33 VSS gf180_tg_lowq
BGPP25 GPP25 VSS I=(v(GPP25)-v(PH2)*v(S2P25)/v(VDD33))/1k
BGPN25 GPN25 VSS I=(v(GPN25)-v(PH2)*(v(VDD33)-v(S2P25))/v(VDD33))/1k
BGNP25 GNP25 VSS I=(v(GNP25)-v(PH2)*v(S2N25)/v(VDD33))/1k
BGNN25 GNN25 VSS I=(v(GNN25)-v(PH2)*(v(VDD33)-v(S2N25))/v(VDD33))/1k
BNOPP25 NGPP25 0 V=v(VDD33)-v(GPP25)
BNOPN25 NGPN25 0 V=v(VDD33)-v(GPN25)
BNONP25 NGNP25 0 V=v(VDD33)-v(GNP25)
BNONN25 NGNN25 0 V=v(VDD33)-v(GNN25)
CGPP25 GPP25 VSS 2p
CGPN25 GPN25 VSS 2p
CGNP25 GNP25 VSS 2p
CGNN25 GNN25 VSS 2p
CNGPP25 NGPP25 VSS 0.2p
CNGPN25 NGPN25 VSS 0.2p
CNGNP25 NGNP25 VSS 0.2p
CNGNN25 NGNN25 VSS 0.2p
XPVP25 CDLP25 VP GPP25 NGPP25 VDD33 VSS gf180_tg_lowq
XPVN25 CDLP25 VN GPN25 NGPN25 VDD33 VSS gf180_tg_lowq
XNVP25 CDLN25 VP GNP25 NGNP25 VDD33 VSS gf180_tg_lowq
XNVN25 CDLN25 VN GNN25 NGNN25 VDD33 VSS gf180_tg_lowq
XDPC25 CDLP25 VCM_REF PH1 NPH1 VDD33 VSS gf180_tg_lowq
XDNC25 CDLN25 VCM_REF PH1 NPH1 VDD33 VSS gf180_tg_lowq
* DAC unit 26
CDP26 CDLP26 CDRP26 {CU}
CDN26 CDLN26 CDRN26 {CU}
XDP126 CDRP26 VCM_REF PH1 NPH1 VDD33 VSS gf180_tg_lowq
XDP226 CDRP26 INP PH2 NPH2 VDD33 VSS gf180_tg_lowq
XDN126 CDRN26 VCM_REF PH1 NPH1 VDD33 VSS gf180_tg_lowq
XDN226 CDRN26 INN PH2 NPH2 VDD33 VSS gf180_tg_lowq
BGPP26 GPP26 VSS I=(v(GPP26)-v(PH2)*v(S2P26)/v(VDD33))/1k
BGPN26 GPN26 VSS I=(v(GPN26)-v(PH2)*(v(VDD33)-v(S2P26))/v(VDD33))/1k
BGNP26 GNP26 VSS I=(v(GNP26)-v(PH2)*v(S2N26)/v(VDD33))/1k
BGNN26 GNN26 VSS I=(v(GNN26)-v(PH2)*(v(VDD33)-v(S2N26))/v(VDD33))/1k
BNOPP26 NGPP26 0 V=v(VDD33)-v(GPP26)
BNOPN26 NGPN26 0 V=v(VDD33)-v(GPN26)
BNONP26 NGNP26 0 V=v(VDD33)-v(GNP26)
BNONN26 NGNN26 0 V=v(VDD33)-v(GNN26)
CGPP26 GPP26 VSS 2p
CGPN26 GPN26 VSS 2p
CGNP26 GNP26 VSS 2p
CGNN26 GNN26 VSS 2p
CNGPP26 NGPP26 VSS 0.2p
CNGPN26 NGPN26 VSS 0.2p
CNGNP26 NGNP26 VSS 0.2p
CNGNN26 NGNN26 VSS 0.2p
XPVP26 CDLP26 VP GPP26 NGPP26 VDD33 VSS gf180_tg_lowq
XPVN26 CDLP26 VN GPN26 NGPN26 VDD33 VSS gf180_tg_lowq
XNVP26 CDLN26 VP GNP26 NGNP26 VDD33 VSS gf180_tg_lowq
XNVN26 CDLN26 VN GNN26 NGNN26 VDD33 VSS gf180_tg_lowq
XDPC26 CDLP26 VCM_REF PH1 NPH1 VDD33 VSS gf180_tg_lowq
XDNC26 CDLN26 VCM_REF PH1 NPH1 VDD33 VSS gf180_tg_lowq
* DAC unit 27
CDP27 CDLP27 CDRP27 {CU}
CDN27 CDLN27 CDRN27 {CU}
XDP127 CDRP27 VCM_REF PH1 NPH1 VDD33 VSS gf180_tg_lowq
XDP227 CDRP27 INP PH2 NPH2 VDD33 VSS gf180_tg_lowq
XDN127 CDRN27 VCM_REF PH1 NPH1 VDD33 VSS gf180_tg_lowq
XDN227 CDRN27 INN PH2 NPH2 VDD33 VSS gf180_tg_lowq
BGPP27 GPP27 VSS I=(v(GPP27)-v(PH2)*v(S2P27)/v(VDD33))/1k
BGPN27 GPN27 VSS I=(v(GPN27)-v(PH2)*(v(VDD33)-v(S2P27))/v(VDD33))/1k
BGNP27 GNP27 VSS I=(v(GNP27)-v(PH2)*v(S2N27)/v(VDD33))/1k
BGNN27 GNN27 VSS I=(v(GNN27)-v(PH2)*(v(VDD33)-v(S2N27))/v(VDD33))/1k
BNOPP27 NGPP27 0 V=v(VDD33)-v(GPP27)
BNOPN27 NGPN27 0 V=v(VDD33)-v(GPN27)
BNONP27 NGNP27 0 V=v(VDD33)-v(GNP27)
BNONN27 NGNN27 0 V=v(VDD33)-v(GNN27)
CGPP27 GPP27 VSS 2p
CGPN27 GPN27 VSS 2p
CGNP27 GNP27 VSS 2p
CGNN27 GNN27 VSS 2p
CNGPP27 NGPP27 VSS 0.2p
CNGPN27 NGPN27 VSS 0.2p
CNGNP27 NGNP27 VSS 0.2p
CNGNN27 NGNN27 VSS 0.2p
XPVP27 CDLP27 VP GPP27 NGPP27 VDD33 VSS gf180_tg_lowq
XPVN27 CDLP27 VN GPN27 NGPN27 VDD33 VSS gf180_tg_lowq
XNVP27 CDLN27 VP GNP27 NGNP27 VDD33 VSS gf180_tg_lowq
XNVN27 CDLN27 VN GNN27 NGNN27 VDD33 VSS gf180_tg_lowq
XDPC27 CDLP27 VCM_REF PH1 NPH1 VDD33 VSS gf180_tg_lowq
XDNC27 CDLN27 VCM_REF PH1 NPH1 VDD33 VSS gf180_tg_lowq
* DAC unit 28
CDP28 CDLP28 CDRP28 {CU}
CDN28 CDLN28 CDRN28 {CU}
XDP128 CDRP28 VCM_REF PH1 NPH1 VDD33 VSS gf180_tg_lowq
XDP228 CDRP28 INP PH2 NPH2 VDD33 VSS gf180_tg_lowq
XDN128 CDRN28 VCM_REF PH1 NPH1 VDD33 VSS gf180_tg_lowq
XDN228 CDRN28 INN PH2 NPH2 VDD33 VSS gf180_tg_lowq
BGPP28 GPP28 VSS I=(v(GPP28)-v(PH2)*v(S2P28)/v(VDD33))/1k
BGPN28 GPN28 VSS I=(v(GPN28)-v(PH2)*(v(VDD33)-v(S2P28))/v(VDD33))/1k
BGNP28 GNP28 VSS I=(v(GNP28)-v(PH2)*v(S2N28)/v(VDD33))/1k
BGNN28 GNN28 VSS I=(v(GNN28)-v(PH2)*(v(VDD33)-v(S2N28))/v(VDD33))/1k
BNOPP28 NGPP28 0 V=v(VDD33)-v(GPP28)
BNOPN28 NGPN28 0 V=v(VDD33)-v(GPN28)
BNONP28 NGNP28 0 V=v(VDD33)-v(GNP28)
BNONN28 NGNN28 0 V=v(VDD33)-v(GNN28)
CGPP28 GPP28 VSS 2p
CGPN28 GPN28 VSS 2p
CGNP28 GNP28 VSS 2p
CGNN28 GNN28 VSS 2p
CNGPP28 NGPP28 VSS 0.2p
CNGPN28 NGPN28 VSS 0.2p
CNGNP28 NGNP28 VSS 0.2p
CNGNN28 NGNN28 VSS 0.2p
XPVP28 CDLP28 VP GPP28 NGPP28 VDD33 VSS gf180_tg_lowq
XPVN28 CDLP28 VN GPN28 NGPN28 VDD33 VSS gf180_tg_lowq
XNVP28 CDLN28 VP GNP28 NGNP28 VDD33 VSS gf180_tg_lowq
XNVN28 CDLN28 VN GNN28 NGNN28 VDD33 VSS gf180_tg_lowq
XDPC28 CDLP28 VCM_REF PH1 NPH1 VDD33 VSS gf180_tg_lowq
XDNC28 CDLN28 VCM_REF PH1 NPH1 VDD33 VSS gf180_tg_lowq
* DAC unit 29
CDP29 CDLP29 CDRP29 {CU}
CDN29 CDLN29 CDRN29 {CU}
XDP129 CDRP29 VCM_REF PH1 NPH1 VDD33 VSS gf180_tg_lowq
XDP229 CDRP29 INP PH2 NPH2 VDD33 VSS gf180_tg_lowq
XDN129 CDRN29 VCM_REF PH1 NPH1 VDD33 VSS gf180_tg_lowq
XDN229 CDRN29 INN PH2 NPH2 VDD33 VSS gf180_tg_lowq
BGPP29 GPP29 VSS I=(v(GPP29)-v(PH2)*v(S2P29)/v(VDD33))/1k
BGPN29 GPN29 VSS I=(v(GPN29)-v(PH2)*(v(VDD33)-v(S2P29))/v(VDD33))/1k
BGNP29 GNP29 VSS I=(v(GNP29)-v(PH2)*v(S2N29)/v(VDD33))/1k
BGNN29 GNN29 VSS I=(v(GNN29)-v(PH2)*(v(VDD33)-v(S2N29))/v(VDD33))/1k
BNOPP29 NGPP29 0 V=v(VDD33)-v(GPP29)
BNOPN29 NGPN29 0 V=v(VDD33)-v(GPN29)
BNONP29 NGNP29 0 V=v(VDD33)-v(GNP29)
BNONN29 NGNN29 0 V=v(VDD33)-v(GNN29)
CGPP29 GPP29 VSS 2p
CGPN29 GPN29 VSS 2p
CGNP29 GNP29 VSS 2p
CGNN29 GNN29 VSS 2p
CNGPP29 NGPP29 VSS 0.2p
CNGPN29 NGPN29 VSS 0.2p
CNGNP29 NGNP29 VSS 0.2p
CNGNN29 NGNN29 VSS 0.2p
XPVP29 CDLP29 VP GPP29 NGPP29 VDD33 VSS gf180_tg_lowq
XPVN29 CDLP29 VN GPN29 NGPN29 VDD33 VSS gf180_tg_lowq
XNVP29 CDLN29 VP GNP29 NGNP29 VDD33 VSS gf180_tg_lowq
XNVN29 CDLN29 VN GNN29 NGNN29 VDD33 VSS gf180_tg_lowq
XDPC29 CDLP29 VCM_REF PH1 NPH1 VDD33 VSS gf180_tg_lowq
XDNC29 CDLN29 VCM_REF PH1 NPH1 VDD33 VSS gf180_tg_lowq
* DAC unit 30
CDP30 CDLP30 CDRP30 {CU}
CDN30 CDLN30 CDRN30 {CU}
XDP130 CDRP30 VCM_REF PH1 NPH1 VDD33 VSS gf180_tg_lowq
XDP230 CDRP30 INP PH2 NPH2 VDD33 VSS gf180_tg_lowq
XDN130 CDRN30 VCM_REF PH1 NPH1 VDD33 VSS gf180_tg_lowq
XDN230 CDRN30 INN PH2 NPH2 VDD33 VSS gf180_tg_lowq
BGPP30 GPP30 VSS I=(v(GPP30)-v(PH2)*v(S2P30)/v(VDD33))/1k
BGPN30 GPN30 VSS I=(v(GPN30)-v(PH2)*(v(VDD33)-v(S2P30))/v(VDD33))/1k
BGNP30 GNP30 VSS I=(v(GNP30)-v(PH2)*v(S2N30)/v(VDD33))/1k
BGNN30 GNN30 VSS I=(v(GNN30)-v(PH2)*(v(VDD33)-v(S2N30))/v(VDD33))/1k
BNOPP30 NGPP30 0 V=v(VDD33)-v(GPP30)
BNOPN30 NGPN30 0 V=v(VDD33)-v(GPN30)
BNONP30 NGNP30 0 V=v(VDD33)-v(GNP30)
BNONN30 NGNN30 0 V=v(VDD33)-v(GNN30)
CGPP30 GPP30 VSS 2p
CGPN30 GPN30 VSS 2p
CGNP30 GNP30 VSS 2p
CGNN30 GNN30 VSS 2p
CNGPP30 NGPP30 VSS 0.2p
CNGPN30 NGPN30 VSS 0.2p
CNGNP30 NGNP30 VSS 0.2p
CNGNN30 NGNN30 VSS 0.2p
XPVP30 CDLP30 VP GPP30 NGPP30 VDD33 VSS gf180_tg_lowq
XPVN30 CDLP30 VN GPN30 NGPN30 VDD33 VSS gf180_tg_lowq
XNVP30 CDLN30 VP GNP30 NGNP30 VDD33 VSS gf180_tg_lowq
XNVN30 CDLN30 VN GNN30 NGNN30 VDD33 VSS gf180_tg_lowq
XDPC30 CDLP30 VCM_REF PH1 NPH1 VDD33 VSS gf180_tg_lowq
XDNC30 CDLN30 VCM_REF PH1 NPH1 VDD33 VSS gf180_tg_lowq
CIP OUTN INP {CI}
CIN OUTP INN {CI}
RBIASP INP VCM_REF 10G
RBIASN INN VCM_REF 10G
.ends gf180_sdm3_int2_mb

* ---- modulator top: sdm3 timing, 4-bit flash + behavioral DWA ----
* Nodes: TH0..TH14 = thermometer lines (H_i). External PUP clock (narrow
* pulse at PH1 rising edge) advances the DWA master register.
.subckt gf180_sdm3_mod_mb VINP VINN VCM_REF VP VN PH1 NPH1 PH2 NPH2 CMPCK PUP VDD33 VSS TH0 TH1 TH2 TH3 TH4 TH5 TH6 TH7 TH8 TH9 TH10 TH11 TH12 TH13 TH14 TH15 TH16 TH17 TH18 TH19 TH20 TH21 TH22 TH23 TH24 TH25 TH26 TH27 TH28 TH29 TH30 params: RSET=25k CC=10p
XINT1 VINN VINP VCM_REF VP VN O1P O1N PH1 NPH1 PH2 NPH2 VDD33 VSS SEL0 SEL1 SEL2 SEL3 SEL4 SEL5 SEL6 SEL7 SEL8 SEL9 SEL10 SEL11 SEL12 SEL13 SEL14 SEL15 SEL16 SEL17 SEL18 SEL19 SEL20 SEL21 SEL22 SEL23 SEL24 SEL25 SEL26 SEL27 SEL28 SEL29 SEL30 SELN0 SELN1 SELN2 SELN3 SELN4 SELN5 SELN6 SELN7 SELN8 SELN9 SELN10 SELN11 SELN12 SELN13 SELN14 SELN15 SELN16 SELN17 SELN18 SELN19 SELN20 SELN21 SELN22 SELN23 SELN24 SELN25 SELN26 SELN27 SELN28 SELN29 SELN30 gf180_sdm3_int1_mb RSET={RSET} CC={CC}
* int2 with swapped clock pins (samples PH2 / integrates PH1)
XINT2 O1N O1P VCM_REF VP VN O2P O2N PH2 NPH2 PH1 NPH1 VDD33 VSS S2L0 S2L1 S2L2 S2L3 S2L4 S2L5 S2L6 S2L7 S2L8 S2L9 S2L10 S2L11 S2L12 S2L13 S2L14 S2L15 S2L16 S2L17 S2L18 S2L19 S2L20 S2L21 S2L22 S2L23 S2L24 S2L25 S2L26 S2L27 S2L28 S2L29 S2L30 S2LN0 S2LN1 S2LN2 S2LN3 S2LN4 S2LN5 S2LN6 S2LN7 S2LN8 S2LN9 S2LN10 S2LN11 S2LN12 S2LN13 S2LN14 S2LN15 S2LN16 S2LN17 S2LN18 S2LN19 S2LN20 S2LN21 S2LN22 S2LN23 S2LN24 S2LN25 S2LN26 S2LN27 S2LN28 S2LN29 S2LN30 gf180_sdm3_int2_mb RSET={RSET} CC={CC}
XFLASH O2P O2N CMPCK VDD33 VSS TH0 TH1 TH2 TH3 TH4 TH5 TH6 TH7 TH8 TH9 TH10 TH11 TH12 TH13 TH14 TH15 TH16 TH17 TH18 TH19 TH20 TH21 TH22 TH23 TH24 TH25 TH26 TH27 TH28 TH29 TH30 gf180_sdm3_flash31
* thermometer count as voltage (1 V per count), RC-filtered (tau ~4 ns)
RTHF0 TH0 THF0 2k
CTHF0 THF0 VSS 2p
RTHF1 TH1 THF1 2k
CTHF1 THF1 VSS 2p
RTHF2 TH2 THF2 2k
CTHF2 THF2 VSS 2p
RTHF3 TH3 THF3 2k
CTHF3 THF3 VSS 2p
RTHF4 TH4 THF4 2k
CTHF4 THF4 VSS 2p
RTHF5 TH5 THF5 2k
CTHF5 THF5 VSS 2p
RTHF6 TH6 THF6 2k
CTHF6 THF6 VSS 2p
RTHF7 TH7 THF7 2k
CTHF7 THF7 VSS 2p
RTHF8 TH8 THF8 2k
CTHF8 THF8 VSS 2p
RTHF9 TH9 THF9 2k
CTHF9 THF9 VSS 2p
RTHF10 TH10 THF10 2k
CTHF10 THF10 VSS 2p
RTHF11 TH11 THF11 2k
CTHF11 THF11 VSS 2p
RTHF12 TH12 THF12 2k
CTHF12 THF12 VSS 2p
RTHF13 TH13 THF13 2k
CTHF13 THF13 VSS 2p
RTHF14 TH14 THF14 2k
CTHF14 THF14 VSS 2p
RTHF15 TH15 THF15 2k
CTHF15 THF15 VSS 2p
RTHF16 TH16 THF16 2k
CTHF16 THF16 VSS 2p
RTHF17 TH17 THF17 2k
CTHF17 THF17 VSS 2p
RTHF18 TH18 THF18 2k
CTHF18 THF18 VSS 2p
RTHF19 TH19 THF19 2k
CTHF19 THF19 VSS 2p
RTHF20 TH20 THF20 2k
CTHF20 THF20 VSS 2p
RTHF21 TH21 THF21 2k
CTHF21 THF21 VSS 2p
RTHF22 TH22 THF22 2k
CTHF22 THF22 VSS 2p
RTHF23 TH23 THF23 2k
CTHF23 THF23 VSS 2p
RTHF24 TH24 THF24 2k
CTHF24 THF24 VSS 2p
RTHF25 TH25 THF25 2k
CTHF25 THF25 VSS 2p
RTHF26 TH26 THF26 2k
CTHF26 THF26 VSS 2p
RTHF27 TH27 THF27 2k
CTHF27 THF27 VSS 2p
RTHF28 TH28 THF28 2k
CTHF28 THF28 VSS 2p
RTHF29 TH29 THF29 2k
CTHF29 THF29 VSS 2p
RTHF30 TH30 THF30 2k
CTHF30 THF30 VSS 2p
BCSUM CSUM 0 V=(v(THF0)+v(THF1)+v(THF2)+v(THF3)+v(THF4)+v(THF5)+v(THF6)+v(THF7)+v(THF8)+v(THF9)+v(THF10)+v(THF11)+v(THF12)+v(THF13)+v(THF14)+v(THF15)+v(THF16)+v(THF17)+v(THF18)+v(THF19)+v(THF20)+v(THF21)+v(THF22)+v(THF23)+v(THF24)+v(THF25)+v(THF26)+v(THF27)+v(THF28)+v(THF29)+v(THF30))/v(VDD33)
* DWA pointer: master samples mod(p_slave - c + 15) during PUP,
* slave tracks master during PH2. p[n+1]=(p[n]-c[n]) mod 31.
* B-source current sample/hold (idsw SW broke transient OP; RC form is OP-clean)
*
* int1 unit selects (straight thermometer): P-side unit j -> VP if j < 15-c.
* RC-smoothed current-source form (tau ~2 ns); sigmoid boundary errors
* cancel pairwise in the summed DAC charge.
BSEL0 SEL0 VSS I=(v(SEL0)-v(VDD33)/(1+exp((0+0.5-(31-v(CSUM)))/0.15)))/1k
BSELN0 SELN0 VSS I=(v(SELN0)-(v(VDD33)-v(SEL0)))/1k
BSEL1 SEL1 VSS I=(v(SEL1)-v(VDD33)/(1+exp((1+0.5-(31-v(CSUM)))/0.15)))/1k
BSELN1 SELN1 VSS I=(v(SELN1)-(v(VDD33)-v(SEL1)))/1k
BSEL2 SEL2 VSS I=(v(SEL2)-v(VDD33)/(1+exp((2+0.5-(31-v(CSUM)))/0.15)))/1k
BSELN2 SELN2 VSS I=(v(SELN2)-(v(VDD33)-v(SEL2)))/1k
BSEL3 SEL3 VSS I=(v(SEL3)-v(VDD33)/(1+exp((3+0.5-(31-v(CSUM)))/0.15)))/1k
BSELN3 SELN3 VSS I=(v(SELN3)-(v(VDD33)-v(SEL3)))/1k
BSEL4 SEL4 VSS I=(v(SEL4)-v(VDD33)/(1+exp((4+0.5-(31-v(CSUM)))/0.15)))/1k
BSELN4 SELN4 VSS I=(v(SELN4)-(v(VDD33)-v(SEL4)))/1k
BSEL5 SEL5 VSS I=(v(SEL5)-v(VDD33)/(1+exp((5+0.5-(31-v(CSUM)))/0.15)))/1k
BSELN5 SELN5 VSS I=(v(SELN5)-(v(VDD33)-v(SEL5)))/1k
BSEL6 SEL6 VSS I=(v(SEL6)-v(VDD33)/(1+exp((6+0.5-(31-v(CSUM)))/0.15)))/1k
BSELN6 SELN6 VSS I=(v(SELN6)-(v(VDD33)-v(SEL6)))/1k
BSEL7 SEL7 VSS I=(v(SEL7)-v(VDD33)/(1+exp((7+0.5-(31-v(CSUM)))/0.15)))/1k
BSELN7 SELN7 VSS I=(v(SELN7)-(v(VDD33)-v(SEL7)))/1k
BSEL8 SEL8 VSS I=(v(SEL8)-v(VDD33)/(1+exp((8+0.5-(31-v(CSUM)))/0.15)))/1k
BSELN8 SELN8 VSS I=(v(SELN8)-(v(VDD33)-v(SEL8)))/1k
BSEL9 SEL9 VSS I=(v(SEL9)-v(VDD33)/(1+exp((9+0.5-(31-v(CSUM)))/0.15)))/1k
BSELN9 SELN9 VSS I=(v(SELN9)-(v(VDD33)-v(SEL9)))/1k
BSEL10 SEL10 VSS I=(v(SEL10)-v(VDD33)/(1+exp((10+0.5-(31-v(CSUM)))/0.15)))/1k
BSELN10 SELN10 VSS I=(v(SELN10)-(v(VDD33)-v(SEL10)))/1k
BSEL11 SEL11 VSS I=(v(SEL11)-v(VDD33)/(1+exp((11+0.5-(31-v(CSUM)))/0.15)))/1k
BSELN11 SELN11 VSS I=(v(SELN11)-(v(VDD33)-v(SEL11)))/1k
BSEL12 SEL12 VSS I=(v(SEL12)-v(VDD33)/(1+exp((12+0.5-(31-v(CSUM)))/0.15)))/1k
BSELN12 SELN12 VSS I=(v(SELN12)-(v(VDD33)-v(SEL12)))/1k
BSEL13 SEL13 VSS I=(v(SEL13)-v(VDD33)/(1+exp((13+0.5-(31-v(CSUM)))/0.15)))/1k
BSELN13 SELN13 VSS I=(v(SELN13)-(v(VDD33)-v(SEL13)))/1k
BSEL14 SEL14 VSS I=(v(SEL14)-v(VDD33)/(1+exp((14+0.5-(31-v(CSUM)))/0.15)))/1k
BSELN14 SELN14 VSS I=(v(SELN14)-(v(VDD33)-v(SEL14)))/1k
BSEL15 SEL15 VSS I=(v(SEL15)-v(VDD33)/(1+exp((15+0.5-(31-v(CSUM)))/0.15)))/1k
BSELN15 SELN15 VSS I=(v(SELN15)-(v(VDD33)-v(SEL15)))/1k
BSEL16 SEL16 VSS I=(v(SEL16)-v(VDD33)/(1+exp((16+0.5-(31-v(CSUM)))/0.15)))/1k
BSELN16 SELN16 VSS I=(v(SELN16)-(v(VDD33)-v(SEL16)))/1k
BSEL17 SEL17 VSS I=(v(SEL17)-v(VDD33)/(1+exp((17+0.5-(31-v(CSUM)))/0.15)))/1k
BSELN17 SELN17 VSS I=(v(SELN17)-(v(VDD33)-v(SEL17)))/1k
BSEL18 SEL18 VSS I=(v(SEL18)-v(VDD33)/(1+exp((18+0.5-(31-v(CSUM)))/0.15)))/1k
BSELN18 SELN18 VSS I=(v(SELN18)-(v(VDD33)-v(SEL18)))/1k
BSEL19 SEL19 VSS I=(v(SEL19)-v(VDD33)/(1+exp((19+0.5-(31-v(CSUM)))/0.15)))/1k
BSELN19 SELN19 VSS I=(v(SELN19)-(v(VDD33)-v(SEL19)))/1k
BSEL20 SEL20 VSS I=(v(SEL20)-v(VDD33)/(1+exp((20+0.5-(31-v(CSUM)))/0.15)))/1k
BSELN20 SELN20 VSS I=(v(SELN20)-(v(VDD33)-v(SEL20)))/1k
BSEL21 SEL21 VSS I=(v(SEL21)-v(VDD33)/(1+exp((21+0.5-(31-v(CSUM)))/0.15)))/1k
BSELN21 SELN21 VSS I=(v(SELN21)-(v(VDD33)-v(SEL21)))/1k
BSEL22 SEL22 VSS I=(v(SEL22)-v(VDD33)/(1+exp((22+0.5-(31-v(CSUM)))/0.15)))/1k
BSELN22 SELN22 VSS I=(v(SELN22)-(v(VDD33)-v(SEL22)))/1k
BSEL23 SEL23 VSS I=(v(SEL23)-v(VDD33)/(1+exp((23+0.5-(31-v(CSUM)))/0.15)))/1k
BSELN23 SELN23 VSS I=(v(SELN23)-(v(VDD33)-v(SEL23)))/1k
BSEL24 SEL24 VSS I=(v(SEL24)-v(VDD33)/(1+exp((24+0.5-(31-v(CSUM)))/0.15)))/1k
BSELN24 SELN24 VSS I=(v(SELN24)-(v(VDD33)-v(SEL24)))/1k
BSEL25 SEL25 VSS I=(v(SEL25)-v(VDD33)/(1+exp((25+0.5-(31-v(CSUM)))/0.15)))/1k
BSELN25 SELN25 VSS I=(v(SELN25)-(v(VDD33)-v(SEL25)))/1k
BSEL26 SEL26 VSS I=(v(SEL26)-v(VDD33)/(1+exp((26+0.5-(31-v(CSUM)))/0.15)))/1k
BSELN26 SELN26 VSS I=(v(SELN26)-(v(VDD33)-v(SEL26)))/1k
BSEL27 SEL27 VSS I=(v(SEL27)-v(VDD33)/(1+exp((27+0.5-(31-v(CSUM)))/0.15)))/1k
BSELN27 SELN27 VSS I=(v(SELN27)-(v(VDD33)-v(SEL27)))/1k
BSEL28 SEL28 VSS I=(v(SEL28)-v(VDD33)/(1+exp((28+0.5-(31-v(CSUM)))/0.15)))/1k
BSELN28 SELN28 VSS I=(v(SELN28)-(v(VDD33)-v(SEL28)))/1k
BSEL29 SEL29 VSS I=(v(SEL29)-v(VDD33)/(1+exp((29+0.5-(31-v(CSUM)))/0.15)))/1k
BSELN29 SELN29 VSS I=(v(SELN29)-(v(VDD33)-v(SEL29)))/1k
BSEL30 SEL30 VSS I=(v(SEL30)-v(VDD33)/(1+exp((30+0.5-(31-v(CSUM)))/0.15)))/1k
BSELN30 SELN30 VSS I=(v(SELN30)-(v(VDD33)-v(SEL30)))/1k
* int2 code register: tracks CSUM during PH2, holds through PH1
* (smoothed B-source sample/hold; idsw SW broke transient OP)
BC2R C2R VSS I=(v(C2R)-v(CSUM))/1k/(1+exp((2.0-v(PH2))/0.05))
CC2R C2R VSS 0.5p
RC2R C2R VSS 1G
* int2 unit selects (straight thermometer from registered code)
BS2L0 S2L0 VSS I=(v(S2L0)-v(VDD33)/(1+exp((0+0.5-(31-v(C2R)))/0.15)))/1k
BS2LN0 S2LN0 VSS I=(v(S2LN0)-(v(VDD33)-v(S2L0)))/1k
BS2L1 S2L1 VSS I=(v(S2L1)-v(VDD33)/(1+exp((1+0.5-(31-v(C2R)))/0.15)))/1k
BS2LN1 S2LN1 VSS I=(v(S2LN1)-(v(VDD33)-v(S2L1)))/1k
BS2L2 S2L2 VSS I=(v(S2L2)-v(VDD33)/(1+exp((2+0.5-(31-v(C2R)))/0.15)))/1k
BS2LN2 S2LN2 VSS I=(v(S2LN2)-(v(VDD33)-v(S2L2)))/1k
BS2L3 S2L3 VSS I=(v(S2L3)-v(VDD33)/(1+exp((3+0.5-(31-v(C2R)))/0.15)))/1k
BS2LN3 S2LN3 VSS I=(v(S2LN3)-(v(VDD33)-v(S2L3)))/1k
BS2L4 S2L4 VSS I=(v(S2L4)-v(VDD33)/(1+exp((4+0.5-(31-v(C2R)))/0.15)))/1k
BS2LN4 S2LN4 VSS I=(v(S2LN4)-(v(VDD33)-v(S2L4)))/1k
BS2L5 S2L5 VSS I=(v(S2L5)-v(VDD33)/(1+exp((5+0.5-(31-v(C2R)))/0.15)))/1k
BS2LN5 S2LN5 VSS I=(v(S2LN5)-(v(VDD33)-v(S2L5)))/1k
BS2L6 S2L6 VSS I=(v(S2L6)-v(VDD33)/(1+exp((6+0.5-(31-v(C2R)))/0.15)))/1k
BS2LN6 S2LN6 VSS I=(v(S2LN6)-(v(VDD33)-v(S2L6)))/1k
BS2L7 S2L7 VSS I=(v(S2L7)-v(VDD33)/(1+exp((7+0.5-(31-v(C2R)))/0.15)))/1k
BS2LN7 S2LN7 VSS I=(v(S2LN7)-(v(VDD33)-v(S2L7)))/1k
BS2L8 S2L8 VSS I=(v(S2L8)-v(VDD33)/(1+exp((8+0.5-(31-v(C2R)))/0.15)))/1k
BS2LN8 S2LN8 VSS I=(v(S2LN8)-(v(VDD33)-v(S2L8)))/1k
BS2L9 S2L9 VSS I=(v(S2L9)-v(VDD33)/(1+exp((9+0.5-(31-v(C2R)))/0.15)))/1k
BS2LN9 S2LN9 VSS I=(v(S2LN9)-(v(VDD33)-v(S2L9)))/1k
BS2L10 S2L10 VSS I=(v(S2L10)-v(VDD33)/(1+exp((10+0.5-(31-v(C2R)))/0.15)))/1k
BS2LN10 S2LN10 VSS I=(v(S2LN10)-(v(VDD33)-v(S2L10)))/1k
BS2L11 S2L11 VSS I=(v(S2L11)-v(VDD33)/(1+exp((11+0.5-(31-v(C2R)))/0.15)))/1k
BS2LN11 S2LN11 VSS I=(v(S2LN11)-(v(VDD33)-v(S2L11)))/1k
BS2L12 S2L12 VSS I=(v(S2L12)-v(VDD33)/(1+exp((12+0.5-(31-v(C2R)))/0.15)))/1k
BS2LN12 S2LN12 VSS I=(v(S2LN12)-(v(VDD33)-v(S2L12)))/1k
BS2L13 S2L13 VSS I=(v(S2L13)-v(VDD33)/(1+exp((13+0.5-(31-v(C2R)))/0.15)))/1k
BS2LN13 S2LN13 VSS I=(v(S2LN13)-(v(VDD33)-v(S2L13)))/1k
BS2L14 S2L14 VSS I=(v(S2L14)-v(VDD33)/(1+exp((14+0.5-(31-v(C2R)))/0.15)))/1k
BS2LN14 S2LN14 VSS I=(v(S2LN14)-(v(VDD33)-v(S2L14)))/1k
BS2L15 S2L15 VSS I=(v(S2L15)-v(VDD33)/(1+exp((15+0.5-(31-v(C2R)))/0.15)))/1k
BS2LN15 S2LN15 VSS I=(v(S2LN15)-(v(VDD33)-v(S2L15)))/1k
BS2L16 S2L16 VSS I=(v(S2L16)-v(VDD33)/(1+exp((16+0.5-(31-v(C2R)))/0.15)))/1k
BS2LN16 S2LN16 VSS I=(v(S2LN16)-(v(VDD33)-v(S2L16)))/1k
BS2L17 S2L17 VSS I=(v(S2L17)-v(VDD33)/(1+exp((17+0.5-(31-v(C2R)))/0.15)))/1k
BS2LN17 S2LN17 VSS I=(v(S2LN17)-(v(VDD33)-v(S2L17)))/1k
BS2L18 S2L18 VSS I=(v(S2L18)-v(VDD33)/(1+exp((18+0.5-(31-v(C2R)))/0.15)))/1k
BS2LN18 S2LN18 VSS I=(v(S2LN18)-(v(VDD33)-v(S2L18)))/1k
BS2L19 S2L19 VSS I=(v(S2L19)-v(VDD33)/(1+exp((19+0.5-(31-v(C2R)))/0.15)))/1k
BS2LN19 S2LN19 VSS I=(v(S2LN19)-(v(VDD33)-v(S2L19)))/1k
BS2L20 S2L20 VSS I=(v(S2L20)-v(VDD33)/(1+exp((20+0.5-(31-v(C2R)))/0.15)))/1k
BS2LN20 S2LN20 VSS I=(v(S2LN20)-(v(VDD33)-v(S2L20)))/1k
BS2L21 S2L21 VSS I=(v(S2L21)-v(VDD33)/(1+exp((21+0.5-(31-v(C2R)))/0.15)))/1k
BS2LN21 S2LN21 VSS I=(v(S2LN21)-(v(VDD33)-v(S2L21)))/1k
BS2L22 S2L22 VSS I=(v(S2L22)-v(VDD33)/(1+exp((22+0.5-(31-v(C2R)))/0.15)))/1k
BS2LN22 S2LN22 VSS I=(v(S2LN22)-(v(VDD33)-v(S2L22)))/1k
BS2L23 S2L23 VSS I=(v(S2L23)-v(VDD33)/(1+exp((23+0.5-(31-v(C2R)))/0.15)))/1k
BS2LN23 S2LN23 VSS I=(v(S2LN23)-(v(VDD33)-v(S2L23)))/1k
BS2L24 S2L24 VSS I=(v(S2L24)-v(VDD33)/(1+exp((24+0.5-(31-v(C2R)))/0.15)))/1k
BS2LN24 S2LN24 VSS I=(v(S2LN24)-(v(VDD33)-v(S2L24)))/1k
BS2L25 S2L25 VSS I=(v(S2L25)-v(VDD33)/(1+exp((25+0.5-(31-v(C2R)))/0.15)))/1k
BS2LN25 S2LN25 VSS I=(v(S2LN25)-(v(VDD33)-v(S2L25)))/1k
BS2L26 S2L26 VSS I=(v(S2L26)-v(VDD33)/(1+exp((26+0.5-(31-v(C2R)))/0.15)))/1k
BS2LN26 S2LN26 VSS I=(v(S2LN26)-(v(VDD33)-v(S2L26)))/1k
BS2L27 S2L27 VSS I=(v(S2L27)-v(VDD33)/(1+exp((27+0.5-(31-v(C2R)))/0.15)))/1k
BS2LN27 S2LN27 VSS I=(v(S2LN27)-(v(VDD33)-v(S2L27)))/1k
BS2L28 S2L28 VSS I=(v(S2L28)-v(VDD33)/(1+exp((28+0.5-(31-v(C2R)))/0.15)))/1k
BS2LN28 S2LN28 VSS I=(v(S2LN28)-(v(VDD33)-v(S2L28)))/1k
BS2L29 S2L29 VSS I=(v(S2L29)-v(VDD33)/(1+exp((29+0.5-(31-v(C2R)))/0.15)))/1k
BS2LN29 S2LN29 VSS I=(v(S2LN29)-(v(VDD33)-v(S2L29)))/1k
BS2L30 S2L30 VSS I=(v(S2L30)-v(VDD33)/(1+exp((30+0.5-(31-v(C2R)))/0.15)))/1k
BS2LN30 S2LN30 VSS I=(v(S2LN30)-(v(VDD33)-v(S2L30)))/1k
CSEL0 SEL0 VSS 2p
CSELN0 SELN0 VSS 2p
CS2L0 S2L0 VSS 2p
CS2LN0 S2LN0 VSS 2p
CSEL1 SEL1 VSS 2p
CSELN1 SELN1 VSS 2p
CS2L1 S2L1 VSS 2p
CS2LN1 S2LN1 VSS 2p
CSEL2 SEL2 VSS 2p
CSELN2 SELN2 VSS 2p
CS2L2 S2L2 VSS 2p
CS2LN2 S2LN2 VSS 2p
CSEL3 SEL3 VSS 2p
CSELN3 SELN3 VSS 2p
CS2L3 S2L3 VSS 2p
CS2LN3 S2LN3 VSS 2p
CSEL4 SEL4 VSS 2p
CSELN4 SELN4 VSS 2p
CS2L4 S2L4 VSS 2p
CS2LN4 S2LN4 VSS 2p
CSEL5 SEL5 VSS 2p
CSELN5 SELN5 VSS 2p
CS2L5 S2L5 VSS 2p
CS2LN5 S2LN5 VSS 2p
CSEL6 SEL6 VSS 2p
CSELN6 SELN6 VSS 2p
CS2L6 S2L6 VSS 2p
CS2LN6 S2LN6 VSS 2p
CSEL7 SEL7 VSS 2p
CSELN7 SELN7 VSS 2p
CS2L7 S2L7 VSS 2p
CS2LN7 S2LN7 VSS 2p
CSEL8 SEL8 VSS 2p
CSELN8 SELN8 VSS 2p
CS2L8 S2L8 VSS 2p
CS2LN8 S2LN8 VSS 2p
CSEL9 SEL9 VSS 2p
CSELN9 SELN9 VSS 2p
CS2L9 S2L9 VSS 2p
CS2LN9 S2LN9 VSS 2p
CSEL10 SEL10 VSS 2p
CSELN10 SELN10 VSS 2p
CS2L10 S2L10 VSS 2p
CS2LN10 S2LN10 VSS 2p
CSEL11 SEL11 VSS 2p
CSELN11 SELN11 VSS 2p
CS2L11 S2L11 VSS 2p
CS2LN11 S2LN11 VSS 2p
CSEL12 SEL12 VSS 2p
CSELN12 SELN12 VSS 2p
CS2L12 S2L12 VSS 2p
CS2LN12 S2LN12 VSS 2p
CSEL13 SEL13 VSS 2p
CSELN13 SELN13 VSS 2p
CS2L13 S2L13 VSS 2p
CS2LN13 S2LN13 VSS 2p
CSEL14 SEL14 VSS 2p
CSELN14 SELN14 VSS 2p
CS2L14 S2L14 VSS 2p
CS2LN14 S2LN14 VSS 2p
CSEL15 SEL15 VSS 2p
CSELN15 SELN15 VSS 2p
CS2L15 S2L15 VSS 2p
CS2LN15 S2LN15 VSS 2p
CSEL16 SEL16 VSS 2p
CSELN16 SELN16 VSS 2p
CS2L16 S2L16 VSS 2p
CS2LN16 S2LN16 VSS 2p
CSEL17 SEL17 VSS 2p
CSELN17 SELN17 VSS 2p
CS2L17 S2L17 VSS 2p
CS2LN17 S2LN17 VSS 2p
CSEL18 SEL18 VSS 2p
CSELN18 SELN18 VSS 2p
CS2L18 S2L18 VSS 2p
CS2LN18 S2LN18 VSS 2p
CSEL19 SEL19 VSS 2p
CSELN19 SELN19 VSS 2p
CS2L19 S2L19 VSS 2p
CS2LN19 S2LN19 VSS 2p
CSEL20 SEL20 VSS 2p
CSELN20 SELN20 VSS 2p
CS2L20 S2L20 VSS 2p
CS2LN20 S2LN20 VSS 2p
CSEL21 SEL21 VSS 2p
CSELN21 SELN21 VSS 2p
CS2L21 S2L21 VSS 2p
CS2LN21 S2LN21 VSS 2p
CSEL22 SEL22 VSS 2p
CSELN22 SELN22 VSS 2p
CS2L22 S2L22 VSS 2p
CS2LN22 S2LN22 VSS 2p
CSEL23 SEL23 VSS 2p
CSELN23 SELN23 VSS 2p
CS2L23 S2L23 VSS 2p
CS2LN23 S2LN23 VSS 2p
CSEL24 SEL24 VSS 2p
CSELN24 SELN24 VSS 2p
CS2L24 S2L24 VSS 2p
CS2LN24 S2LN24 VSS 2p
CSEL25 SEL25 VSS 2p
CSELN25 SELN25 VSS 2p
CS2L25 S2L25 VSS 2p
CS2LN25 S2LN25 VSS 2p
CSEL26 SEL26 VSS 2p
CSELN26 SELN26 VSS 2p
CS2L26 S2L26 VSS 2p
CS2LN26 S2LN26 VSS 2p
CSEL27 SEL27 VSS 2p
CSELN27 SELN27 VSS 2p
CS2L27 S2L27 VSS 2p
CS2LN27 S2LN27 VSS 2p
CSEL28 SEL28 VSS 2p
CSELN28 SELN28 VSS 2p
CS2L28 S2L28 VSS 2p
CS2LN28 S2LN28 VSS 2p
CSEL29 SEL29 VSS 2p
CSELN29 SELN29 VSS 2p
CS2L29 S2L29 VSS 2p
CS2LN29 S2LN29 VSS 2p
CSEL30 SEL30 VSS 2p
CSELN30 SELN30 VSS 2p
CS2L30 S2L30 VSS 2p
CS2LN30 S2LN30 VSS 2p
CCSUM CSUM VSS 0.5p
.ends gf180_sdm3_mod_mb
