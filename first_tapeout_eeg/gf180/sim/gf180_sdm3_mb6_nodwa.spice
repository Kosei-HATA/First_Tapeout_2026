* gf180_sdm3_mb6_nodwa.spice - 6-bit STRAIGHT-THERMOMETER (no DWA) (63-level) sdm3 variant for fs=512 kHz
* GENERATED by gen_sdm3_mb_nodwa.py - do not edit by hand.
* All behavioral B-sources are RC-smoothed current-source form
* (target-v)/R into a hold cap: ngspice-46 fails to converge on
* discontinuous B-source voltage branches (timestep-too-small at
* the input zero crossing, t=62.5026 ms). tau ~2 ns everywhere.
* Requires: gf180_afe_cells.spice (OTA/TG/bias) + gf180_sdm3.spice
* (strongarm, nand2, inv). Loop timing/coefficients identical to sdm3.
* Flash thresholds and DWA/thermometer logic are BEHAVIORAL (ideal
* sources / B-sources) - silicon needs a ladder + DWA RTL.

* ---- 63-level flash: strongarm + SR latch per slice ----
* H_i=1 <=> O2D > theta_i, theta_i=(i-31)*1.5625mV; H_i is the latch's NBIT
* terminal (BIT_i=1 <=> O2D<theta_i, same convention as 1-bit sdm3).
.subckt gf180_sdm3_flash63 O2P O2N CMPCK VDD33 VSS H0 H1 H2 H3 H4 H5 H6 H7 H8 H9 H10 H11 H12 H13 H14 H15 H16 H17 H18 H19 H20 H21 H22 H23 H24 H25 H26 H27 H28 H29 H30 H31 H32 H33 H34 H35 H36 H37 H38 H39 H40 H41 H42 H43 H44 H45 H46 H47 H48 H49 H50 H51 H52 H53 H54 H55 H56 H57 H58 H59 H60 H61 H62
* slice 0: theta=-48.44 mV diff
VOFFP0 O2P INPP0 2.421875e-02
VOFFN0 O2N INNN0 -2.421875e-02
XCMP0 INPP0 INNN0 QP0 QN0 CMPCK VDD33 VSS gf180_strongarm
CQP0 QP0 VSS 0.5p
CQN0 QN0 VSS 0.5p
XND10 QP0 H0 BIT0 VDD33 VSS gf180_sdm3_nand2
XND20 QN0 BIT0 H0 VDD33 VSS gf180_sdm3_nand2
* slice 1: theta=-46.88 mV diff
VOFFP1 O2P INPP1 2.343750e-02
VOFFN1 O2N INNN1 -2.343750e-02
XCMP1 INPP1 INNN1 QP1 QN1 CMPCK VDD33 VSS gf180_strongarm
CQP1 QP1 VSS 0.5p
CQN1 QN1 VSS 0.5p
XND11 QP1 H1 BIT1 VDD33 VSS gf180_sdm3_nand2
XND21 QN1 BIT1 H1 VDD33 VSS gf180_sdm3_nand2
* slice 2: theta=-45.31 mV diff
VOFFP2 O2P INPP2 2.265625e-02
VOFFN2 O2N INNN2 -2.265625e-02
XCMP2 INPP2 INNN2 QP2 QN2 CMPCK VDD33 VSS gf180_strongarm
CQP2 QP2 VSS 0.5p
CQN2 QN2 VSS 0.5p
XND12 QP2 H2 BIT2 VDD33 VSS gf180_sdm3_nand2
XND22 QN2 BIT2 H2 VDD33 VSS gf180_sdm3_nand2
* slice 3: theta=-43.75 mV diff
VOFFP3 O2P INPP3 2.187500e-02
VOFFN3 O2N INNN3 -2.187500e-02
XCMP3 INPP3 INNN3 QP3 QN3 CMPCK VDD33 VSS gf180_strongarm
CQP3 QP3 VSS 0.5p
CQN3 QN3 VSS 0.5p
XND13 QP3 H3 BIT3 VDD33 VSS gf180_sdm3_nand2
XND23 QN3 BIT3 H3 VDD33 VSS gf180_sdm3_nand2
* slice 4: theta=-42.19 mV diff
VOFFP4 O2P INPP4 2.109375e-02
VOFFN4 O2N INNN4 -2.109375e-02
XCMP4 INPP4 INNN4 QP4 QN4 CMPCK VDD33 VSS gf180_strongarm
CQP4 QP4 VSS 0.5p
CQN4 QN4 VSS 0.5p
XND14 QP4 H4 BIT4 VDD33 VSS gf180_sdm3_nand2
XND24 QN4 BIT4 H4 VDD33 VSS gf180_sdm3_nand2
* slice 5: theta=-40.62 mV diff
VOFFP5 O2P INPP5 2.031250e-02
VOFFN5 O2N INNN5 -2.031250e-02
XCMP5 INPP5 INNN5 QP5 QN5 CMPCK VDD33 VSS gf180_strongarm
CQP5 QP5 VSS 0.5p
CQN5 QN5 VSS 0.5p
XND15 QP5 H5 BIT5 VDD33 VSS gf180_sdm3_nand2
XND25 QN5 BIT5 H5 VDD33 VSS gf180_sdm3_nand2
* slice 6: theta=-39.06 mV diff
VOFFP6 O2P INPP6 1.953125e-02
VOFFN6 O2N INNN6 -1.953125e-02
XCMP6 INPP6 INNN6 QP6 QN6 CMPCK VDD33 VSS gf180_strongarm
CQP6 QP6 VSS 0.5p
CQN6 QN6 VSS 0.5p
XND16 QP6 H6 BIT6 VDD33 VSS gf180_sdm3_nand2
XND26 QN6 BIT6 H6 VDD33 VSS gf180_sdm3_nand2
* slice 7: theta=-37.50 mV diff
VOFFP7 O2P INPP7 1.875000e-02
VOFFN7 O2N INNN7 -1.875000e-02
XCMP7 INPP7 INNN7 QP7 QN7 CMPCK VDD33 VSS gf180_strongarm
CQP7 QP7 VSS 0.5p
CQN7 QN7 VSS 0.5p
XND17 QP7 H7 BIT7 VDD33 VSS gf180_sdm3_nand2
XND27 QN7 BIT7 H7 VDD33 VSS gf180_sdm3_nand2
* slice 8: theta=-35.94 mV diff
VOFFP8 O2P INPP8 1.796875e-02
VOFFN8 O2N INNN8 -1.796875e-02
XCMP8 INPP8 INNN8 QP8 QN8 CMPCK VDD33 VSS gf180_strongarm
CQP8 QP8 VSS 0.5p
CQN8 QN8 VSS 0.5p
XND18 QP8 H8 BIT8 VDD33 VSS gf180_sdm3_nand2
XND28 QN8 BIT8 H8 VDD33 VSS gf180_sdm3_nand2
* slice 9: theta=-34.38 mV diff
VOFFP9 O2P INPP9 1.718750e-02
VOFFN9 O2N INNN9 -1.718750e-02
XCMP9 INPP9 INNN9 QP9 QN9 CMPCK VDD33 VSS gf180_strongarm
CQP9 QP9 VSS 0.5p
CQN9 QN9 VSS 0.5p
XND19 QP9 H9 BIT9 VDD33 VSS gf180_sdm3_nand2
XND29 QN9 BIT9 H9 VDD33 VSS gf180_sdm3_nand2
* slice 10: theta=-32.81 mV diff
VOFFP10 O2P INPP10 1.640625e-02
VOFFN10 O2N INNN10 -1.640625e-02
XCMP10 INPP10 INNN10 QP10 QN10 CMPCK VDD33 VSS gf180_strongarm
CQP10 QP10 VSS 0.5p
CQN10 QN10 VSS 0.5p
XND110 QP10 H10 BIT10 VDD33 VSS gf180_sdm3_nand2
XND210 QN10 BIT10 H10 VDD33 VSS gf180_sdm3_nand2
* slice 11: theta=-31.25 mV diff
VOFFP11 O2P INPP11 1.562500e-02
VOFFN11 O2N INNN11 -1.562500e-02
XCMP11 INPP11 INNN11 QP11 QN11 CMPCK VDD33 VSS gf180_strongarm
CQP11 QP11 VSS 0.5p
CQN11 QN11 VSS 0.5p
XND111 QP11 H11 BIT11 VDD33 VSS gf180_sdm3_nand2
XND211 QN11 BIT11 H11 VDD33 VSS gf180_sdm3_nand2
* slice 12: theta=-29.69 mV diff
VOFFP12 O2P INPP12 1.484375e-02
VOFFN12 O2N INNN12 -1.484375e-02
XCMP12 INPP12 INNN12 QP12 QN12 CMPCK VDD33 VSS gf180_strongarm
CQP12 QP12 VSS 0.5p
CQN12 QN12 VSS 0.5p
XND112 QP12 H12 BIT12 VDD33 VSS gf180_sdm3_nand2
XND212 QN12 BIT12 H12 VDD33 VSS gf180_sdm3_nand2
* slice 13: theta=-28.12 mV diff
VOFFP13 O2P INPP13 1.406250e-02
VOFFN13 O2N INNN13 -1.406250e-02
XCMP13 INPP13 INNN13 QP13 QN13 CMPCK VDD33 VSS gf180_strongarm
CQP13 QP13 VSS 0.5p
CQN13 QN13 VSS 0.5p
XND113 QP13 H13 BIT13 VDD33 VSS gf180_sdm3_nand2
XND213 QN13 BIT13 H13 VDD33 VSS gf180_sdm3_nand2
* slice 14: theta=-26.56 mV diff
VOFFP14 O2P INPP14 1.328125e-02
VOFFN14 O2N INNN14 -1.328125e-02
XCMP14 INPP14 INNN14 QP14 QN14 CMPCK VDD33 VSS gf180_strongarm
CQP14 QP14 VSS 0.5p
CQN14 QN14 VSS 0.5p
XND114 QP14 H14 BIT14 VDD33 VSS gf180_sdm3_nand2
XND214 QN14 BIT14 H14 VDD33 VSS gf180_sdm3_nand2
* slice 15: theta=-25.00 mV diff
VOFFP15 O2P INPP15 1.250000e-02
VOFFN15 O2N INNN15 -1.250000e-02
XCMP15 INPP15 INNN15 QP15 QN15 CMPCK VDD33 VSS gf180_strongarm
CQP15 QP15 VSS 0.5p
CQN15 QN15 VSS 0.5p
XND115 QP15 H15 BIT15 VDD33 VSS gf180_sdm3_nand2
XND215 QN15 BIT15 H15 VDD33 VSS gf180_sdm3_nand2
* slice 16: theta=-23.44 mV diff
VOFFP16 O2P INPP16 1.171875e-02
VOFFN16 O2N INNN16 -1.171875e-02
XCMP16 INPP16 INNN16 QP16 QN16 CMPCK VDD33 VSS gf180_strongarm
CQP16 QP16 VSS 0.5p
CQN16 QN16 VSS 0.5p
XND116 QP16 H16 BIT16 VDD33 VSS gf180_sdm3_nand2
XND216 QN16 BIT16 H16 VDD33 VSS gf180_sdm3_nand2
* slice 17: theta=-21.88 mV diff
VOFFP17 O2P INPP17 1.093750e-02
VOFFN17 O2N INNN17 -1.093750e-02
XCMP17 INPP17 INNN17 QP17 QN17 CMPCK VDD33 VSS gf180_strongarm
CQP17 QP17 VSS 0.5p
CQN17 QN17 VSS 0.5p
XND117 QP17 H17 BIT17 VDD33 VSS gf180_sdm3_nand2
XND217 QN17 BIT17 H17 VDD33 VSS gf180_sdm3_nand2
* slice 18: theta=-20.31 mV diff
VOFFP18 O2P INPP18 1.015625e-02
VOFFN18 O2N INNN18 -1.015625e-02
XCMP18 INPP18 INNN18 QP18 QN18 CMPCK VDD33 VSS gf180_strongarm
CQP18 QP18 VSS 0.5p
CQN18 QN18 VSS 0.5p
XND118 QP18 H18 BIT18 VDD33 VSS gf180_sdm3_nand2
XND218 QN18 BIT18 H18 VDD33 VSS gf180_sdm3_nand2
* slice 19: theta=-18.75 mV diff
VOFFP19 O2P INPP19 9.375000e-03
VOFFN19 O2N INNN19 -9.375000e-03
XCMP19 INPP19 INNN19 QP19 QN19 CMPCK VDD33 VSS gf180_strongarm
CQP19 QP19 VSS 0.5p
CQN19 QN19 VSS 0.5p
XND119 QP19 H19 BIT19 VDD33 VSS gf180_sdm3_nand2
XND219 QN19 BIT19 H19 VDD33 VSS gf180_sdm3_nand2
* slice 20: theta=-17.19 mV diff
VOFFP20 O2P INPP20 8.593750e-03
VOFFN20 O2N INNN20 -8.593750e-03
XCMP20 INPP20 INNN20 QP20 QN20 CMPCK VDD33 VSS gf180_strongarm
CQP20 QP20 VSS 0.5p
CQN20 QN20 VSS 0.5p
XND120 QP20 H20 BIT20 VDD33 VSS gf180_sdm3_nand2
XND220 QN20 BIT20 H20 VDD33 VSS gf180_sdm3_nand2
* slice 21: theta=-15.62 mV diff
VOFFP21 O2P INPP21 7.812500e-03
VOFFN21 O2N INNN21 -7.812500e-03
XCMP21 INPP21 INNN21 QP21 QN21 CMPCK VDD33 VSS gf180_strongarm
CQP21 QP21 VSS 0.5p
CQN21 QN21 VSS 0.5p
XND121 QP21 H21 BIT21 VDD33 VSS gf180_sdm3_nand2
XND221 QN21 BIT21 H21 VDD33 VSS gf180_sdm3_nand2
* slice 22: theta=-14.06 mV diff
VOFFP22 O2P INPP22 7.031250e-03
VOFFN22 O2N INNN22 -7.031250e-03
XCMP22 INPP22 INNN22 QP22 QN22 CMPCK VDD33 VSS gf180_strongarm
CQP22 QP22 VSS 0.5p
CQN22 QN22 VSS 0.5p
XND122 QP22 H22 BIT22 VDD33 VSS gf180_sdm3_nand2
XND222 QN22 BIT22 H22 VDD33 VSS gf180_sdm3_nand2
* slice 23: theta=-12.50 mV diff
VOFFP23 O2P INPP23 6.250000e-03
VOFFN23 O2N INNN23 -6.250000e-03
XCMP23 INPP23 INNN23 QP23 QN23 CMPCK VDD33 VSS gf180_strongarm
CQP23 QP23 VSS 0.5p
CQN23 QN23 VSS 0.5p
XND123 QP23 H23 BIT23 VDD33 VSS gf180_sdm3_nand2
XND223 QN23 BIT23 H23 VDD33 VSS gf180_sdm3_nand2
* slice 24: theta=-10.94 mV diff
VOFFP24 O2P INPP24 5.468750e-03
VOFFN24 O2N INNN24 -5.468750e-03
XCMP24 INPP24 INNN24 QP24 QN24 CMPCK VDD33 VSS gf180_strongarm
CQP24 QP24 VSS 0.5p
CQN24 QN24 VSS 0.5p
XND124 QP24 H24 BIT24 VDD33 VSS gf180_sdm3_nand2
XND224 QN24 BIT24 H24 VDD33 VSS gf180_sdm3_nand2
* slice 25: theta=-9.38 mV diff
VOFFP25 O2P INPP25 4.687500e-03
VOFFN25 O2N INNN25 -4.687500e-03
XCMP25 INPP25 INNN25 QP25 QN25 CMPCK VDD33 VSS gf180_strongarm
CQP25 QP25 VSS 0.5p
CQN25 QN25 VSS 0.5p
XND125 QP25 H25 BIT25 VDD33 VSS gf180_sdm3_nand2
XND225 QN25 BIT25 H25 VDD33 VSS gf180_sdm3_nand2
* slice 26: theta=-7.81 mV diff
VOFFP26 O2P INPP26 3.906250e-03
VOFFN26 O2N INNN26 -3.906250e-03
XCMP26 INPP26 INNN26 QP26 QN26 CMPCK VDD33 VSS gf180_strongarm
CQP26 QP26 VSS 0.5p
CQN26 QN26 VSS 0.5p
XND126 QP26 H26 BIT26 VDD33 VSS gf180_sdm3_nand2
XND226 QN26 BIT26 H26 VDD33 VSS gf180_sdm3_nand2
* slice 27: theta=-6.25 mV diff
VOFFP27 O2P INPP27 3.125000e-03
VOFFN27 O2N INNN27 -3.125000e-03
XCMP27 INPP27 INNN27 QP27 QN27 CMPCK VDD33 VSS gf180_strongarm
CQP27 QP27 VSS 0.5p
CQN27 QN27 VSS 0.5p
XND127 QP27 H27 BIT27 VDD33 VSS gf180_sdm3_nand2
XND227 QN27 BIT27 H27 VDD33 VSS gf180_sdm3_nand2
* slice 28: theta=-4.69 mV diff
VOFFP28 O2P INPP28 2.343750e-03
VOFFN28 O2N INNN28 -2.343750e-03
XCMP28 INPP28 INNN28 QP28 QN28 CMPCK VDD33 VSS gf180_strongarm
CQP28 QP28 VSS 0.5p
CQN28 QN28 VSS 0.5p
XND128 QP28 H28 BIT28 VDD33 VSS gf180_sdm3_nand2
XND228 QN28 BIT28 H28 VDD33 VSS gf180_sdm3_nand2
* slice 29: theta=-3.12 mV diff
VOFFP29 O2P INPP29 1.562500e-03
VOFFN29 O2N INNN29 -1.562500e-03
XCMP29 INPP29 INNN29 QP29 QN29 CMPCK VDD33 VSS gf180_strongarm
CQP29 QP29 VSS 0.5p
CQN29 QN29 VSS 0.5p
XND129 QP29 H29 BIT29 VDD33 VSS gf180_sdm3_nand2
XND229 QN29 BIT29 H29 VDD33 VSS gf180_sdm3_nand2
* slice 30: theta=-1.56 mV diff
VOFFP30 O2P INPP30 7.812500e-04
VOFFN30 O2N INNN30 -7.812500e-04
XCMP30 INPP30 INNN30 QP30 QN30 CMPCK VDD33 VSS gf180_strongarm
CQP30 QP30 VSS 0.5p
CQN30 QN30 VSS 0.5p
XND130 QP30 H30 BIT30 VDD33 VSS gf180_sdm3_nand2
XND230 QN30 BIT30 H30 VDD33 VSS gf180_sdm3_nand2
* slice 31: theta=+0.00 mV diff
VOFFP31 O2P INPP31 -0.000000e+00
VOFFN31 O2N INNN31 0.000000e+00
XCMP31 INPP31 INNN31 QP31 QN31 CMPCK VDD33 VSS gf180_strongarm
CQP31 QP31 VSS 0.5p
CQN31 QN31 VSS 0.5p
XND131 QP31 H31 BIT31 VDD33 VSS gf180_sdm3_nand2
XND231 QN31 BIT31 H31 VDD33 VSS gf180_sdm3_nand2
* slice 32: theta=+1.56 mV diff
VOFFP32 O2P INPP32 -7.812500e-04
VOFFN32 O2N INNN32 7.812500e-04
XCMP32 INPP32 INNN32 QP32 QN32 CMPCK VDD33 VSS gf180_strongarm
CQP32 QP32 VSS 0.5p
CQN32 QN32 VSS 0.5p
XND132 QP32 H32 BIT32 VDD33 VSS gf180_sdm3_nand2
XND232 QN32 BIT32 H32 VDD33 VSS gf180_sdm3_nand2
* slice 33: theta=+3.12 mV diff
VOFFP33 O2P INPP33 -1.562500e-03
VOFFN33 O2N INNN33 1.562500e-03
XCMP33 INPP33 INNN33 QP33 QN33 CMPCK VDD33 VSS gf180_strongarm
CQP33 QP33 VSS 0.5p
CQN33 QN33 VSS 0.5p
XND133 QP33 H33 BIT33 VDD33 VSS gf180_sdm3_nand2
XND233 QN33 BIT33 H33 VDD33 VSS gf180_sdm3_nand2
* slice 34: theta=+4.69 mV diff
VOFFP34 O2P INPP34 -2.343750e-03
VOFFN34 O2N INNN34 2.343750e-03
XCMP34 INPP34 INNN34 QP34 QN34 CMPCK VDD33 VSS gf180_strongarm
CQP34 QP34 VSS 0.5p
CQN34 QN34 VSS 0.5p
XND134 QP34 H34 BIT34 VDD33 VSS gf180_sdm3_nand2
XND234 QN34 BIT34 H34 VDD33 VSS gf180_sdm3_nand2
* slice 35: theta=+6.25 mV diff
VOFFP35 O2P INPP35 -3.125000e-03
VOFFN35 O2N INNN35 3.125000e-03
XCMP35 INPP35 INNN35 QP35 QN35 CMPCK VDD33 VSS gf180_strongarm
CQP35 QP35 VSS 0.5p
CQN35 QN35 VSS 0.5p
XND135 QP35 H35 BIT35 VDD33 VSS gf180_sdm3_nand2
XND235 QN35 BIT35 H35 VDD33 VSS gf180_sdm3_nand2
* slice 36: theta=+7.81 mV diff
VOFFP36 O2P INPP36 -3.906250e-03
VOFFN36 O2N INNN36 3.906250e-03
XCMP36 INPP36 INNN36 QP36 QN36 CMPCK VDD33 VSS gf180_strongarm
CQP36 QP36 VSS 0.5p
CQN36 QN36 VSS 0.5p
XND136 QP36 H36 BIT36 VDD33 VSS gf180_sdm3_nand2
XND236 QN36 BIT36 H36 VDD33 VSS gf180_sdm3_nand2
* slice 37: theta=+9.38 mV diff
VOFFP37 O2P INPP37 -4.687500e-03
VOFFN37 O2N INNN37 4.687500e-03
XCMP37 INPP37 INNN37 QP37 QN37 CMPCK VDD33 VSS gf180_strongarm
CQP37 QP37 VSS 0.5p
CQN37 QN37 VSS 0.5p
XND137 QP37 H37 BIT37 VDD33 VSS gf180_sdm3_nand2
XND237 QN37 BIT37 H37 VDD33 VSS gf180_sdm3_nand2
* slice 38: theta=+10.94 mV diff
VOFFP38 O2P INPP38 -5.468750e-03
VOFFN38 O2N INNN38 5.468750e-03
XCMP38 INPP38 INNN38 QP38 QN38 CMPCK VDD33 VSS gf180_strongarm
CQP38 QP38 VSS 0.5p
CQN38 QN38 VSS 0.5p
XND138 QP38 H38 BIT38 VDD33 VSS gf180_sdm3_nand2
XND238 QN38 BIT38 H38 VDD33 VSS gf180_sdm3_nand2
* slice 39: theta=+12.50 mV diff
VOFFP39 O2P INPP39 -6.250000e-03
VOFFN39 O2N INNN39 6.250000e-03
XCMP39 INPP39 INNN39 QP39 QN39 CMPCK VDD33 VSS gf180_strongarm
CQP39 QP39 VSS 0.5p
CQN39 QN39 VSS 0.5p
XND139 QP39 H39 BIT39 VDD33 VSS gf180_sdm3_nand2
XND239 QN39 BIT39 H39 VDD33 VSS gf180_sdm3_nand2
* slice 40: theta=+14.06 mV diff
VOFFP40 O2P INPP40 -7.031250e-03
VOFFN40 O2N INNN40 7.031250e-03
XCMP40 INPP40 INNN40 QP40 QN40 CMPCK VDD33 VSS gf180_strongarm
CQP40 QP40 VSS 0.5p
CQN40 QN40 VSS 0.5p
XND140 QP40 H40 BIT40 VDD33 VSS gf180_sdm3_nand2
XND240 QN40 BIT40 H40 VDD33 VSS gf180_sdm3_nand2
* slice 41: theta=+15.62 mV diff
VOFFP41 O2P INPP41 -7.812500e-03
VOFFN41 O2N INNN41 7.812500e-03
XCMP41 INPP41 INNN41 QP41 QN41 CMPCK VDD33 VSS gf180_strongarm
CQP41 QP41 VSS 0.5p
CQN41 QN41 VSS 0.5p
XND141 QP41 H41 BIT41 VDD33 VSS gf180_sdm3_nand2
XND241 QN41 BIT41 H41 VDD33 VSS gf180_sdm3_nand2
* slice 42: theta=+17.19 mV diff
VOFFP42 O2P INPP42 -8.593750e-03
VOFFN42 O2N INNN42 8.593750e-03
XCMP42 INPP42 INNN42 QP42 QN42 CMPCK VDD33 VSS gf180_strongarm
CQP42 QP42 VSS 0.5p
CQN42 QN42 VSS 0.5p
XND142 QP42 H42 BIT42 VDD33 VSS gf180_sdm3_nand2
XND242 QN42 BIT42 H42 VDD33 VSS gf180_sdm3_nand2
* slice 43: theta=+18.75 mV diff
VOFFP43 O2P INPP43 -9.375000e-03
VOFFN43 O2N INNN43 9.375000e-03
XCMP43 INPP43 INNN43 QP43 QN43 CMPCK VDD33 VSS gf180_strongarm
CQP43 QP43 VSS 0.5p
CQN43 QN43 VSS 0.5p
XND143 QP43 H43 BIT43 VDD33 VSS gf180_sdm3_nand2
XND243 QN43 BIT43 H43 VDD33 VSS gf180_sdm3_nand2
* slice 44: theta=+20.31 mV diff
VOFFP44 O2P INPP44 -1.015625e-02
VOFFN44 O2N INNN44 1.015625e-02
XCMP44 INPP44 INNN44 QP44 QN44 CMPCK VDD33 VSS gf180_strongarm
CQP44 QP44 VSS 0.5p
CQN44 QN44 VSS 0.5p
XND144 QP44 H44 BIT44 VDD33 VSS gf180_sdm3_nand2
XND244 QN44 BIT44 H44 VDD33 VSS gf180_sdm3_nand2
* slice 45: theta=+21.88 mV diff
VOFFP45 O2P INPP45 -1.093750e-02
VOFFN45 O2N INNN45 1.093750e-02
XCMP45 INPP45 INNN45 QP45 QN45 CMPCK VDD33 VSS gf180_strongarm
CQP45 QP45 VSS 0.5p
CQN45 QN45 VSS 0.5p
XND145 QP45 H45 BIT45 VDD33 VSS gf180_sdm3_nand2
XND245 QN45 BIT45 H45 VDD33 VSS gf180_sdm3_nand2
* slice 46: theta=+23.44 mV diff
VOFFP46 O2P INPP46 -1.171875e-02
VOFFN46 O2N INNN46 1.171875e-02
XCMP46 INPP46 INNN46 QP46 QN46 CMPCK VDD33 VSS gf180_strongarm
CQP46 QP46 VSS 0.5p
CQN46 QN46 VSS 0.5p
XND146 QP46 H46 BIT46 VDD33 VSS gf180_sdm3_nand2
XND246 QN46 BIT46 H46 VDD33 VSS gf180_sdm3_nand2
* slice 47: theta=+25.00 mV diff
VOFFP47 O2P INPP47 -1.250000e-02
VOFFN47 O2N INNN47 1.250000e-02
XCMP47 INPP47 INNN47 QP47 QN47 CMPCK VDD33 VSS gf180_strongarm
CQP47 QP47 VSS 0.5p
CQN47 QN47 VSS 0.5p
XND147 QP47 H47 BIT47 VDD33 VSS gf180_sdm3_nand2
XND247 QN47 BIT47 H47 VDD33 VSS gf180_sdm3_nand2
* slice 48: theta=+26.56 mV diff
VOFFP48 O2P INPP48 -1.328125e-02
VOFFN48 O2N INNN48 1.328125e-02
XCMP48 INPP48 INNN48 QP48 QN48 CMPCK VDD33 VSS gf180_strongarm
CQP48 QP48 VSS 0.5p
CQN48 QN48 VSS 0.5p
XND148 QP48 H48 BIT48 VDD33 VSS gf180_sdm3_nand2
XND248 QN48 BIT48 H48 VDD33 VSS gf180_sdm3_nand2
* slice 49: theta=+28.12 mV diff
VOFFP49 O2P INPP49 -1.406250e-02
VOFFN49 O2N INNN49 1.406250e-02
XCMP49 INPP49 INNN49 QP49 QN49 CMPCK VDD33 VSS gf180_strongarm
CQP49 QP49 VSS 0.5p
CQN49 QN49 VSS 0.5p
XND149 QP49 H49 BIT49 VDD33 VSS gf180_sdm3_nand2
XND249 QN49 BIT49 H49 VDD33 VSS gf180_sdm3_nand2
* slice 50: theta=+29.69 mV diff
VOFFP50 O2P INPP50 -1.484375e-02
VOFFN50 O2N INNN50 1.484375e-02
XCMP50 INPP50 INNN50 QP50 QN50 CMPCK VDD33 VSS gf180_strongarm
CQP50 QP50 VSS 0.5p
CQN50 QN50 VSS 0.5p
XND150 QP50 H50 BIT50 VDD33 VSS gf180_sdm3_nand2
XND250 QN50 BIT50 H50 VDD33 VSS gf180_sdm3_nand2
* slice 51: theta=+31.25 mV diff
VOFFP51 O2P INPP51 -1.562500e-02
VOFFN51 O2N INNN51 1.562500e-02
XCMP51 INPP51 INNN51 QP51 QN51 CMPCK VDD33 VSS gf180_strongarm
CQP51 QP51 VSS 0.5p
CQN51 QN51 VSS 0.5p
XND151 QP51 H51 BIT51 VDD33 VSS gf180_sdm3_nand2
XND251 QN51 BIT51 H51 VDD33 VSS gf180_sdm3_nand2
* slice 52: theta=+32.81 mV diff
VOFFP52 O2P INPP52 -1.640625e-02
VOFFN52 O2N INNN52 1.640625e-02
XCMP52 INPP52 INNN52 QP52 QN52 CMPCK VDD33 VSS gf180_strongarm
CQP52 QP52 VSS 0.5p
CQN52 QN52 VSS 0.5p
XND152 QP52 H52 BIT52 VDD33 VSS gf180_sdm3_nand2
XND252 QN52 BIT52 H52 VDD33 VSS gf180_sdm3_nand2
* slice 53: theta=+34.38 mV diff
VOFFP53 O2P INPP53 -1.718750e-02
VOFFN53 O2N INNN53 1.718750e-02
XCMP53 INPP53 INNN53 QP53 QN53 CMPCK VDD33 VSS gf180_strongarm
CQP53 QP53 VSS 0.5p
CQN53 QN53 VSS 0.5p
XND153 QP53 H53 BIT53 VDD33 VSS gf180_sdm3_nand2
XND253 QN53 BIT53 H53 VDD33 VSS gf180_sdm3_nand2
* slice 54: theta=+35.94 mV diff
VOFFP54 O2P INPP54 -1.796875e-02
VOFFN54 O2N INNN54 1.796875e-02
XCMP54 INPP54 INNN54 QP54 QN54 CMPCK VDD33 VSS gf180_strongarm
CQP54 QP54 VSS 0.5p
CQN54 QN54 VSS 0.5p
XND154 QP54 H54 BIT54 VDD33 VSS gf180_sdm3_nand2
XND254 QN54 BIT54 H54 VDD33 VSS gf180_sdm3_nand2
* slice 55: theta=+37.50 mV diff
VOFFP55 O2P INPP55 -1.875000e-02
VOFFN55 O2N INNN55 1.875000e-02
XCMP55 INPP55 INNN55 QP55 QN55 CMPCK VDD33 VSS gf180_strongarm
CQP55 QP55 VSS 0.5p
CQN55 QN55 VSS 0.5p
XND155 QP55 H55 BIT55 VDD33 VSS gf180_sdm3_nand2
XND255 QN55 BIT55 H55 VDD33 VSS gf180_sdm3_nand2
* slice 56: theta=+39.06 mV diff
VOFFP56 O2P INPP56 -1.953125e-02
VOFFN56 O2N INNN56 1.953125e-02
XCMP56 INPP56 INNN56 QP56 QN56 CMPCK VDD33 VSS gf180_strongarm
CQP56 QP56 VSS 0.5p
CQN56 QN56 VSS 0.5p
XND156 QP56 H56 BIT56 VDD33 VSS gf180_sdm3_nand2
XND256 QN56 BIT56 H56 VDD33 VSS gf180_sdm3_nand2
* slice 57: theta=+40.62 mV diff
VOFFP57 O2P INPP57 -2.031250e-02
VOFFN57 O2N INNN57 2.031250e-02
XCMP57 INPP57 INNN57 QP57 QN57 CMPCK VDD33 VSS gf180_strongarm
CQP57 QP57 VSS 0.5p
CQN57 QN57 VSS 0.5p
XND157 QP57 H57 BIT57 VDD33 VSS gf180_sdm3_nand2
XND257 QN57 BIT57 H57 VDD33 VSS gf180_sdm3_nand2
* slice 58: theta=+42.19 mV diff
VOFFP58 O2P INPP58 -2.109375e-02
VOFFN58 O2N INNN58 2.109375e-02
XCMP58 INPP58 INNN58 QP58 QN58 CMPCK VDD33 VSS gf180_strongarm
CQP58 QP58 VSS 0.5p
CQN58 QN58 VSS 0.5p
XND158 QP58 H58 BIT58 VDD33 VSS gf180_sdm3_nand2
XND258 QN58 BIT58 H58 VDD33 VSS gf180_sdm3_nand2
* slice 59: theta=+43.75 mV diff
VOFFP59 O2P INPP59 -2.187500e-02
VOFFN59 O2N INNN59 2.187500e-02
XCMP59 INPP59 INNN59 QP59 QN59 CMPCK VDD33 VSS gf180_strongarm
CQP59 QP59 VSS 0.5p
CQN59 QN59 VSS 0.5p
XND159 QP59 H59 BIT59 VDD33 VSS gf180_sdm3_nand2
XND259 QN59 BIT59 H59 VDD33 VSS gf180_sdm3_nand2
* slice 60: theta=+45.31 mV diff
VOFFP60 O2P INPP60 -2.265625e-02
VOFFN60 O2N INNN60 2.265625e-02
XCMP60 INPP60 INNN60 QP60 QN60 CMPCK VDD33 VSS gf180_strongarm
CQP60 QP60 VSS 0.5p
CQN60 QN60 VSS 0.5p
XND160 QP60 H60 BIT60 VDD33 VSS gf180_sdm3_nand2
XND260 QN60 BIT60 H60 VDD33 VSS gf180_sdm3_nand2
* slice 61: theta=+46.88 mV diff
VOFFP61 O2P INPP61 -2.343750e-02
VOFFN61 O2N INNN61 2.343750e-02
XCMP61 INPP61 INNN61 QP61 QN61 CMPCK VDD33 VSS gf180_strongarm
CQP61 QP61 VSS 0.5p
CQN61 QN61 VSS 0.5p
XND161 QP61 H61 BIT61 VDD33 VSS gf180_sdm3_nand2
XND261 QN61 BIT61 H61 VDD33 VSS gf180_sdm3_nand2
* slice 62: theta=+48.44 mV diff
VOFFP62 O2P INPP62 -2.421875e-02
VOFFN62 O2N INNN62 2.421875e-02
XCMP62 INPP62 INNN62 QP62 QN62 CMPCK VDD33 VSS gf180_strongarm
CQP62 QP62 VSS 0.5p
CQN62 QN62 VSS 0.5p
XND162 QP62 H62 BIT62 VDD33 VSS gf180_sdm3_nand2
XND262 QN62 BIT62 H62 VDD33 VSS gf180_sdm3_nand2
.ends gf180_sdm3_flash63

* ---- int1 mb: CS=16p sampled input + 63x0.25p/side direct DAC, CI=8p ----
* SELP_j/SELN_j: 0/VDD level, unit j P-side left plate -> VP if SELP_j,
* else VN during PH2 (complement on N side: SELN_j=1 -> NP side to VP).
.subckt gf180_sdm3_int1_mb INP_S INN_S VCM_REF VP VN OUTP OUTN PH1 NPH1 PH2 NPH2 VDD33 VSS SP0 SP1 SP2 SP3 SP4 SP5 SP6 SP7 SP8 SP9 SP10 SP11 SP12 SP13 SP14 SP15 SP16 SP17 SP18 SP19 SP20 SP21 SP22 SP23 SP24 SP25 SP26 SP27 SP28 SP29 SP30 SP31 SP32 SP33 SP34 SP35 SP36 SP37 SP38 SP39 SP40 SP41 SP42 SP43 SP44 SP45 SP46 SP47 SP48 SP49 SP50 SP51 SP52 SP53 SP54 SP55 SP56 SP57 SP58 SP59 SP60 SP61 SP62 SN0 SN1 SN2 SN3 SN4 SN5 SN6 SN7 SN8 SN9 SN10 SN11 SN12 SN13 SN14 SN15 SN16 SN17 SN18 SN19 SN20 SN21 SN22 SN23 SN24 SN25 SN26 SN27 SN28 SN29 SN30 SN31 SN32 SN33 SN34 SN35 SN36 SN37 SN38 SN39 SN40 SN41 SN42 SN43 SN44 SN45 SN46 SN47 SN48 SN49 SN50 SN51 SN52 SN53 SN54 SN55 SN56 SN57 SN58 SN59 SN60 SN61 SN62 params: CS=16p CU=0.25p CI=8p W91=11u L91=2u W92=6u L92=2u W10=12u RSET=25k CC=10p
XOTA INP INN VCM_REF OUTP OUTN VDD33 VSS gf180_fd_ota_full2_nc W91={W91} L91={L91} W92={W92} L92={L92} W10={W10} RSET={RSET} CC={CC}
CSP CSLP CSRP {CS}
CSN CSLN CSRN {CS}
XS1A CSLP INP_S PH1 NPH1 VDD33 VSS gf180_tg_lowq
XS1B CSRP VCM_REF PH1 NPH1 VDD33 VSS gf180_tg_lowq
XS1C CSLN INN_S PH1 NPH1 VDD33 VSS gf180_tg_lowq
XS1D CSRN VCM_REF PH1 NPH1 VDD33 VSS gf180_tg_lowq
XS2A CSLP VCM_REF PH2 NPH2 VDD33 VSS gf180_tg_lowq
XS2B CSRP INP PH2 NPH2 VDD33 VSS gf180_tg_lowq
XS2C CSLN VCM_REF PH2 NPH2 VDD33 VSS gf180_tg_lowq
XS2D CSRN INN PH2 NPH2 VDD33 VSS gf180_tg_lowq
* DAC unit 0 (P side DP0, N side DN0)
CDP0 CDLP0 CDRP0 {CU}
CDN0 CDLN0 CDRN0 {CU}
XDPA0 CDLP0 VCM_REF PH1 NPH1 VDD33 VSS gf180_tg_lowq
XDPB0 CDRP0 VCM_REF PH1 NPH1 VDD33 VSS gf180_tg_lowq
XDNA0 CDLN0 VCM_REF PH1 NPH1 VDD33 VSS gf180_tg_lowq
XDNB0 CDRN0 VCM_REF PH1 NPH1 VDD33 VSS gf180_tg_lowq
XDP20 CDRP0 INP PH2 NPH2 VDD33 VSS gf180_tg_lowq
XDN20 CDRN0 INN PH2 NPH2 VDD33 VSS gf180_tg_lowq
BGPP0 GPP0 VSS I=(v(GPP0)-v(PH2)*v(SP0)/v(VDD33))/1k
BGPN0 GPN0 VSS I=(v(GPN0)-v(PH2)*(v(VDD33)-v(SP0))/v(VDD33))/1k
BGNP0 GNP0 VSS I=(v(GNP0)-v(PH2)*v(SN0)/v(VDD33))/1k
BGNN0 GNN0 VSS I=(v(GNN0)-v(PH2)*(v(VDD33)-v(SN0))/v(VDD33))/1k
BNOPP0 NGPP0 0 V=v(VDD33)-v(GPP0)
BNOPN0 NGPN0 0 V=v(VDD33)-v(GPN0)
BNONP0 NGNP0 0 V=v(VDD33)-v(GNP0)
BNONN0 NGNN0 0 V=v(VDD33)-v(GNN0)
CGPP0 GPP0 VSS 2p
CGPN0 GPN0 VSS 2p
CGNP0 GNP0 VSS 2p
CGNN0 GNN0 VSS 2p
CNGPP0 NGPP0 VSS 0.2p
CNGPN0 NGPN0 VSS 0.2p
CNGNP0 NGNP0 VSS 0.2p
CNGNN0 NGNN0 VSS 0.2p
XPVP0 CDLP0 VP GPP0 NGPP0 VDD33 VSS gf180_tg_lowq
XPVN0 CDLP0 VN GPN0 NGPN0 VDD33 VSS gf180_tg_lowq
XNVP0 CDLN0 VP GNP0 NGNP0 VDD33 VSS gf180_tg_lowq
XNVN0 CDLN0 VN GNN0 NGNN0 VDD33 VSS gf180_tg_lowq
* DAC unit 1 (P side DP1, N side DN1)
CDP1 CDLP1 CDRP1 {CU}
CDN1 CDLN1 CDRN1 {CU}
XDPA1 CDLP1 VCM_REF PH1 NPH1 VDD33 VSS gf180_tg_lowq
XDPB1 CDRP1 VCM_REF PH1 NPH1 VDD33 VSS gf180_tg_lowq
XDNA1 CDLN1 VCM_REF PH1 NPH1 VDD33 VSS gf180_tg_lowq
XDNB1 CDRN1 VCM_REF PH1 NPH1 VDD33 VSS gf180_tg_lowq
XDP21 CDRP1 INP PH2 NPH2 VDD33 VSS gf180_tg_lowq
XDN21 CDRN1 INN PH2 NPH2 VDD33 VSS gf180_tg_lowq
BGPP1 GPP1 VSS I=(v(GPP1)-v(PH2)*v(SP1)/v(VDD33))/1k
BGPN1 GPN1 VSS I=(v(GPN1)-v(PH2)*(v(VDD33)-v(SP1))/v(VDD33))/1k
BGNP1 GNP1 VSS I=(v(GNP1)-v(PH2)*v(SN1)/v(VDD33))/1k
BGNN1 GNN1 VSS I=(v(GNN1)-v(PH2)*(v(VDD33)-v(SN1))/v(VDD33))/1k
BNOPP1 NGPP1 0 V=v(VDD33)-v(GPP1)
BNOPN1 NGPN1 0 V=v(VDD33)-v(GPN1)
BNONP1 NGNP1 0 V=v(VDD33)-v(GNP1)
BNONN1 NGNN1 0 V=v(VDD33)-v(GNN1)
CGPP1 GPP1 VSS 2p
CGPN1 GPN1 VSS 2p
CGNP1 GNP1 VSS 2p
CGNN1 GNN1 VSS 2p
CNGPP1 NGPP1 VSS 0.2p
CNGPN1 NGPN1 VSS 0.2p
CNGNP1 NGNP1 VSS 0.2p
CNGNN1 NGNN1 VSS 0.2p
XPVP1 CDLP1 VP GPP1 NGPP1 VDD33 VSS gf180_tg_lowq
XPVN1 CDLP1 VN GPN1 NGPN1 VDD33 VSS gf180_tg_lowq
XNVP1 CDLN1 VP GNP1 NGNP1 VDD33 VSS gf180_tg_lowq
XNVN1 CDLN1 VN GNN1 NGNN1 VDD33 VSS gf180_tg_lowq
* DAC unit 2 (P side DP2, N side DN2)
CDP2 CDLP2 CDRP2 {CU}
CDN2 CDLN2 CDRN2 {CU}
XDPA2 CDLP2 VCM_REF PH1 NPH1 VDD33 VSS gf180_tg_lowq
XDPB2 CDRP2 VCM_REF PH1 NPH1 VDD33 VSS gf180_tg_lowq
XDNA2 CDLN2 VCM_REF PH1 NPH1 VDD33 VSS gf180_tg_lowq
XDNB2 CDRN2 VCM_REF PH1 NPH1 VDD33 VSS gf180_tg_lowq
XDP22 CDRP2 INP PH2 NPH2 VDD33 VSS gf180_tg_lowq
XDN22 CDRN2 INN PH2 NPH2 VDD33 VSS gf180_tg_lowq
BGPP2 GPP2 VSS I=(v(GPP2)-v(PH2)*v(SP2)/v(VDD33))/1k
BGPN2 GPN2 VSS I=(v(GPN2)-v(PH2)*(v(VDD33)-v(SP2))/v(VDD33))/1k
BGNP2 GNP2 VSS I=(v(GNP2)-v(PH2)*v(SN2)/v(VDD33))/1k
BGNN2 GNN2 VSS I=(v(GNN2)-v(PH2)*(v(VDD33)-v(SN2))/v(VDD33))/1k
BNOPP2 NGPP2 0 V=v(VDD33)-v(GPP2)
BNOPN2 NGPN2 0 V=v(VDD33)-v(GPN2)
BNONP2 NGNP2 0 V=v(VDD33)-v(GNP2)
BNONN2 NGNN2 0 V=v(VDD33)-v(GNN2)
CGPP2 GPP2 VSS 2p
CGPN2 GPN2 VSS 2p
CGNP2 GNP2 VSS 2p
CGNN2 GNN2 VSS 2p
CNGPP2 NGPP2 VSS 0.2p
CNGPN2 NGPN2 VSS 0.2p
CNGNP2 NGNP2 VSS 0.2p
CNGNN2 NGNN2 VSS 0.2p
XPVP2 CDLP2 VP GPP2 NGPP2 VDD33 VSS gf180_tg_lowq
XPVN2 CDLP2 VN GPN2 NGPN2 VDD33 VSS gf180_tg_lowq
XNVP2 CDLN2 VP GNP2 NGNP2 VDD33 VSS gf180_tg_lowq
XNVN2 CDLN2 VN GNN2 NGNN2 VDD33 VSS gf180_tg_lowq
* DAC unit 3 (P side DP3, N side DN3)
CDP3 CDLP3 CDRP3 {CU}
CDN3 CDLN3 CDRN3 {CU}
XDPA3 CDLP3 VCM_REF PH1 NPH1 VDD33 VSS gf180_tg_lowq
XDPB3 CDRP3 VCM_REF PH1 NPH1 VDD33 VSS gf180_tg_lowq
XDNA3 CDLN3 VCM_REF PH1 NPH1 VDD33 VSS gf180_tg_lowq
XDNB3 CDRN3 VCM_REF PH1 NPH1 VDD33 VSS gf180_tg_lowq
XDP23 CDRP3 INP PH2 NPH2 VDD33 VSS gf180_tg_lowq
XDN23 CDRN3 INN PH2 NPH2 VDD33 VSS gf180_tg_lowq
BGPP3 GPP3 VSS I=(v(GPP3)-v(PH2)*v(SP3)/v(VDD33))/1k
BGPN3 GPN3 VSS I=(v(GPN3)-v(PH2)*(v(VDD33)-v(SP3))/v(VDD33))/1k
BGNP3 GNP3 VSS I=(v(GNP3)-v(PH2)*v(SN3)/v(VDD33))/1k
BGNN3 GNN3 VSS I=(v(GNN3)-v(PH2)*(v(VDD33)-v(SN3))/v(VDD33))/1k
BNOPP3 NGPP3 0 V=v(VDD33)-v(GPP3)
BNOPN3 NGPN3 0 V=v(VDD33)-v(GPN3)
BNONP3 NGNP3 0 V=v(VDD33)-v(GNP3)
BNONN3 NGNN3 0 V=v(VDD33)-v(GNN3)
CGPP3 GPP3 VSS 2p
CGPN3 GPN3 VSS 2p
CGNP3 GNP3 VSS 2p
CGNN3 GNN3 VSS 2p
CNGPP3 NGPP3 VSS 0.2p
CNGPN3 NGPN3 VSS 0.2p
CNGNP3 NGNP3 VSS 0.2p
CNGNN3 NGNN3 VSS 0.2p
XPVP3 CDLP3 VP GPP3 NGPP3 VDD33 VSS gf180_tg_lowq
XPVN3 CDLP3 VN GPN3 NGPN3 VDD33 VSS gf180_tg_lowq
XNVP3 CDLN3 VP GNP3 NGNP3 VDD33 VSS gf180_tg_lowq
XNVN3 CDLN3 VN GNN3 NGNN3 VDD33 VSS gf180_tg_lowq
* DAC unit 4 (P side DP4, N side DN4)
CDP4 CDLP4 CDRP4 {CU}
CDN4 CDLN4 CDRN4 {CU}
XDPA4 CDLP4 VCM_REF PH1 NPH1 VDD33 VSS gf180_tg_lowq
XDPB4 CDRP4 VCM_REF PH1 NPH1 VDD33 VSS gf180_tg_lowq
XDNA4 CDLN4 VCM_REF PH1 NPH1 VDD33 VSS gf180_tg_lowq
XDNB4 CDRN4 VCM_REF PH1 NPH1 VDD33 VSS gf180_tg_lowq
XDP24 CDRP4 INP PH2 NPH2 VDD33 VSS gf180_tg_lowq
XDN24 CDRN4 INN PH2 NPH2 VDD33 VSS gf180_tg_lowq
BGPP4 GPP4 VSS I=(v(GPP4)-v(PH2)*v(SP4)/v(VDD33))/1k
BGPN4 GPN4 VSS I=(v(GPN4)-v(PH2)*(v(VDD33)-v(SP4))/v(VDD33))/1k
BGNP4 GNP4 VSS I=(v(GNP4)-v(PH2)*v(SN4)/v(VDD33))/1k
BGNN4 GNN4 VSS I=(v(GNN4)-v(PH2)*(v(VDD33)-v(SN4))/v(VDD33))/1k
BNOPP4 NGPP4 0 V=v(VDD33)-v(GPP4)
BNOPN4 NGPN4 0 V=v(VDD33)-v(GPN4)
BNONP4 NGNP4 0 V=v(VDD33)-v(GNP4)
BNONN4 NGNN4 0 V=v(VDD33)-v(GNN4)
CGPP4 GPP4 VSS 2p
CGPN4 GPN4 VSS 2p
CGNP4 GNP4 VSS 2p
CGNN4 GNN4 VSS 2p
CNGPP4 NGPP4 VSS 0.2p
CNGPN4 NGPN4 VSS 0.2p
CNGNP4 NGNP4 VSS 0.2p
CNGNN4 NGNN4 VSS 0.2p
XPVP4 CDLP4 VP GPP4 NGPP4 VDD33 VSS gf180_tg_lowq
XPVN4 CDLP4 VN GPN4 NGPN4 VDD33 VSS gf180_tg_lowq
XNVP4 CDLN4 VP GNP4 NGNP4 VDD33 VSS gf180_tg_lowq
XNVN4 CDLN4 VN GNN4 NGNN4 VDD33 VSS gf180_tg_lowq
* DAC unit 5 (P side DP5, N side DN5)
CDP5 CDLP5 CDRP5 {CU}
CDN5 CDLN5 CDRN5 {CU}
XDPA5 CDLP5 VCM_REF PH1 NPH1 VDD33 VSS gf180_tg_lowq
XDPB5 CDRP5 VCM_REF PH1 NPH1 VDD33 VSS gf180_tg_lowq
XDNA5 CDLN5 VCM_REF PH1 NPH1 VDD33 VSS gf180_tg_lowq
XDNB5 CDRN5 VCM_REF PH1 NPH1 VDD33 VSS gf180_tg_lowq
XDP25 CDRP5 INP PH2 NPH2 VDD33 VSS gf180_tg_lowq
XDN25 CDRN5 INN PH2 NPH2 VDD33 VSS gf180_tg_lowq
BGPP5 GPP5 VSS I=(v(GPP5)-v(PH2)*v(SP5)/v(VDD33))/1k
BGPN5 GPN5 VSS I=(v(GPN5)-v(PH2)*(v(VDD33)-v(SP5))/v(VDD33))/1k
BGNP5 GNP5 VSS I=(v(GNP5)-v(PH2)*v(SN5)/v(VDD33))/1k
BGNN5 GNN5 VSS I=(v(GNN5)-v(PH2)*(v(VDD33)-v(SN5))/v(VDD33))/1k
BNOPP5 NGPP5 0 V=v(VDD33)-v(GPP5)
BNOPN5 NGPN5 0 V=v(VDD33)-v(GPN5)
BNONP5 NGNP5 0 V=v(VDD33)-v(GNP5)
BNONN5 NGNN5 0 V=v(VDD33)-v(GNN5)
CGPP5 GPP5 VSS 2p
CGPN5 GPN5 VSS 2p
CGNP5 GNP5 VSS 2p
CGNN5 GNN5 VSS 2p
CNGPP5 NGPP5 VSS 0.2p
CNGPN5 NGPN5 VSS 0.2p
CNGNP5 NGNP5 VSS 0.2p
CNGNN5 NGNN5 VSS 0.2p
XPVP5 CDLP5 VP GPP5 NGPP5 VDD33 VSS gf180_tg_lowq
XPVN5 CDLP5 VN GPN5 NGPN5 VDD33 VSS gf180_tg_lowq
XNVP5 CDLN5 VP GNP5 NGNP5 VDD33 VSS gf180_tg_lowq
XNVN5 CDLN5 VN GNN5 NGNN5 VDD33 VSS gf180_tg_lowq
* DAC unit 6 (P side DP6, N side DN6)
CDP6 CDLP6 CDRP6 {CU}
CDN6 CDLN6 CDRN6 {CU}
XDPA6 CDLP6 VCM_REF PH1 NPH1 VDD33 VSS gf180_tg_lowq
XDPB6 CDRP6 VCM_REF PH1 NPH1 VDD33 VSS gf180_tg_lowq
XDNA6 CDLN6 VCM_REF PH1 NPH1 VDD33 VSS gf180_tg_lowq
XDNB6 CDRN6 VCM_REF PH1 NPH1 VDD33 VSS gf180_tg_lowq
XDP26 CDRP6 INP PH2 NPH2 VDD33 VSS gf180_tg_lowq
XDN26 CDRN6 INN PH2 NPH2 VDD33 VSS gf180_tg_lowq
BGPP6 GPP6 VSS I=(v(GPP6)-v(PH2)*v(SP6)/v(VDD33))/1k
BGPN6 GPN6 VSS I=(v(GPN6)-v(PH2)*(v(VDD33)-v(SP6))/v(VDD33))/1k
BGNP6 GNP6 VSS I=(v(GNP6)-v(PH2)*v(SN6)/v(VDD33))/1k
BGNN6 GNN6 VSS I=(v(GNN6)-v(PH2)*(v(VDD33)-v(SN6))/v(VDD33))/1k
BNOPP6 NGPP6 0 V=v(VDD33)-v(GPP6)
BNOPN6 NGPN6 0 V=v(VDD33)-v(GPN6)
BNONP6 NGNP6 0 V=v(VDD33)-v(GNP6)
BNONN6 NGNN6 0 V=v(VDD33)-v(GNN6)
CGPP6 GPP6 VSS 2p
CGPN6 GPN6 VSS 2p
CGNP6 GNP6 VSS 2p
CGNN6 GNN6 VSS 2p
CNGPP6 NGPP6 VSS 0.2p
CNGPN6 NGPN6 VSS 0.2p
CNGNP6 NGNP6 VSS 0.2p
CNGNN6 NGNN6 VSS 0.2p
XPVP6 CDLP6 VP GPP6 NGPP6 VDD33 VSS gf180_tg_lowq
XPVN6 CDLP6 VN GPN6 NGPN6 VDD33 VSS gf180_tg_lowq
XNVP6 CDLN6 VP GNP6 NGNP6 VDD33 VSS gf180_tg_lowq
XNVN6 CDLN6 VN GNN6 NGNN6 VDD33 VSS gf180_tg_lowq
* DAC unit 7 (P side DP7, N side DN7)
CDP7 CDLP7 CDRP7 {CU}
CDN7 CDLN7 CDRN7 {CU}
XDPA7 CDLP7 VCM_REF PH1 NPH1 VDD33 VSS gf180_tg_lowq
XDPB7 CDRP7 VCM_REF PH1 NPH1 VDD33 VSS gf180_tg_lowq
XDNA7 CDLN7 VCM_REF PH1 NPH1 VDD33 VSS gf180_tg_lowq
XDNB7 CDRN7 VCM_REF PH1 NPH1 VDD33 VSS gf180_tg_lowq
XDP27 CDRP7 INP PH2 NPH2 VDD33 VSS gf180_tg_lowq
XDN27 CDRN7 INN PH2 NPH2 VDD33 VSS gf180_tg_lowq
BGPP7 GPP7 VSS I=(v(GPP7)-v(PH2)*v(SP7)/v(VDD33))/1k
BGPN7 GPN7 VSS I=(v(GPN7)-v(PH2)*(v(VDD33)-v(SP7))/v(VDD33))/1k
BGNP7 GNP7 VSS I=(v(GNP7)-v(PH2)*v(SN7)/v(VDD33))/1k
BGNN7 GNN7 VSS I=(v(GNN7)-v(PH2)*(v(VDD33)-v(SN7))/v(VDD33))/1k
BNOPP7 NGPP7 0 V=v(VDD33)-v(GPP7)
BNOPN7 NGPN7 0 V=v(VDD33)-v(GPN7)
BNONP7 NGNP7 0 V=v(VDD33)-v(GNP7)
BNONN7 NGNN7 0 V=v(VDD33)-v(GNN7)
CGPP7 GPP7 VSS 2p
CGPN7 GPN7 VSS 2p
CGNP7 GNP7 VSS 2p
CGNN7 GNN7 VSS 2p
CNGPP7 NGPP7 VSS 0.2p
CNGPN7 NGPN7 VSS 0.2p
CNGNP7 NGNP7 VSS 0.2p
CNGNN7 NGNN7 VSS 0.2p
XPVP7 CDLP7 VP GPP7 NGPP7 VDD33 VSS gf180_tg_lowq
XPVN7 CDLP7 VN GPN7 NGPN7 VDD33 VSS gf180_tg_lowq
XNVP7 CDLN7 VP GNP7 NGNP7 VDD33 VSS gf180_tg_lowq
XNVN7 CDLN7 VN GNN7 NGNN7 VDD33 VSS gf180_tg_lowq
* DAC unit 8 (P side DP8, N side DN8)
CDP8 CDLP8 CDRP8 {CU}
CDN8 CDLN8 CDRN8 {CU}
XDPA8 CDLP8 VCM_REF PH1 NPH1 VDD33 VSS gf180_tg_lowq
XDPB8 CDRP8 VCM_REF PH1 NPH1 VDD33 VSS gf180_tg_lowq
XDNA8 CDLN8 VCM_REF PH1 NPH1 VDD33 VSS gf180_tg_lowq
XDNB8 CDRN8 VCM_REF PH1 NPH1 VDD33 VSS gf180_tg_lowq
XDP28 CDRP8 INP PH2 NPH2 VDD33 VSS gf180_tg_lowq
XDN28 CDRN8 INN PH2 NPH2 VDD33 VSS gf180_tg_lowq
BGPP8 GPP8 VSS I=(v(GPP8)-v(PH2)*v(SP8)/v(VDD33))/1k
BGPN8 GPN8 VSS I=(v(GPN8)-v(PH2)*(v(VDD33)-v(SP8))/v(VDD33))/1k
BGNP8 GNP8 VSS I=(v(GNP8)-v(PH2)*v(SN8)/v(VDD33))/1k
BGNN8 GNN8 VSS I=(v(GNN8)-v(PH2)*(v(VDD33)-v(SN8))/v(VDD33))/1k
BNOPP8 NGPP8 0 V=v(VDD33)-v(GPP8)
BNOPN8 NGPN8 0 V=v(VDD33)-v(GPN8)
BNONP8 NGNP8 0 V=v(VDD33)-v(GNP8)
BNONN8 NGNN8 0 V=v(VDD33)-v(GNN8)
CGPP8 GPP8 VSS 2p
CGPN8 GPN8 VSS 2p
CGNP8 GNP8 VSS 2p
CGNN8 GNN8 VSS 2p
CNGPP8 NGPP8 VSS 0.2p
CNGPN8 NGPN8 VSS 0.2p
CNGNP8 NGNP8 VSS 0.2p
CNGNN8 NGNN8 VSS 0.2p
XPVP8 CDLP8 VP GPP8 NGPP8 VDD33 VSS gf180_tg_lowq
XPVN8 CDLP8 VN GPN8 NGPN8 VDD33 VSS gf180_tg_lowq
XNVP8 CDLN8 VP GNP8 NGNP8 VDD33 VSS gf180_tg_lowq
XNVN8 CDLN8 VN GNN8 NGNN8 VDD33 VSS gf180_tg_lowq
* DAC unit 9 (P side DP9, N side DN9)
CDP9 CDLP9 CDRP9 {CU}
CDN9 CDLN9 CDRN9 {CU}
XDPA9 CDLP9 VCM_REF PH1 NPH1 VDD33 VSS gf180_tg_lowq
XDPB9 CDRP9 VCM_REF PH1 NPH1 VDD33 VSS gf180_tg_lowq
XDNA9 CDLN9 VCM_REF PH1 NPH1 VDD33 VSS gf180_tg_lowq
XDNB9 CDRN9 VCM_REF PH1 NPH1 VDD33 VSS gf180_tg_lowq
XDP29 CDRP9 INP PH2 NPH2 VDD33 VSS gf180_tg_lowq
XDN29 CDRN9 INN PH2 NPH2 VDD33 VSS gf180_tg_lowq
BGPP9 GPP9 VSS I=(v(GPP9)-v(PH2)*v(SP9)/v(VDD33))/1k
BGPN9 GPN9 VSS I=(v(GPN9)-v(PH2)*(v(VDD33)-v(SP9))/v(VDD33))/1k
BGNP9 GNP9 VSS I=(v(GNP9)-v(PH2)*v(SN9)/v(VDD33))/1k
BGNN9 GNN9 VSS I=(v(GNN9)-v(PH2)*(v(VDD33)-v(SN9))/v(VDD33))/1k
BNOPP9 NGPP9 0 V=v(VDD33)-v(GPP9)
BNOPN9 NGPN9 0 V=v(VDD33)-v(GPN9)
BNONP9 NGNP9 0 V=v(VDD33)-v(GNP9)
BNONN9 NGNN9 0 V=v(VDD33)-v(GNN9)
CGPP9 GPP9 VSS 2p
CGPN9 GPN9 VSS 2p
CGNP9 GNP9 VSS 2p
CGNN9 GNN9 VSS 2p
CNGPP9 NGPP9 VSS 0.2p
CNGPN9 NGPN9 VSS 0.2p
CNGNP9 NGNP9 VSS 0.2p
CNGNN9 NGNN9 VSS 0.2p
XPVP9 CDLP9 VP GPP9 NGPP9 VDD33 VSS gf180_tg_lowq
XPVN9 CDLP9 VN GPN9 NGPN9 VDD33 VSS gf180_tg_lowq
XNVP9 CDLN9 VP GNP9 NGNP9 VDD33 VSS gf180_tg_lowq
XNVN9 CDLN9 VN GNN9 NGNN9 VDD33 VSS gf180_tg_lowq
* DAC unit 10 (P side DP10, N side DN10)
CDP10 CDLP10 CDRP10 {CU}
CDN10 CDLN10 CDRN10 {CU}
XDPA10 CDLP10 VCM_REF PH1 NPH1 VDD33 VSS gf180_tg_lowq
XDPB10 CDRP10 VCM_REF PH1 NPH1 VDD33 VSS gf180_tg_lowq
XDNA10 CDLN10 VCM_REF PH1 NPH1 VDD33 VSS gf180_tg_lowq
XDNB10 CDRN10 VCM_REF PH1 NPH1 VDD33 VSS gf180_tg_lowq
XDP210 CDRP10 INP PH2 NPH2 VDD33 VSS gf180_tg_lowq
XDN210 CDRN10 INN PH2 NPH2 VDD33 VSS gf180_tg_lowq
BGPP10 GPP10 VSS I=(v(GPP10)-v(PH2)*v(SP10)/v(VDD33))/1k
BGPN10 GPN10 VSS I=(v(GPN10)-v(PH2)*(v(VDD33)-v(SP10))/v(VDD33))/1k
BGNP10 GNP10 VSS I=(v(GNP10)-v(PH2)*v(SN10)/v(VDD33))/1k
BGNN10 GNN10 VSS I=(v(GNN10)-v(PH2)*(v(VDD33)-v(SN10))/v(VDD33))/1k
BNOPP10 NGPP10 0 V=v(VDD33)-v(GPP10)
BNOPN10 NGPN10 0 V=v(VDD33)-v(GPN10)
BNONP10 NGNP10 0 V=v(VDD33)-v(GNP10)
BNONN10 NGNN10 0 V=v(VDD33)-v(GNN10)
CGPP10 GPP10 VSS 2p
CGPN10 GPN10 VSS 2p
CGNP10 GNP10 VSS 2p
CGNN10 GNN10 VSS 2p
CNGPP10 NGPP10 VSS 0.2p
CNGPN10 NGPN10 VSS 0.2p
CNGNP10 NGNP10 VSS 0.2p
CNGNN10 NGNN10 VSS 0.2p
XPVP10 CDLP10 VP GPP10 NGPP10 VDD33 VSS gf180_tg_lowq
XPVN10 CDLP10 VN GPN10 NGPN10 VDD33 VSS gf180_tg_lowq
XNVP10 CDLN10 VP GNP10 NGNP10 VDD33 VSS gf180_tg_lowq
XNVN10 CDLN10 VN GNN10 NGNN10 VDD33 VSS gf180_tg_lowq
* DAC unit 11 (P side DP11, N side DN11)
CDP11 CDLP11 CDRP11 {CU}
CDN11 CDLN11 CDRN11 {CU}
XDPA11 CDLP11 VCM_REF PH1 NPH1 VDD33 VSS gf180_tg_lowq
XDPB11 CDRP11 VCM_REF PH1 NPH1 VDD33 VSS gf180_tg_lowq
XDNA11 CDLN11 VCM_REF PH1 NPH1 VDD33 VSS gf180_tg_lowq
XDNB11 CDRN11 VCM_REF PH1 NPH1 VDD33 VSS gf180_tg_lowq
XDP211 CDRP11 INP PH2 NPH2 VDD33 VSS gf180_tg_lowq
XDN211 CDRN11 INN PH2 NPH2 VDD33 VSS gf180_tg_lowq
BGPP11 GPP11 VSS I=(v(GPP11)-v(PH2)*v(SP11)/v(VDD33))/1k
BGPN11 GPN11 VSS I=(v(GPN11)-v(PH2)*(v(VDD33)-v(SP11))/v(VDD33))/1k
BGNP11 GNP11 VSS I=(v(GNP11)-v(PH2)*v(SN11)/v(VDD33))/1k
BGNN11 GNN11 VSS I=(v(GNN11)-v(PH2)*(v(VDD33)-v(SN11))/v(VDD33))/1k
BNOPP11 NGPP11 0 V=v(VDD33)-v(GPP11)
BNOPN11 NGPN11 0 V=v(VDD33)-v(GPN11)
BNONP11 NGNP11 0 V=v(VDD33)-v(GNP11)
BNONN11 NGNN11 0 V=v(VDD33)-v(GNN11)
CGPP11 GPP11 VSS 2p
CGPN11 GPN11 VSS 2p
CGNP11 GNP11 VSS 2p
CGNN11 GNN11 VSS 2p
CNGPP11 NGPP11 VSS 0.2p
CNGPN11 NGPN11 VSS 0.2p
CNGNP11 NGNP11 VSS 0.2p
CNGNN11 NGNN11 VSS 0.2p
XPVP11 CDLP11 VP GPP11 NGPP11 VDD33 VSS gf180_tg_lowq
XPVN11 CDLP11 VN GPN11 NGPN11 VDD33 VSS gf180_tg_lowq
XNVP11 CDLN11 VP GNP11 NGNP11 VDD33 VSS gf180_tg_lowq
XNVN11 CDLN11 VN GNN11 NGNN11 VDD33 VSS gf180_tg_lowq
* DAC unit 12 (P side DP12, N side DN12)
CDP12 CDLP12 CDRP12 {CU}
CDN12 CDLN12 CDRN12 {CU}
XDPA12 CDLP12 VCM_REF PH1 NPH1 VDD33 VSS gf180_tg_lowq
XDPB12 CDRP12 VCM_REF PH1 NPH1 VDD33 VSS gf180_tg_lowq
XDNA12 CDLN12 VCM_REF PH1 NPH1 VDD33 VSS gf180_tg_lowq
XDNB12 CDRN12 VCM_REF PH1 NPH1 VDD33 VSS gf180_tg_lowq
XDP212 CDRP12 INP PH2 NPH2 VDD33 VSS gf180_tg_lowq
XDN212 CDRN12 INN PH2 NPH2 VDD33 VSS gf180_tg_lowq
BGPP12 GPP12 VSS I=(v(GPP12)-v(PH2)*v(SP12)/v(VDD33))/1k
BGPN12 GPN12 VSS I=(v(GPN12)-v(PH2)*(v(VDD33)-v(SP12))/v(VDD33))/1k
BGNP12 GNP12 VSS I=(v(GNP12)-v(PH2)*v(SN12)/v(VDD33))/1k
BGNN12 GNN12 VSS I=(v(GNN12)-v(PH2)*(v(VDD33)-v(SN12))/v(VDD33))/1k
BNOPP12 NGPP12 0 V=v(VDD33)-v(GPP12)
BNOPN12 NGPN12 0 V=v(VDD33)-v(GPN12)
BNONP12 NGNP12 0 V=v(VDD33)-v(GNP12)
BNONN12 NGNN12 0 V=v(VDD33)-v(GNN12)
CGPP12 GPP12 VSS 2p
CGPN12 GPN12 VSS 2p
CGNP12 GNP12 VSS 2p
CGNN12 GNN12 VSS 2p
CNGPP12 NGPP12 VSS 0.2p
CNGPN12 NGPN12 VSS 0.2p
CNGNP12 NGNP12 VSS 0.2p
CNGNN12 NGNN12 VSS 0.2p
XPVP12 CDLP12 VP GPP12 NGPP12 VDD33 VSS gf180_tg_lowq
XPVN12 CDLP12 VN GPN12 NGPN12 VDD33 VSS gf180_tg_lowq
XNVP12 CDLN12 VP GNP12 NGNP12 VDD33 VSS gf180_tg_lowq
XNVN12 CDLN12 VN GNN12 NGNN12 VDD33 VSS gf180_tg_lowq
* DAC unit 13 (P side DP13, N side DN13)
CDP13 CDLP13 CDRP13 {CU}
CDN13 CDLN13 CDRN13 {CU}
XDPA13 CDLP13 VCM_REF PH1 NPH1 VDD33 VSS gf180_tg_lowq
XDPB13 CDRP13 VCM_REF PH1 NPH1 VDD33 VSS gf180_tg_lowq
XDNA13 CDLN13 VCM_REF PH1 NPH1 VDD33 VSS gf180_tg_lowq
XDNB13 CDRN13 VCM_REF PH1 NPH1 VDD33 VSS gf180_tg_lowq
XDP213 CDRP13 INP PH2 NPH2 VDD33 VSS gf180_tg_lowq
XDN213 CDRN13 INN PH2 NPH2 VDD33 VSS gf180_tg_lowq
BGPP13 GPP13 VSS I=(v(GPP13)-v(PH2)*v(SP13)/v(VDD33))/1k
BGPN13 GPN13 VSS I=(v(GPN13)-v(PH2)*(v(VDD33)-v(SP13))/v(VDD33))/1k
BGNP13 GNP13 VSS I=(v(GNP13)-v(PH2)*v(SN13)/v(VDD33))/1k
BGNN13 GNN13 VSS I=(v(GNN13)-v(PH2)*(v(VDD33)-v(SN13))/v(VDD33))/1k
BNOPP13 NGPP13 0 V=v(VDD33)-v(GPP13)
BNOPN13 NGPN13 0 V=v(VDD33)-v(GPN13)
BNONP13 NGNP13 0 V=v(VDD33)-v(GNP13)
BNONN13 NGNN13 0 V=v(VDD33)-v(GNN13)
CGPP13 GPP13 VSS 2p
CGPN13 GPN13 VSS 2p
CGNP13 GNP13 VSS 2p
CGNN13 GNN13 VSS 2p
CNGPP13 NGPP13 VSS 0.2p
CNGPN13 NGPN13 VSS 0.2p
CNGNP13 NGNP13 VSS 0.2p
CNGNN13 NGNN13 VSS 0.2p
XPVP13 CDLP13 VP GPP13 NGPP13 VDD33 VSS gf180_tg_lowq
XPVN13 CDLP13 VN GPN13 NGPN13 VDD33 VSS gf180_tg_lowq
XNVP13 CDLN13 VP GNP13 NGNP13 VDD33 VSS gf180_tg_lowq
XNVN13 CDLN13 VN GNN13 NGNN13 VDD33 VSS gf180_tg_lowq
* DAC unit 14 (P side DP14, N side DN14)
CDP14 CDLP14 CDRP14 {CU}
CDN14 CDLN14 CDRN14 {CU}
XDPA14 CDLP14 VCM_REF PH1 NPH1 VDD33 VSS gf180_tg_lowq
XDPB14 CDRP14 VCM_REF PH1 NPH1 VDD33 VSS gf180_tg_lowq
XDNA14 CDLN14 VCM_REF PH1 NPH1 VDD33 VSS gf180_tg_lowq
XDNB14 CDRN14 VCM_REF PH1 NPH1 VDD33 VSS gf180_tg_lowq
XDP214 CDRP14 INP PH2 NPH2 VDD33 VSS gf180_tg_lowq
XDN214 CDRN14 INN PH2 NPH2 VDD33 VSS gf180_tg_lowq
BGPP14 GPP14 VSS I=(v(GPP14)-v(PH2)*v(SP14)/v(VDD33))/1k
BGPN14 GPN14 VSS I=(v(GPN14)-v(PH2)*(v(VDD33)-v(SP14))/v(VDD33))/1k
BGNP14 GNP14 VSS I=(v(GNP14)-v(PH2)*v(SN14)/v(VDD33))/1k
BGNN14 GNN14 VSS I=(v(GNN14)-v(PH2)*(v(VDD33)-v(SN14))/v(VDD33))/1k
BNOPP14 NGPP14 0 V=v(VDD33)-v(GPP14)
BNOPN14 NGPN14 0 V=v(VDD33)-v(GPN14)
BNONP14 NGNP14 0 V=v(VDD33)-v(GNP14)
BNONN14 NGNN14 0 V=v(VDD33)-v(GNN14)
CGPP14 GPP14 VSS 2p
CGPN14 GPN14 VSS 2p
CGNP14 GNP14 VSS 2p
CGNN14 GNN14 VSS 2p
CNGPP14 NGPP14 VSS 0.2p
CNGPN14 NGPN14 VSS 0.2p
CNGNP14 NGNP14 VSS 0.2p
CNGNN14 NGNN14 VSS 0.2p
XPVP14 CDLP14 VP GPP14 NGPP14 VDD33 VSS gf180_tg_lowq
XPVN14 CDLP14 VN GPN14 NGPN14 VDD33 VSS gf180_tg_lowq
XNVP14 CDLN14 VP GNP14 NGNP14 VDD33 VSS gf180_tg_lowq
XNVN14 CDLN14 VN GNN14 NGNN14 VDD33 VSS gf180_tg_lowq
* DAC unit 15 (P side DP15, N side DN15)
CDP15 CDLP15 CDRP15 {CU}
CDN15 CDLN15 CDRN15 {CU}
XDPA15 CDLP15 VCM_REF PH1 NPH1 VDD33 VSS gf180_tg_lowq
XDPB15 CDRP15 VCM_REF PH1 NPH1 VDD33 VSS gf180_tg_lowq
XDNA15 CDLN15 VCM_REF PH1 NPH1 VDD33 VSS gf180_tg_lowq
XDNB15 CDRN15 VCM_REF PH1 NPH1 VDD33 VSS gf180_tg_lowq
XDP215 CDRP15 INP PH2 NPH2 VDD33 VSS gf180_tg_lowq
XDN215 CDRN15 INN PH2 NPH2 VDD33 VSS gf180_tg_lowq
BGPP15 GPP15 VSS I=(v(GPP15)-v(PH2)*v(SP15)/v(VDD33))/1k
BGPN15 GPN15 VSS I=(v(GPN15)-v(PH2)*(v(VDD33)-v(SP15))/v(VDD33))/1k
BGNP15 GNP15 VSS I=(v(GNP15)-v(PH2)*v(SN15)/v(VDD33))/1k
BGNN15 GNN15 VSS I=(v(GNN15)-v(PH2)*(v(VDD33)-v(SN15))/v(VDD33))/1k
BNOPP15 NGPP15 0 V=v(VDD33)-v(GPP15)
BNOPN15 NGPN15 0 V=v(VDD33)-v(GPN15)
BNONP15 NGNP15 0 V=v(VDD33)-v(GNP15)
BNONN15 NGNN15 0 V=v(VDD33)-v(GNN15)
CGPP15 GPP15 VSS 2p
CGPN15 GPN15 VSS 2p
CGNP15 GNP15 VSS 2p
CGNN15 GNN15 VSS 2p
CNGPP15 NGPP15 VSS 0.2p
CNGPN15 NGPN15 VSS 0.2p
CNGNP15 NGNP15 VSS 0.2p
CNGNN15 NGNN15 VSS 0.2p
XPVP15 CDLP15 VP GPP15 NGPP15 VDD33 VSS gf180_tg_lowq
XPVN15 CDLP15 VN GPN15 NGPN15 VDD33 VSS gf180_tg_lowq
XNVP15 CDLN15 VP GNP15 NGNP15 VDD33 VSS gf180_tg_lowq
XNVN15 CDLN15 VN GNN15 NGNN15 VDD33 VSS gf180_tg_lowq
* DAC unit 16 (P side DP16, N side DN16)
CDP16 CDLP16 CDRP16 {CU}
CDN16 CDLN16 CDRN16 {CU}
XDPA16 CDLP16 VCM_REF PH1 NPH1 VDD33 VSS gf180_tg_lowq
XDPB16 CDRP16 VCM_REF PH1 NPH1 VDD33 VSS gf180_tg_lowq
XDNA16 CDLN16 VCM_REF PH1 NPH1 VDD33 VSS gf180_tg_lowq
XDNB16 CDRN16 VCM_REF PH1 NPH1 VDD33 VSS gf180_tg_lowq
XDP216 CDRP16 INP PH2 NPH2 VDD33 VSS gf180_tg_lowq
XDN216 CDRN16 INN PH2 NPH2 VDD33 VSS gf180_tg_lowq
BGPP16 GPP16 VSS I=(v(GPP16)-v(PH2)*v(SP16)/v(VDD33))/1k
BGPN16 GPN16 VSS I=(v(GPN16)-v(PH2)*(v(VDD33)-v(SP16))/v(VDD33))/1k
BGNP16 GNP16 VSS I=(v(GNP16)-v(PH2)*v(SN16)/v(VDD33))/1k
BGNN16 GNN16 VSS I=(v(GNN16)-v(PH2)*(v(VDD33)-v(SN16))/v(VDD33))/1k
BNOPP16 NGPP16 0 V=v(VDD33)-v(GPP16)
BNOPN16 NGPN16 0 V=v(VDD33)-v(GPN16)
BNONP16 NGNP16 0 V=v(VDD33)-v(GNP16)
BNONN16 NGNN16 0 V=v(VDD33)-v(GNN16)
CGPP16 GPP16 VSS 2p
CGPN16 GPN16 VSS 2p
CGNP16 GNP16 VSS 2p
CGNN16 GNN16 VSS 2p
CNGPP16 NGPP16 VSS 0.2p
CNGPN16 NGPN16 VSS 0.2p
CNGNP16 NGNP16 VSS 0.2p
CNGNN16 NGNN16 VSS 0.2p
XPVP16 CDLP16 VP GPP16 NGPP16 VDD33 VSS gf180_tg_lowq
XPVN16 CDLP16 VN GPN16 NGPN16 VDD33 VSS gf180_tg_lowq
XNVP16 CDLN16 VP GNP16 NGNP16 VDD33 VSS gf180_tg_lowq
XNVN16 CDLN16 VN GNN16 NGNN16 VDD33 VSS gf180_tg_lowq
* DAC unit 17 (P side DP17, N side DN17)
CDP17 CDLP17 CDRP17 {CU}
CDN17 CDLN17 CDRN17 {CU}
XDPA17 CDLP17 VCM_REF PH1 NPH1 VDD33 VSS gf180_tg_lowq
XDPB17 CDRP17 VCM_REF PH1 NPH1 VDD33 VSS gf180_tg_lowq
XDNA17 CDLN17 VCM_REF PH1 NPH1 VDD33 VSS gf180_tg_lowq
XDNB17 CDRN17 VCM_REF PH1 NPH1 VDD33 VSS gf180_tg_lowq
XDP217 CDRP17 INP PH2 NPH2 VDD33 VSS gf180_tg_lowq
XDN217 CDRN17 INN PH2 NPH2 VDD33 VSS gf180_tg_lowq
BGPP17 GPP17 VSS I=(v(GPP17)-v(PH2)*v(SP17)/v(VDD33))/1k
BGPN17 GPN17 VSS I=(v(GPN17)-v(PH2)*(v(VDD33)-v(SP17))/v(VDD33))/1k
BGNP17 GNP17 VSS I=(v(GNP17)-v(PH2)*v(SN17)/v(VDD33))/1k
BGNN17 GNN17 VSS I=(v(GNN17)-v(PH2)*(v(VDD33)-v(SN17))/v(VDD33))/1k
BNOPP17 NGPP17 0 V=v(VDD33)-v(GPP17)
BNOPN17 NGPN17 0 V=v(VDD33)-v(GPN17)
BNONP17 NGNP17 0 V=v(VDD33)-v(GNP17)
BNONN17 NGNN17 0 V=v(VDD33)-v(GNN17)
CGPP17 GPP17 VSS 2p
CGPN17 GPN17 VSS 2p
CGNP17 GNP17 VSS 2p
CGNN17 GNN17 VSS 2p
CNGPP17 NGPP17 VSS 0.2p
CNGPN17 NGPN17 VSS 0.2p
CNGNP17 NGNP17 VSS 0.2p
CNGNN17 NGNN17 VSS 0.2p
XPVP17 CDLP17 VP GPP17 NGPP17 VDD33 VSS gf180_tg_lowq
XPVN17 CDLP17 VN GPN17 NGPN17 VDD33 VSS gf180_tg_lowq
XNVP17 CDLN17 VP GNP17 NGNP17 VDD33 VSS gf180_tg_lowq
XNVN17 CDLN17 VN GNN17 NGNN17 VDD33 VSS gf180_tg_lowq
* DAC unit 18 (P side DP18, N side DN18)
CDP18 CDLP18 CDRP18 {CU}
CDN18 CDLN18 CDRN18 {CU}
XDPA18 CDLP18 VCM_REF PH1 NPH1 VDD33 VSS gf180_tg_lowq
XDPB18 CDRP18 VCM_REF PH1 NPH1 VDD33 VSS gf180_tg_lowq
XDNA18 CDLN18 VCM_REF PH1 NPH1 VDD33 VSS gf180_tg_lowq
XDNB18 CDRN18 VCM_REF PH1 NPH1 VDD33 VSS gf180_tg_lowq
XDP218 CDRP18 INP PH2 NPH2 VDD33 VSS gf180_tg_lowq
XDN218 CDRN18 INN PH2 NPH2 VDD33 VSS gf180_tg_lowq
BGPP18 GPP18 VSS I=(v(GPP18)-v(PH2)*v(SP18)/v(VDD33))/1k
BGPN18 GPN18 VSS I=(v(GPN18)-v(PH2)*(v(VDD33)-v(SP18))/v(VDD33))/1k
BGNP18 GNP18 VSS I=(v(GNP18)-v(PH2)*v(SN18)/v(VDD33))/1k
BGNN18 GNN18 VSS I=(v(GNN18)-v(PH2)*(v(VDD33)-v(SN18))/v(VDD33))/1k
BNOPP18 NGPP18 0 V=v(VDD33)-v(GPP18)
BNOPN18 NGPN18 0 V=v(VDD33)-v(GPN18)
BNONP18 NGNP18 0 V=v(VDD33)-v(GNP18)
BNONN18 NGNN18 0 V=v(VDD33)-v(GNN18)
CGPP18 GPP18 VSS 2p
CGPN18 GPN18 VSS 2p
CGNP18 GNP18 VSS 2p
CGNN18 GNN18 VSS 2p
CNGPP18 NGPP18 VSS 0.2p
CNGPN18 NGPN18 VSS 0.2p
CNGNP18 NGNP18 VSS 0.2p
CNGNN18 NGNN18 VSS 0.2p
XPVP18 CDLP18 VP GPP18 NGPP18 VDD33 VSS gf180_tg_lowq
XPVN18 CDLP18 VN GPN18 NGPN18 VDD33 VSS gf180_tg_lowq
XNVP18 CDLN18 VP GNP18 NGNP18 VDD33 VSS gf180_tg_lowq
XNVN18 CDLN18 VN GNN18 NGNN18 VDD33 VSS gf180_tg_lowq
* DAC unit 19 (P side DP19, N side DN19)
CDP19 CDLP19 CDRP19 {CU}
CDN19 CDLN19 CDRN19 {CU}
XDPA19 CDLP19 VCM_REF PH1 NPH1 VDD33 VSS gf180_tg_lowq
XDPB19 CDRP19 VCM_REF PH1 NPH1 VDD33 VSS gf180_tg_lowq
XDNA19 CDLN19 VCM_REF PH1 NPH1 VDD33 VSS gf180_tg_lowq
XDNB19 CDRN19 VCM_REF PH1 NPH1 VDD33 VSS gf180_tg_lowq
XDP219 CDRP19 INP PH2 NPH2 VDD33 VSS gf180_tg_lowq
XDN219 CDRN19 INN PH2 NPH2 VDD33 VSS gf180_tg_lowq
BGPP19 GPP19 VSS I=(v(GPP19)-v(PH2)*v(SP19)/v(VDD33))/1k
BGPN19 GPN19 VSS I=(v(GPN19)-v(PH2)*(v(VDD33)-v(SP19))/v(VDD33))/1k
BGNP19 GNP19 VSS I=(v(GNP19)-v(PH2)*v(SN19)/v(VDD33))/1k
BGNN19 GNN19 VSS I=(v(GNN19)-v(PH2)*(v(VDD33)-v(SN19))/v(VDD33))/1k
BNOPP19 NGPP19 0 V=v(VDD33)-v(GPP19)
BNOPN19 NGPN19 0 V=v(VDD33)-v(GPN19)
BNONP19 NGNP19 0 V=v(VDD33)-v(GNP19)
BNONN19 NGNN19 0 V=v(VDD33)-v(GNN19)
CGPP19 GPP19 VSS 2p
CGPN19 GPN19 VSS 2p
CGNP19 GNP19 VSS 2p
CGNN19 GNN19 VSS 2p
CNGPP19 NGPP19 VSS 0.2p
CNGPN19 NGPN19 VSS 0.2p
CNGNP19 NGNP19 VSS 0.2p
CNGNN19 NGNN19 VSS 0.2p
XPVP19 CDLP19 VP GPP19 NGPP19 VDD33 VSS gf180_tg_lowq
XPVN19 CDLP19 VN GPN19 NGPN19 VDD33 VSS gf180_tg_lowq
XNVP19 CDLN19 VP GNP19 NGNP19 VDD33 VSS gf180_tg_lowq
XNVN19 CDLN19 VN GNN19 NGNN19 VDD33 VSS gf180_tg_lowq
* DAC unit 20 (P side DP20, N side DN20)
CDP20 CDLP20 CDRP20 {CU}
CDN20 CDLN20 CDRN20 {CU}
XDPA20 CDLP20 VCM_REF PH1 NPH1 VDD33 VSS gf180_tg_lowq
XDPB20 CDRP20 VCM_REF PH1 NPH1 VDD33 VSS gf180_tg_lowq
XDNA20 CDLN20 VCM_REF PH1 NPH1 VDD33 VSS gf180_tg_lowq
XDNB20 CDRN20 VCM_REF PH1 NPH1 VDD33 VSS gf180_tg_lowq
XDP220 CDRP20 INP PH2 NPH2 VDD33 VSS gf180_tg_lowq
XDN220 CDRN20 INN PH2 NPH2 VDD33 VSS gf180_tg_lowq
BGPP20 GPP20 VSS I=(v(GPP20)-v(PH2)*v(SP20)/v(VDD33))/1k
BGPN20 GPN20 VSS I=(v(GPN20)-v(PH2)*(v(VDD33)-v(SP20))/v(VDD33))/1k
BGNP20 GNP20 VSS I=(v(GNP20)-v(PH2)*v(SN20)/v(VDD33))/1k
BGNN20 GNN20 VSS I=(v(GNN20)-v(PH2)*(v(VDD33)-v(SN20))/v(VDD33))/1k
BNOPP20 NGPP20 0 V=v(VDD33)-v(GPP20)
BNOPN20 NGPN20 0 V=v(VDD33)-v(GPN20)
BNONP20 NGNP20 0 V=v(VDD33)-v(GNP20)
BNONN20 NGNN20 0 V=v(VDD33)-v(GNN20)
CGPP20 GPP20 VSS 2p
CGPN20 GPN20 VSS 2p
CGNP20 GNP20 VSS 2p
CGNN20 GNN20 VSS 2p
CNGPP20 NGPP20 VSS 0.2p
CNGPN20 NGPN20 VSS 0.2p
CNGNP20 NGNP20 VSS 0.2p
CNGNN20 NGNN20 VSS 0.2p
XPVP20 CDLP20 VP GPP20 NGPP20 VDD33 VSS gf180_tg_lowq
XPVN20 CDLP20 VN GPN20 NGPN20 VDD33 VSS gf180_tg_lowq
XNVP20 CDLN20 VP GNP20 NGNP20 VDD33 VSS gf180_tg_lowq
XNVN20 CDLN20 VN GNN20 NGNN20 VDD33 VSS gf180_tg_lowq
* DAC unit 21 (P side DP21, N side DN21)
CDP21 CDLP21 CDRP21 {CU}
CDN21 CDLN21 CDRN21 {CU}
XDPA21 CDLP21 VCM_REF PH1 NPH1 VDD33 VSS gf180_tg_lowq
XDPB21 CDRP21 VCM_REF PH1 NPH1 VDD33 VSS gf180_tg_lowq
XDNA21 CDLN21 VCM_REF PH1 NPH1 VDD33 VSS gf180_tg_lowq
XDNB21 CDRN21 VCM_REF PH1 NPH1 VDD33 VSS gf180_tg_lowq
XDP221 CDRP21 INP PH2 NPH2 VDD33 VSS gf180_tg_lowq
XDN221 CDRN21 INN PH2 NPH2 VDD33 VSS gf180_tg_lowq
BGPP21 GPP21 VSS I=(v(GPP21)-v(PH2)*v(SP21)/v(VDD33))/1k
BGPN21 GPN21 VSS I=(v(GPN21)-v(PH2)*(v(VDD33)-v(SP21))/v(VDD33))/1k
BGNP21 GNP21 VSS I=(v(GNP21)-v(PH2)*v(SN21)/v(VDD33))/1k
BGNN21 GNN21 VSS I=(v(GNN21)-v(PH2)*(v(VDD33)-v(SN21))/v(VDD33))/1k
BNOPP21 NGPP21 0 V=v(VDD33)-v(GPP21)
BNOPN21 NGPN21 0 V=v(VDD33)-v(GPN21)
BNONP21 NGNP21 0 V=v(VDD33)-v(GNP21)
BNONN21 NGNN21 0 V=v(VDD33)-v(GNN21)
CGPP21 GPP21 VSS 2p
CGPN21 GPN21 VSS 2p
CGNP21 GNP21 VSS 2p
CGNN21 GNN21 VSS 2p
CNGPP21 NGPP21 VSS 0.2p
CNGPN21 NGPN21 VSS 0.2p
CNGNP21 NGNP21 VSS 0.2p
CNGNN21 NGNN21 VSS 0.2p
XPVP21 CDLP21 VP GPP21 NGPP21 VDD33 VSS gf180_tg_lowq
XPVN21 CDLP21 VN GPN21 NGPN21 VDD33 VSS gf180_tg_lowq
XNVP21 CDLN21 VP GNP21 NGNP21 VDD33 VSS gf180_tg_lowq
XNVN21 CDLN21 VN GNN21 NGNN21 VDD33 VSS gf180_tg_lowq
* DAC unit 22 (P side DP22, N side DN22)
CDP22 CDLP22 CDRP22 {CU}
CDN22 CDLN22 CDRN22 {CU}
XDPA22 CDLP22 VCM_REF PH1 NPH1 VDD33 VSS gf180_tg_lowq
XDPB22 CDRP22 VCM_REF PH1 NPH1 VDD33 VSS gf180_tg_lowq
XDNA22 CDLN22 VCM_REF PH1 NPH1 VDD33 VSS gf180_tg_lowq
XDNB22 CDRN22 VCM_REF PH1 NPH1 VDD33 VSS gf180_tg_lowq
XDP222 CDRP22 INP PH2 NPH2 VDD33 VSS gf180_tg_lowq
XDN222 CDRN22 INN PH2 NPH2 VDD33 VSS gf180_tg_lowq
BGPP22 GPP22 VSS I=(v(GPP22)-v(PH2)*v(SP22)/v(VDD33))/1k
BGPN22 GPN22 VSS I=(v(GPN22)-v(PH2)*(v(VDD33)-v(SP22))/v(VDD33))/1k
BGNP22 GNP22 VSS I=(v(GNP22)-v(PH2)*v(SN22)/v(VDD33))/1k
BGNN22 GNN22 VSS I=(v(GNN22)-v(PH2)*(v(VDD33)-v(SN22))/v(VDD33))/1k
BNOPP22 NGPP22 0 V=v(VDD33)-v(GPP22)
BNOPN22 NGPN22 0 V=v(VDD33)-v(GPN22)
BNONP22 NGNP22 0 V=v(VDD33)-v(GNP22)
BNONN22 NGNN22 0 V=v(VDD33)-v(GNN22)
CGPP22 GPP22 VSS 2p
CGPN22 GPN22 VSS 2p
CGNP22 GNP22 VSS 2p
CGNN22 GNN22 VSS 2p
CNGPP22 NGPP22 VSS 0.2p
CNGPN22 NGPN22 VSS 0.2p
CNGNP22 NGNP22 VSS 0.2p
CNGNN22 NGNN22 VSS 0.2p
XPVP22 CDLP22 VP GPP22 NGPP22 VDD33 VSS gf180_tg_lowq
XPVN22 CDLP22 VN GPN22 NGPN22 VDD33 VSS gf180_tg_lowq
XNVP22 CDLN22 VP GNP22 NGNP22 VDD33 VSS gf180_tg_lowq
XNVN22 CDLN22 VN GNN22 NGNN22 VDD33 VSS gf180_tg_lowq
* DAC unit 23 (P side DP23, N side DN23)
CDP23 CDLP23 CDRP23 {CU}
CDN23 CDLN23 CDRN23 {CU}
XDPA23 CDLP23 VCM_REF PH1 NPH1 VDD33 VSS gf180_tg_lowq
XDPB23 CDRP23 VCM_REF PH1 NPH1 VDD33 VSS gf180_tg_lowq
XDNA23 CDLN23 VCM_REF PH1 NPH1 VDD33 VSS gf180_tg_lowq
XDNB23 CDRN23 VCM_REF PH1 NPH1 VDD33 VSS gf180_tg_lowq
XDP223 CDRP23 INP PH2 NPH2 VDD33 VSS gf180_tg_lowq
XDN223 CDRN23 INN PH2 NPH2 VDD33 VSS gf180_tg_lowq
BGPP23 GPP23 VSS I=(v(GPP23)-v(PH2)*v(SP23)/v(VDD33))/1k
BGPN23 GPN23 VSS I=(v(GPN23)-v(PH2)*(v(VDD33)-v(SP23))/v(VDD33))/1k
BGNP23 GNP23 VSS I=(v(GNP23)-v(PH2)*v(SN23)/v(VDD33))/1k
BGNN23 GNN23 VSS I=(v(GNN23)-v(PH2)*(v(VDD33)-v(SN23))/v(VDD33))/1k
BNOPP23 NGPP23 0 V=v(VDD33)-v(GPP23)
BNOPN23 NGPN23 0 V=v(VDD33)-v(GPN23)
BNONP23 NGNP23 0 V=v(VDD33)-v(GNP23)
BNONN23 NGNN23 0 V=v(VDD33)-v(GNN23)
CGPP23 GPP23 VSS 2p
CGPN23 GPN23 VSS 2p
CGNP23 GNP23 VSS 2p
CGNN23 GNN23 VSS 2p
CNGPP23 NGPP23 VSS 0.2p
CNGPN23 NGPN23 VSS 0.2p
CNGNP23 NGNP23 VSS 0.2p
CNGNN23 NGNN23 VSS 0.2p
XPVP23 CDLP23 VP GPP23 NGPP23 VDD33 VSS gf180_tg_lowq
XPVN23 CDLP23 VN GPN23 NGPN23 VDD33 VSS gf180_tg_lowq
XNVP23 CDLN23 VP GNP23 NGNP23 VDD33 VSS gf180_tg_lowq
XNVN23 CDLN23 VN GNN23 NGNN23 VDD33 VSS gf180_tg_lowq
* DAC unit 24 (P side DP24, N side DN24)
CDP24 CDLP24 CDRP24 {CU}
CDN24 CDLN24 CDRN24 {CU}
XDPA24 CDLP24 VCM_REF PH1 NPH1 VDD33 VSS gf180_tg_lowq
XDPB24 CDRP24 VCM_REF PH1 NPH1 VDD33 VSS gf180_tg_lowq
XDNA24 CDLN24 VCM_REF PH1 NPH1 VDD33 VSS gf180_tg_lowq
XDNB24 CDRN24 VCM_REF PH1 NPH1 VDD33 VSS gf180_tg_lowq
XDP224 CDRP24 INP PH2 NPH2 VDD33 VSS gf180_tg_lowq
XDN224 CDRN24 INN PH2 NPH2 VDD33 VSS gf180_tg_lowq
BGPP24 GPP24 VSS I=(v(GPP24)-v(PH2)*v(SP24)/v(VDD33))/1k
BGPN24 GPN24 VSS I=(v(GPN24)-v(PH2)*(v(VDD33)-v(SP24))/v(VDD33))/1k
BGNP24 GNP24 VSS I=(v(GNP24)-v(PH2)*v(SN24)/v(VDD33))/1k
BGNN24 GNN24 VSS I=(v(GNN24)-v(PH2)*(v(VDD33)-v(SN24))/v(VDD33))/1k
BNOPP24 NGPP24 0 V=v(VDD33)-v(GPP24)
BNOPN24 NGPN24 0 V=v(VDD33)-v(GPN24)
BNONP24 NGNP24 0 V=v(VDD33)-v(GNP24)
BNONN24 NGNN24 0 V=v(VDD33)-v(GNN24)
CGPP24 GPP24 VSS 2p
CGPN24 GPN24 VSS 2p
CGNP24 GNP24 VSS 2p
CGNN24 GNN24 VSS 2p
CNGPP24 NGPP24 VSS 0.2p
CNGPN24 NGPN24 VSS 0.2p
CNGNP24 NGNP24 VSS 0.2p
CNGNN24 NGNN24 VSS 0.2p
XPVP24 CDLP24 VP GPP24 NGPP24 VDD33 VSS gf180_tg_lowq
XPVN24 CDLP24 VN GPN24 NGPN24 VDD33 VSS gf180_tg_lowq
XNVP24 CDLN24 VP GNP24 NGNP24 VDD33 VSS gf180_tg_lowq
XNVN24 CDLN24 VN GNN24 NGNN24 VDD33 VSS gf180_tg_lowq
* DAC unit 25 (P side DP25, N side DN25)
CDP25 CDLP25 CDRP25 {CU}
CDN25 CDLN25 CDRN25 {CU}
XDPA25 CDLP25 VCM_REF PH1 NPH1 VDD33 VSS gf180_tg_lowq
XDPB25 CDRP25 VCM_REF PH1 NPH1 VDD33 VSS gf180_tg_lowq
XDNA25 CDLN25 VCM_REF PH1 NPH1 VDD33 VSS gf180_tg_lowq
XDNB25 CDRN25 VCM_REF PH1 NPH1 VDD33 VSS gf180_tg_lowq
XDP225 CDRP25 INP PH2 NPH2 VDD33 VSS gf180_tg_lowq
XDN225 CDRN25 INN PH2 NPH2 VDD33 VSS gf180_tg_lowq
BGPP25 GPP25 VSS I=(v(GPP25)-v(PH2)*v(SP25)/v(VDD33))/1k
BGPN25 GPN25 VSS I=(v(GPN25)-v(PH2)*(v(VDD33)-v(SP25))/v(VDD33))/1k
BGNP25 GNP25 VSS I=(v(GNP25)-v(PH2)*v(SN25)/v(VDD33))/1k
BGNN25 GNN25 VSS I=(v(GNN25)-v(PH2)*(v(VDD33)-v(SN25))/v(VDD33))/1k
BNOPP25 NGPP25 0 V=v(VDD33)-v(GPP25)
BNOPN25 NGPN25 0 V=v(VDD33)-v(GPN25)
BNONP25 NGNP25 0 V=v(VDD33)-v(GNP25)
BNONN25 NGNN25 0 V=v(VDD33)-v(GNN25)
CGPP25 GPP25 VSS 2p
CGPN25 GPN25 VSS 2p
CGNP25 GNP25 VSS 2p
CGNN25 GNN25 VSS 2p
CNGPP25 NGPP25 VSS 0.2p
CNGPN25 NGPN25 VSS 0.2p
CNGNP25 NGNP25 VSS 0.2p
CNGNN25 NGNN25 VSS 0.2p
XPVP25 CDLP25 VP GPP25 NGPP25 VDD33 VSS gf180_tg_lowq
XPVN25 CDLP25 VN GPN25 NGPN25 VDD33 VSS gf180_tg_lowq
XNVP25 CDLN25 VP GNP25 NGNP25 VDD33 VSS gf180_tg_lowq
XNVN25 CDLN25 VN GNN25 NGNN25 VDD33 VSS gf180_tg_lowq
* DAC unit 26 (P side DP26, N side DN26)
CDP26 CDLP26 CDRP26 {CU}
CDN26 CDLN26 CDRN26 {CU}
XDPA26 CDLP26 VCM_REF PH1 NPH1 VDD33 VSS gf180_tg_lowq
XDPB26 CDRP26 VCM_REF PH1 NPH1 VDD33 VSS gf180_tg_lowq
XDNA26 CDLN26 VCM_REF PH1 NPH1 VDD33 VSS gf180_tg_lowq
XDNB26 CDRN26 VCM_REF PH1 NPH1 VDD33 VSS gf180_tg_lowq
XDP226 CDRP26 INP PH2 NPH2 VDD33 VSS gf180_tg_lowq
XDN226 CDRN26 INN PH2 NPH2 VDD33 VSS gf180_tg_lowq
BGPP26 GPP26 VSS I=(v(GPP26)-v(PH2)*v(SP26)/v(VDD33))/1k
BGPN26 GPN26 VSS I=(v(GPN26)-v(PH2)*(v(VDD33)-v(SP26))/v(VDD33))/1k
BGNP26 GNP26 VSS I=(v(GNP26)-v(PH2)*v(SN26)/v(VDD33))/1k
BGNN26 GNN26 VSS I=(v(GNN26)-v(PH2)*(v(VDD33)-v(SN26))/v(VDD33))/1k
BNOPP26 NGPP26 0 V=v(VDD33)-v(GPP26)
BNOPN26 NGPN26 0 V=v(VDD33)-v(GPN26)
BNONP26 NGNP26 0 V=v(VDD33)-v(GNP26)
BNONN26 NGNN26 0 V=v(VDD33)-v(GNN26)
CGPP26 GPP26 VSS 2p
CGPN26 GPN26 VSS 2p
CGNP26 GNP26 VSS 2p
CGNN26 GNN26 VSS 2p
CNGPP26 NGPP26 VSS 0.2p
CNGPN26 NGPN26 VSS 0.2p
CNGNP26 NGNP26 VSS 0.2p
CNGNN26 NGNN26 VSS 0.2p
XPVP26 CDLP26 VP GPP26 NGPP26 VDD33 VSS gf180_tg_lowq
XPVN26 CDLP26 VN GPN26 NGPN26 VDD33 VSS gf180_tg_lowq
XNVP26 CDLN26 VP GNP26 NGNP26 VDD33 VSS gf180_tg_lowq
XNVN26 CDLN26 VN GNN26 NGNN26 VDD33 VSS gf180_tg_lowq
* DAC unit 27 (P side DP27, N side DN27)
CDP27 CDLP27 CDRP27 {CU}
CDN27 CDLN27 CDRN27 {CU}
XDPA27 CDLP27 VCM_REF PH1 NPH1 VDD33 VSS gf180_tg_lowq
XDPB27 CDRP27 VCM_REF PH1 NPH1 VDD33 VSS gf180_tg_lowq
XDNA27 CDLN27 VCM_REF PH1 NPH1 VDD33 VSS gf180_tg_lowq
XDNB27 CDRN27 VCM_REF PH1 NPH1 VDD33 VSS gf180_tg_lowq
XDP227 CDRP27 INP PH2 NPH2 VDD33 VSS gf180_tg_lowq
XDN227 CDRN27 INN PH2 NPH2 VDD33 VSS gf180_tg_lowq
BGPP27 GPP27 VSS I=(v(GPP27)-v(PH2)*v(SP27)/v(VDD33))/1k
BGPN27 GPN27 VSS I=(v(GPN27)-v(PH2)*(v(VDD33)-v(SP27))/v(VDD33))/1k
BGNP27 GNP27 VSS I=(v(GNP27)-v(PH2)*v(SN27)/v(VDD33))/1k
BGNN27 GNN27 VSS I=(v(GNN27)-v(PH2)*(v(VDD33)-v(SN27))/v(VDD33))/1k
BNOPP27 NGPP27 0 V=v(VDD33)-v(GPP27)
BNOPN27 NGPN27 0 V=v(VDD33)-v(GPN27)
BNONP27 NGNP27 0 V=v(VDD33)-v(GNP27)
BNONN27 NGNN27 0 V=v(VDD33)-v(GNN27)
CGPP27 GPP27 VSS 2p
CGPN27 GPN27 VSS 2p
CGNP27 GNP27 VSS 2p
CGNN27 GNN27 VSS 2p
CNGPP27 NGPP27 VSS 0.2p
CNGPN27 NGPN27 VSS 0.2p
CNGNP27 NGNP27 VSS 0.2p
CNGNN27 NGNN27 VSS 0.2p
XPVP27 CDLP27 VP GPP27 NGPP27 VDD33 VSS gf180_tg_lowq
XPVN27 CDLP27 VN GPN27 NGPN27 VDD33 VSS gf180_tg_lowq
XNVP27 CDLN27 VP GNP27 NGNP27 VDD33 VSS gf180_tg_lowq
XNVN27 CDLN27 VN GNN27 NGNN27 VDD33 VSS gf180_tg_lowq
* DAC unit 28 (P side DP28, N side DN28)
CDP28 CDLP28 CDRP28 {CU}
CDN28 CDLN28 CDRN28 {CU}
XDPA28 CDLP28 VCM_REF PH1 NPH1 VDD33 VSS gf180_tg_lowq
XDPB28 CDRP28 VCM_REF PH1 NPH1 VDD33 VSS gf180_tg_lowq
XDNA28 CDLN28 VCM_REF PH1 NPH1 VDD33 VSS gf180_tg_lowq
XDNB28 CDRN28 VCM_REF PH1 NPH1 VDD33 VSS gf180_tg_lowq
XDP228 CDRP28 INP PH2 NPH2 VDD33 VSS gf180_tg_lowq
XDN228 CDRN28 INN PH2 NPH2 VDD33 VSS gf180_tg_lowq
BGPP28 GPP28 VSS I=(v(GPP28)-v(PH2)*v(SP28)/v(VDD33))/1k
BGPN28 GPN28 VSS I=(v(GPN28)-v(PH2)*(v(VDD33)-v(SP28))/v(VDD33))/1k
BGNP28 GNP28 VSS I=(v(GNP28)-v(PH2)*v(SN28)/v(VDD33))/1k
BGNN28 GNN28 VSS I=(v(GNN28)-v(PH2)*(v(VDD33)-v(SN28))/v(VDD33))/1k
BNOPP28 NGPP28 0 V=v(VDD33)-v(GPP28)
BNOPN28 NGPN28 0 V=v(VDD33)-v(GPN28)
BNONP28 NGNP28 0 V=v(VDD33)-v(GNP28)
BNONN28 NGNN28 0 V=v(VDD33)-v(GNN28)
CGPP28 GPP28 VSS 2p
CGPN28 GPN28 VSS 2p
CGNP28 GNP28 VSS 2p
CGNN28 GNN28 VSS 2p
CNGPP28 NGPP28 VSS 0.2p
CNGPN28 NGPN28 VSS 0.2p
CNGNP28 NGNP28 VSS 0.2p
CNGNN28 NGNN28 VSS 0.2p
XPVP28 CDLP28 VP GPP28 NGPP28 VDD33 VSS gf180_tg_lowq
XPVN28 CDLP28 VN GPN28 NGPN28 VDD33 VSS gf180_tg_lowq
XNVP28 CDLN28 VP GNP28 NGNP28 VDD33 VSS gf180_tg_lowq
XNVN28 CDLN28 VN GNN28 NGNN28 VDD33 VSS gf180_tg_lowq
* DAC unit 29 (P side DP29, N side DN29)
CDP29 CDLP29 CDRP29 {CU}
CDN29 CDLN29 CDRN29 {CU}
XDPA29 CDLP29 VCM_REF PH1 NPH1 VDD33 VSS gf180_tg_lowq
XDPB29 CDRP29 VCM_REF PH1 NPH1 VDD33 VSS gf180_tg_lowq
XDNA29 CDLN29 VCM_REF PH1 NPH1 VDD33 VSS gf180_tg_lowq
XDNB29 CDRN29 VCM_REF PH1 NPH1 VDD33 VSS gf180_tg_lowq
XDP229 CDRP29 INP PH2 NPH2 VDD33 VSS gf180_tg_lowq
XDN229 CDRN29 INN PH2 NPH2 VDD33 VSS gf180_tg_lowq
BGPP29 GPP29 VSS I=(v(GPP29)-v(PH2)*v(SP29)/v(VDD33))/1k
BGPN29 GPN29 VSS I=(v(GPN29)-v(PH2)*(v(VDD33)-v(SP29))/v(VDD33))/1k
BGNP29 GNP29 VSS I=(v(GNP29)-v(PH2)*v(SN29)/v(VDD33))/1k
BGNN29 GNN29 VSS I=(v(GNN29)-v(PH2)*(v(VDD33)-v(SN29))/v(VDD33))/1k
BNOPP29 NGPP29 0 V=v(VDD33)-v(GPP29)
BNOPN29 NGPN29 0 V=v(VDD33)-v(GPN29)
BNONP29 NGNP29 0 V=v(VDD33)-v(GNP29)
BNONN29 NGNN29 0 V=v(VDD33)-v(GNN29)
CGPP29 GPP29 VSS 2p
CGPN29 GPN29 VSS 2p
CGNP29 GNP29 VSS 2p
CGNN29 GNN29 VSS 2p
CNGPP29 NGPP29 VSS 0.2p
CNGPN29 NGPN29 VSS 0.2p
CNGNP29 NGNP29 VSS 0.2p
CNGNN29 NGNN29 VSS 0.2p
XPVP29 CDLP29 VP GPP29 NGPP29 VDD33 VSS gf180_tg_lowq
XPVN29 CDLP29 VN GPN29 NGPN29 VDD33 VSS gf180_tg_lowq
XNVP29 CDLN29 VP GNP29 NGNP29 VDD33 VSS gf180_tg_lowq
XNVN29 CDLN29 VN GNN29 NGNN29 VDD33 VSS gf180_tg_lowq
* DAC unit 30 (P side DP30, N side DN30)
CDP30 CDLP30 CDRP30 {CU}
CDN30 CDLN30 CDRN30 {CU}
XDPA30 CDLP30 VCM_REF PH1 NPH1 VDD33 VSS gf180_tg_lowq
XDPB30 CDRP30 VCM_REF PH1 NPH1 VDD33 VSS gf180_tg_lowq
XDNA30 CDLN30 VCM_REF PH1 NPH1 VDD33 VSS gf180_tg_lowq
XDNB30 CDRN30 VCM_REF PH1 NPH1 VDD33 VSS gf180_tg_lowq
XDP230 CDRP30 INP PH2 NPH2 VDD33 VSS gf180_tg_lowq
XDN230 CDRN30 INN PH2 NPH2 VDD33 VSS gf180_tg_lowq
BGPP30 GPP30 VSS I=(v(GPP30)-v(PH2)*v(SP30)/v(VDD33))/1k
BGPN30 GPN30 VSS I=(v(GPN30)-v(PH2)*(v(VDD33)-v(SP30))/v(VDD33))/1k
BGNP30 GNP30 VSS I=(v(GNP30)-v(PH2)*v(SN30)/v(VDD33))/1k
BGNN30 GNN30 VSS I=(v(GNN30)-v(PH2)*(v(VDD33)-v(SN30))/v(VDD33))/1k
BNOPP30 NGPP30 0 V=v(VDD33)-v(GPP30)
BNOPN30 NGPN30 0 V=v(VDD33)-v(GPN30)
BNONP30 NGNP30 0 V=v(VDD33)-v(GNP30)
BNONN30 NGNN30 0 V=v(VDD33)-v(GNN30)
CGPP30 GPP30 VSS 2p
CGPN30 GPN30 VSS 2p
CGNP30 GNP30 VSS 2p
CGNN30 GNN30 VSS 2p
CNGPP30 NGPP30 VSS 0.2p
CNGPN30 NGPN30 VSS 0.2p
CNGNP30 NGNP30 VSS 0.2p
CNGNN30 NGNN30 VSS 0.2p
XPVP30 CDLP30 VP GPP30 NGPP30 VDD33 VSS gf180_tg_lowq
XPVN30 CDLP30 VN GPN30 NGPN30 VDD33 VSS gf180_tg_lowq
XNVP30 CDLN30 VP GNP30 NGNP30 VDD33 VSS gf180_tg_lowq
XNVN30 CDLN30 VN GNN30 NGNN30 VDD33 VSS gf180_tg_lowq
* DAC unit 31 (P side DP31, N side DN31)
CDP31 CDLP31 CDRP31 {CU}
CDN31 CDLN31 CDRN31 {CU}
XDPA31 CDLP31 VCM_REF PH1 NPH1 VDD33 VSS gf180_tg_lowq
XDPB31 CDRP31 VCM_REF PH1 NPH1 VDD33 VSS gf180_tg_lowq
XDNA31 CDLN31 VCM_REF PH1 NPH1 VDD33 VSS gf180_tg_lowq
XDNB31 CDRN31 VCM_REF PH1 NPH1 VDD33 VSS gf180_tg_lowq
XDP231 CDRP31 INP PH2 NPH2 VDD33 VSS gf180_tg_lowq
XDN231 CDRN31 INN PH2 NPH2 VDD33 VSS gf180_tg_lowq
BGPP31 GPP31 VSS I=(v(GPP31)-v(PH2)*v(SP31)/v(VDD33))/1k
BGPN31 GPN31 VSS I=(v(GPN31)-v(PH2)*(v(VDD33)-v(SP31))/v(VDD33))/1k
BGNP31 GNP31 VSS I=(v(GNP31)-v(PH2)*v(SN31)/v(VDD33))/1k
BGNN31 GNN31 VSS I=(v(GNN31)-v(PH2)*(v(VDD33)-v(SN31))/v(VDD33))/1k
BNOPP31 NGPP31 0 V=v(VDD33)-v(GPP31)
BNOPN31 NGPN31 0 V=v(VDD33)-v(GPN31)
BNONP31 NGNP31 0 V=v(VDD33)-v(GNP31)
BNONN31 NGNN31 0 V=v(VDD33)-v(GNN31)
CGPP31 GPP31 VSS 2p
CGPN31 GPN31 VSS 2p
CGNP31 GNP31 VSS 2p
CGNN31 GNN31 VSS 2p
CNGPP31 NGPP31 VSS 0.2p
CNGPN31 NGPN31 VSS 0.2p
CNGNP31 NGNP31 VSS 0.2p
CNGNN31 NGNN31 VSS 0.2p
XPVP31 CDLP31 VP GPP31 NGPP31 VDD33 VSS gf180_tg_lowq
XPVN31 CDLP31 VN GPN31 NGPN31 VDD33 VSS gf180_tg_lowq
XNVP31 CDLN31 VP GNP31 NGNP31 VDD33 VSS gf180_tg_lowq
XNVN31 CDLN31 VN GNN31 NGNN31 VDD33 VSS gf180_tg_lowq
* DAC unit 32 (P side DP32, N side DN32)
CDP32 CDLP32 CDRP32 {CU}
CDN32 CDLN32 CDRN32 {CU}
XDPA32 CDLP32 VCM_REF PH1 NPH1 VDD33 VSS gf180_tg_lowq
XDPB32 CDRP32 VCM_REF PH1 NPH1 VDD33 VSS gf180_tg_lowq
XDNA32 CDLN32 VCM_REF PH1 NPH1 VDD33 VSS gf180_tg_lowq
XDNB32 CDRN32 VCM_REF PH1 NPH1 VDD33 VSS gf180_tg_lowq
XDP232 CDRP32 INP PH2 NPH2 VDD33 VSS gf180_tg_lowq
XDN232 CDRN32 INN PH2 NPH2 VDD33 VSS gf180_tg_lowq
BGPP32 GPP32 VSS I=(v(GPP32)-v(PH2)*v(SP32)/v(VDD33))/1k
BGPN32 GPN32 VSS I=(v(GPN32)-v(PH2)*(v(VDD33)-v(SP32))/v(VDD33))/1k
BGNP32 GNP32 VSS I=(v(GNP32)-v(PH2)*v(SN32)/v(VDD33))/1k
BGNN32 GNN32 VSS I=(v(GNN32)-v(PH2)*(v(VDD33)-v(SN32))/v(VDD33))/1k
BNOPP32 NGPP32 0 V=v(VDD33)-v(GPP32)
BNOPN32 NGPN32 0 V=v(VDD33)-v(GPN32)
BNONP32 NGNP32 0 V=v(VDD33)-v(GNP32)
BNONN32 NGNN32 0 V=v(VDD33)-v(GNN32)
CGPP32 GPP32 VSS 2p
CGPN32 GPN32 VSS 2p
CGNP32 GNP32 VSS 2p
CGNN32 GNN32 VSS 2p
CNGPP32 NGPP32 VSS 0.2p
CNGPN32 NGPN32 VSS 0.2p
CNGNP32 NGNP32 VSS 0.2p
CNGNN32 NGNN32 VSS 0.2p
XPVP32 CDLP32 VP GPP32 NGPP32 VDD33 VSS gf180_tg_lowq
XPVN32 CDLP32 VN GPN32 NGPN32 VDD33 VSS gf180_tg_lowq
XNVP32 CDLN32 VP GNP32 NGNP32 VDD33 VSS gf180_tg_lowq
XNVN32 CDLN32 VN GNN32 NGNN32 VDD33 VSS gf180_tg_lowq
* DAC unit 33 (P side DP33, N side DN33)
CDP33 CDLP33 CDRP33 {CU}
CDN33 CDLN33 CDRN33 {CU}
XDPA33 CDLP33 VCM_REF PH1 NPH1 VDD33 VSS gf180_tg_lowq
XDPB33 CDRP33 VCM_REF PH1 NPH1 VDD33 VSS gf180_tg_lowq
XDNA33 CDLN33 VCM_REF PH1 NPH1 VDD33 VSS gf180_tg_lowq
XDNB33 CDRN33 VCM_REF PH1 NPH1 VDD33 VSS gf180_tg_lowq
XDP233 CDRP33 INP PH2 NPH2 VDD33 VSS gf180_tg_lowq
XDN233 CDRN33 INN PH2 NPH2 VDD33 VSS gf180_tg_lowq
BGPP33 GPP33 VSS I=(v(GPP33)-v(PH2)*v(SP33)/v(VDD33))/1k
BGPN33 GPN33 VSS I=(v(GPN33)-v(PH2)*(v(VDD33)-v(SP33))/v(VDD33))/1k
BGNP33 GNP33 VSS I=(v(GNP33)-v(PH2)*v(SN33)/v(VDD33))/1k
BGNN33 GNN33 VSS I=(v(GNN33)-v(PH2)*(v(VDD33)-v(SN33))/v(VDD33))/1k
BNOPP33 NGPP33 0 V=v(VDD33)-v(GPP33)
BNOPN33 NGPN33 0 V=v(VDD33)-v(GPN33)
BNONP33 NGNP33 0 V=v(VDD33)-v(GNP33)
BNONN33 NGNN33 0 V=v(VDD33)-v(GNN33)
CGPP33 GPP33 VSS 2p
CGPN33 GPN33 VSS 2p
CGNP33 GNP33 VSS 2p
CGNN33 GNN33 VSS 2p
CNGPP33 NGPP33 VSS 0.2p
CNGPN33 NGPN33 VSS 0.2p
CNGNP33 NGNP33 VSS 0.2p
CNGNN33 NGNN33 VSS 0.2p
XPVP33 CDLP33 VP GPP33 NGPP33 VDD33 VSS gf180_tg_lowq
XPVN33 CDLP33 VN GPN33 NGPN33 VDD33 VSS gf180_tg_lowq
XNVP33 CDLN33 VP GNP33 NGNP33 VDD33 VSS gf180_tg_lowq
XNVN33 CDLN33 VN GNN33 NGNN33 VDD33 VSS gf180_tg_lowq
* DAC unit 34 (P side DP34, N side DN34)
CDP34 CDLP34 CDRP34 {CU}
CDN34 CDLN34 CDRN34 {CU}
XDPA34 CDLP34 VCM_REF PH1 NPH1 VDD33 VSS gf180_tg_lowq
XDPB34 CDRP34 VCM_REF PH1 NPH1 VDD33 VSS gf180_tg_lowq
XDNA34 CDLN34 VCM_REF PH1 NPH1 VDD33 VSS gf180_tg_lowq
XDNB34 CDRN34 VCM_REF PH1 NPH1 VDD33 VSS gf180_tg_lowq
XDP234 CDRP34 INP PH2 NPH2 VDD33 VSS gf180_tg_lowq
XDN234 CDRN34 INN PH2 NPH2 VDD33 VSS gf180_tg_lowq
BGPP34 GPP34 VSS I=(v(GPP34)-v(PH2)*v(SP34)/v(VDD33))/1k
BGPN34 GPN34 VSS I=(v(GPN34)-v(PH2)*(v(VDD33)-v(SP34))/v(VDD33))/1k
BGNP34 GNP34 VSS I=(v(GNP34)-v(PH2)*v(SN34)/v(VDD33))/1k
BGNN34 GNN34 VSS I=(v(GNN34)-v(PH2)*(v(VDD33)-v(SN34))/v(VDD33))/1k
BNOPP34 NGPP34 0 V=v(VDD33)-v(GPP34)
BNOPN34 NGPN34 0 V=v(VDD33)-v(GPN34)
BNONP34 NGNP34 0 V=v(VDD33)-v(GNP34)
BNONN34 NGNN34 0 V=v(VDD33)-v(GNN34)
CGPP34 GPP34 VSS 2p
CGPN34 GPN34 VSS 2p
CGNP34 GNP34 VSS 2p
CGNN34 GNN34 VSS 2p
CNGPP34 NGPP34 VSS 0.2p
CNGPN34 NGPN34 VSS 0.2p
CNGNP34 NGNP34 VSS 0.2p
CNGNN34 NGNN34 VSS 0.2p
XPVP34 CDLP34 VP GPP34 NGPP34 VDD33 VSS gf180_tg_lowq
XPVN34 CDLP34 VN GPN34 NGPN34 VDD33 VSS gf180_tg_lowq
XNVP34 CDLN34 VP GNP34 NGNP34 VDD33 VSS gf180_tg_lowq
XNVN34 CDLN34 VN GNN34 NGNN34 VDD33 VSS gf180_tg_lowq
* DAC unit 35 (P side DP35, N side DN35)
CDP35 CDLP35 CDRP35 {CU}
CDN35 CDLN35 CDRN35 {CU}
XDPA35 CDLP35 VCM_REF PH1 NPH1 VDD33 VSS gf180_tg_lowq
XDPB35 CDRP35 VCM_REF PH1 NPH1 VDD33 VSS gf180_tg_lowq
XDNA35 CDLN35 VCM_REF PH1 NPH1 VDD33 VSS gf180_tg_lowq
XDNB35 CDRN35 VCM_REF PH1 NPH1 VDD33 VSS gf180_tg_lowq
XDP235 CDRP35 INP PH2 NPH2 VDD33 VSS gf180_tg_lowq
XDN235 CDRN35 INN PH2 NPH2 VDD33 VSS gf180_tg_lowq
BGPP35 GPP35 VSS I=(v(GPP35)-v(PH2)*v(SP35)/v(VDD33))/1k
BGPN35 GPN35 VSS I=(v(GPN35)-v(PH2)*(v(VDD33)-v(SP35))/v(VDD33))/1k
BGNP35 GNP35 VSS I=(v(GNP35)-v(PH2)*v(SN35)/v(VDD33))/1k
BGNN35 GNN35 VSS I=(v(GNN35)-v(PH2)*(v(VDD33)-v(SN35))/v(VDD33))/1k
BNOPP35 NGPP35 0 V=v(VDD33)-v(GPP35)
BNOPN35 NGPN35 0 V=v(VDD33)-v(GPN35)
BNONP35 NGNP35 0 V=v(VDD33)-v(GNP35)
BNONN35 NGNN35 0 V=v(VDD33)-v(GNN35)
CGPP35 GPP35 VSS 2p
CGPN35 GPN35 VSS 2p
CGNP35 GNP35 VSS 2p
CGNN35 GNN35 VSS 2p
CNGPP35 NGPP35 VSS 0.2p
CNGPN35 NGPN35 VSS 0.2p
CNGNP35 NGNP35 VSS 0.2p
CNGNN35 NGNN35 VSS 0.2p
XPVP35 CDLP35 VP GPP35 NGPP35 VDD33 VSS gf180_tg_lowq
XPVN35 CDLP35 VN GPN35 NGPN35 VDD33 VSS gf180_tg_lowq
XNVP35 CDLN35 VP GNP35 NGNP35 VDD33 VSS gf180_tg_lowq
XNVN35 CDLN35 VN GNN35 NGNN35 VDD33 VSS gf180_tg_lowq
* DAC unit 36 (P side DP36, N side DN36)
CDP36 CDLP36 CDRP36 {CU}
CDN36 CDLN36 CDRN36 {CU}
XDPA36 CDLP36 VCM_REF PH1 NPH1 VDD33 VSS gf180_tg_lowq
XDPB36 CDRP36 VCM_REF PH1 NPH1 VDD33 VSS gf180_tg_lowq
XDNA36 CDLN36 VCM_REF PH1 NPH1 VDD33 VSS gf180_tg_lowq
XDNB36 CDRN36 VCM_REF PH1 NPH1 VDD33 VSS gf180_tg_lowq
XDP236 CDRP36 INP PH2 NPH2 VDD33 VSS gf180_tg_lowq
XDN236 CDRN36 INN PH2 NPH2 VDD33 VSS gf180_tg_lowq
BGPP36 GPP36 VSS I=(v(GPP36)-v(PH2)*v(SP36)/v(VDD33))/1k
BGPN36 GPN36 VSS I=(v(GPN36)-v(PH2)*(v(VDD33)-v(SP36))/v(VDD33))/1k
BGNP36 GNP36 VSS I=(v(GNP36)-v(PH2)*v(SN36)/v(VDD33))/1k
BGNN36 GNN36 VSS I=(v(GNN36)-v(PH2)*(v(VDD33)-v(SN36))/v(VDD33))/1k
BNOPP36 NGPP36 0 V=v(VDD33)-v(GPP36)
BNOPN36 NGPN36 0 V=v(VDD33)-v(GPN36)
BNONP36 NGNP36 0 V=v(VDD33)-v(GNP36)
BNONN36 NGNN36 0 V=v(VDD33)-v(GNN36)
CGPP36 GPP36 VSS 2p
CGPN36 GPN36 VSS 2p
CGNP36 GNP36 VSS 2p
CGNN36 GNN36 VSS 2p
CNGPP36 NGPP36 VSS 0.2p
CNGPN36 NGPN36 VSS 0.2p
CNGNP36 NGNP36 VSS 0.2p
CNGNN36 NGNN36 VSS 0.2p
XPVP36 CDLP36 VP GPP36 NGPP36 VDD33 VSS gf180_tg_lowq
XPVN36 CDLP36 VN GPN36 NGPN36 VDD33 VSS gf180_tg_lowq
XNVP36 CDLN36 VP GNP36 NGNP36 VDD33 VSS gf180_tg_lowq
XNVN36 CDLN36 VN GNN36 NGNN36 VDD33 VSS gf180_tg_lowq
* DAC unit 37 (P side DP37, N side DN37)
CDP37 CDLP37 CDRP37 {CU}
CDN37 CDLN37 CDRN37 {CU}
XDPA37 CDLP37 VCM_REF PH1 NPH1 VDD33 VSS gf180_tg_lowq
XDPB37 CDRP37 VCM_REF PH1 NPH1 VDD33 VSS gf180_tg_lowq
XDNA37 CDLN37 VCM_REF PH1 NPH1 VDD33 VSS gf180_tg_lowq
XDNB37 CDRN37 VCM_REF PH1 NPH1 VDD33 VSS gf180_tg_lowq
XDP237 CDRP37 INP PH2 NPH2 VDD33 VSS gf180_tg_lowq
XDN237 CDRN37 INN PH2 NPH2 VDD33 VSS gf180_tg_lowq
BGPP37 GPP37 VSS I=(v(GPP37)-v(PH2)*v(SP37)/v(VDD33))/1k
BGPN37 GPN37 VSS I=(v(GPN37)-v(PH2)*(v(VDD33)-v(SP37))/v(VDD33))/1k
BGNP37 GNP37 VSS I=(v(GNP37)-v(PH2)*v(SN37)/v(VDD33))/1k
BGNN37 GNN37 VSS I=(v(GNN37)-v(PH2)*(v(VDD33)-v(SN37))/v(VDD33))/1k
BNOPP37 NGPP37 0 V=v(VDD33)-v(GPP37)
BNOPN37 NGPN37 0 V=v(VDD33)-v(GPN37)
BNONP37 NGNP37 0 V=v(VDD33)-v(GNP37)
BNONN37 NGNN37 0 V=v(VDD33)-v(GNN37)
CGPP37 GPP37 VSS 2p
CGPN37 GPN37 VSS 2p
CGNP37 GNP37 VSS 2p
CGNN37 GNN37 VSS 2p
CNGPP37 NGPP37 VSS 0.2p
CNGPN37 NGPN37 VSS 0.2p
CNGNP37 NGNP37 VSS 0.2p
CNGNN37 NGNN37 VSS 0.2p
XPVP37 CDLP37 VP GPP37 NGPP37 VDD33 VSS gf180_tg_lowq
XPVN37 CDLP37 VN GPN37 NGPN37 VDD33 VSS gf180_tg_lowq
XNVP37 CDLN37 VP GNP37 NGNP37 VDD33 VSS gf180_tg_lowq
XNVN37 CDLN37 VN GNN37 NGNN37 VDD33 VSS gf180_tg_lowq
* DAC unit 38 (P side DP38, N side DN38)
CDP38 CDLP38 CDRP38 {CU}
CDN38 CDLN38 CDRN38 {CU}
XDPA38 CDLP38 VCM_REF PH1 NPH1 VDD33 VSS gf180_tg_lowq
XDPB38 CDRP38 VCM_REF PH1 NPH1 VDD33 VSS gf180_tg_lowq
XDNA38 CDLN38 VCM_REF PH1 NPH1 VDD33 VSS gf180_tg_lowq
XDNB38 CDRN38 VCM_REF PH1 NPH1 VDD33 VSS gf180_tg_lowq
XDP238 CDRP38 INP PH2 NPH2 VDD33 VSS gf180_tg_lowq
XDN238 CDRN38 INN PH2 NPH2 VDD33 VSS gf180_tg_lowq
BGPP38 GPP38 VSS I=(v(GPP38)-v(PH2)*v(SP38)/v(VDD33))/1k
BGPN38 GPN38 VSS I=(v(GPN38)-v(PH2)*(v(VDD33)-v(SP38))/v(VDD33))/1k
BGNP38 GNP38 VSS I=(v(GNP38)-v(PH2)*v(SN38)/v(VDD33))/1k
BGNN38 GNN38 VSS I=(v(GNN38)-v(PH2)*(v(VDD33)-v(SN38))/v(VDD33))/1k
BNOPP38 NGPP38 0 V=v(VDD33)-v(GPP38)
BNOPN38 NGPN38 0 V=v(VDD33)-v(GPN38)
BNONP38 NGNP38 0 V=v(VDD33)-v(GNP38)
BNONN38 NGNN38 0 V=v(VDD33)-v(GNN38)
CGPP38 GPP38 VSS 2p
CGPN38 GPN38 VSS 2p
CGNP38 GNP38 VSS 2p
CGNN38 GNN38 VSS 2p
CNGPP38 NGPP38 VSS 0.2p
CNGPN38 NGPN38 VSS 0.2p
CNGNP38 NGNP38 VSS 0.2p
CNGNN38 NGNN38 VSS 0.2p
XPVP38 CDLP38 VP GPP38 NGPP38 VDD33 VSS gf180_tg_lowq
XPVN38 CDLP38 VN GPN38 NGPN38 VDD33 VSS gf180_tg_lowq
XNVP38 CDLN38 VP GNP38 NGNP38 VDD33 VSS gf180_tg_lowq
XNVN38 CDLN38 VN GNN38 NGNN38 VDD33 VSS gf180_tg_lowq
* DAC unit 39 (P side DP39, N side DN39)
CDP39 CDLP39 CDRP39 {CU}
CDN39 CDLN39 CDRN39 {CU}
XDPA39 CDLP39 VCM_REF PH1 NPH1 VDD33 VSS gf180_tg_lowq
XDPB39 CDRP39 VCM_REF PH1 NPH1 VDD33 VSS gf180_tg_lowq
XDNA39 CDLN39 VCM_REF PH1 NPH1 VDD33 VSS gf180_tg_lowq
XDNB39 CDRN39 VCM_REF PH1 NPH1 VDD33 VSS gf180_tg_lowq
XDP239 CDRP39 INP PH2 NPH2 VDD33 VSS gf180_tg_lowq
XDN239 CDRN39 INN PH2 NPH2 VDD33 VSS gf180_tg_lowq
BGPP39 GPP39 VSS I=(v(GPP39)-v(PH2)*v(SP39)/v(VDD33))/1k
BGPN39 GPN39 VSS I=(v(GPN39)-v(PH2)*(v(VDD33)-v(SP39))/v(VDD33))/1k
BGNP39 GNP39 VSS I=(v(GNP39)-v(PH2)*v(SN39)/v(VDD33))/1k
BGNN39 GNN39 VSS I=(v(GNN39)-v(PH2)*(v(VDD33)-v(SN39))/v(VDD33))/1k
BNOPP39 NGPP39 0 V=v(VDD33)-v(GPP39)
BNOPN39 NGPN39 0 V=v(VDD33)-v(GPN39)
BNONP39 NGNP39 0 V=v(VDD33)-v(GNP39)
BNONN39 NGNN39 0 V=v(VDD33)-v(GNN39)
CGPP39 GPP39 VSS 2p
CGPN39 GPN39 VSS 2p
CGNP39 GNP39 VSS 2p
CGNN39 GNN39 VSS 2p
CNGPP39 NGPP39 VSS 0.2p
CNGPN39 NGPN39 VSS 0.2p
CNGNP39 NGNP39 VSS 0.2p
CNGNN39 NGNN39 VSS 0.2p
XPVP39 CDLP39 VP GPP39 NGPP39 VDD33 VSS gf180_tg_lowq
XPVN39 CDLP39 VN GPN39 NGPN39 VDD33 VSS gf180_tg_lowq
XNVP39 CDLN39 VP GNP39 NGNP39 VDD33 VSS gf180_tg_lowq
XNVN39 CDLN39 VN GNN39 NGNN39 VDD33 VSS gf180_tg_lowq
* DAC unit 40 (P side DP40, N side DN40)
CDP40 CDLP40 CDRP40 {CU}
CDN40 CDLN40 CDRN40 {CU}
XDPA40 CDLP40 VCM_REF PH1 NPH1 VDD33 VSS gf180_tg_lowq
XDPB40 CDRP40 VCM_REF PH1 NPH1 VDD33 VSS gf180_tg_lowq
XDNA40 CDLN40 VCM_REF PH1 NPH1 VDD33 VSS gf180_tg_lowq
XDNB40 CDRN40 VCM_REF PH1 NPH1 VDD33 VSS gf180_tg_lowq
XDP240 CDRP40 INP PH2 NPH2 VDD33 VSS gf180_tg_lowq
XDN240 CDRN40 INN PH2 NPH2 VDD33 VSS gf180_tg_lowq
BGPP40 GPP40 VSS I=(v(GPP40)-v(PH2)*v(SP40)/v(VDD33))/1k
BGPN40 GPN40 VSS I=(v(GPN40)-v(PH2)*(v(VDD33)-v(SP40))/v(VDD33))/1k
BGNP40 GNP40 VSS I=(v(GNP40)-v(PH2)*v(SN40)/v(VDD33))/1k
BGNN40 GNN40 VSS I=(v(GNN40)-v(PH2)*(v(VDD33)-v(SN40))/v(VDD33))/1k
BNOPP40 NGPP40 0 V=v(VDD33)-v(GPP40)
BNOPN40 NGPN40 0 V=v(VDD33)-v(GPN40)
BNONP40 NGNP40 0 V=v(VDD33)-v(GNP40)
BNONN40 NGNN40 0 V=v(VDD33)-v(GNN40)
CGPP40 GPP40 VSS 2p
CGPN40 GPN40 VSS 2p
CGNP40 GNP40 VSS 2p
CGNN40 GNN40 VSS 2p
CNGPP40 NGPP40 VSS 0.2p
CNGPN40 NGPN40 VSS 0.2p
CNGNP40 NGNP40 VSS 0.2p
CNGNN40 NGNN40 VSS 0.2p
XPVP40 CDLP40 VP GPP40 NGPP40 VDD33 VSS gf180_tg_lowq
XPVN40 CDLP40 VN GPN40 NGPN40 VDD33 VSS gf180_tg_lowq
XNVP40 CDLN40 VP GNP40 NGNP40 VDD33 VSS gf180_tg_lowq
XNVN40 CDLN40 VN GNN40 NGNN40 VDD33 VSS gf180_tg_lowq
* DAC unit 41 (P side DP41, N side DN41)
CDP41 CDLP41 CDRP41 {CU}
CDN41 CDLN41 CDRN41 {CU}
XDPA41 CDLP41 VCM_REF PH1 NPH1 VDD33 VSS gf180_tg_lowq
XDPB41 CDRP41 VCM_REF PH1 NPH1 VDD33 VSS gf180_tg_lowq
XDNA41 CDLN41 VCM_REF PH1 NPH1 VDD33 VSS gf180_tg_lowq
XDNB41 CDRN41 VCM_REF PH1 NPH1 VDD33 VSS gf180_tg_lowq
XDP241 CDRP41 INP PH2 NPH2 VDD33 VSS gf180_tg_lowq
XDN241 CDRN41 INN PH2 NPH2 VDD33 VSS gf180_tg_lowq
BGPP41 GPP41 VSS I=(v(GPP41)-v(PH2)*v(SP41)/v(VDD33))/1k
BGPN41 GPN41 VSS I=(v(GPN41)-v(PH2)*(v(VDD33)-v(SP41))/v(VDD33))/1k
BGNP41 GNP41 VSS I=(v(GNP41)-v(PH2)*v(SN41)/v(VDD33))/1k
BGNN41 GNN41 VSS I=(v(GNN41)-v(PH2)*(v(VDD33)-v(SN41))/v(VDD33))/1k
BNOPP41 NGPP41 0 V=v(VDD33)-v(GPP41)
BNOPN41 NGPN41 0 V=v(VDD33)-v(GPN41)
BNONP41 NGNP41 0 V=v(VDD33)-v(GNP41)
BNONN41 NGNN41 0 V=v(VDD33)-v(GNN41)
CGPP41 GPP41 VSS 2p
CGPN41 GPN41 VSS 2p
CGNP41 GNP41 VSS 2p
CGNN41 GNN41 VSS 2p
CNGPP41 NGPP41 VSS 0.2p
CNGPN41 NGPN41 VSS 0.2p
CNGNP41 NGNP41 VSS 0.2p
CNGNN41 NGNN41 VSS 0.2p
XPVP41 CDLP41 VP GPP41 NGPP41 VDD33 VSS gf180_tg_lowq
XPVN41 CDLP41 VN GPN41 NGPN41 VDD33 VSS gf180_tg_lowq
XNVP41 CDLN41 VP GNP41 NGNP41 VDD33 VSS gf180_tg_lowq
XNVN41 CDLN41 VN GNN41 NGNN41 VDD33 VSS gf180_tg_lowq
* DAC unit 42 (P side DP42, N side DN42)
CDP42 CDLP42 CDRP42 {CU}
CDN42 CDLN42 CDRN42 {CU}
XDPA42 CDLP42 VCM_REF PH1 NPH1 VDD33 VSS gf180_tg_lowq
XDPB42 CDRP42 VCM_REF PH1 NPH1 VDD33 VSS gf180_tg_lowq
XDNA42 CDLN42 VCM_REF PH1 NPH1 VDD33 VSS gf180_tg_lowq
XDNB42 CDRN42 VCM_REF PH1 NPH1 VDD33 VSS gf180_tg_lowq
XDP242 CDRP42 INP PH2 NPH2 VDD33 VSS gf180_tg_lowq
XDN242 CDRN42 INN PH2 NPH2 VDD33 VSS gf180_tg_lowq
BGPP42 GPP42 VSS I=(v(GPP42)-v(PH2)*v(SP42)/v(VDD33))/1k
BGPN42 GPN42 VSS I=(v(GPN42)-v(PH2)*(v(VDD33)-v(SP42))/v(VDD33))/1k
BGNP42 GNP42 VSS I=(v(GNP42)-v(PH2)*v(SN42)/v(VDD33))/1k
BGNN42 GNN42 VSS I=(v(GNN42)-v(PH2)*(v(VDD33)-v(SN42))/v(VDD33))/1k
BNOPP42 NGPP42 0 V=v(VDD33)-v(GPP42)
BNOPN42 NGPN42 0 V=v(VDD33)-v(GPN42)
BNONP42 NGNP42 0 V=v(VDD33)-v(GNP42)
BNONN42 NGNN42 0 V=v(VDD33)-v(GNN42)
CGPP42 GPP42 VSS 2p
CGPN42 GPN42 VSS 2p
CGNP42 GNP42 VSS 2p
CGNN42 GNN42 VSS 2p
CNGPP42 NGPP42 VSS 0.2p
CNGPN42 NGPN42 VSS 0.2p
CNGNP42 NGNP42 VSS 0.2p
CNGNN42 NGNN42 VSS 0.2p
XPVP42 CDLP42 VP GPP42 NGPP42 VDD33 VSS gf180_tg_lowq
XPVN42 CDLP42 VN GPN42 NGPN42 VDD33 VSS gf180_tg_lowq
XNVP42 CDLN42 VP GNP42 NGNP42 VDD33 VSS gf180_tg_lowq
XNVN42 CDLN42 VN GNN42 NGNN42 VDD33 VSS gf180_tg_lowq
* DAC unit 43 (P side DP43, N side DN43)
CDP43 CDLP43 CDRP43 {CU}
CDN43 CDLN43 CDRN43 {CU}
XDPA43 CDLP43 VCM_REF PH1 NPH1 VDD33 VSS gf180_tg_lowq
XDPB43 CDRP43 VCM_REF PH1 NPH1 VDD33 VSS gf180_tg_lowq
XDNA43 CDLN43 VCM_REF PH1 NPH1 VDD33 VSS gf180_tg_lowq
XDNB43 CDRN43 VCM_REF PH1 NPH1 VDD33 VSS gf180_tg_lowq
XDP243 CDRP43 INP PH2 NPH2 VDD33 VSS gf180_tg_lowq
XDN243 CDRN43 INN PH2 NPH2 VDD33 VSS gf180_tg_lowq
BGPP43 GPP43 VSS I=(v(GPP43)-v(PH2)*v(SP43)/v(VDD33))/1k
BGPN43 GPN43 VSS I=(v(GPN43)-v(PH2)*(v(VDD33)-v(SP43))/v(VDD33))/1k
BGNP43 GNP43 VSS I=(v(GNP43)-v(PH2)*v(SN43)/v(VDD33))/1k
BGNN43 GNN43 VSS I=(v(GNN43)-v(PH2)*(v(VDD33)-v(SN43))/v(VDD33))/1k
BNOPP43 NGPP43 0 V=v(VDD33)-v(GPP43)
BNOPN43 NGPN43 0 V=v(VDD33)-v(GPN43)
BNONP43 NGNP43 0 V=v(VDD33)-v(GNP43)
BNONN43 NGNN43 0 V=v(VDD33)-v(GNN43)
CGPP43 GPP43 VSS 2p
CGPN43 GPN43 VSS 2p
CGNP43 GNP43 VSS 2p
CGNN43 GNN43 VSS 2p
CNGPP43 NGPP43 VSS 0.2p
CNGPN43 NGPN43 VSS 0.2p
CNGNP43 NGNP43 VSS 0.2p
CNGNN43 NGNN43 VSS 0.2p
XPVP43 CDLP43 VP GPP43 NGPP43 VDD33 VSS gf180_tg_lowq
XPVN43 CDLP43 VN GPN43 NGPN43 VDD33 VSS gf180_tg_lowq
XNVP43 CDLN43 VP GNP43 NGNP43 VDD33 VSS gf180_tg_lowq
XNVN43 CDLN43 VN GNN43 NGNN43 VDD33 VSS gf180_tg_lowq
* DAC unit 44 (P side DP44, N side DN44)
CDP44 CDLP44 CDRP44 {CU}
CDN44 CDLN44 CDRN44 {CU}
XDPA44 CDLP44 VCM_REF PH1 NPH1 VDD33 VSS gf180_tg_lowq
XDPB44 CDRP44 VCM_REF PH1 NPH1 VDD33 VSS gf180_tg_lowq
XDNA44 CDLN44 VCM_REF PH1 NPH1 VDD33 VSS gf180_tg_lowq
XDNB44 CDRN44 VCM_REF PH1 NPH1 VDD33 VSS gf180_tg_lowq
XDP244 CDRP44 INP PH2 NPH2 VDD33 VSS gf180_tg_lowq
XDN244 CDRN44 INN PH2 NPH2 VDD33 VSS gf180_tg_lowq
BGPP44 GPP44 VSS I=(v(GPP44)-v(PH2)*v(SP44)/v(VDD33))/1k
BGPN44 GPN44 VSS I=(v(GPN44)-v(PH2)*(v(VDD33)-v(SP44))/v(VDD33))/1k
BGNP44 GNP44 VSS I=(v(GNP44)-v(PH2)*v(SN44)/v(VDD33))/1k
BGNN44 GNN44 VSS I=(v(GNN44)-v(PH2)*(v(VDD33)-v(SN44))/v(VDD33))/1k
BNOPP44 NGPP44 0 V=v(VDD33)-v(GPP44)
BNOPN44 NGPN44 0 V=v(VDD33)-v(GPN44)
BNONP44 NGNP44 0 V=v(VDD33)-v(GNP44)
BNONN44 NGNN44 0 V=v(VDD33)-v(GNN44)
CGPP44 GPP44 VSS 2p
CGPN44 GPN44 VSS 2p
CGNP44 GNP44 VSS 2p
CGNN44 GNN44 VSS 2p
CNGPP44 NGPP44 VSS 0.2p
CNGPN44 NGPN44 VSS 0.2p
CNGNP44 NGNP44 VSS 0.2p
CNGNN44 NGNN44 VSS 0.2p
XPVP44 CDLP44 VP GPP44 NGPP44 VDD33 VSS gf180_tg_lowq
XPVN44 CDLP44 VN GPN44 NGPN44 VDD33 VSS gf180_tg_lowq
XNVP44 CDLN44 VP GNP44 NGNP44 VDD33 VSS gf180_tg_lowq
XNVN44 CDLN44 VN GNN44 NGNN44 VDD33 VSS gf180_tg_lowq
* DAC unit 45 (P side DP45, N side DN45)
CDP45 CDLP45 CDRP45 {CU}
CDN45 CDLN45 CDRN45 {CU}
XDPA45 CDLP45 VCM_REF PH1 NPH1 VDD33 VSS gf180_tg_lowq
XDPB45 CDRP45 VCM_REF PH1 NPH1 VDD33 VSS gf180_tg_lowq
XDNA45 CDLN45 VCM_REF PH1 NPH1 VDD33 VSS gf180_tg_lowq
XDNB45 CDRN45 VCM_REF PH1 NPH1 VDD33 VSS gf180_tg_lowq
XDP245 CDRP45 INP PH2 NPH2 VDD33 VSS gf180_tg_lowq
XDN245 CDRN45 INN PH2 NPH2 VDD33 VSS gf180_tg_lowq
BGPP45 GPP45 VSS I=(v(GPP45)-v(PH2)*v(SP45)/v(VDD33))/1k
BGPN45 GPN45 VSS I=(v(GPN45)-v(PH2)*(v(VDD33)-v(SP45))/v(VDD33))/1k
BGNP45 GNP45 VSS I=(v(GNP45)-v(PH2)*v(SN45)/v(VDD33))/1k
BGNN45 GNN45 VSS I=(v(GNN45)-v(PH2)*(v(VDD33)-v(SN45))/v(VDD33))/1k
BNOPP45 NGPP45 0 V=v(VDD33)-v(GPP45)
BNOPN45 NGPN45 0 V=v(VDD33)-v(GPN45)
BNONP45 NGNP45 0 V=v(VDD33)-v(GNP45)
BNONN45 NGNN45 0 V=v(VDD33)-v(GNN45)
CGPP45 GPP45 VSS 2p
CGPN45 GPN45 VSS 2p
CGNP45 GNP45 VSS 2p
CGNN45 GNN45 VSS 2p
CNGPP45 NGPP45 VSS 0.2p
CNGPN45 NGPN45 VSS 0.2p
CNGNP45 NGNP45 VSS 0.2p
CNGNN45 NGNN45 VSS 0.2p
XPVP45 CDLP45 VP GPP45 NGPP45 VDD33 VSS gf180_tg_lowq
XPVN45 CDLP45 VN GPN45 NGPN45 VDD33 VSS gf180_tg_lowq
XNVP45 CDLN45 VP GNP45 NGNP45 VDD33 VSS gf180_tg_lowq
XNVN45 CDLN45 VN GNN45 NGNN45 VDD33 VSS gf180_tg_lowq
* DAC unit 46 (P side DP46, N side DN46)
CDP46 CDLP46 CDRP46 {CU}
CDN46 CDLN46 CDRN46 {CU}
XDPA46 CDLP46 VCM_REF PH1 NPH1 VDD33 VSS gf180_tg_lowq
XDPB46 CDRP46 VCM_REF PH1 NPH1 VDD33 VSS gf180_tg_lowq
XDNA46 CDLN46 VCM_REF PH1 NPH1 VDD33 VSS gf180_tg_lowq
XDNB46 CDRN46 VCM_REF PH1 NPH1 VDD33 VSS gf180_tg_lowq
XDP246 CDRP46 INP PH2 NPH2 VDD33 VSS gf180_tg_lowq
XDN246 CDRN46 INN PH2 NPH2 VDD33 VSS gf180_tg_lowq
BGPP46 GPP46 VSS I=(v(GPP46)-v(PH2)*v(SP46)/v(VDD33))/1k
BGPN46 GPN46 VSS I=(v(GPN46)-v(PH2)*(v(VDD33)-v(SP46))/v(VDD33))/1k
BGNP46 GNP46 VSS I=(v(GNP46)-v(PH2)*v(SN46)/v(VDD33))/1k
BGNN46 GNN46 VSS I=(v(GNN46)-v(PH2)*(v(VDD33)-v(SN46))/v(VDD33))/1k
BNOPP46 NGPP46 0 V=v(VDD33)-v(GPP46)
BNOPN46 NGPN46 0 V=v(VDD33)-v(GPN46)
BNONP46 NGNP46 0 V=v(VDD33)-v(GNP46)
BNONN46 NGNN46 0 V=v(VDD33)-v(GNN46)
CGPP46 GPP46 VSS 2p
CGPN46 GPN46 VSS 2p
CGNP46 GNP46 VSS 2p
CGNN46 GNN46 VSS 2p
CNGPP46 NGPP46 VSS 0.2p
CNGPN46 NGPN46 VSS 0.2p
CNGNP46 NGNP46 VSS 0.2p
CNGNN46 NGNN46 VSS 0.2p
XPVP46 CDLP46 VP GPP46 NGPP46 VDD33 VSS gf180_tg_lowq
XPVN46 CDLP46 VN GPN46 NGPN46 VDD33 VSS gf180_tg_lowq
XNVP46 CDLN46 VP GNP46 NGNP46 VDD33 VSS gf180_tg_lowq
XNVN46 CDLN46 VN GNN46 NGNN46 VDD33 VSS gf180_tg_lowq
* DAC unit 47 (P side DP47, N side DN47)
CDP47 CDLP47 CDRP47 {CU}
CDN47 CDLN47 CDRN47 {CU}
XDPA47 CDLP47 VCM_REF PH1 NPH1 VDD33 VSS gf180_tg_lowq
XDPB47 CDRP47 VCM_REF PH1 NPH1 VDD33 VSS gf180_tg_lowq
XDNA47 CDLN47 VCM_REF PH1 NPH1 VDD33 VSS gf180_tg_lowq
XDNB47 CDRN47 VCM_REF PH1 NPH1 VDD33 VSS gf180_tg_lowq
XDP247 CDRP47 INP PH2 NPH2 VDD33 VSS gf180_tg_lowq
XDN247 CDRN47 INN PH2 NPH2 VDD33 VSS gf180_tg_lowq
BGPP47 GPP47 VSS I=(v(GPP47)-v(PH2)*v(SP47)/v(VDD33))/1k
BGPN47 GPN47 VSS I=(v(GPN47)-v(PH2)*(v(VDD33)-v(SP47))/v(VDD33))/1k
BGNP47 GNP47 VSS I=(v(GNP47)-v(PH2)*v(SN47)/v(VDD33))/1k
BGNN47 GNN47 VSS I=(v(GNN47)-v(PH2)*(v(VDD33)-v(SN47))/v(VDD33))/1k
BNOPP47 NGPP47 0 V=v(VDD33)-v(GPP47)
BNOPN47 NGPN47 0 V=v(VDD33)-v(GPN47)
BNONP47 NGNP47 0 V=v(VDD33)-v(GNP47)
BNONN47 NGNN47 0 V=v(VDD33)-v(GNN47)
CGPP47 GPP47 VSS 2p
CGPN47 GPN47 VSS 2p
CGNP47 GNP47 VSS 2p
CGNN47 GNN47 VSS 2p
CNGPP47 NGPP47 VSS 0.2p
CNGPN47 NGPN47 VSS 0.2p
CNGNP47 NGNP47 VSS 0.2p
CNGNN47 NGNN47 VSS 0.2p
XPVP47 CDLP47 VP GPP47 NGPP47 VDD33 VSS gf180_tg_lowq
XPVN47 CDLP47 VN GPN47 NGPN47 VDD33 VSS gf180_tg_lowq
XNVP47 CDLN47 VP GNP47 NGNP47 VDD33 VSS gf180_tg_lowq
XNVN47 CDLN47 VN GNN47 NGNN47 VDD33 VSS gf180_tg_lowq
* DAC unit 48 (P side DP48, N side DN48)
CDP48 CDLP48 CDRP48 {CU}
CDN48 CDLN48 CDRN48 {CU}
XDPA48 CDLP48 VCM_REF PH1 NPH1 VDD33 VSS gf180_tg_lowq
XDPB48 CDRP48 VCM_REF PH1 NPH1 VDD33 VSS gf180_tg_lowq
XDNA48 CDLN48 VCM_REF PH1 NPH1 VDD33 VSS gf180_tg_lowq
XDNB48 CDRN48 VCM_REF PH1 NPH1 VDD33 VSS gf180_tg_lowq
XDP248 CDRP48 INP PH2 NPH2 VDD33 VSS gf180_tg_lowq
XDN248 CDRN48 INN PH2 NPH2 VDD33 VSS gf180_tg_lowq
BGPP48 GPP48 VSS I=(v(GPP48)-v(PH2)*v(SP48)/v(VDD33))/1k
BGPN48 GPN48 VSS I=(v(GPN48)-v(PH2)*(v(VDD33)-v(SP48))/v(VDD33))/1k
BGNP48 GNP48 VSS I=(v(GNP48)-v(PH2)*v(SN48)/v(VDD33))/1k
BGNN48 GNN48 VSS I=(v(GNN48)-v(PH2)*(v(VDD33)-v(SN48))/v(VDD33))/1k
BNOPP48 NGPP48 0 V=v(VDD33)-v(GPP48)
BNOPN48 NGPN48 0 V=v(VDD33)-v(GPN48)
BNONP48 NGNP48 0 V=v(VDD33)-v(GNP48)
BNONN48 NGNN48 0 V=v(VDD33)-v(GNN48)
CGPP48 GPP48 VSS 2p
CGPN48 GPN48 VSS 2p
CGNP48 GNP48 VSS 2p
CGNN48 GNN48 VSS 2p
CNGPP48 NGPP48 VSS 0.2p
CNGPN48 NGPN48 VSS 0.2p
CNGNP48 NGNP48 VSS 0.2p
CNGNN48 NGNN48 VSS 0.2p
XPVP48 CDLP48 VP GPP48 NGPP48 VDD33 VSS gf180_tg_lowq
XPVN48 CDLP48 VN GPN48 NGPN48 VDD33 VSS gf180_tg_lowq
XNVP48 CDLN48 VP GNP48 NGNP48 VDD33 VSS gf180_tg_lowq
XNVN48 CDLN48 VN GNN48 NGNN48 VDD33 VSS gf180_tg_lowq
* DAC unit 49 (P side DP49, N side DN49)
CDP49 CDLP49 CDRP49 {CU}
CDN49 CDLN49 CDRN49 {CU}
XDPA49 CDLP49 VCM_REF PH1 NPH1 VDD33 VSS gf180_tg_lowq
XDPB49 CDRP49 VCM_REF PH1 NPH1 VDD33 VSS gf180_tg_lowq
XDNA49 CDLN49 VCM_REF PH1 NPH1 VDD33 VSS gf180_tg_lowq
XDNB49 CDRN49 VCM_REF PH1 NPH1 VDD33 VSS gf180_tg_lowq
XDP249 CDRP49 INP PH2 NPH2 VDD33 VSS gf180_tg_lowq
XDN249 CDRN49 INN PH2 NPH2 VDD33 VSS gf180_tg_lowq
BGPP49 GPP49 VSS I=(v(GPP49)-v(PH2)*v(SP49)/v(VDD33))/1k
BGPN49 GPN49 VSS I=(v(GPN49)-v(PH2)*(v(VDD33)-v(SP49))/v(VDD33))/1k
BGNP49 GNP49 VSS I=(v(GNP49)-v(PH2)*v(SN49)/v(VDD33))/1k
BGNN49 GNN49 VSS I=(v(GNN49)-v(PH2)*(v(VDD33)-v(SN49))/v(VDD33))/1k
BNOPP49 NGPP49 0 V=v(VDD33)-v(GPP49)
BNOPN49 NGPN49 0 V=v(VDD33)-v(GPN49)
BNONP49 NGNP49 0 V=v(VDD33)-v(GNP49)
BNONN49 NGNN49 0 V=v(VDD33)-v(GNN49)
CGPP49 GPP49 VSS 2p
CGPN49 GPN49 VSS 2p
CGNP49 GNP49 VSS 2p
CGNN49 GNN49 VSS 2p
CNGPP49 NGPP49 VSS 0.2p
CNGPN49 NGPN49 VSS 0.2p
CNGNP49 NGNP49 VSS 0.2p
CNGNN49 NGNN49 VSS 0.2p
XPVP49 CDLP49 VP GPP49 NGPP49 VDD33 VSS gf180_tg_lowq
XPVN49 CDLP49 VN GPN49 NGPN49 VDD33 VSS gf180_tg_lowq
XNVP49 CDLN49 VP GNP49 NGNP49 VDD33 VSS gf180_tg_lowq
XNVN49 CDLN49 VN GNN49 NGNN49 VDD33 VSS gf180_tg_lowq
* DAC unit 50 (P side DP50, N side DN50)
CDP50 CDLP50 CDRP50 {CU}
CDN50 CDLN50 CDRN50 {CU}
XDPA50 CDLP50 VCM_REF PH1 NPH1 VDD33 VSS gf180_tg_lowq
XDPB50 CDRP50 VCM_REF PH1 NPH1 VDD33 VSS gf180_tg_lowq
XDNA50 CDLN50 VCM_REF PH1 NPH1 VDD33 VSS gf180_tg_lowq
XDNB50 CDRN50 VCM_REF PH1 NPH1 VDD33 VSS gf180_tg_lowq
XDP250 CDRP50 INP PH2 NPH2 VDD33 VSS gf180_tg_lowq
XDN250 CDRN50 INN PH2 NPH2 VDD33 VSS gf180_tg_lowq
BGPP50 GPP50 VSS I=(v(GPP50)-v(PH2)*v(SP50)/v(VDD33))/1k
BGPN50 GPN50 VSS I=(v(GPN50)-v(PH2)*(v(VDD33)-v(SP50))/v(VDD33))/1k
BGNP50 GNP50 VSS I=(v(GNP50)-v(PH2)*v(SN50)/v(VDD33))/1k
BGNN50 GNN50 VSS I=(v(GNN50)-v(PH2)*(v(VDD33)-v(SN50))/v(VDD33))/1k
BNOPP50 NGPP50 0 V=v(VDD33)-v(GPP50)
BNOPN50 NGPN50 0 V=v(VDD33)-v(GPN50)
BNONP50 NGNP50 0 V=v(VDD33)-v(GNP50)
BNONN50 NGNN50 0 V=v(VDD33)-v(GNN50)
CGPP50 GPP50 VSS 2p
CGPN50 GPN50 VSS 2p
CGNP50 GNP50 VSS 2p
CGNN50 GNN50 VSS 2p
CNGPP50 NGPP50 VSS 0.2p
CNGPN50 NGPN50 VSS 0.2p
CNGNP50 NGNP50 VSS 0.2p
CNGNN50 NGNN50 VSS 0.2p
XPVP50 CDLP50 VP GPP50 NGPP50 VDD33 VSS gf180_tg_lowq
XPVN50 CDLP50 VN GPN50 NGPN50 VDD33 VSS gf180_tg_lowq
XNVP50 CDLN50 VP GNP50 NGNP50 VDD33 VSS gf180_tg_lowq
XNVN50 CDLN50 VN GNN50 NGNN50 VDD33 VSS gf180_tg_lowq
* DAC unit 51 (P side DP51, N side DN51)
CDP51 CDLP51 CDRP51 {CU}
CDN51 CDLN51 CDRN51 {CU}
XDPA51 CDLP51 VCM_REF PH1 NPH1 VDD33 VSS gf180_tg_lowq
XDPB51 CDRP51 VCM_REF PH1 NPH1 VDD33 VSS gf180_tg_lowq
XDNA51 CDLN51 VCM_REF PH1 NPH1 VDD33 VSS gf180_tg_lowq
XDNB51 CDRN51 VCM_REF PH1 NPH1 VDD33 VSS gf180_tg_lowq
XDP251 CDRP51 INP PH2 NPH2 VDD33 VSS gf180_tg_lowq
XDN251 CDRN51 INN PH2 NPH2 VDD33 VSS gf180_tg_lowq
BGPP51 GPP51 VSS I=(v(GPP51)-v(PH2)*v(SP51)/v(VDD33))/1k
BGPN51 GPN51 VSS I=(v(GPN51)-v(PH2)*(v(VDD33)-v(SP51))/v(VDD33))/1k
BGNP51 GNP51 VSS I=(v(GNP51)-v(PH2)*v(SN51)/v(VDD33))/1k
BGNN51 GNN51 VSS I=(v(GNN51)-v(PH2)*(v(VDD33)-v(SN51))/v(VDD33))/1k
BNOPP51 NGPP51 0 V=v(VDD33)-v(GPP51)
BNOPN51 NGPN51 0 V=v(VDD33)-v(GPN51)
BNONP51 NGNP51 0 V=v(VDD33)-v(GNP51)
BNONN51 NGNN51 0 V=v(VDD33)-v(GNN51)
CGPP51 GPP51 VSS 2p
CGPN51 GPN51 VSS 2p
CGNP51 GNP51 VSS 2p
CGNN51 GNN51 VSS 2p
CNGPP51 NGPP51 VSS 0.2p
CNGPN51 NGPN51 VSS 0.2p
CNGNP51 NGNP51 VSS 0.2p
CNGNN51 NGNN51 VSS 0.2p
XPVP51 CDLP51 VP GPP51 NGPP51 VDD33 VSS gf180_tg_lowq
XPVN51 CDLP51 VN GPN51 NGPN51 VDD33 VSS gf180_tg_lowq
XNVP51 CDLN51 VP GNP51 NGNP51 VDD33 VSS gf180_tg_lowq
XNVN51 CDLN51 VN GNN51 NGNN51 VDD33 VSS gf180_tg_lowq
* DAC unit 52 (P side DP52, N side DN52)
CDP52 CDLP52 CDRP52 {CU}
CDN52 CDLN52 CDRN52 {CU}
XDPA52 CDLP52 VCM_REF PH1 NPH1 VDD33 VSS gf180_tg_lowq
XDPB52 CDRP52 VCM_REF PH1 NPH1 VDD33 VSS gf180_tg_lowq
XDNA52 CDLN52 VCM_REF PH1 NPH1 VDD33 VSS gf180_tg_lowq
XDNB52 CDRN52 VCM_REF PH1 NPH1 VDD33 VSS gf180_tg_lowq
XDP252 CDRP52 INP PH2 NPH2 VDD33 VSS gf180_tg_lowq
XDN252 CDRN52 INN PH2 NPH2 VDD33 VSS gf180_tg_lowq
BGPP52 GPP52 VSS I=(v(GPP52)-v(PH2)*v(SP52)/v(VDD33))/1k
BGPN52 GPN52 VSS I=(v(GPN52)-v(PH2)*(v(VDD33)-v(SP52))/v(VDD33))/1k
BGNP52 GNP52 VSS I=(v(GNP52)-v(PH2)*v(SN52)/v(VDD33))/1k
BGNN52 GNN52 VSS I=(v(GNN52)-v(PH2)*(v(VDD33)-v(SN52))/v(VDD33))/1k
BNOPP52 NGPP52 0 V=v(VDD33)-v(GPP52)
BNOPN52 NGPN52 0 V=v(VDD33)-v(GPN52)
BNONP52 NGNP52 0 V=v(VDD33)-v(GNP52)
BNONN52 NGNN52 0 V=v(VDD33)-v(GNN52)
CGPP52 GPP52 VSS 2p
CGPN52 GPN52 VSS 2p
CGNP52 GNP52 VSS 2p
CGNN52 GNN52 VSS 2p
CNGPP52 NGPP52 VSS 0.2p
CNGPN52 NGPN52 VSS 0.2p
CNGNP52 NGNP52 VSS 0.2p
CNGNN52 NGNN52 VSS 0.2p
XPVP52 CDLP52 VP GPP52 NGPP52 VDD33 VSS gf180_tg_lowq
XPVN52 CDLP52 VN GPN52 NGPN52 VDD33 VSS gf180_tg_lowq
XNVP52 CDLN52 VP GNP52 NGNP52 VDD33 VSS gf180_tg_lowq
XNVN52 CDLN52 VN GNN52 NGNN52 VDD33 VSS gf180_tg_lowq
* DAC unit 53 (P side DP53, N side DN53)
CDP53 CDLP53 CDRP53 {CU}
CDN53 CDLN53 CDRN53 {CU}
XDPA53 CDLP53 VCM_REF PH1 NPH1 VDD33 VSS gf180_tg_lowq
XDPB53 CDRP53 VCM_REF PH1 NPH1 VDD33 VSS gf180_tg_lowq
XDNA53 CDLN53 VCM_REF PH1 NPH1 VDD33 VSS gf180_tg_lowq
XDNB53 CDRN53 VCM_REF PH1 NPH1 VDD33 VSS gf180_tg_lowq
XDP253 CDRP53 INP PH2 NPH2 VDD33 VSS gf180_tg_lowq
XDN253 CDRN53 INN PH2 NPH2 VDD33 VSS gf180_tg_lowq
BGPP53 GPP53 VSS I=(v(GPP53)-v(PH2)*v(SP53)/v(VDD33))/1k
BGPN53 GPN53 VSS I=(v(GPN53)-v(PH2)*(v(VDD33)-v(SP53))/v(VDD33))/1k
BGNP53 GNP53 VSS I=(v(GNP53)-v(PH2)*v(SN53)/v(VDD33))/1k
BGNN53 GNN53 VSS I=(v(GNN53)-v(PH2)*(v(VDD33)-v(SN53))/v(VDD33))/1k
BNOPP53 NGPP53 0 V=v(VDD33)-v(GPP53)
BNOPN53 NGPN53 0 V=v(VDD33)-v(GPN53)
BNONP53 NGNP53 0 V=v(VDD33)-v(GNP53)
BNONN53 NGNN53 0 V=v(VDD33)-v(GNN53)
CGPP53 GPP53 VSS 2p
CGPN53 GPN53 VSS 2p
CGNP53 GNP53 VSS 2p
CGNN53 GNN53 VSS 2p
CNGPP53 NGPP53 VSS 0.2p
CNGPN53 NGPN53 VSS 0.2p
CNGNP53 NGNP53 VSS 0.2p
CNGNN53 NGNN53 VSS 0.2p
XPVP53 CDLP53 VP GPP53 NGPP53 VDD33 VSS gf180_tg_lowq
XPVN53 CDLP53 VN GPN53 NGPN53 VDD33 VSS gf180_tg_lowq
XNVP53 CDLN53 VP GNP53 NGNP53 VDD33 VSS gf180_tg_lowq
XNVN53 CDLN53 VN GNN53 NGNN53 VDD33 VSS gf180_tg_lowq
* DAC unit 54 (P side DP54, N side DN54)
CDP54 CDLP54 CDRP54 {CU}
CDN54 CDLN54 CDRN54 {CU}
XDPA54 CDLP54 VCM_REF PH1 NPH1 VDD33 VSS gf180_tg_lowq
XDPB54 CDRP54 VCM_REF PH1 NPH1 VDD33 VSS gf180_tg_lowq
XDNA54 CDLN54 VCM_REF PH1 NPH1 VDD33 VSS gf180_tg_lowq
XDNB54 CDRN54 VCM_REF PH1 NPH1 VDD33 VSS gf180_tg_lowq
XDP254 CDRP54 INP PH2 NPH2 VDD33 VSS gf180_tg_lowq
XDN254 CDRN54 INN PH2 NPH2 VDD33 VSS gf180_tg_lowq
BGPP54 GPP54 VSS I=(v(GPP54)-v(PH2)*v(SP54)/v(VDD33))/1k
BGPN54 GPN54 VSS I=(v(GPN54)-v(PH2)*(v(VDD33)-v(SP54))/v(VDD33))/1k
BGNP54 GNP54 VSS I=(v(GNP54)-v(PH2)*v(SN54)/v(VDD33))/1k
BGNN54 GNN54 VSS I=(v(GNN54)-v(PH2)*(v(VDD33)-v(SN54))/v(VDD33))/1k
BNOPP54 NGPP54 0 V=v(VDD33)-v(GPP54)
BNOPN54 NGPN54 0 V=v(VDD33)-v(GPN54)
BNONP54 NGNP54 0 V=v(VDD33)-v(GNP54)
BNONN54 NGNN54 0 V=v(VDD33)-v(GNN54)
CGPP54 GPP54 VSS 2p
CGPN54 GPN54 VSS 2p
CGNP54 GNP54 VSS 2p
CGNN54 GNN54 VSS 2p
CNGPP54 NGPP54 VSS 0.2p
CNGPN54 NGPN54 VSS 0.2p
CNGNP54 NGNP54 VSS 0.2p
CNGNN54 NGNN54 VSS 0.2p
XPVP54 CDLP54 VP GPP54 NGPP54 VDD33 VSS gf180_tg_lowq
XPVN54 CDLP54 VN GPN54 NGPN54 VDD33 VSS gf180_tg_lowq
XNVP54 CDLN54 VP GNP54 NGNP54 VDD33 VSS gf180_tg_lowq
XNVN54 CDLN54 VN GNN54 NGNN54 VDD33 VSS gf180_tg_lowq
* DAC unit 55 (P side DP55, N side DN55)
CDP55 CDLP55 CDRP55 {CU}
CDN55 CDLN55 CDRN55 {CU}
XDPA55 CDLP55 VCM_REF PH1 NPH1 VDD33 VSS gf180_tg_lowq
XDPB55 CDRP55 VCM_REF PH1 NPH1 VDD33 VSS gf180_tg_lowq
XDNA55 CDLN55 VCM_REF PH1 NPH1 VDD33 VSS gf180_tg_lowq
XDNB55 CDRN55 VCM_REF PH1 NPH1 VDD33 VSS gf180_tg_lowq
XDP255 CDRP55 INP PH2 NPH2 VDD33 VSS gf180_tg_lowq
XDN255 CDRN55 INN PH2 NPH2 VDD33 VSS gf180_tg_lowq
BGPP55 GPP55 VSS I=(v(GPP55)-v(PH2)*v(SP55)/v(VDD33))/1k
BGPN55 GPN55 VSS I=(v(GPN55)-v(PH2)*(v(VDD33)-v(SP55))/v(VDD33))/1k
BGNP55 GNP55 VSS I=(v(GNP55)-v(PH2)*v(SN55)/v(VDD33))/1k
BGNN55 GNN55 VSS I=(v(GNN55)-v(PH2)*(v(VDD33)-v(SN55))/v(VDD33))/1k
BNOPP55 NGPP55 0 V=v(VDD33)-v(GPP55)
BNOPN55 NGPN55 0 V=v(VDD33)-v(GPN55)
BNONP55 NGNP55 0 V=v(VDD33)-v(GNP55)
BNONN55 NGNN55 0 V=v(VDD33)-v(GNN55)
CGPP55 GPP55 VSS 2p
CGPN55 GPN55 VSS 2p
CGNP55 GNP55 VSS 2p
CGNN55 GNN55 VSS 2p
CNGPP55 NGPP55 VSS 0.2p
CNGPN55 NGPN55 VSS 0.2p
CNGNP55 NGNP55 VSS 0.2p
CNGNN55 NGNN55 VSS 0.2p
XPVP55 CDLP55 VP GPP55 NGPP55 VDD33 VSS gf180_tg_lowq
XPVN55 CDLP55 VN GPN55 NGPN55 VDD33 VSS gf180_tg_lowq
XNVP55 CDLN55 VP GNP55 NGNP55 VDD33 VSS gf180_tg_lowq
XNVN55 CDLN55 VN GNN55 NGNN55 VDD33 VSS gf180_tg_lowq
* DAC unit 56 (P side DP56, N side DN56)
CDP56 CDLP56 CDRP56 {CU}
CDN56 CDLN56 CDRN56 {CU}
XDPA56 CDLP56 VCM_REF PH1 NPH1 VDD33 VSS gf180_tg_lowq
XDPB56 CDRP56 VCM_REF PH1 NPH1 VDD33 VSS gf180_tg_lowq
XDNA56 CDLN56 VCM_REF PH1 NPH1 VDD33 VSS gf180_tg_lowq
XDNB56 CDRN56 VCM_REF PH1 NPH1 VDD33 VSS gf180_tg_lowq
XDP256 CDRP56 INP PH2 NPH2 VDD33 VSS gf180_tg_lowq
XDN256 CDRN56 INN PH2 NPH2 VDD33 VSS gf180_tg_lowq
BGPP56 GPP56 VSS I=(v(GPP56)-v(PH2)*v(SP56)/v(VDD33))/1k
BGPN56 GPN56 VSS I=(v(GPN56)-v(PH2)*(v(VDD33)-v(SP56))/v(VDD33))/1k
BGNP56 GNP56 VSS I=(v(GNP56)-v(PH2)*v(SN56)/v(VDD33))/1k
BGNN56 GNN56 VSS I=(v(GNN56)-v(PH2)*(v(VDD33)-v(SN56))/v(VDD33))/1k
BNOPP56 NGPP56 0 V=v(VDD33)-v(GPP56)
BNOPN56 NGPN56 0 V=v(VDD33)-v(GPN56)
BNONP56 NGNP56 0 V=v(VDD33)-v(GNP56)
BNONN56 NGNN56 0 V=v(VDD33)-v(GNN56)
CGPP56 GPP56 VSS 2p
CGPN56 GPN56 VSS 2p
CGNP56 GNP56 VSS 2p
CGNN56 GNN56 VSS 2p
CNGPP56 NGPP56 VSS 0.2p
CNGPN56 NGPN56 VSS 0.2p
CNGNP56 NGNP56 VSS 0.2p
CNGNN56 NGNN56 VSS 0.2p
XPVP56 CDLP56 VP GPP56 NGPP56 VDD33 VSS gf180_tg_lowq
XPVN56 CDLP56 VN GPN56 NGPN56 VDD33 VSS gf180_tg_lowq
XNVP56 CDLN56 VP GNP56 NGNP56 VDD33 VSS gf180_tg_lowq
XNVN56 CDLN56 VN GNN56 NGNN56 VDD33 VSS gf180_tg_lowq
* DAC unit 57 (P side DP57, N side DN57)
CDP57 CDLP57 CDRP57 {CU}
CDN57 CDLN57 CDRN57 {CU}
XDPA57 CDLP57 VCM_REF PH1 NPH1 VDD33 VSS gf180_tg_lowq
XDPB57 CDRP57 VCM_REF PH1 NPH1 VDD33 VSS gf180_tg_lowq
XDNA57 CDLN57 VCM_REF PH1 NPH1 VDD33 VSS gf180_tg_lowq
XDNB57 CDRN57 VCM_REF PH1 NPH1 VDD33 VSS gf180_tg_lowq
XDP257 CDRP57 INP PH2 NPH2 VDD33 VSS gf180_tg_lowq
XDN257 CDRN57 INN PH2 NPH2 VDD33 VSS gf180_tg_lowq
BGPP57 GPP57 VSS I=(v(GPP57)-v(PH2)*v(SP57)/v(VDD33))/1k
BGPN57 GPN57 VSS I=(v(GPN57)-v(PH2)*(v(VDD33)-v(SP57))/v(VDD33))/1k
BGNP57 GNP57 VSS I=(v(GNP57)-v(PH2)*v(SN57)/v(VDD33))/1k
BGNN57 GNN57 VSS I=(v(GNN57)-v(PH2)*(v(VDD33)-v(SN57))/v(VDD33))/1k
BNOPP57 NGPP57 0 V=v(VDD33)-v(GPP57)
BNOPN57 NGPN57 0 V=v(VDD33)-v(GPN57)
BNONP57 NGNP57 0 V=v(VDD33)-v(GNP57)
BNONN57 NGNN57 0 V=v(VDD33)-v(GNN57)
CGPP57 GPP57 VSS 2p
CGPN57 GPN57 VSS 2p
CGNP57 GNP57 VSS 2p
CGNN57 GNN57 VSS 2p
CNGPP57 NGPP57 VSS 0.2p
CNGPN57 NGPN57 VSS 0.2p
CNGNP57 NGNP57 VSS 0.2p
CNGNN57 NGNN57 VSS 0.2p
XPVP57 CDLP57 VP GPP57 NGPP57 VDD33 VSS gf180_tg_lowq
XPVN57 CDLP57 VN GPN57 NGPN57 VDD33 VSS gf180_tg_lowq
XNVP57 CDLN57 VP GNP57 NGNP57 VDD33 VSS gf180_tg_lowq
XNVN57 CDLN57 VN GNN57 NGNN57 VDD33 VSS gf180_tg_lowq
* DAC unit 58 (P side DP58, N side DN58)
CDP58 CDLP58 CDRP58 {CU}
CDN58 CDLN58 CDRN58 {CU}
XDPA58 CDLP58 VCM_REF PH1 NPH1 VDD33 VSS gf180_tg_lowq
XDPB58 CDRP58 VCM_REF PH1 NPH1 VDD33 VSS gf180_tg_lowq
XDNA58 CDLN58 VCM_REF PH1 NPH1 VDD33 VSS gf180_tg_lowq
XDNB58 CDRN58 VCM_REF PH1 NPH1 VDD33 VSS gf180_tg_lowq
XDP258 CDRP58 INP PH2 NPH2 VDD33 VSS gf180_tg_lowq
XDN258 CDRN58 INN PH2 NPH2 VDD33 VSS gf180_tg_lowq
BGPP58 GPP58 VSS I=(v(GPP58)-v(PH2)*v(SP58)/v(VDD33))/1k
BGPN58 GPN58 VSS I=(v(GPN58)-v(PH2)*(v(VDD33)-v(SP58))/v(VDD33))/1k
BGNP58 GNP58 VSS I=(v(GNP58)-v(PH2)*v(SN58)/v(VDD33))/1k
BGNN58 GNN58 VSS I=(v(GNN58)-v(PH2)*(v(VDD33)-v(SN58))/v(VDD33))/1k
BNOPP58 NGPP58 0 V=v(VDD33)-v(GPP58)
BNOPN58 NGPN58 0 V=v(VDD33)-v(GPN58)
BNONP58 NGNP58 0 V=v(VDD33)-v(GNP58)
BNONN58 NGNN58 0 V=v(VDD33)-v(GNN58)
CGPP58 GPP58 VSS 2p
CGPN58 GPN58 VSS 2p
CGNP58 GNP58 VSS 2p
CGNN58 GNN58 VSS 2p
CNGPP58 NGPP58 VSS 0.2p
CNGPN58 NGPN58 VSS 0.2p
CNGNP58 NGNP58 VSS 0.2p
CNGNN58 NGNN58 VSS 0.2p
XPVP58 CDLP58 VP GPP58 NGPP58 VDD33 VSS gf180_tg_lowq
XPVN58 CDLP58 VN GPN58 NGPN58 VDD33 VSS gf180_tg_lowq
XNVP58 CDLN58 VP GNP58 NGNP58 VDD33 VSS gf180_tg_lowq
XNVN58 CDLN58 VN GNN58 NGNN58 VDD33 VSS gf180_tg_lowq
* DAC unit 59 (P side DP59, N side DN59)
CDP59 CDLP59 CDRP59 {CU}
CDN59 CDLN59 CDRN59 {CU}
XDPA59 CDLP59 VCM_REF PH1 NPH1 VDD33 VSS gf180_tg_lowq
XDPB59 CDRP59 VCM_REF PH1 NPH1 VDD33 VSS gf180_tg_lowq
XDNA59 CDLN59 VCM_REF PH1 NPH1 VDD33 VSS gf180_tg_lowq
XDNB59 CDRN59 VCM_REF PH1 NPH1 VDD33 VSS gf180_tg_lowq
XDP259 CDRP59 INP PH2 NPH2 VDD33 VSS gf180_tg_lowq
XDN259 CDRN59 INN PH2 NPH2 VDD33 VSS gf180_tg_lowq
BGPP59 GPP59 VSS I=(v(GPP59)-v(PH2)*v(SP59)/v(VDD33))/1k
BGPN59 GPN59 VSS I=(v(GPN59)-v(PH2)*(v(VDD33)-v(SP59))/v(VDD33))/1k
BGNP59 GNP59 VSS I=(v(GNP59)-v(PH2)*v(SN59)/v(VDD33))/1k
BGNN59 GNN59 VSS I=(v(GNN59)-v(PH2)*(v(VDD33)-v(SN59))/v(VDD33))/1k
BNOPP59 NGPP59 0 V=v(VDD33)-v(GPP59)
BNOPN59 NGPN59 0 V=v(VDD33)-v(GPN59)
BNONP59 NGNP59 0 V=v(VDD33)-v(GNP59)
BNONN59 NGNN59 0 V=v(VDD33)-v(GNN59)
CGPP59 GPP59 VSS 2p
CGPN59 GPN59 VSS 2p
CGNP59 GNP59 VSS 2p
CGNN59 GNN59 VSS 2p
CNGPP59 NGPP59 VSS 0.2p
CNGPN59 NGPN59 VSS 0.2p
CNGNP59 NGNP59 VSS 0.2p
CNGNN59 NGNN59 VSS 0.2p
XPVP59 CDLP59 VP GPP59 NGPP59 VDD33 VSS gf180_tg_lowq
XPVN59 CDLP59 VN GPN59 NGPN59 VDD33 VSS gf180_tg_lowq
XNVP59 CDLN59 VP GNP59 NGNP59 VDD33 VSS gf180_tg_lowq
XNVN59 CDLN59 VN GNN59 NGNN59 VDD33 VSS gf180_tg_lowq
* DAC unit 60 (P side DP60, N side DN60)
CDP60 CDLP60 CDRP60 {CU}
CDN60 CDLN60 CDRN60 {CU}
XDPA60 CDLP60 VCM_REF PH1 NPH1 VDD33 VSS gf180_tg_lowq
XDPB60 CDRP60 VCM_REF PH1 NPH1 VDD33 VSS gf180_tg_lowq
XDNA60 CDLN60 VCM_REF PH1 NPH1 VDD33 VSS gf180_tg_lowq
XDNB60 CDRN60 VCM_REF PH1 NPH1 VDD33 VSS gf180_tg_lowq
XDP260 CDRP60 INP PH2 NPH2 VDD33 VSS gf180_tg_lowq
XDN260 CDRN60 INN PH2 NPH2 VDD33 VSS gf180_tg_lowq
BGPP60 GPP60 VSS I=(v(GPP60)-v(PH2)*v(SP60)/v(VDD33))/1k
BGPN60 GPN60 VSS I=(v(GPN60)-v(PH2)*(v(VDD33)-v(SP60))/v(VDD33))/1k
BGNP60 GNP60 VSS I=(v(GNP60)-v(PH2)*v(SN60)/v(VDD33))/1k
BGNN60 GNN60 VSS I=(v(GNN60)-v(PH2)*(v(VDD33)-v(SN60))/v(VDD33))/1k
BNOPP60 NGPP60 0 V=v(VDD33)-v(GPP60)
BNOPN60 NGPN60 0 V=v(VDD33)-v(GPN60)
BNONP60 NGNP60 0 V=v(VDD33)-v(GNP60)
BNONN60 NGNN60 0 V=v(VDD33)-v(GNN60)
CGPP60 GPP60 VSS 2p
CGPN60 GPN60 VSS 2p
CGNP60 GNP60 VSS 2p
CGNN60 GNN60 VSS 2p
CNGPP60 NGPP60 VSS 0.2p
CNGPN60 NGPN60 VSS 0.2p
CNGNP60 NGNP60 VSS 0.2p
CNGNN60 NGNN60 VSS 0.2p
XPVP60 CDLP60 VP GPP60 NGPP60 VDD33 VSS gf180_tg_lowq
XPVN60 CDLP60 VN GPN60 NGPN60 VDD33 VSS gf180_tg_lowq
XNVP60 CDLN60 VP GNP60 NGNP60 VDD33 VSS gf180_tg_lowq
XNVN60 CDLN60 VN GNN60 NGNN60 VDD33 VSS gf180_tg_lowq
* DAC unit 61 (P side DP61, N side DN61)
CDP61 CDLP61 CDRP61 {CU}
CDN61 CDLN61 CDRN61 {CU}
XDPA61 CDLP61 VCM_REF PH1 NPH1 VDD33 VSS gf180_tg_lowq
XDPB61 CDRP61 VCM_REF PH1 NPH1 VDD33 VSS gf180_tg_lowq
XDNA61 CDLN61 VCM_REF PH1 NPH1 VDD33 VSS gf180_tg_lowq
XDNB61 CDRN61 VCM_REF PH1 NPH1 VDD33 VSS gf180_tg_lowq
XDP261 CDRP61 INP PH2 NPH2 VDD33 VSS gf180_tg_lowq
XDN261 CDRN61 INN PH2 NPH2 VDD33 VSS gf180_tg_lowq
BGPP61 GPP61 VSS I=(v(GPP61)-v(PH2)*v(SP61)/v(VDD33))/1k
BGPN61 GPN61 VSS I=(v(GPN61)-v(PH2)*(v(VDD33)-v(SP61))/v(VDD33))/1k
BGNP61 GNP61 VSS I=(v(GNP61)-v(PH2)*v(SN61)/v(VDD33))/1k
BGNN61 GNN61 VSS I=(v(GNN61)-v(PH2)*(v(VDD33)-v(SN61))/v(VDD33))/1k
BNOPP61 NGPP61 0 V=v(VDD33)-v(GPP61)
BNOPN61 NGPN61 0 V=v(VDD33)-v(GPN61)
BNONP61 NGNP61 0 V=v(VDD33)-v(GNP61)
BNONN61 NGNN61 0 V=v(VDD33)-v(GNN61)
CGPP61 GPP61 VSS 2p
CGPN61 GPN61 VSS 2p
CGNP61 GNP61 VSS 2p
CGNN61 GNN61 VSS 2p
CNGPP61 NGPP61 VSS 0.2p
CNGPN61 NGPN61 VSS 0.2p
CNGNP61 NGNP61 VSS 0.2p
CNGNN61 NGNN61 VSS 0.2p
XPVP61 CDLP61 VP GPP61 NGPP61 VDD33 VSS gf180_tg_lowq
XPVN61 CDLP61 VN GPN61 NGPN61 VDD33 VSS gf180_tg_lowq
XNVP61 CDLN61 VP GNP61 NGNP61 VDD33 VSS gf180_tg_lowq
XNVN61 CDLN61 VN GNN61 NGNN61 VDD33 VSS gf180_tg_lowq
* DAC unit 62 (P side DP62, N side DN62)
CDP62 CDLP62 CDRP62 {CU}
CDN62 CDLN62 CDRN62 {CU}
XDPA62 CDLP62 VCM_REF PH1 NPH1 VDD33 VSS gf180_tg_lowq
XDPB62 CDRP62 VCM_REF PH1 NPH1 VDD33 VSS gf180_tg_lowq
XDNA62 CDLN62 VCM_REF PH1 NPH1 VDD33 VSS gf180_tg_lowq
XDNB62 CDRN62 VCM_REF PH1 NPH1 VDD33 VSS gf180_tg_lowq
XDP262 CDRP62 INP PH2 NPH2 VDD33 VSS gf180_tg_lowq
XDN262 CDRN62 INN PH2 NPH2 VDD33 VSS gf180_tg_lowq
BGPP62 GPP62 VSS I=(v(GPP62)-v(PH2)*v(SP62)/v(VDD33))/1k
BGPN62 GPN62 VSS I=(v(GPN62)-v(PH2)*(v(VDD33)-v(SP62))/v(VDD33))/1k
BGNP62 GNP62 VSS I=(v(GNP62)-v(PH2)*v(SN62)/v(VDD33))/1k
BGNN62 GNN62 VSS I=(v(GNN62)-v(PH2)*(v(VDD33)-v(SN62))/v(VDD33))/1k
BNOPP62 NGPP62 0 V=v(VDD33)-v(GPP62)
BNOPN62 NGPN62 0 V=v(VDD33)-v(GPN62)
BNONP62 NGNP62 0 V=v(VDD33)-v(GNP62)
BNONN62 NGNN62 0 V=v(VDD33)-v(GNN62)
CGPP62 GPP62 VSS 2p
CGPN62 GPN62 VSS 2p
CGNP62 GNP62 VSS 2p
CGNN62 GNN62 VSS 2p
CNGPP62 NGPP62 VSS 0.2p
CNGPN62 NGPN62 VSS 0.2p
CNGNP62 NGNP62 VSS 0.2p
CNGNN62 NGNN62 VSS 0.2p
XPVP62 CDLP62 VP GPP62 NGPP62 VDD33 VSS gf180_tg_lowq
XPVN62 CDLP62 VN GPN62 NGPN62 VDD33 VSS gf180_tg_lowq
XNVP62 CDLN62 VP GNP62 NGNP62 VDD33 VSS gf180_tg_lowq
XNVN62 CDLN62 VN GNN62 NGNN62 VDD33 VSS gf180_tg_lowq
CIP OUTN INP {CI}
CIN OUTP INN {CI}
RBIASP INP VCM_REF 10G
RBIASN INN VCM_REF 10G
.ends gf180_sdm3_int1_mb

* ---- int2 mb: CS=2p, CI=4p, 63x0.0625p/side DAC (S2P/S2N selects, PH1 int)
* int2 integrates during PH1 with the REGISTERED code (applied via S2*).
.subckt gf180_sdm3_int2_mb INP_S INN_S VCM_REF VP VN OUTP OUTN PH1 NPH1 PH2 NPH2 VDD33 VSS S2P0 S2P1 S2P2 S2P3 S2P4 S2P5 S2P6 S2P7 S2P8 S2P9 S2P10 S2P11 S2P12 S2P13 S2P14 S2P15 S2P16 S2P17 S2P18 S2P19 S2P20 S2P21 S2P22 S2P23 S2P24 S2P25 S2P26 S2P27 S2P28 S2P29 S2P30 S2P31 S2P32 S2P33 S2P34 S2P35 S2P36 S2P37 S2P38 S2P39 S2P40 S2P41 S2P42 S2P43 S2P44 S2P45 S2P46 S2P47 S2P48 S2P49 S2P50 S2P51 S2P52 S2P53 S2P54 S2P55 S2P56 S2P57 S2P58 S2P59 S2P60 S2P61 S2P62 S2N0 S2N1 S2N2 S2N3 S2N4 S2N5 S2N6 S2N7 S2N8 S2N9 S2N10 S2N11 S2N12 S2N13 S2N14 S2N15 S2N16 S2N17 S2N18 S2N19 S2N20 S2N21 S2N22 S2N23 S2N24 S2N25 S2N26 S2N27 S2N28 S2N29 S2N30 S2N31 S2N32 S2N33 S2N34 S2N35 S2N36 S2N37 S2N38 S2N39 S2N40 S2N41 S2N42 S2N43 S2N44 S2N45 S2N46 S2N47 S2N48 S2N49 S2N50 S2N51 S2N52 S2N53 S2N54 S2N55 S2N56 S2N57 S2N58 S2N59 S2N60 S2N61 S2N62 params: CS=2p CU=0.0625p CI=4p W91=11u L91=2u W92=6u L92=2u W10=12u RSET=25k CC=10p
XOTA INP INN VCM_REF OUTP OUTN VDD33 VSS gf180_fd_ota_full2_nc W91={W91} L91={L91} W92={W92} L92={L92} W10={W10} RSET={RSET} CC={CC}
CSP CSLP CSRP {CS}
CSN CSLN CSRN {CS}
XS1A CSLP INP_S PH1 NPH1 VDD33 VSS gf180_tg_lowq
XS1B CSRP VCM_REF PH1 NPH1 VDD33 VSS gf180_tg_lowq
XS1C CSLN INN_S PH1 NPH1 VDD33 VSS gf180_tg_lowq
XS1D CSRN VCM_REF PH1 NPH1 VDD33 VSS gf180_tg_lowq
XS2A CSLP VCM_REF PH2 NPH2 VDD33 VSS gf180_tg_lowq
XS2B CSRP INP PH2 NPH2 VDD33 VSS gf180_tg_lowq
XS2C CSLN VCM_REF PH2 NPH2 VDD33 VSS gf180_tg_lowq
XS2D CSRN INN PH2 NPH2 VDD33 VSS gf180_tg_lowq
* DAC unit 0
CDP0 CDLP0 CDRP0 {CU}
CDN0 CDLN0 CDRN0 {CU}
XDP10 CDRP0 VCM_REF PH1 NPH1 VDD33 VSS gf180_tg_lowq
XDP20 CDRP0 INP PH2 NPH2 VDD33 VSS gf180_tg_lowq
XDN10 CDRN0 VCM_REF PH1 NPH1 VDD33 VSS gf180_tg_lowq
XDN20 CDRN0 INN PH2 NPH2 VDD33 VSS gf180_tg_lowq
BGPP0 GPP0 VSS I=(v(GPP0)-v(PH2)*v(S2P0)/v(VDD33))/1k
BGPN0 GPN0 VSS I=(v(GPN0)-v(PH2)*(v(VDD33)-v(S2P0))/v(VDD33))/1k
BGNP0 GNP0 VSS I=(v(GNP0)-v(PH2)*v(S2N0)/v(VDD33))/1k
BGNN0 GNN0 VSS I=(v(GNN0)-v(PH2)*(v(VDD33)-v(S2N0))/v(VDD33))/1k
BNOPP0 NGPP0 0 V=v(VDD33)-v(GPP0)
BNOPN0 NGPN0 0 V=v(VDD33)-v(GPN0)
BNONP0 NGNP0 0 V=v(VDD33)-v(GNP0)
BNONN0 NGNN0 0 V=v(VDD33)-v(GNN0)
CGPP0 GPP0 VSS 2p
CGPN0 GPN0 VSS 2p
CGNP0 GNP0 VSS 2p
CGNN0 GNN0 VSS 2p
CNGPP0 NGPP0 VSS 0.2p
CNGPN0 NGPN0 VSS 0.2p
CNGNP0 NGNP0 VSS 0.2p
CNGNN0 NGNN0 VSS 0.2p
XPVP0 CDLP0 VP GPP0 NGPP0 VDD33 VSS gf180_tg_lowq
XPVN0 CDLP0 VN GPN0 NGPN0 VDD33 VSS gf180_tg_lowq
XNVP0 CDLN0 VP GNP0 NGNP0 VDD33 VSS gf180_tg_lowq
XNVN0 CDLN0 VN GNN0 NGNN0 VDD33 VSS gf180_tg_lowq
XDPC0 CDLP0 VCM_REF PH1 NPH1 VDD33 VSS gf180_tg_lowq
XDNC0 CDLN0 VCM_REF PH1 NPH1 VDD33 VSS gf180_tg_lowq
* DAC unit 1
CDP1 CDLP1 CDRP1 {CU}
CDN1 CDLN1 CDRN1 {CU}
XDP11 CDRP1 VCM_REF PH1 NPH1 VDD33 VSS gf180_tg_lowq
XDP21 CDRP1 INP PH2 NPH2 VDD33 VSS gf180_tg_lowq
XDN11 CDRN1 VCM_REF PH1 NPH1 VDD33 VSS gf180_tg_lowq
XDN21 CDRN1 INN PH2 NPH2 VDD33 VSS gf180_tg_lowq
BGPP1 GPP1 VSS I=(v(GPP1)-v(PH2)*v(S2P1)/v(VDD33))/1k
BGPN1 GPN1 VSS I=(v(GPN1)-v(PH2)*(v(VDD33)-v(S2P1))/v(VDD33))/1k
BGNP1 GNP1 VSS I=(v(GNP1)-v(PH2)*v(S2N1)/v(VDD33))/1k
BGNN1 GNN1 VSS I=(v(GNN1)-v(PH2)*(v(VDD33)-v(S2N1))/v(VDD33))/1k
BNOPP1 NGPP1 0 V=v(VDD33)-v(GPP1)
BNOPN1 NGPN1 0 V=v(VDD33)-v(GPN1)
BNONP1 NGNP1 0 V=v(VDD33)-v(GNP1)
BNONN1 NGNN1 0 V=v(VDD33)-v(GNN1)
CGPP1 GPP1 VSS 2p
CGPN1 GPN1 VSS 2p
CGNP1 GNP1 VSS 2p
CGNN1 GNN1 VSS 2p
CNGPP1 NGPP1 VSS 0.2p
CNGPN1 NGPN1 VSS 0.2p
CNGNP1 NGNP1 VSS 0.2p
CNGNN1 NGNN1 VSS 0.2p
XPVP1 CDLP1 VP GPP1 NGPP1 VDD33 VSS gf180_tg_lowq
XPVN1 CDLP1 VN GPN1 NGPN1 VDD33 VSS gf180_tg_lowq
XNVP1 CDLN1 VP GNP1 NGNP1 VDD33 VSS gf180_tg_lowq
XNVN1 CDLN1 VN GNN1 NGNN1 VDD33 VSS gf180_tg_lowq
XDPC1 CDLP1 VCM_REF PH1 NPH1 VDD33 VSS gf180_tg_lowq
XDNC1 CDLN1 VCM_REF PH1 NPH1 VDD33 VSS gf180_tg_lowq
* DAC unit 2
CDP2 CDLP2 CDRP2 {CU}
CDN2 CDLN2 CDRN2 {CU}
XDP12 CDRP2 VCM_REF PH1 NPH1 VDD33 VSS gf180_tg_lowq
XDP22 CDRP2 INP PH2 NPH2 VDD33 VSS gf180_tg_lowq
XDN12 CDRN2 VCM_REF PH1 NPH1 VDD33 VSS gf180_tg_lowq
XDN22 CDRN2 INN PH2 NPH2 VDD33 VSS gf180_tg_lowq
BGPP2 GPP2 VSS I=(v(GPP2)-v(PH2)*v(S2P2)/v(VDD33))/1k
BGPN2 GPN2 VSS I=(v(GPN2)-v(PH2)*(v(VDD33)-v(S2P2))/v(VDD33))/1k
BGNP2 GNP2 VSS I=(v(GNP2)-v(PH2)*v(S2N2)/v(VDD33))/1k
BGNN2 GNN2 VSS I=(v(GNN2)-v(PH2)*(v(VDD33)-v(S2N2))/v(VDD33))/1k
BNOPP2 NGPP2 0 V=v(VDD33)-v(GPP2)
BNOPN2 NGPN2 0 V=v(VDD33)-v(GPN2)
BNONP2 NGNP2 0 V=v(VDD33)-v(GNP2)
BNONN2 NGNN2 0 V=v(VDD33)-v(GNN2)
CGPP2 GPP2 VSS 2p
CGPN2 GPN2 VSS 2p
CGNP2 GNP2 VSS 2p
CGNN2 GNN2 VSS 2p
CNGPP2 NGPP2 VSS 0.2p
CNGPN2 NGPN2 VSS 0.2p
CNGNP2 NGNP2 VSS 0.2p
CNGNN2 NGNN2 VSS 0.2p
XPVP2 CDLP2 VP GPP2 NGPP2 VDD33 VSS gf180_tg_lowq
XPVN2 CDLP2 VN GPN2 NGPN2 VDD33 VSS gf180_tg_lowq
XNVP2 CDLN2 VP GNP2 NGNP2 VDD33 VSS gf180_tg_lowq
XNVN2 CDLN2 VN GNN2 NGNN2 VDD33 VSS gf180_tg_lowq
XDPC2 CDLP2 VCM_REF PH1 NPH1 VDD33 VSS gf180_tg_lowq
XDNC2 CDLN2 VCM_REF PH1 NPH1 VDD33 VSS gf180_tg_lowq
* DAC unit 3
CDP3 CDLP3 CDRP3 {CU}
CDN3 CDLN3 CDRN3 {CU}
XDP13 CDRP3 VCM_REF PH1 NPH1 VDD33 VSS gf180_tg_lowq
XDP23 CDRP3 INP PH2 NPH2 VDD33 VSS gf180_tg_lowq
XDN13 CDRN3 VCM_REF PH1 NPH1 VDD33 VSS gf180_tg_lowq
XDN23 CDRN3 INN PH2 NPH2 VDD33 VSS gf180_tg_lowq
BGPP3 GPP3 VSS I=(v(GPP3)-v(PH2)*v(S2P3)/v(VDD33))/1k
BGPN3 GPN3 VSS I=(v(GPN3)-v(PH2)*(v(VDD33)-v(S2P3))/v(VDD33))/1k
BGNP3 GNP3 VSS I=(v(GNP3)-v(PH2)*v(S2N3)/v(VDD33))/1k
BGNN3 GNN3 VSS I=(v(GNN3)-v(PH2)*(v(VDD33)-v(S2N3))/v(VDD33))/1k
BNOPP3 NGPP3 0 V=v(VDD33)-v(GPP3)
BNOPN3 NGPN3 0 V=v(VDD33)-v(GPN3)
BNONP3 NGNP3 0 V=v(VDD33)-v(GNP3)
BNONN3 NGNN3 0 V=v(VDD33)-v(GNN3)
CGPP3 GPP3 VSS 2p
CGPN3 GPN3 VSS 2p
CGNP3 GNP3 VSS 2p
CGNN3 GNN3 VSS 2p
CNGPP3 NGPP3 VSS 0.2p
CNGPN3 NGPN3 VSS 0.2p
CNGNP3 NGNP3 VSS 0.2p
CNGNN3 NGNN3 VSS 0.2p
XPVP3 CDLP3 VP GPP3 NGPP3 VDD33 VSS gf180_tg_lowq
XPVN3 CDLP3 VN GPN3 NGPN3 VDD33 VSS gf180_tg_lowq
XNVP3 CDLN3 VP GNP3 NGNP3 VDD33 VSS gf180_tg_lowq
XNVN3 CDLN3 VN GNN3 NGNN3 VDD33 VSS gf180_tg_lowq
XDPC3 CDLP3 VCM_REF PH1 NPH1 VDD33 VSS gf180_tg_lowq
XDNC3 CDLN3 VCM_REF PH1 NPH1 VDD33 VSS gf180_tg_lowq
* DAC unit 4
CDP4 CDLP4 CDRP4 {CU}
CDN4 CDLN4 CDRN4 {CU}
XDP14 CDRP4 VCM_REF PH1 NPH1 VDD33 VSS gf180_tg_lowq
XDP24 CDRP4 INP PH2 NPH2 VDD33 VSS gf180_tg_lowq
XDN14 CDRN4 VCM_REF PH1 NPH1 VDD33 VSS gf180_tg_lowq
XDN24 CDRN4 INN PH2 NPH2 VDD33 VSS gf180_tg_lowq
BGPP4 GPP4 VSS I=(v(GPP4)-v(PH2)*v(S2P4)/v(VDD33))/1k
BGPN4 GPN4 VSS I=(v(GPN4)-v(PH2)*(v(VDD33)-v(S2P4))/v(VDD33))/1k
BGNP4 GNP4 VSS I=(v(GNP4)-v(PH2)*v(S2N4)/v(VDD33))/1k
BGNN4 GNN4 VSS I=(v(GNN4)-v(PH2)*(v(VDD33)-v(S2N4))/v(VDD33))/1k
BNOPP4 NGPP4 0 V=v(VDD33)-v(GPP4)
BNOPN4 NGPN4 0 V=v(VDD33)-v(GPN4)
BNONP4 NGNP4 0 V=v(VDD33)-v(GNP4)
BNONN4 NGNN4 0 V=v(VDD33)-v(GNN4)
CGPP4 GPP4 VSS 2p
CGPN4 GPN4 VSS 2p
CGNP4 GNP4 VSS 2p
CGNN4 GNN4 VSS 2p
CNGPP4 NGPP4 VSS 0.2p
CNGPN4 NGPN4 VSS 0.2p
CNGNP4 NGNP4 VSS 0.2p
CNGNN4 NGNN4 VSS 0.2p
XPVP4 CDLP4 VP GPP4 NGPP4 VDD33 VSS gf180_tg_lowq
XPVN4 CDLP4 VN GPN4 NGPN4 VDD33 VSS gf180_tg_lowq
XNVP4 CDLN4 VP GNP4 NGNP4 VDD33 VSS gf180_tg_lowq
XNVN4 CDLN4 VN GNN4 NGNN4 VDD33 VSS gf180_tg_lowq
XDPC4 CDLP4 VCM_REF PH1 NPH1 VDD33 VSS gf180_tg_lowq
XDNC4 CDLN4 VCM_REF PH1 NPH1 VDD33 VSS gf180_tg_lowq
* DAC unit 5
CDP5 CDLP5 CDRP5 {CU}
CDN5 CDLN5 CDRN5 {CU}
XDP15 CDRP5 VCM_REF PH1 NPH1 VDD33 VSS gf180_tg_lowq
XDP25 CDRP5 INP PH2 NPH2 VDD33 VSS gf180_tg_lowq
XDN15 CDRN5 VCM_REF PH1 NPH1 VDD33 VSS gf180_tg_lowq
XDN25 CDRN5 INN PH2 NPH2 VDD33 VSS gf180_tg_lowq
BGPP5 GPP5 VSS I=(v(GPP5)-v(PH2)*v(S2P5)/v(VDD33))/1k
BGPN5 GPN5 VSS I=(v(GPN5)-v(PH2)*(v(VDD33)-v(S2P5))/v(VDD33))/1k
BGNP5 GNP5 VSS I=(v(GNP5)-v(PH2)*v(S2N5)/v(VDD33))/1k
BGNN5 GNN5 VSS I=(v(GNN5)-v(PH2)*(v(VDD33)-v(S2N5))/v(VDD33))/1k
BNOPP5 NGPP5 0 V=v(VDD33)-v(GPP5)
BNOPN5 NGPN5 0 V=v(VDD33)-v(GPN5)
BNONP5 NGNP5 0 V=v(VDD33)-v(GNP5)
BNONN5 NGNN5 0 V=v(VDD33)-v(GNN5)
CGPP5 GPP5 VSS 2p
CGPN5 GPN5 VSS 2p
CGNP5 GNP5 VSS 2p
CGNN5 GNN5 VSS 2p
CNGPP5 NGPP5 VSS 0.2p
CNGPN5 NGPN5 VSS 0.2p
CNGNP5 NGNP5 VSS 0.2p
CNGNN5 NGNN5 VSS 0.2p
XPVP5 CDLP5 VP GPP5 NGPP5 VDD33 VSS gf180_tg_lowq
XPVN5 CDLP5 VN GPN5 NGPN5 VDD33 VSS gf180_tg_lowq
XNVP5 CDLN5 VP GNP5 NGNP5 VDD33 VSS gf180_tg_lowq
XNVN5 CDLN5 VN GNN5 NGNN5 VDD33 VSS gf180_tg_lowq
XDPC5 CDLP5 VCM_REF PH1 NPH1 VDD33 VSS gf180_tg_lowq
XDNC5 CDLN5 VCM_REF PH1 NPH1 VDD33 VSS gf180_tg_lowq
* DAC unit 6
CDP6 CDLP6 CDRP6 {CU}
CDN6 CDLN6 CDRN6 {CU}
XDP16 CDRP6 VCM_REF PH1 NPH1 VDD33 VSS gf180_tg_lowq
XDP26 CDRP6 INP PH2 NPH2 VDD33 VSS gf180_tg_lowq
XDN16 CDRN6 VCM_REF PH1 NPH1 VDD33 VSS gf180_tg_lowq
XDN26 CDRN6 INN PH2 NPH2 VDD33 VSS gf180_tg_lowq
BGPP6 GPP6 VSS I=(v(GPP6)-v(PH2)*v(S2P6)/v(VDD33))/1k
BGPN6 GPN6 VSS I=(v(GPN6)-v(PH2)*(v(VDD33)-v(S2P6))/v(VDD33))/1k
BGNP6 GNP6 VSS I=(v(GNP6)-v(PH2)*v(S2N6)/v(VDD33))/1k
BGNN6 GNN6 VSS I=(v(GNN6)-v(PH2)*(v(VDD33)-v(S2N6))/v(VDD33))/1k
BNOPP6 NGPP6 0 V=v(VDD33)-v(GPP6)
BNOPN6 NGPN6 0 V=v(VDD33)-v(GPN6)
BNONP6 NGNP6 0 V=v(VDD33)-v(GNP6)
BNONN6 NGNN6 0 V=v(VDD33)-v(GNN6)
CGPP6 GPP6 VSS 2p
CGPN6 GPN6 VSS 2p
CGNP6 GNP6 VSS 2p
CGNN6 GNN6 VSS 2p
CNGPP6 NGPP6 VSS 0.2p
CNGPN6 NGPN6 VSS 0.2p
CNGNP6 NGNP6 VSS 0.2p
CNGNN6 NGNN6 VSS 0.2p
XPVP6 CDLP6 VP GPP6 NGPP6 VDD33 VSS gf180_tg_lowq
XPVN6 CDLP6 VN GPN6 NGPN6 VDD33 VSS gf180_tg_lowq
XNVP6 CDLN6 VP GNP6 NGNP6 VDD33 VSS gf180_tg_lowq
XNVN6 CDLN6 VN GNN6 NGNN6 VDD33 VSS gf180_tg_lowq
XDPC6 CDLP6 VCM_REF PH1 NPH1 VDD33 VSS gf180_tg_lowq
XDNC6 CDLN6 VCM_REF PH1 NPH1 VDD33 VSS gf180_tg_lowq
* DAC unit 7
CDP7 CDLP7 CDRP7 {CU}
CDN7 CDLN7 CDRN7 {CU}
XDP17 CDRP7 VCM_REF PH1 NPH1 VDD33 VSS gf180_tg_lowq
XDP27 CDRP7 INP PH2 NPH2 VDD33 VSS gf180_tg_lowq
XDN17 CDRN7 VCM_REF PH1 NPH1 VDD33 VSS gf180_tg_lowq
XDN27 CDRN7 INN PH2 NPH2 VDD33 VSS gf180_tg_lowq
BGPP7 GPP7 VSS I=(v(GPP7)-v(PH2)*v(S2P7)/v(VDD33))/1k
BGPN7 GPN7 VSS I=(v(GPN7)-v(PH2)*(v(VDD33)-v(S2P7))/v(VDD33))/1k
BGNP7 GNP7 VSS I=(v(GNP7)-v(PH2)*v(S2N7)/v(VDD33))/1k
BGNN7 GNN7 VSS I=(v(GNN7)-v(PH2)*(v(VDD33)-v(S2N7))/v(VDD33))/1k
BNOPP7 NGPP7 0 V=v(VDD33)-v(GPP7)
BNOPN7 NGPN7 0 V=v(VDD33)-v(GPN7)
BNONP7 NGNP7 0 V=v(VDD33)-v(GNP7)
BNONN7 NGNN7 0 V=v(VDD33)-v(GNN7)
CGPP7 GPP7 VSS 2p
CGPN7 GPN7 VSS 2p
CGNP7 GNP7 VSS 2p
CGNN7 GNN7 VSS 2p
CNGPP7 NGPP7 VSS 0.2p
CNGPN7 NGPN7 VSS 0.2p
CNGNP7 NGNP7 VSS 0.2p
CNGNN7 NGNN7 VSS 0.2p
XPVP7 CDLP7 VP GPP7 NGPP7 VDD33 VSS gf180_tg_lowq
XPVN7 CDLP7 VN GPN7 NGPN7 VDD33 VSS gf180_tg_lowq
XNVP7 CDLN7 VP GNP7 NGNP7 VDD33 VSS gf180_tg_lowq
XNVN7 CDLN7 VN GNN7 NGNN7 VDD33 VSS gf180_tg_lowq
XDPC7 CDLP7 VCM_REF PH1 NPH1 VDD33 VSS gf180_tg_lowq
XDNC7 CDLN7 VCM_REF PH1 NPH1 VDD33 VSS gf180_tg_lowq
* DAC unit 8
CDP8 CDLP8 CDRP8 {CU}
CDN8 CDLN8 CDRN8 {CU}
XDP18 CDRP8 VCM_REF PH1 NPH1 VDD33 VSS gf180_tg_lowq
XDP28 CDRP8 INP PH2 NPH2 VDD33 VSS gf180_tg_lowq
XDN18 CDRN8 VCM_REF PH1 NPH1 VDD33 VSS gf180_tg_lowq
XDN28 CDRN8 INN PH2 NPH2 VDD33 VSS gf180_tg_lowq
BGPP8 GPP8 VSS I=(v(GPP8)-v(PH2)*v(S2P8)/v(VDD33))/1k
BGPN8 GPN8 VSS I=(v(GPN8)-v(PH2)*(v(VDD33)-v(S2P8))/v(VDD33))/1k
BGNP8 GNP8 VSS I=(v(GNP8)-v(PH2)*v(S2N8)/v(VDD33))/1k
BGNN8 GNN8 VSS I=(v(GNN8)-v(PH2)*(v(VDD33)-v(S2N8))/v(VDD33))/1k
BNOPP8 NGPP8 0 V=v(VDD33)-v(GPP8)
BNOPN8 NGPN8 0 V=v(VDD33)-v(GPN8)
BNONP8 NGNP8 0 V=v(VDD33)-v(GNP8)
BNONN8 NGNN8 0 V=v(VDD33)-v(GNN8)
CGPP8 GPP8 VSS 2p
CGPN8 GPN8 VSS 2p
CGNP8 GNP8 VSS 2p
CGNN8 GNN8 VSS 2p
CNGPP8 NGPP8 VSS 0.2p
CNGPN8 NGPN8 VSS 0.2p
CNGNP8 NGNP8 VSS 0.2p
CNGNN8 NGNN8 VSS 0.2p
XPVP8 CDLP8 VP GPP8 NGPP8 VDD33 VSS gf180_tg_lowq
XPVN8 CDLP8 VN GPN8 NGPN8 VDD33 VSS gf180_tg_lowq
XNVP8 CDLN8 VP GNP8 NGNP8 VDD33 VSS gf180_tg_lowq
XNVN8 CDLN8 VN GNN8 NGNN8 VDD33 VSS gf180_tg_lowq
XDPC8 CDLP8 VCM_REF PH1 NPH1 VDD33 VSS gf180_tg_lowq
XDNC8 CDLN8 VCM_REF PH1 NPH1 VDD33 VSS gf180_tg_lowq
* DAC unit 9
CDP9 CDLP9 CDRP9 {CU}
CDN9 CDLN9 CDRN9 {CU}
XDP19 CDRP9 VCM_REF PH1 NPH1 VDD33 VSS gf180_tg_lowq
XDP29 CDRP9 INP PH2 NPH2 VDD33 VSS gf180_tg_lowq
XDN19 CDRN9 VCM_REF PH1 NPH1 VDD33 VSS gf180_tg_lowq
XDN29 CDRN9 INN PH2 NPH2 VDD33 VSS gf180_tg_lowq
BGPP9 GPP9 VSS I=(v(GPP9)-v(PH2)*v(S2P9)/v(VDD33))/1k
BGPN9 GPN9 VSS I=(v(GPN9)-v(PH2)*(v(VDD33)-v(S2P9))/v(VDD33))/1k
BGNP9 GNP9 VSS I=(v(GNP9)-v(PH2)*v(S2N9)/v(VDD33))/1k
BGNN9 GNN9 VSS I=(v(GNN9)-v(PH2)*(v(VDD33)-v(S2N9))/v(VDD33))/1k
BNOPP9 NGPP9 0 V=v(VDD33)-v(GPP9)
BNOPN9 NGPN9 0 V=v(VDD33)-v(GPN9)
BNONP9 NGNP9 0 V=v(VDD33)-v(GNP9)
BNONN9 NGNN9 0 V=v(VDD33)-v(GNN9)
CGPP9 GPP9 VSS 2p
CGPN9 GPN9 VSS 2p
CGNP9 GNP9 VSS 2p
CGNN9 GNN9 VSS 2p
CNGPP9 NGPP9 VSS 0.2p
CNGPN9 NGPN9 VSS 0.2p
CNGNP9 NGNP9 VSS 0.2p
CNGNN9 NGNN9 VSS 0.2p
XPVP9 CDLP9 VP GPP9 NGPP9 VDD33 VSS gf180_tg_lowq
XPVN9 CDLP9 VN GPN9 NGPN9 VDD33 VSS gf180_tg_lowq
XNVP9 CDLN9 VP GNP9 NGNP9 VDD33 VSS gf180_tg_lowq
XNVN9 CDLN9 VN GNN9 NGNN9 VDD33 VSS gf180_tg_lowq
XDPC9 CDLP9 VCM_REF PH1 NPH1 VDD33 VSS gf180_tg_lowq
XDNC9 CDLN9 VCM_REF PH1 NPH1 VDD33 VSS gf180_tg_lowq
* DAC unit 10
CDP10 CDLP10 CDRP10 {CU}
CDN10 CDLN10 CDRN10 {CU}
XDP110 CDRP10 VCM_REF PH1 NPH1 VDD33 VSS gf180_tg_lowq
XDP210 CDRP10 INP PH2 NPH2 VDD33 VSS gf180_tg_lowq
XDN110 CDRN10 VCM_REF PH1 NPH1 VDD33 VSS gf180_tg_lowq
XDN210 CDRN10 INN PH2 NPH2 VDD33 VSS gf180_tg_lowq
BGPP10 GPP10 VSS I=(v(GPP10)-v(PH2)*v(S2P10)/v(VDD33))/1k
BGPN10 GPN10 VSS I=(v(GPN10)-v(PH2)*(v(VDD33)-v(S2P10))/v(VDD33))/1k
BGNP10 GNP10 VSS I=(v(GNP10)-v(PH2)*v(S2N10)/v(VDD33))/1k
BGNN10 GNN10 VSS I=(v(GNN10)-v(PH2)*(v(VDD33)-v(S2N10))/v(VDD33))/1k
BNOPP10 NGPP10 0 V=v(VDD33)-v(GPP10)
BNOPN10 NGPN10 0 V=v(VDD33)-v(GPN10)
BNONP10 NGNP10 0 V=v(VDD33)-v(GNP10)
BNONN10 NGNN10 0 V=v(VDD33)-v(GNN10)
CGPP10 GPP10 VSS 2p
CGPN10 GPN10 VSS 2p
CGNP10 GNP10 VSS 2p
CGNN10 GNN10 VSS 2p
CNGPP10 NGPP10 VSS 0.2p
CNGPN10 NGPN10 VSS 0.2p
CNGNP10 NGNP10 VSS 0.2p
CNGNN10 NGNN10 VSS 0.2p
XPVP10 CDLP10 VP GPP10 NGPP10 VDD33 VSS gf180_tg_lowq
XPVN10 CDLP10 VN GPN10 NGPN10 VDD33 VSS gf180_tg_lowq
XNVP10 CDLN10 VP GNP10 NGNP10 VDD33 VSS gf180_tg_lowq
XNVN10 CDLN10 VN GNN10 NGNN10 VDD33 VSS gf180_tg_lowq
XDPC10 CDLP10 VCM_REF PH1 NPH1 VDD33 VSS gf180_tg_lowq
XDNC10 CDLN10 VCM_REF PH1 NPH1 VDD33 VSS gf180_tg_lowq
* DAC unit 11
CDP11 CDLP11 CDRP11 {CU}
CDN11 CDLN11 CDRN11 {CU}
XDP111 CDRP11 VCM_REF PH1 NPH1 VDD33 VSS gf180_tg_lowq
XDP211 CDRP11 INP PH2 NPH2 VDD33 VSS gf180_tg_lowq
XDN111 CDRN11 VCM_REF PH1 NPH1 VDD33 VSS gf180_tg_lowq
XDN211 CDRN11 INN PH2 NPH2 VDD33 VSS gf180_tg_lowq
BGPP11 GPP11 VSS I=(v(GPP11)-v(PH2)*v(S2P11)/v(VDD33))/1k
BGPN11 GPN11 VSS I=(v(GPN11)-v(PH2)*(v(VDD33)-v(S2P11))/v(VDD33))/1k
BGNP11 GNP11 VSS I=(v(GNP11)-v(PH2)*v(S2N11)/v(VDD33))/1k
BGNN11 GNN11 VSS I=(v(GNN11)-v(PH2)*(v(VDD33)-v(S2N11))/v(VDD33))/1k
BNOPP11 NGPP11 0 V=v(VDD33)-v(GPP11)
BNOPN11 NGPN11 0 V=v(VDD33)-v(GPN11)
BNONP11 NGNP11 0 V=v(VDD33)-v(GNP11)
BNONN11 NGNN11 0 V=v(VDD33)-v(GNN11)
CGPP11 GPP11 VSS 2p
CGPN11 GPN11 VSS 2p
CGNP11 GNP11 VSS 2p
CGNN11 GNN11 VSS 2p
CNGPP11 NGPP11 VSS 0.2p
CNGPN11 NGPN11 VSS 0.2p
CNGNP11 NGNP11 VSS 0.2p
CNGNN11 NGNN11 VSS 0.2p
XPVP11 CDLP11 VP GPP11 NGPP11 VDD33 VSS gf180_tg_lowq
XPVN11 CDLP11 VN GPN11 NGPN11 VDD33 VSS gf180_tg_lowq
XNVP11 CDLN11 VP GNP11 NGNP11 VDD33 VSS gf180_tg_lowq
XNVN11 CDLN11 VN GNN11 NGNN11 VDD33 VSS gf180_tg_lowq
XDPC11 CDLP11 VCM_REF PH1 NPH1 VDD33 VSS gf180_tg_lowq
XDNC11 CDLN11 VCM_REF PH1 NPH1 VDD33 VSS gf180_tg_lowq
* DAC unit 12
CDP12 CDLP12 CDRP12 {CU}
CDN12 CDLN12 CDRN12 {CU}
XDP112 CDRP12 VCM_REF PH1 NPH1 VDD33 VSS gf180_tg_lowq
XDP212 CDRP12 INP PH2 NPH2 VDD33 VSS gf180_tg_lowq
XDN112 CDRN12 VCM_REF PH1 NPH1 VDD33 VSS gf180_tg_lowq
XDN212 CDRN12 INN PH2 NPH2 VDD33 VSS gf180_tg_lowq
BGPP12 GPP12 VSS I=(v(GPP12)-v(PH2)*v(S2P12)/v(VDD33))/1k
BGPN12 GPN12 VSS I=(v(GPN12)-v(PH2)*(v(VDD33)-v(S2P12))/v(VDD33))/1k
BGNP12 GNP12 VSS I=(v(GNP12)-v(PH2)*v(S2N12)/v(VDD33))/1k
BGNN12 GNN12 VSS I=(v(GNN12)-v(PH2)*(v(VDD33)-v(S2N12))/v(VDD33))/1k
BNOPP12 NGPP12 0 V=v(VDD33)-v(GPP12)
BNOPN12 NGPN12 0 V=v(VDD33)-v(GPN12)
BNONP12 NGNP12 0 V=v(VDD33)-v(GNP12)
BNONN12 NGNN12 0 V=v(VDD33)-v(GNN12)
CGPP12 GPP12 VSS 2p
CGPN12 GPN12 VSS 2p
CGNP12 GNP12 VSS 2p
CGNN12 GNN12 VSS 2p
CNGPP12 NGPP12 VSS 0.2p
CNGPN12 NGPN12 VSS 0.2p
CNGNP12 NGNP12 VSS 0.2p
CNGNN12 NGNN12 VSS 0.2p
XPVP12 CDLP12 VP GPP12 NGPP12 VDD33 VSS gf180_tg_lowq
XPVN12 CDLP12 VN GPN12 NGPN12 VDD33 VSS gf180_tg_lowq
XNVP12 CDLN12 VP GNP12 NGNP12 VDD33 VSS gf180_tg_lowq
XNVN12 CDLN12 VN GNN12 NGNN12 VDD33 VSS gf180_tg_lowq
XDPC12 CDLP12 VCM_REF PH1 NPH1 VDD33 VSS gf180_tg_lowq
XDNC12 CDLN12 VCM_REF PH1 NPH1 VDD33 VSS gf180_tg_lowq
* DAC unit 13
CDP13 CDLP13 CDRP13 {CU}
CDN13 CDLN13 CDRN13 {CU}
XDP113 CDRP13 VCM_REF PH1 NPH1 VDD33 VSS gf180_tg_lowq
XDP213 CDRP13 INP PH2 NPH2 VDD33 VSS gf180_tg_lowq
XDN113 CDRN13 VCM_REF PH1 NPH1 VDD33 VSS gf180_tg_lowq
XDN213 CDRN13 INN PH2 NPH2 VDD33 VSS gf180_tg_lowq
BGPP13 GPP13 VSS I=(v(GPP13)-v(PH2)*v(S2P13)/v(VDD33))/1k
BGPN13 GPN13 VSS I=(v(GPN13)-v(PH2)*(v(VDD33)-v(S2P13))/v(VDD33))/1k
BGNP13 GNP13 VSS I=(v(GNP13)-v(PH2)*v(S2N13)/v(VDD33))/1k
BGNN13 GNN13 VSS I=(v(GNN13)-v(PH2)*(v(VDD33)-v(S2N13))/v(VDD33))/1k
BNOPP13 NGPP13 0 V=v(VDD33)-v(GPP13)
BNOPN13 NGPN13 0 V=v(VDD33)-v(GPN13)
BNONP13 NGNP13 0 V=v(VDD33)-v(GNP13)
BNONN13 NGNN13 0 V=v(VDD33)-v(GNN13)
CGPP13 GPP13 VSS 2p
CGPN13 GPN13 VSS 2p
CGNP13 GNP13 VSS 2p
CGNN13 GNN13 VSS 2p
CNGPP13 NGPP13 VSS 0.2p
CNGPN13 NGPN13 VSS 0.2p
CNGNP13 NGNP13 VSS 0.2p
CNGNN13 NGNN13 VSS 0.2p
XPVP13 CDLP13 VP GPP13 NGPP13 VDD33 VSS gf180_tg_lowq
XPVN13 CDLP13 VN GPN13 NGPN13 VDD33 VSS gf180_tg_lowq
XNVP13 CDLN13 VP GNP13 NGNP13 VDD33 VSS gf180_tg_lowq
XNVN13 CDLN13 VN GNN13 NGNN13 VDD33 VSS gf180_tg_lowq
XDPC13 CDLP13 VCM_REF PH1 NPH1 VDD33 VSS gf180_tg_lowq
XDNC13 CDLN13 VCM_REF PH1 NPH1 VDD33 VSS gf180_tg_lowq
* DAC unit 14
CDP14 CDLP14 CDRP14 {CU}
CDN14 CDLN14 CDRN14 {CU}
XDP114 CDRP14 VCM_REF PH1 NPH1 VDD33 VSS gf180_tg_lowq
XDP214 CDRP14 INP PH2 NPH2 VDD33 VSS gf180_tg_lowq
XDN114 CDRN14 VCM_REF PH1 NPH1 VDD33 VSS gf180_tg_lowq
XDN214 CDRN14 INN PH2 NPH2 VDD33 VSS gf180_tg_lowq
BGPP14 GPP14 VSS I=(v(GPP14)-v(PH2)*v(S2P14)/v(VDD33))/1k
BGPN14 GPN14 VSS I=(v(GPN14)-v(PH2)*(v(VDD33)-v(S2P14))/v(VDD33))/1k
BGNP14 GNP14 VSS I=(v(GNP14)-v(PH2)*v(S2N14)/v(VDD33))/1k
BGNN14 GNN14 VSS I=(v(GNN14)-v(PH2)*(v(VDD33)-v(S2N14))/v(VDD33))/1k
BNOPP14 NGPP14 0 V=v(VDD33)-v(GPP14)
BNOPN14 NGPN14 0 V=v(VDD33)-v(GPN14)
BNONP14 NGNP14 0 V=v(VDD33)-v(GNP14)
BNONN14 NGNN14 0 V=v(VDD33)-v(GNN14)
CGPP14 GPP14 VSS 2p
CGPN14 GPN14 VSS 2p
CGNP14 GNP14 VSS 2p
CGNN14 GNN14 VSS 2p
CNGPP14 NGPP14 VSS 0.2p
CNGPN14 NGPN14 VSS 0.2p
CNGNP14 NGNP14 VSS 0.2p
CNGNN14 NGNN14 VSS 0.2p
XPVP14 CDLP14 VP GPP14 NGPP14 VDD33 VSS gf180_tg_lowq
XPVN14 CDLP14 VN GPN14 NGPN14 VDD33 VSS gf180_tg_lowq
XNVP14 CDLN14 VP GNP14 NGNP14 VDD33 VSS gf180_tg_lowq
XNVN14 CDLN14 VN GNN14 NGNN14 VDD33 VSS gf180_tg_lowq
XDPC14 CDLP14 VCM_REF PH1 NPH1 VDD33 VSS gf180_tg_lowq
XDNC14 CDLN14 VCM_REF PH1 NPH1 VDD33 VSS gf180_tg_lowq
* DAC unit 15
CDP15 CDLP15 CDRP15 {CU}
CDN15 CDLN15 CDRN15 {CU}
XDP115 CDRP15 VCM_REF PH1 NPH1 VDD33 VSS gf180_tg_lowq
XDP215 CDRP15 INP PH2 NPH2 VDD33 VSS gf180_tg_lowq
XDN115 CDRN15 VCM_REF PH1 NPH1 VDD33 VSS gf180_tg_lowq
XDN215 CDRN15 INN PH2 NPH2 VDD33 VSS gf180_tg_lowq
BGPP15 GPP15 VSS I=(v(GPP15)-v(PH2)*v(S2P15)/v(VDD33))/1k
BGPN15 GPN15 VSS I=(v(GPN15)-v(PH2)*(v(VDD33)-v(S2P15))/v(VDD33))/1k
BGNP15 GNP15 VSS I=(v(GNP15)-v(PH2)*v(S2N15)/v(VDD33))/1k
BGNN15 GNN15 VSS I=(v(GNN15)-v(PH2)*(v(VDD33)-v(S2N15))/v(VDD33))/1k
BNOPP15 NGPP15 0 V=v(VDD33)-v(GPP15)
BNOPN15 NGPN15 0 V=v(VDD33)-v(GPN15)
BNONP15 NGNP15 0 V=v(VDD33)-v(GNP15)
BNONN15 NGNN15 0 V=v(VDD33)-v(GNN15)
CGPP15 GPP15 VSS 2p
CGPN15 GPN15 VSS 2p
CGNP15 GNP15 VSS 2p
CGNN15 GNN15 VSS 2p
CNGPP15 NGPP15 VSS 0.2p
CNGPN15 NGPN15 VSS 0.2p
CNGNP15 NGNP15 VSS 0.2p
CNGNN15 NGNN15 VSS 0.2p
XPVP15 CDLP15 VP GPP15 NGPP15 VDD33 VSS gf180_tg_lowq
XPVN15 CDLP15 VN GPN15 NGPN15 VDD33 VSS gf180_tg_lowq
XNVP15 CDLN15 VP GNP15 NGNP15 VDD33 VSS gf180_tg_lowq
XNVN15 CDLN15 VN GNN15 NGNN15 VDD33 VSS gf180_tg_lowq
XDPC15 CDLP15 VCM_REF PH1 NPH1 VDD33 VSS gf180_tg_lowq
XDNC15 CDLN15 VCM_REF PH1 NPH1 VDD33 VSS gf180_tg_lowq
* DAC unit 16
CDP16 CDLP16 CDRP16 {CU}
CDN16 CDLN16 CDRN16 {CU}
XDP116 CDRP16 VCM_REF PH1 NPH1 VDD33 VSS gf180_tg_lowq
XDP216 CDRP16 INP PH2 NPH2 VDD33 VSS gf180_tg_lowq
XDN116 CDRN16 VCM_REF PH1 NPH1 VDD33 VSS gf180_tg_lowq
XDN216 CDRN16 INN PH2 NPH2 VDD33 VSS gf180_tg_lowq
BGPP16 GPP16 VSS I=(v(GPP16)-v(PH2)*v(S2P16)/v(VDD33))/1k
BGPN16 GPN16 VSS I=(v(GPN16)-v(PH2)*(v(VDD33)-v(S2P16))/v(VDD33))/1k
BGNP16 GNP16 VSS I=(v(GNP16)-v(PH2)*v(S2N16)/v(VDD33))/1k
BGNN16 GNN16 VSS I=(v(GNN16)-v(PH2)*(v(VDD33)-v(S2N16))/v(VDD33))/1k
BNOPP16 NGPP16 0 V=v(VDD33)-v(GPP16)
BNOPN16 NGPN16 0 V=v(VDD33)-v(GPN16)
BNONP16 NGNP16 0 V=v(VDD33)-v(GNP16)
BNONN16 NGNN16 0 V=v(VDD33)-v(GNN16)
CGPP16 GPP16 VSS 2p
CGPN16 GPN16 VSS 2p
CGNP16 GNP16 VSS 2p
CGNN16 GNN16 VSS 2p
CNGPP16 NGPP16 VSS 0.2p
CNGPN16 NGPN16 VSS 0.2p
CNGNP16 NGNP16 VSS 0.2p
CNGNN16 NGNN16 VSS 0.2p
XPVP16 CDLP16 VP GPP16 NGPP16 VDD33 VSS gf180_tg_lowq
XPVN16 CDLP16 VN GPN16 NGPN16 VDD33 VSS gf180_tg_lowq
XNVP16 CDLN16 VP GNP16 NGNP16 VDD33 VSS gf180_tg_lowq
XNVN16 CDLN16 VN GNN16 NGNN16 VDD33 VSS gf180_tg_lowq
XDPC16 CDLP16 VCM_REF PH1 NPH1 VDD33 VSS gf180_tg_lowq
XDNC16 CDLN16 VCM_REF PH1 NPH1 VDD33 VSS gf180_tg_lowq
* DAC unit 17
CDP17 CDLP17 CDRP17 {CU}
CDN17 CDLN17 CDRN17 {CU}
XDP117 CDRP17 VCM_REF PH1 NPH1 VDD33 VSS gf180_tg_lowq
XDP217 CDRP17 INP PH2 NPH2 VDD33 VSS gf180_tg_lowq
XDN117 CDRN17 VCM_REF PH1 NPH1 VDD33 VSS gf180_tg_lowq
XDN217 CDRN17 INN PH2 NPH2 VDD33 VSS gf180_tg_lowq
BGPP17 GPP17 VSS I=(v(GPP17)-v(PH2)*v(S2P17)/v(VDD33))/1k
BGPN17 GPN17 VSS I=(v(GPN17)-v(PH2)*(v(VDD33)-v(S2P17))/v(VDD33))/1k
BGNP17 GNP17 VSS I=(v(GNP17)-v(PH2)*v(S2N17)/v(VDD33))/1k
BGNN17 GNN17 VSS I=(v(GNN17)-v(PH2)*(v(VDD33)-v(S2N17))/v(VDD33))/1k
BNOPP17 NGPP17 0 V=v(VDD33)-v(GPP17)
BNOPN17 NGPN17 0 V=v(VDD33)-v(GPN17)
BNONP17 NGNP17 0 V=v(VDD33)-v(GNP17)
BNONN17 NGNN17 0 V=v(VDD33)-v(GNN17)
CGPP17 GPP17 VSS 2p
CGPN17 GPN17 VSS 2p
CGNP17 GNP17 VSS 2p
CGNN17 GNN17 VSS 2p
CNGPP17 NGPP17 VSS 0.2p
CNGPN17 NGPN17 VSS 0.2p
CNGNP17 NGNP17 VSS 0.2p
CNGNN17 NGNN17 VSS 0.2p
XPVP17 CDLP17 VP GPP17 NGPP17 VDD33 VSS gf180_tg_lowq
XPVN17 CDLP17 VN GPN17 NGPN17 VDD33 VSS gf180_tg_lowq
XNVP17 CDLN17 VP GNP17 NGNP17 VDD33 VSS gf180_tg_lowq
XNVN17 CDLN17 VN GNN17 NGNN17 VDD33 VSS gf180_tg_lowq
XDPC17 CDLP17 VCM_REF PH1 NPH1 VDD33 VSS gf180_tg_lowq
XDNC17 CDLN17 VCM_REF PH1 NPH1 VDD33 VSS gf180_tg_lowq
* DAC unit 18
CDP18 CDLP18 CDRP18 {CU}
CDN18 CDLN18 CDRN18 {CU}
XDP118 CDRP18 VCM_REF PH1 NPH1 VDD33 VSS gf180_tg_lowq
XDP218 CDRP18 INP PH2 NPH2 VDD33 VSS gf180_tg_lowq
XDN118 CDRN18 VCM_REF PH1 NPH1 VDD33 VSS gf180_tg_lowq
XDN218 CDRN18 INN PH2 NPH2 VDD33 VSS gf180_tg_lowq
BGPP18 GPP18 VSS I=(v(GPP18)-v(PH2)*v(S2P18)/v(VDD33))/1k
BGPN18 GPN18 VSS I=(v(GPN18)-v(PH2)*(v(VDD33)-v(S2P18))/v(VDD33))/1k
BGNP18 GNP18 VSS I=(v(GNP18)-v(PH2)*v(S2N18)/v(VDD33))/1k
BGNN18 GNN18 VSS I=(v(GNN18)-v(PH2)*(v(VDD33)-v(S2N18))/v(VDD33))/1k
BNOPP18 NGPP18 0 V=v(VDD33)-v(GPP18)
BNOPN18 NGPN18 0 V=v(VDD33)-v(GPN18)
BNONP18 NGNP18 0 V=v(VDD33)-v(GNP18)
BNONN18 NGNN18 0 V=v(VDD33)-v(GNN18)
CGPP18 GPP18 VSS 2p
CGPN18 GPN18 VSS 2p
CGNP18 GNP18 VSS 2p
CGNN18 GNN18 VSS 2p
CNGPP18 NGPP18 VSS 0.2p
CNGPN18 NGPN18 VSS 0.2p
CNGNP18 NGNP18 VSS 0.2p
CNGNN18 NGNN18 VSS 0.2p
XPVP18 CDLP18 VP GPP18 NGPP18 VDD33 VSS gf180_tg_lowq
XPVN18 CDLP18 VN GPN18 NGPN18 VDD33 VSS gf180_tg_lowq
XNVP18 CDLN18 VP GNP18 NGNP18 VDD33 VSS gf180_tg_lowq
XNVN18 CDLN18 VN GNN18 NGNN18 VDD33 VSS gf180_tg_lowq
XDPC18 CDLP18 VCM_REF PH1 NPH1 VDD33 VSS gf180_tg_lowq
XDNC18 CDLN18 VCM_REF PH1 NPH1 VDD33 VSS gf180_tg_lowq
* DAC unit 19
CDP19 CDLP19 CDRP19 {CU}
CDN19 CDLN19 CDRN19 {CU}
XDP119 CDRP19 VCM_REF PH1 NPH1 VDD33 VSS gf180_tg_lowq
XDP219 CDRP19 INP PH2 NPH2 VDD33 VSS gf180_tg_lowq
XDN119 CDRN19 VCM_REF PH1 NPH1 VDD33 VSS gf180_tg_lowq
XDN219 CDRN19 INN PH2 NPH2 VDD33 VSS gf180_tg_lowq
BGPP19 GPP19 VSS I=(v(GPP19)-v(PH2)*v(S2P19)/v(VDD33))/1k
BGPN19 GPN19 VSS I=(v(GPN19)-v(PH2)*(v(VDD33)-v(S2P19))/v(VDD33))/1k
BGNP19 GNP19 VSS I=(v(GNP19)-v(PH2)*v(S2N19)/v(VDD33))/1k
BGNN19 GNN19 VSS I=(v(GNN19)-v(PH2)*(v(VDD33)-v(S2N19))/v(VDD33))/1k
BNOPP19 NGPP19 0 V=v(VDD33)-v(GPP19)
BNOPN19 NGPN19 0 V=v(VDD33)-v(GPN19)
BNONP19 NGNP19 0 V=v(VDD33)-v(GNP19)
BNONN19 NGNN19 0 V=v(VDD33)-v(GNN19)
CGPP19 GPP19 VSS 2p
CGPN19 GPN19 VSS 2p
CGNP19 GNP19 VSS 2p
CGNN19 GNN19 VSS 2p
CNGPP19 NGPP19 VSS 0.2p
CNGPN19 NGPN19 VSS 0.2p
CNGNP19 NGNP19 VSS 0.2p
CNGNN19 NGNN19 VSS 0.2p
XPVP19 CDLP19 VP GPP19 NGPP19 VDD33 VSS gf180_tg_lowq
XPVN19 CDLP19 VN GPN19 NGPN19 VDD33 VSS gf180_tg_lowq
XNVP19 CDLN19 VP GNP19 NGNP19 VDD33 VSS gf180_tg_lowq
XNVN19 CDLN19 VN GNN19 NGNN19 VDD33 VSS gf180_tg_lowq
XDPC19 CDLP19 VCM_REF PH1 NPH1 VDD33 VSS gf180_tg_lowq
XDNC19 CDLN19 VCM_REF PH1 NPH1 VDD33 VSS gf180_tg_lowq
* DAC unit 20
CDP20 CDLP20 CDRP20 {CU}
CDN20 CDLN20 CDRN20 {CU}
XDP120 CDRP20 VCM_REF PH1 NPH1 VDD33 VSS gf180_tg_lowq
XDP220 CDRP20 INP PH2 NPH2 VDD33 VSS gf180_tg_lowq
XDN120 CDRN20 VCM_REF PH1 NPH1 VDD33 VSS gf180_tg_lowq
XDN220 CDRN20 INN PH2 NPH2 VDD33 VSS gf180_tg_lowq
BGPP20 GPP20 VSS I=(v(GPP20)-v(PH2)*v(S2P20)/v(VDD33))/1k
BGPN20 GPN20 VSS I=(v(GPN20)-v(PH2)*(v(VDD33)-v(S2P20))/v(VDD33))/1k
BGNP20 GNP20 VSS I=(v(GNP20)-v(PH2)*v(S2N20)/v(VDD33))/1k
BGNN20 GNN20 VSS I=(v(GNN20)-v(PH2)*(v(VDD33)-v(S2N20))/v(VDD33))/1k
BNOPP20 NGPP20 0 V=v(VDD33)-v(GPP20)
BNOPN20 NGPN20 0 V=v(VDD33)-v(GPN20)
BNONP20 NGNP20 0 V=v(VDD33)-v(GNP20)
BNONN20 NGNN20 0 V=v(VDD33)-v(GNN20)
CGPP20 GPP20 VSS 2p
CGPN20 GPN20 VSS 2p
CGNP20 GNP20 VSS 2p
CGNN20 GNN20 VSS 2p
CNGPP20 NGPP20 VSS 0.2p
CNGPN20 NGPN20 VSS 0.2p
CNGNP20 NGNP20 VSS 0.2p
CNGNN20 NGNN20 VSS 0.2p
XPVP20 CDLP20 VP GPP20 NGPP20 VDD33 VSS gf180_tg_lowq
XPVN20 CDLP20 VN GPN20 NGPN20 VDD33 VSS gf180_tg_lowq
XNVP20 CDLN20 VP GNP20 NGNP20 VDD33 VSS gf180_tg_lowq
XNVN20 CDLN20 VN GNN20 NGNN20 VDD33 VSS gf180_tg_lowq
XDPC20 CDLP20 VCM_REF PH1 NPH1 VDD33 VSS gf180_tg_lowq
XDNC20 CDLN20 VCM_REF PH1 NPH1 VDD33 VSS gf180_tg_lowq
* DAC unit 21
CDP21 CDLP21 CDRP21 {CU}
CDN21 CDLN21 CDRN21 {CU}
XDP121 CDRP21 VCM_REF PH1 NPH1 VDD33 VSS gf180_tg_lowq
XDP221 CDRP21 INP PH2 NPH2 VDD33 VSS gf180_tg_lowq
XDN121 CDRN21 VCM_REF PH1 NPH1 VDD33 VSS gf180_tg_lowq
XDN221 CDRN21 INN PH2 NPH2 VDD33 VSS gf180_tg_lowq
BGPP21 GPP21 VSS I=(v(GPP21)-v(PH2)*v(S2P21)/v(VDD33))/1k
BGPN21 GPN21 VSS I=(v(GPN21)-v(PH2)*(v(VDD33)-v(S2P21))/v(VDD33))/1k
BGNP21 GNP21 VSS I=(v(GNP21)-v(PH2)*v(S2N21)/v(VDD33))/1k
BGNN21 GNN21 VSS I=(v(GNN21)-v(PH2)*(v(VDD33)-v(S2N21))/v(VDD33))/1k
BNOPP21 NGPP21 0 V=v(VDD33)-v(GPP21)
BNOPN21 NGPN21 0 V=v(VDD33)-v(GPN21)
BNONP21 NGNP21 0 V=v(VDD33)-v(GNP21)
BNONN21 NGNN21 0 V=v(VDD33)-v(GNN21)
CGPP21 GPP21 VSS 2p
CGPN21 GPN21 VSS 2p
CGNP21 GNP21 VSS 2p
CGNN21 GNN21 VSS 2p
CNGPP21 NGPP21 VSS 0.2p
CNGPN21 NGPN21 VSS 0.2p
CNGNP21 NGNP21 VSS 0.2p
CNGNN21 NGNN21 VSS 0.2p
XPVP21 CDLP21 VP GPP21 NGPP21 VDD33 VSS gf180_tg_lowq
XPVN21 CDLP21 VN GPN21 NGPN21 VDD33 VSS gf180_tg_lowq
XNVP21 CDLN21 VP GNP21 NGNP21 VDD33 VSS gf180_tg_lowq
XNVN21 CDLN21 VN GNN21 NGNN21 VDD33 VSS gf180_tg_lowq
XDPC21 CDLP21 VCM_REF PH1 NPH1 VDD33 VSS gf180_tg_lowq
XDNC21 CDLN21 VCM_REF PH1 NPH1 VDD33 VSS gf180_tg_lowq
* DAC unit 22
CDP22 CDLP22 CDRP22 {CU}
CDN22 CDLN22 CDRN22 {CU}
XDP122 CDRP22 VCM_REF PH1 NPH1 VDD33 VSS gf180_tg_lowq
XDP222 CDRP22 INP PH2 NPH2 VDD33 VSS gf180_tg_lowq
XDN122 CDRN22 VCM_REF PH1 NPH1 VDD33 VSS gf180_tg_lowq
XDN222 CDRN22 INN PH2 NPH2 VDD33 VSS gf180_tg_lowq
BGPP22 GPP22 VSS I=(v(GPP22)-v(PH2)*v(S2P22)/v(VDD33))/1k
BGPN22 GPN22 VSS I=(v(GPN22)-v(PH2)*(v(VDD33)-v(S2P22))/v(VDD33))/1k
BGNP22 GNP22 VSS I=(v(GNP22)-v(PH2)*v(S2N22)/v(VDD33))/1k
BGNN22 GNN22 VSS I=(v(GNN22)-v(PH2)*(v(VDD33)-v(S2N22))/v(VDD33))/1k
BNOPP22 NGPP22 0 V=v(VDD33)-v(GPP22)
BNOPN22 NGPN22 0 V=v(VDD33)-v(GPN22)
BNONP22 NGNP22 0 V=v(VDD33)-v(GNP22)
BNONN22 NGNN22 0 V=v(VDD33)-v(GNN22)
CGPP22 GPP22 VSS 2p
CGPN22 GPN22 VSS 2p
CGNP22 GNP22 VSS 2p
CGNN22 GNN22 VSS 2p
CNGPP22 NGPP22 VSS 0.2p
CNGPN22 NGPN22 VSS 0.2p
CNGNP22 NGNP22 VSS 0.2p
CNGNN22 NGNN22 VSS 0.2p
XPVP22 CDLP22 VP GPP22 NGPP22 VDD33 VSS gf180_tg_lowq
XPVN22 CDLP22 VN GPN22 NGPN22 VDD33 VSS gf180_tg_lowq
XNVP22 CDLN22 VP GNP22 NGNP22 VDD33 VSS gf180_tg_lowq
XNVN22 CDLN22 VN GNN22 NGNN22 VDD33 VSS gf180_tg_lowq
XDPC22 CDLP22 VCM_REF PH1 NPH1 VDD33 VSS gf180_tg_lowq
XDNC22 CDLN22 VCM_REF PH1 NPH1 VDD33 VSS gf180_tg_lowq
* DAC unit 23
CDP23 CDLP23 CDRP23 {CU}
CDN23 CDLN23 CDRN23 {CU}
XDP123 CDRP23 VCM_REF PH1 NPH1 VDD33 VSS gf180_tg_lowq
XDP223 CDRP23 INP PH2 NPH2 VDD33 VSS gf180_tg_lowq
XDN123 CDRN23 VCM_REF PH1 NPH1 VDD33 VSS gf180_tg_lowq
XDN223 CDRN23 INN PH2 NPH2 VDD33 VSS gf180_tg_lowq
BGPP23 GPP23 VSS I=(v(GPP23)-v(PH2)*v(S2P23)/v(VDD33))/1k
BGPN23 GPN23 VSS I=(v(GPN23)-v(PH2)*(v(VDD33)-v(S2P23))/v(VDD33))/1k
BGNP23 GNP23 VSS I=(v(GNP23)-v(PH2)*v(S2N23)/v(VDD33))/1k
BGNN23 GNN23 VSS I=(v(GNN23)-v(PH2)*(v(VDD33)-v(S2N23))/v(VDD33))/1k
BNOPP23 NGPP23 0 V=v(VDD33)-v(GPP23)
BNOPN23 NGPN23 0 V=v(VDD33)-v(GPN23)
BNONP23 NGNP23 0 V=v(VDD33)-v(GNP23)
BNONN23 NGNN23 0 V=v(VDD33)-v(GNN23)
CGPP23 GPP23 VSS 2p
CGPN23 GPN23 VSS 2p
CGNP23 GNP23 VSS 2p
CGNN23 GNN23 VSS 2p
CNGPP23 NGPP23 VSS 0.2p
CNGPN23 NGPN23 VSS 0.2p
CNGNP23 NGNP23 VSS 0.2p
CNGNN23 NGNN23 VSS 0.2p
XPVP23 CDLP23 VP GPP23 NGPP23 VDD33 VSS gf180_tg_lowq
XPVN23 CDLP23 VN GPN23 NGPN23 VDD33 VSS gf180_tg_lowq
XNVP23 CDLN23 VP GNP23 NGNP23 VDD33 VSS gf180_tg_lowq
XNVN23 CDLN23 VN GNN23 NGNN23 VDD33 VSS gf180_tg_lowq
XDPC23 CDLP23 VCM_REF PH1 NPH1 VDD33 VSS gf180_tg_lowq
XDNC23 CDLN23 VCM_REF PH1 NPH1 VDD33 VSS gf180_tg_lowq
* DAC unit 24
CDP24 CDLP24 CDRP24 {CU}
CDN24 CDLN24 CDRN24 {CU}
XDP124 CDRP24 VCM_REF PH1 NPH1 VDD33 VSS gf180_tg_lowq
XDP224 CDRP24 INP PH2 NPH2 VDD33 VSS gf180_tg_lowq
XDN124 CDRN24 VCM_REF PH1 NPH1 VDD33 VSS gf180_tg_lowq
XDN224 CDRN24 INN PH2 NPH2 VDD33 VSS gf180_tg_lowq
BGPP24 GPP24 VSS I=(v(GPP24)-v(PH2)*v(S2P24)/v(VDD33))/1k
BGPN24 GPN24 VSS I=(v(GPN24)-v(PH2)*(v(VDD33)-v(S2P24))/v(VDD33))/1k
BGNP24 GNP24 VSS I=(v(GNP24)-v(PH2)*v(S2N24)/v(VDD33))/1k
BGNN24 GNN24 VSS I=(v(GNN24)-v(PH2)*(v(VDD33)-v(S2N24))/v(VDD33))/1k
BNOPP24 NGPP24 0 V=v(VDD33)-v(GPP24)
BNOPN24 NGPN24 0 V=v(VDD33)-v(GPN24)
BNONP24 NGNP24 0 V=v(VDD33)-v(GNP24)
BNONN24 NGNN24 0 V=v(VDD33)-v(GNN24)
CGPP24 GPP24 VSS 2p
CGPN24 GPN24 VSS 2p
CGNP24 GNP24 VSS 2p
CGNN24 GNN24 VSS 2p
CNGPP24 NGPP24 VSS 0.2p
CNGPN24 NGPN24 VSS 0.2p
CNGNP24 NGNP24 VSS 0.2p
CNGNN24 NGNN24 VSS 0.2p
XPVP24 CDLP24 VP GPP24 NGPP24 VDD33 VSS gf180_tg_lowq
XPVN24 CDLP24 VN GPN24 NGPN24 VDD33 VSS gf180_tg_lowq
XNVP24 CDLN24 VP GNP24 NGNP24 VDD33 VSS gf180_tg_lowq
XNVN24 CDLN24 VN GNN24 NGNN24 VDD33 VSS gf180_tg_lowq
XDPC24 CDLP24 VCM_REF PH1 NPH1 VDD33 VSS gf180_tg_lowq
XDNC24 CDLN24 VCM_REF PH1 NPH1 VDD33 VSS gf180_tg_lowq
* DAC unit 25
CDP25 CDLP25 CDRP25 {CU}
CDN25 CDLN25 CDRN25 {CU}
XDP125 CDRP25 VCM_REF PH1 NPH1 VDD33 VSS gf180_tg_lowq
XDP225 CDRP25 INP PH2 NPH2 VDD33 VSS gf180_tg_lowq
XDN125 CDRN25 VCM_REF PH1 NPH1 VDD33 VSS gf180_tg_lowq
XDN225 CDRN25 INN PH2 NPH2 VDD33 VSS gf180_tg_lowq
BGPP25 GPP25 VSS I=(v(GPP25)-v(PH2)*v(S2P25)/v(VDD33))/1k
BGPN25 GPN25 VSS I=(v(GPN25)-v(PH2)*(v(VDD33)-v(S2P25))/v(VDD33))/1k
BGNP25 GNP25 VSS I=(v(GNP25)-v(PH2)*v(S2N25)/v(VDD33))/1k
BGNN25 GNN25 VSS I=(v(GNN25)-v(PH2)*(v(VDD33)-v(S2N25))/v(VDD33))/1k
BNOPP25 NGPP25 0 V=v(VDD33)-v(GPP25)
BNOPN25 NGPN25 0 V=v(VDD33)-v(GPN25)
BNONP25 NGNP25 0 V=v(VDD33)-v(GNP25)
BNONN25 NGNN25 0 V=v(VDD33)-v(GNN25)
CGPP25 GPP25 VSS 2p
CGPN25 GPN25 VSS 2p
CGNP25 GNP25 VSS 2p
CGNN25 GNN25 VSS 2p
CNGPP25 NGPP25 VSS 0.2p
CNGPN25 NGPN25 VSS 0.2p
CNGNP25 NGNP25 VSS 0.2p
CNGNN25 NGNN25 VSS 0.2p
XPVP25 CDLP25 VP GPP25 NGPP25 VDD33 VSS gf180_tg_lowq
XPVN25 CDLP25 VN GPN25 NGPN25 VDD33 VSS gf180_tg_lowq
XNVP25 CDLN25 VP GNP25 NGNP25 VDD33 VSS gf180_tg_lowq
XNVN25 CDLN25 VN GNN25 NGNN25 VDD33 VSS gf180_tg_lowq
XDPC25 CDLP25 VCM_REF PH1 NPH1 VDD33 VSS gf180_tg_lowq
XDNC25 CDLN25 VCM_REF PH1 NPH1 VDD33 VSS gf180_tg_lowq
* DAC unit 26
CDP26 CDLP26 CDRP26 {CU}
CDN26 CDLN26 CDRN26 {CU}
XDP126 CDRP26 VCM_REF PH1 NPH1 VDD33 VSS gf180_tg_lowq
XDP226 CDRP26 INP PH2 NPH2 VDD33 VSS gf180_tg_lowq
XDN126 CDRN26 VCM_REF PH1 NPH1 VDD33 VSS gf180_tg_lowq
XDN226 CDRN26 INN PH2 NPH2 VDD33 VSS gf180_tg_lowq
BGPP26 GPP26 VSS I=(v(GPP26)-v(PH2)*v(S2P26)/v(VDD33))/1k
BGPN26 GPN26 VSS I=(v(GPN26)-v(PH2)*(v(VDD33)-v(S2P26))/v(VDD33))/1k
BGNP26 GNP26 VSS I=(v(GNP26)-v(PH2)*v(S2N26)/v(VDD33))/1k
BGNN26 GNN26 VSS I=(v(GNN26)-v(PH2)*(v(VDD33)-v(S2N26))/v(VDD33))/1k
BNOPP26 NGPP26 0 V=v(VDD33)-v(GPP26)
BNOPN26 NGPN26 0 V=v(VDD33)-v(GPN26)
BNONP26 NGNP26 0 V=v(VDD33)-v(GNP26)
BNONN26 NGNN26 0 V=v(VDD33)-v(GNN26)
CGPP26 GPP26 VSS 2p
CGPN26 GPN26 VSS 2p
CGNP26 GNP26 VSS 2p
CGNN26 GNN26 VSS 2p
CNGPP26 NGPP26 VSS 0.2p
CNGPN26 NGPN26 VSS 0.2p
CNGNP26 NGNP26 VSS 0.2p
CNGNN26 NGNN26 VSS 0.2p
XPVP26 CDLP26 VP GPP26 NGPP26 VDD33 VSS gf180_tg_lowq
XPVN26 CDLP26 VN GPN26 NGPN26 VDD33 VSS gf180_tg_lowq
XNVP26 CDLN26 VP GNP26 NGNP26 VDD33 VSS gf180_tg_lowq
XNVN26 CDLN26 VN GNN26 NGNN26 VDD33 VSS gf180_tg_lowq
XDPC26 CDLP26 VCM_REF PH1 NPH1 VDD33 VSS gf180_tg_lowq
XDNC26 CDLN26 VCM_REF PH1 NPH1 VDD33 VSS gf180_tg_lowq
* DAC unit 27
CDP27 CDLP27 CDRP27 {CU}
CDN27 CDLN27 CDRN27 {CU}
XDP127 CDRP27 VCM_REF PH1 NPH1 VDD33 VSS gf180_tg_lowq
XDP227 CDRP27 INP PH2 NPH2 VDD33 VSS gf180_tg_lowq
XDN127 CDRN27 VCM_REF PH1 NPH1 VDD33 VSS gf180_tg_lowq
XDN227 CDRN27 INN PH2 NPH2 VDD33 VSS gf180_tg_lowq
BGPP27 GPP27 VSS I=(v(GPP27)-v(PH2)*v(S2P27)/v(VDD33))/1k
BGPN27 GPN27 VSS I=(v(GPN27)-v(PH2)*(v(VDD33)-v(S2P27))/v(VDD33))/1k
BGNP27 GNP27 VSS I=(v(GNP27)-v(PH2)*v(S2N27)/v(VDD33))/1k
BGNN27 GNN27 VSS I=(v(GNN27)-v(PH2)*(v(VDD33)-v(S2N27))/v(VDD33))/1k
BNOPP27 NGPP27 0 V=v(VDD33)-v(GPP27)
BNOPN27 NGPN27 0 V=v(VDD33)-v(GPN27)
BNONP27 NGNP27 0 V=v(VDD33)-v(GNP27)
BNONN27 NGNN27 0 V=v(VDD33)-v(GNN27)
CGPP27 GPP27 VSS 2p
CGPN27 GPN27 VSS 2p
CGNP27 GNP27 VSS 2p
CGNN27 GNN27 VSS 2p
CNGPP27 NGPP27 VSS 0.2p
CNGPN27 NGPN27 VSS 0.2p
CNGNP27 NGNP27 VSS 0.2p
CNGNN27 NGNN27 VSS 0.2p
XPVP27 CDLP27 VP GPP27 NGPP27 VDD33 VSS gf180_tg_lowq
XPVN27 CDLP27 VN GPN27 NGPN27 VDD33 VSS gf180_tg_lowq
XNVP27 CDLN27 VP GNP27 NGNP27 VDD33 VSS gf180_tg_lowq
XNVN27 CDLN27 VN GNN27 NGNN27 VDD33 VSS gf180_tg_lowq
XDPC27 CDLP27 VCM_REF PH1 NPH1 VDD33 VSS gf180_tg_lowq
XDNC27 CDLN27 VCM_REF PH1 NPH1 VDD33 VSS gf180_tg_lowq
* DAC unit 28
CDP28 CDLP28 CDRP28 {CU}
CDN28 CDLN28 CDRN28 {CU}
XDP128 CDRP28 VCM_REF PH1 NPH1 VDD33 VSS gf180_tg_lowq
XDP228 CDRP28 INP PH2 NPH2 VDD33 VSS gf180_tg_lowq
XDN128 CDRN28 VCM_REF PH1 NPH1 VDD33 VSS gf180_tg_lowq
XDN228 CDRN28 INN PH2 NPH2 VDD33 VSS gf180_tg_lowq
BGPP28 GPP28 VSS I=(v(GPP28)-v(PH2)*v(S2P28)/v(VDD33))/1k
BGPN28 GPN28 VSS I=(v(GPN28)-v(PH2)*(v(VDD33)-v(S2P28))/v(VDD33))/1k
BGNP28 GNP28 VSS I=(v(GNP28)-v(PH2)*v(S2N28)/v(VDD33))/1k
BGNN28 GNN28 VSS I=(v(GNN28)-v(PH2)*(v(VDD33)-v(S2N28))/v(VDD33))/1k
BNOPP28 NGPP28 0 V=v(VDD33)-v(GPP28)
BNOPN28 NGPN28 0 V=v(VDD33)-v(GPN28)
BNONP28 NGNP28 0 V=v(VDD33)-v(GNP28)
BNONN28 NGNN28 0 V=v(VDD33)-v(GNN28)
CGPP28 GPP28 VSS 2p
CGPN28 GPN28 VSS 2p
CGNP28 GNP28 VSS 2p
CGNN28 GNN28 VSS 2p
CNGPP28 NGPP28 VSS 0.2p
CNGPN28 NGPN28 VSS 0.2p
CNGNP28 NGNP28 VSS 0.2p
CNGNN28 NGNN28 VSS 0.2p
XPVP28 CDLP28 VP GPP28 NGPP28 VDD33 VSS gf180_tg_lowq
XPVN28 CDLP28 VN GPN28 NGPN28 VDD33 VSS gf180_tg_lowq
XNVP28 CDLN28 VP GNP28 NGNP28 VDD33 VSS gf180_tg_lowq
XNVN28 CDLN28 VN GNN28 NGNN28 VDD33 VSS gf180_tg_lowq
XDPC28 CDLP28 VCM_REF PH1 NPH1 VDD33 VSS gf180_tg_lowq
XDNC28 CDLN28 VCM_REF PH1 NPH1 VDD33 VSS gf180_tg_lowq
* DAC unit 29
CDP29 CDLP29 CDRP29 {CU}
CDN29 CDLN29 CDRN29 {CU}
XDP129 CDRP29 VCM_REF PH1 NPH1 VDD33 VSS gf180_tg_lowq
XDP229 CDRP29 INP PH2 NPH2 VDD33 VSS gf180_tg_lowq
XDN129 CDRN29 VCM_REF PH1 NPH1 VDD33 VSS gf180_tg_lowq
XDN229 CDRN29 INN PH2 NPH2 VDD33 VSS gf180_tg_lowq
BGPP29 GPP29 VSS I=(v(GPP29)-v(PH2)*v(S2P29)/v(VDD33))/1k
BGPN29 GPN29 VSS I=(v(GPN29)-v(PH2)*(v(VDD33)-v(S2P29))/v(VDD33))/1k
BGNP29 GNP29 VSS I=(v(GNP29)-v(PH2)*v(S2N29)/v(VDD33))/1k
BGNN29 GNN29 VSS I=(v(GNN29)-v(PH2)*(v(VDD33)-v(S2N29))/v(VDD33))/1k
BNOPP29 NGPP29 0 V=v(VDD33)-v(GPP29)
BNOPN29 NGPN29 0 V=v(VDD33)-v(GPN29)
BNONP29 NGNP29 0 V=v(VDD33)-v(GNP29)
BNONN29 NGNN29 0 V=v(VDD33)-v(GNN29)
CGPP29 GPP29 VSS 2p
CGPN29 GPN29 VSS 2p
CGNP29 GNP29 VSS 2p
CGNN29 GNN29 VSS 2p
CNGPP29 NGPP29 VSS 0.2p
CNGPN29 NGPN29 VSS 0.2p
CNGNP29 NGNP29 VSS 0.2p
CNGNN29 NGNN29 VSS 0.2p
XPVP29 CDLP29 VP GPP29 NGPP29 VDD33 VSS gf180_tg_lowq
XPVN29 CDLP29 VN GPN29 NGPN29 VDD33 VSS gf180_tg_lowq
XNVP29 CDLN29 VP GNP29 NGNP29 VDD33 VSS gf180_tg_lowq
XNVN29 CDLN29 VN GNN29 NGNN29 VDD33 VSS gf180_tg_lowq
XDPC29 CDLP29 VCM_REF PH1 NPH1 VDD33 VSS gf180_tg_lowq
XDNC29 CDLN29 VCM_REF PH1 NPH1 VDD33 VSS gf180_tg_lowq
* DAC unit 30
CDP30 CDLP30 CDRP30 {CU}
CDN30 CDLN30 CDRN30 {CU}
XDP130 CDRP30 VCM_REF PH1 NPH1 VDD33 VSS gf180_tg_lowq
XDP230 CDRP30 INP PH2 NPH2 VDD33 VSS gf180_tg_lowq
XDN130 CDRN30 VCM_REF PH1 NPH1 VDD33 VSS gf180_tg_lowq
XDN230 CDRN30 INN PH2 NPH2 VDD33 VSS gf180_tg_lowq
BGPP30 GPP30 VSS I=(v(GPP30)-v(PH2)*v(S2P30)/v(VDD33))/1k
BGPN30 GPN30 VSS I=(v(GPN30)-v(PH2)*(v(VDD33)-v(S2P30))/v(VDD33))/1k
BGNP30 GNP30 VSS I=(v(GNP30)-v(PH2)*v(S2N30)/v(VDD33))/1k
BGNN30 GNN30 VSS I=(v(GNN30)-v(PH2)*(v(VDD33)-v(S2N30))/v(VDD33))/1k
BNOPP30 NGPP30 0 V=v(VDD33)-v(GPP30)
BNOPN30 NGPN30 0 V=v(VDD33)-v(GPN30)
BNONP30 NGNP30 0 V=v(VDD33)-v(GNP30)
BNONN30 NGNN30 0 V=v(VDD33)-v(GNN30)
CGPP30 GPP30 VSS 2p
CGPN30 GPN30 VSS 2p
CGNP30 GNP30 VSS 2p
CGNN30 GNN30 VSS 2p
CNGPP30 NGPP30 VSS 0.2p
CNGPN30 NGPN30 VSS 0.2p
CNGNP30 NGNP30 VSS 0.2p
CNGNN30 NGNN30 VSS 0.2p
XPVP30 CDLP30 VP GPP30 NGPP30 VDD33 VSS gf180_tg_lowq
XPVN30 CDLP30 VN GPN30 NGPN30 VDD33 VSS gf180_tg_lowq
XNVP30 CDLN30 VP GNP30 NGNP30 VDD33 VSS gf180_tg_lowq
XNVN30 CDLN30 VN GNN30 NGNN30 VDD33 VSS gf180_tg_lowq
XDPC30 CDLP30 VCM_REF PH1 NPH1 VDD33 VSS gf180_tg_lowq
XDNC30 CDLN30 VCM_REF PH1 NPH1 VDD33 VSS gf180_tg_lowq
* DAC unit 31
CDP31 CDLP31 CDRP31 {CU}
CDN31 CDLN31 CDRN31 {CU}
XDP131 CDRP31 VCM_REF PH1 NPH1 VDD33 VSS gf180_tg_lowq
XDP231 CDRP31 INP PH2 NPH2 VDD33 VSS gf180_tg_lowq
XDN131 CDRN31 VCM_REF PH1 NPH1 VDD33 VSS gf180_tg_lowq
XDN231 CDRN31 INN PH2 NPH2 VDD33 VSS gf180_tg_lowq
BGPP31 GPP31 VSS I=(v(GPP31)-v(PH2)*v(S2P31)/v(VDD33))/1k
BGPN31 GPN31 VSS I=(v(GPN31)-v(PH2)*(v(VDD33)-v(S2P31))/v(VDD33))/1k
BGNP31 GNP31 VSS I=(v(GNP31)-v(PH2)*v(S2N31)/v(VDD33))/1k
BGNN31 GNN31 VSS I=(v(GNN31)-v(PH2)*(v(VDD33)-v(S2N31))/v(VDD33))/1k
BNOPP31 NGPP31 0 V=v(VDD33)-v(GPP31)
BNOPN31 NGPN31 0 V=v(VDD33)-v(GPN31)
BNONP31 NGNP31 0 V=v(VDD33)-v(GNP31)
BNONN31 NGNN31 0 V=v(VDD33)-v(GNN31)
CGPP31 GPP31 VSS 2p
CGPN31 GPN31 VSS 2p
CGNP31 GNP31 VSS 2p
CGNN31 GNN31 VSS 2p
CNGPP31 NGPP31 VSS 0.2p
CNGPN31 NGPN31 VSS 0.2p
CNGNP31 NGNP31 VSS 0.2p
CNGNN31 NGNN31 VSS 0.2p
XPVP31 CDLP31 VP GPP31 NGPP31 VDD33 VSS gf180_tg_lowq
XPVN31 CDLP31 VN GPN31 NGPN31 VDD33 VSS gf180_tg_lowq
XNVP31 CDLN31 VP GNP31 NGNP31 VDD33 VSS gf180_tg_lowq
XNVN31 CDLN31 VN GNN31 NGNN31 VDD33 VSS gf180_tg_lowq
XDPC31 CDLP31 VCM_REF PH1 NPH1 VDD33 VSS gf180_tg_lowq
XDNC31 CDLN31 VCM_REF PH1 NPH1 VDD33 VSS gf180_tg_lowq
* DAC unit 32
CDP32 CDLP32 CDRP32 {CU}
CDN32 CDLN32 CDRN32 {CU}
XDP132 CDRP32 VCM_REF PH1 NPH1 VDD33 VSS gf180_tg_lowq
XDP232 CDRP32 INP PH2 NPH2 VDD33 VSS gf180_tg_lowq
XDN132 CDRN32 VCM_REF PH1 NPH1 VDD33 VSS gf180_tg_lowq
XDN232 CDRN32 INN PH2 NPH2 VDD33 VSS gf180_tg_lowq
BGPP32 GPP32 VSS I=(v(GPP32)-v(PH2)*v(S2P32)/v(VDD33))/1k
BGPN32 GPN32 VSS I=(v(GPN32)-v(PH2)*(v(VDD33)-v(S2P32))/v(VDD33))/1k
BGNP32 GNP32 VSS I=(v(GNP32)-v(PH2)*v(S2N32)/v(VDD33))/1k
BGNN32 GNN32 VSS I=(v(GNN32)-v(PH2)*(v(VDD33)-v(S2N32))/v(VDD33))/1k
BNOPP32 NGPP32 0 V=v(VDD33)-v(GPP32)
BNOPN32 NGPN32 0 V=v(VDD33)-v(GPN32)
BNONP32 NGNP32 0 V=v(VDD33)-v(GNP32)
BNONN32 NGNN32 0 V=v(VDD33)-v(GNN32)
CGPP32 GPP32 VSS 2p
CGPN32 GPN32 VSS 2p
CGNP32 GNP32 VSS 2p
CGNN32 GNN32 VSS 2p
CNGPP32 NGPP32 VSS 0.2p
CNGPN32 NGPN32 VSS 0.2p
CNGNP32 NGNP32 VSS 0.2p
CNGNN32 NGNN32 VSS 0.2p
XPVP32 CDLP32 VP GPP32 NGPP32 VDD33 VSS gf180_tg_lowq
XPVN32 CDLP32 VN GPN32 NGPN32 VDD33 VSS gf180_tg_lowq
XNVP32 CDLN32 VP GNP32 NGNP32 VDD33 VSS gf180_tg_lowq
XNVN32 CDLN32 VN GNN32 NGNN32 VDD33 VSS gf180_tg_lowq
XDPC32 CDLP32 VCM_REF PH1 NPH1 VDD33 VSS gf180_tg_lowq
XDNC32 CDLN32 VCM_REF PH1 NPH1 VDD33 VSS gf180_tg_lowq
* DAC unit 33
CDP33 CDLP33 CDRP33 {CU}
CDN33 CDLN33 CDRN33 {CU}
XDP133 CDRP33 VCM_REF PH1 NPH1 VDD33 VSS gf180_tg_lowq
XDP233 CDRP33 INP PH2 NPH2 VDD33 VSS gf180_tg_lowq
XDN133 CDRN33 VCM_REF PH1 NPH1 VDD33 VSS gf180_tg_lowq
XDN233 CDRN33 INN PH2 NPH2 VDD33 VSS gf180_tg_lowq
BGPP33 GPP33 VSS I=(v(GPP33)-v(PH2)*v(S2P33)/v(VDD33))/1k
BGPN33 GPN33 VSS I=(v(GPN33)-v(PH2)*(v(VDD33)-v(S2P33))/v(VDD33))/1k
BGNP33 GNP33 VSS I=(v(GNP33)-v(PH2)*v(S2N33)/v(VDD33))/1k
BGNN33 GNN33 VSS I=(v(GNN33)-v(PH2)*(v(VDD33)-v(S2N33))/v(VDD33))/1k
BNOPP33 NGPP33 0 V=v(VDD33)-v(GPP33)
BNOPN33 NGPN33 0 V=v(VDD33)-v(GPN33)
BNONP33 NGNP33 0 V=v(VDD33)-v(GNP33)
BNONN33 NGNN33 0 V=v(VDD33)-v(GNN33)
CGPP33 GPP33 VSS 2p
CGPN33 GPN33 VSS 2p
CGNP33 GNP33 VSS 2p
CGNN33 GNN33 VSS 2p
CNGPP33 NGPP33 VSS 0.2p
CNGPN33 NGPN33 VSS 0.2p
CNGNP33 NGNP33 VSS 0.2p
CNGNN33 NGNN33 VSS 0.2p
XPVP33 CDLP33 VP GPP33 NGPP33 VDD33 VSS gf180_tg_lowq
XPVN33 CDLP33 VN GPN33 NGPN33 VDD33 VSS gf180_tg_lowq
XNVP33 CDLN33 VP GNP33 NGNP33 VDD33 VSS gf180_tg_lowq
XNVN33 CDLN33 VN GNN33 NGNN33 VDD33 VSS gf180_tg_lowq
XDPC33 CDLP33 VCM_REF PH1 NPH1 VDD33 VSS gf180_tg_lowq
XDNC33 CDLN33 VCM_REF PH1 NPH1 VDD33 VSS gf180_tg_lowq
* DAC unit 34
CDP34 CDLP34 CDRP34 {CU}
CDN34 CDLN34 CDRN34 {CU}
XDP134 CDRP34 VCM_REF PH1 NPH1 VDD33 VSS gf180_tg_lowq
XDP234 CDRP34 INP PH2 NPH2 VDD33 VSS gf180_tg_lowq
XDN134 CDRN34 VCM_REF PH1 NPH1 VDD33 VSS gf180_tg_lowq
XDN234 CDRN34 INN PH2 NPH2 VDD33 VSS gf180_tg_lowq
BGPP34 GPP34 VSS I=(v(GPP34)-v(PH2)*v(S2P34)/v(VDD33))/1k
BGPN34 GPN34 VSS I=(v(GPN34)-v(PH2)*(v(VDD33)-v(S2P34))/v(VDD33))/1k
BGNP34 GNP34 VSS I=(v(GNP34)-v(PH2)*v(S2N34)/v(VDD33))/1k
BGNN34 GNN34 VSS I=(v(GNN34)-v(PH2)*(v(VDD33)-v(S2N34))/v(VDD33))/1k
BNOPP34 NGPP34 0 V=v(VDD33)-v(GPP34)
BNOPN34 NGPN34 0 V=v(VDD33)-v(GPN34)
BNONP34 NGNP34 0 V=v(VDD33)-v(GNP34)
BNONN34 NGNN34 0 V=v(VDD33)-v(GNN34)
CGPP34 GPP34 VSS 2p
CGPN34 GPN34 VSS 2p
CGNP34 GNP34 VSS 2p
CGNN34 GNN34 VSS 2p
CNGPP34 NGPP34 VSS 0.2p
CNGPN34 NGPN34 VSS 0.2p
CNGNP34 NGNP34 VSS 0.2p
CNGNN34 NGNN34 VSS 0.2p
XPVP34 CDLP34 VP GPP34 NGPP34 VDD33 VSS gf180_tg_lowq
XPVN34 CDLP34 VN GPN34 NGPN34 VDD33 VSS gf180_tg_lowq
XNVP34 CDLN34 VP GNP34 NGNP34 VDD33 VSS gf180_tg_lowq
XNVN34 CDLN34 VN GNN34 NGNN34 VDD33 VSS gf180_tg_lowq
XDPC34 CDLP34 VCM_REF PH1 NPH1 VDD33 VSS gf180_tg_lowq
XDNC34 CDLN34 VCM_REF PH1 NPH1 VDD33 VSS gf180_tg_lowq
* DAC unit 35
CDP35 CDLP35 CDRP35 {CU}
CDN35 CDLN35 CDRN35 {CU}
XDP135 CDRP35 VCM_REF PH1 NPH1 VDD33 VSS gf180_tg_lowq
XDP235 CDRP35 INP PH2 NPH2 VDD33 VSS gf180_tg_lowq
XDN135 CDRN35 VCM_REF PH1 NPH1 VDD33 VSS gf180_tg_lowq
XDN235 CDRN35 INN PH2 NPH2 VDD33 VSS gf180_tg_lowq
BGPP35 GPP35 VSS I=(v(GPP35)-v(PH2)*v(S2P35)/v(VDD33))/1k
BGPN35 GPN35 VSS I=(v(GPN35)-v(PH2)*(v(VDD33)-v(S2P35))/v(VDD33))/1k
BGNP35 GNP35 VSS I=(v(GNP35)-v(PH2)*v(S2N35)/v(VDD33))/1k
BGNN35 GNN35 VSS I=(v(GNN35)-v(PH2)*(v(VDD33)-v(S2N35))/v(VDD33))/1k
BNOPP35 NGPP35 0 V=v(VDD33)-v(GPP35)
BNOPN35 NGPN35 0 V=v(VDD33)-v(GPN35)
BNONP35 NGNP35 0 V=v(VDD33)-v(GNP35)
BNONN35 NGNN35 0 V=v(VDD33)-v(GNN35)
CGPP35 GPP35 VSS 2p
CGPN35 GPN35 VSS 2p
CGNP35 GNP35 VSS 2p
CGNN35 GNN35 VSS 2p
CNGPP35 NGPP35 VSS 0.2p
CNGPN35 NGPN35 VSS 0.2p
CNGNP35 NGNP35 VSS 0.2p
CNGNN35 NGNN35 VSS 0.2p
XPVP35 CDLP35 VP GPP35 NGPP35 VDD33 VSS gf180_tg_lowq
XPVN35 CDLP35 VN GPN35 NGPN35 VDD33 VSS gf180_tg_lowq
XNVP35 CDLN35 VP GNP35 NGNP35 VDD33 VSS gf180_tg_lowq
XNVN35 CDLN35 VN GNN35 NGNN35 VDD33 VSS gf180_tg_lowq
XDPC35 CDLP35 VCM_REF PH1 NPH1 VDD33 VSS gf180_tg_lowq
XDNC35 CDLN35 VCM_REF PH1 NPH1 VDD33 VSS gf180_tg_lowq
* DAC unit 36
CDP36 CDLP36 CDRP36 {CU}
CDN36 CDLN36 CDRN36 {CU}
XDP136 CDRP36 VCM_REF PH1 NPH1 VDD33 VSS gf180_tg_lowq
XDP236 CDRP36 INP PH2 NPH2 VDD33 VSS gf180_tg_lowq
XDN136 CDRN36 VCM_REF PH1 NPH1 VDD33 VSS gf180_tg_lowq
XDN236 CDRN36 INN PH2 NPH2 VDD33 VSS gf180_tg_lowq
BGPP36 GPP36 VSS I=(v(GPP36)-v(PH2)*v(S2P36)/v(VDD33))/1k
BGPN36 GPN36 VSS I=(v(GPN36)-v(PH2)*(v(VDD33)-v(S2P36))/v(VDD33))/1k
BGNP36 GNP36 VSS I=(v(GNP36)-v(PH2)*v(S2N36)/v(VDD33))/1k
BGNN36 GNN36 VSS I=(v(GNN36)-v(PH2)*(v(VDD33)-v(S2N36))/v(VDD33))/1k
BNOPP36 NGPP36 0 V=v(VDD33)-v(GPP36)
BNOPN36 NGPN36 0 V=v(VDD33)-v(GPN36)
BNONP36 NGNP36 0 V=v(VDD33)-v(GNP36)
BNONN36 NGNN36 0 V=v(VDD33)-v(GNN36)
CGPP36 GPP36 VSS 2p
CGPN36 GPN36 VSS 2p
CGNP36 GNP36 VSS 2p
CGNN36 GNN36 VSS 2p
CNGPP36 NGPP36 VSS 0.2p
CNGPN36 NGPN36 VSS 0.2p
CNGNP36 NGNP36 VSS 0.2p
CNGNN36 NGNN36 VSS 0.2p
XPVP36 CDLP36 VP GPP36 NGPP36 VDD33 VSS gf180_tg_lowq
XPVN36 CDLP36 VN GPN36 NGPN36 VDD33 VSS gf180_tg_lowq
XNVP36 CDLN36 VP GNP36 NGNP36 VDD33 VSS gf180_tg_lowq
XNVN36 CDLN36 VN GNN36 NGNN36 VDD33 VSS gf180_tg_lowq
XDPC36 CDLP36 VCM_REF PH1 NPH1 VDD33 VSS gf180_tg_lowq
XDNC36 CDLN36 VCM_REF PH1 NPH1 VDD33 VSS gf180_tg_lowq
* DAC unit 37
CDP37 CDLP37 CDRP37 {CU}
CDN37 CDLN37 CDRN37 {CU}
XDP137 CDRP37 VCM_REF PH1 NPH1 VDD33 VSS gf180_tg_lowq
XDP237 CDRP37 INP PH2 NPH2 VDD33 VSS gf180_tg_lowq
XDN137 CDRN37 VCM_REF PH1 NPH1 VDD33 VSS gf180_tg_lowq
XDN237 CDRN37 INN PH2 NPH2 VDD33 VSS gf180_tg_lowq
BGPP37 GPP37 VSS I=(v(GPP37)-v(PH2)*v(S2P37)/v(VDD33))/1k
BGPN37 GPN37 VSS I=(v(GPN37)-v(PH2)*(v(VDD33)-v(S2P37))/v(VDD33))/1k
BGNP37 GNP37 VSS I=(v(GNP37)-v(PH2)*v(S2N37)/v(VDD33))/1k
BGNN37 GNN37 VSS I=(v(GNN37)-v(PH2)*(v(VDD33)-v(S2N37))/v(VDD33))/1k
BNOPP37 NGPP37 0 V=v(VDD33)-v(GPP37)
BNOPN37 NGPN37 0 V=v(VDD33)-v(GPN37)
BNONP37 NGNP37 0 V=v(VDD33)-v(GNP37)
BNONN37 NGNN37 0 V=v(VDD33)-v(GNN37)
CGPP37 GPP37 VSS 2p
CGPN37 GPN37 VSS 2p
CGNP37 GNP37 VSS 2p
CGNN37 GNN37 VSS 2p
CNGPP37 NGPP37 VSS 0.2p
CNGPN37 NGPN37 VSS 0.2p
CNGNP37 NGNP37 VSS 0.2p
CNGNN37 NGNN37 VSS 0.2p
XPVP37 CDLP37 VP GPP37 NGPP37 VDD33 VSS gf180_tg_lowq
XPVN37 CDLP37 VN GPN37 NGPN37 VDD33 VSS gf180_tg_lowq
XNVP37 CDLN37 VP GNP37 NGNP37 VDD33 VSS gf180_tg_lowq
XNVN37 CDLN37 VN GNN37 NGNN37 VDD33 VSS gf180_tg_lowq
XDPC37 CDLP37 VCM_REF PH1 NPH1 VDD33 VSS gf180_tg_lowq
XDNC37 CDLN37 VCM_REF PH1 NPH1 VDD33 VSS gf180_tg_lowq
* DAC unit 38
CDP38 CDLP38 CDRP38 {CU}
CDN38 CDLN38 CDRN38 {CU}
XDP138 CDRP38 VCM_REF PH1 NPH1 VDD33 VSS gf180_tg_lowq
XDP238 CDRP38 INP PH2 NPH2 VDD33 VSS gf180_tg_lowq
XDN138 CDRN38 VCM_REF PH1 NPH1 VDD33 VSS gf180_tg_lowq
XDN238 CDRN38 INN PH2 NPH2 VDD33 VSS gf180_tg_lowq
BGPP38 GPP38 VSS I=(v(GPP38)-v(PH2)*v(S2P38)/v(VDD33))/1k
BGPN38 GPN38 VSS I=(v(GPN38)-v(PH2)*(v(VDD33)-v(S2P38))/v(VDD33))/1k
BGNP38 GNP38 VSS I=(v(GNP38)-v(PH2)*v(S2N38)/v(VDD33))/1k
BGNN38 GNN38 VSS I=(v(GNN38)-v(PH2)*(v(VDD33)-v(S2N38))/v(VDD33))/1k
BNOPP38 NGPP38 0 V=v(VDD33)-v(GPP38)
BNOPN38 NGPN38 0 V=v(VDD33)-v(GPN38)
BNONP38 NGNP38 0 V=v(VDD33)-v(GNP38)
BNONN38 NGNN38 0 V=v(VDD33)-v(GNN38)
CGPP38 GPP38 VSS 2p
CGPN38 GPN38 VSS 2p
CGNP38 GNP38 VSS 2p
CGNN38 GNN38 VSS 2p
CNGPP38 NGPP38 VSS 0.2p
CNGPN38 NGPN38 VSS 0.2p
CNGNP38 NGNP38 VSS 0.2p
CNGNN38 NGNN38 VSS 0.2p
XPVP38 CDLP38 VP GPP38 NGPP38 VDD33 VSS gf180_tg_lowq
XPVN38 CDLP38 VN GPN38 NGPN38 VDD33 VSS gf180_tg_lowq
XNVP38 CDLN38 VP GNP38 NGNP38 VDD33 VSS gf180_tg_lowq
XNVN38 CDLN38 VN GNN38 NGNN38 VDD33 VSS gf180_tg_lowq
XDPC38 CDLP38 VCM_REF PH1 NPH1 VDD33 VSS gf180_tg_lowq
XDNC38 CDLN38 VCM_REF PH1 NPH1 VDD33 VSS gf180_tg_lowq
* DAC unit 39
CDP39 CDLP39 CDRP39 {CU}
CDN39 CDLN39 CDRN39 {CU}
XDP139 CDRP39 VCM_REF PH1 NPH1 VDD33 VSS gf180_tg_lowq
XDP239 CDRP39 INP PH2 NPH2 VDD33 VSS gf180_tg_lowq
XDN139 CDRN39 VCM_REF PH1 NPH1 VDD33 VSS gf180_tg_lowq
XDN239 CDRN39 INN PH2 NPH2 VDD33 VSS gf180_tg_lowq
BGPP39 GPP39 VSS I=(v(GPP39)-v(PH2)*v(S2P39)/v(VDD33))/1k
BGPN39 GPN39 VSS I=(v(GPN39)-v(PH2)*(v(VDD33)-v(S2P39))/v(VDD33))/1k
BGNP39 GNP39 VSS I=(v(GNP39)-v(PH2)*v(S2N39)/v(VDD33))/1k
BGNN39 GNN39 VSS I=(v(GNN39)-v(PH2)*(v(VDD33)-v(S2N39))/v(VDD33))/1k
BNOPP39 NGPP39 0 V=v(VDD33)-v(GPP39)
BNOPN39 NGPN39 0 V=v(VDD33)-v(GPN39)
BNONP39 NGNP39 0 V=v(VDD33)-v(GNP39)
BNONN39 NGNN39 0 V=v(VDD33)-v(GNN39)
CGPP39 GPP39 VSS 2p
CGPN39 GPN39 VSS 2p
CGNP39 GNP39 VSS 2p
CGNN39 GNN39 VSS 2p
CNGPP39 NGPP39 VSS 0.2p
CNGPN39 NGPN39 VSS 0.2p
CNGNP39 NGNP39 VSS 0.2p
CNGNN39 NGNN39 VSS 0.2p
XPVP39 CDLP39 VP GPP39 NGPP39 VDD33 VSS gf180_tg_lowq
XPVN39 CDLP39 VN GPN39 NGPN39 VDD33 VSS gf180_tg_lowq
XNVP39 CDLN39 VP GNP39 NGNP39 VDD33 VSS gf180_tg_lowq
XNVN39 CDLN39 VN GNN39 NGNN39 VDD33 VSS gf180_tg_lowq
XDPC39 CDLP39 VCM_REF PH1 NPH1 VDD33 VSS gf180_tg_lowq
XDNC39 CDLN39 VCM_REF PH1 NPH1 VDD33 VSS gf180_tg_lowq
* DAC unit 40
CDP40 CDLP40 CDRP40 {CU}
CDN40 CDLN40 CDRN40 {CU}
XDP140 CDRP40 VCM_REF PH1 NPH1 VDD33 VSS gf180_tg_lowq
XDP240 CDRP40 INP PH2 NPH2 VDD33 VSS gf180_tg_lowq
XDN140 CDRN40 VCM_REF PH1 NPH1 VDD33 VSS gf180_tg_lowq
XDN240 CDRN40 INN PH2 NPH2 VDD33 VSS gf180_tg_lowq
BGPP40 GPP40 VSS I=(v(GPP40)-v(PH2)*v(S2P40)/v(VDD33))/1k
BGPN40 GPN40 VSS I=(v(GPN40)-v(PH2)*(v(VDD33)-v(S2P40))/v(VDD33))/1k
BGNP40 GNP40 VSS I=(v(GNP40)-v(PH2)*v(S2N40)/v(VDD33))/1k
BGNN40 GNN40 VSS I=(v(GNN40)-v(PH2)*(v(VDD33)-v(S2N40))/v(VDD33))/1k
BNOPP40 NGPP40 0 V=v(VDD33)-v(GPP40)
BNOPN40 NGPN40 0 V=v(VDD33)-v(GPN40)
BNONP40 NGNP40 0 V=v(VDD33)-v(GNP40)
BNONN40 NGNN40 0 V=v(VDD33)-v(GNN40)
CGPP40 GPP40 VSS 2p
CGPN40 GPN40 VSS 2p
CGNP40 GNP40 VSS 2p
CGNN40 GNN40 VSS 2p
CNGPP40 NGPP40 VSS 0.2p
CNGPN40 NGPN40 VSS 0.2p
CNGNP40 NGNP40 VSS 0.2p
CNGNN40 NGNN40 VSS 0.2p
XPVP40 CDLP40 VP GPP40 NGPP40 VDD33 VSS gf180_tg_lowq
XPVN40 CDLP40 VN GPN40 NGPN40 VDD33 VSS gf180_tg_lowq
XNVP40 CDLN40 VP GNP40 NGNP40 VDD33 VSS gf180_tg_lowq
XNVN40 CDLN40 VN GNN40 NGNN40 VDD33 VSS gf180_tg_lowq
XDPC40 CDLP40 VCM_REF PH1 NPH1 VDD33 VSS gf180_tg_lowq
XDNC40 CDLN40 VCM_REF PH1 NPH1 VDD33 VSS gf180_tg_lowq
* DAC unit 41
CDP41 CDLP41 CDRP41 {CU}
CDN41 CDLN41 CDRN41 {CU}
XDP141 CDRP41 VCM_REF PH1 NPH1 VDD33 VSS gf180_tg_lowq
XDP241 CDRP41 INP PH2 NPH2 VDD33 VSS gf180_tg_lowq
XDN141 CDRN41 VCM_REF PH1 NPH1 VDD33 VSS gf180_tg_lowq
XDN241 CDRN41 INN PH2 NPH2 VDD33 VSS gf180_tg_lowq
BGPP41 GPP41 VSS I=(v(GPP41)-v(PH2)*v(S2P41)/v(VDD33))/1k
BGPN41 GPN41 VSS I=(v(GPN41)-v(PH2)*(v(VDD33)-v(S2P41))/v(VDD33))/1k
BGNP41 GNP41 VSS I=(v(GNP41)-v(PH2)*v(S2N41)/v(VDD33))/1k
BGNN41 GNN41 VSS I=(v(GNN41)-v(PH2)*(v(VDD33)-v(S2N41))/v(VDD33))/1k
BNOPP41 NGPP41 0 V=v(VDD33)-v(GPP41)
BNOPN41 NGPN41 0 V=v(VDD33)-v(GPN41)
BNONP41 NGNP41 0 V=v(VDD33)-v(GNP41)
BNONN41 NGNN41 0 V=v(VDD33)-v(GNN41)
CGPP41 GPP41 VSS 2p
CGPN41 GPN41 VSS 2p
CGNP41 GNP41 VSS 2p
CGNN41 GNN41 VSS 2p
CNGPP41 NGPP41 VSS 0.2p
CNGPN41 NGPN41 VSS 0.2p
CNGNP41 NGNP41 VSS 0.2p
CNGNN41 NGNN41 VSS 0.2p
XPVP41 CDLP41 VP GPP41 NGPP41 VDD33 VSS gf180_tg_lowq
XPVN41 CDLP41 VN GPN41 NGPN41 VDD33 VSS gf180_tg_lowq
XNVP41 CDLN41 VP GNP41 NGNP41 VDD33 VSS gf180_tg_lowq
XNVN41 CDLN41 VN GNN41 NGNN41 VDD33 VSS gf180_tg_lowq
XDPC41 CDLP41 VCM_REF PH1 NPH1 VDD33 VSS gf180_tg_lowq
XDNC41 CDLN41 VCM_REF PH1 NPH1 VDD33 VSS gf180_tg_lowq
* DAC unit 42
CDP42 CDLP42 CDRP42 {CU}
CDN42 CDLN42 CDRN42 {CU}
XDP142 CDRP42 VCM_REF PH1 NPH1 VDD33 VSS gf180_tg_lowq
XDP242 CDRP42 INP PH2 NPH2 VDD33 VSS gf180_tg_lowq
XDN142 CDRN42 VCM_REF PH1 NPH1 VDD33 VSS gf180_tg_lowq
XDN242 CDRN42 INN PH2 NPH2 VDD33 VSS gf180_tg_lowq
BGPP42 GPP42 VSS I=(v(GPP42)-v(PH2)*v(S2P42)/v(VDD33))/1k
BGPN42 GPN42 VSS I=(v(GPN42)-v(PH2)*(v(VDD33)-v(S2P42))/v(VDD33))/1k
BGNP42 GNP42 VSS I=(v(GNP42)-v(PH2)*v(S2N42)/v(VDD33))/1k
BGNN42 GNN42 VSS I=(v(GNN42)-v(PH2)*(v(VDD33)-v(S2N42))/v(VDD33))/1k
BNOPP42 NGPP42 0 V=v(VDD33)-v(GPP42)
BNOPN42 NGPN42 0 V=v(VDD33)-v(GPN42)
BNONP42 NGNP42 0 V=v(VDD33)-v(GNP42)
BNONN42 NGNN42 0 V=v(VDD33)-v(GNN42)
CGPP42 GPP42 VSS 2p
CGPN42 GPN42 VSS 2p
CGNP42 GNP42 VSS 2p
CGNN42 GNN42 VSS 2p
CNGPP42 NGPP42 VSS 0.2p
CNGPN42 NGPN42 VSS 0.2p
CNGNP42 NGNP42 VSS 0.2p
CNGNN42 NGNN42 VSS 0.2p
XPVP42 CDLP42 VP GPP42 NGPP42 VDD33 VSS gf180_tg_lowq
XPVN42 CDLP42 VN GPN42 NGPN42 VDD33 VSS gf180_tg_lowq
XNVP42 CDLN42 VP GNP42 NGNP42 VDD33 VSS gf180_tg_lowq
XNVN42 CDLN42 VN GNN42 NGNN42 VDD33 VSS gf180_tg_lowq
XDPC42 CDLP42 VCM_REF PH1 NPH1 VDD33 VSS gf180_tg_lowq
XDNC42 CDLN42 VCM_REF PH1 NPH1 VDD33 VSS gf180_tg_lowq
* DAC unit 43
CDP43 CDLP43 CDRP43 {CU}
CDN43 CDLN43 CDRN43 {CU}
XDP143 CDRP43 VCM_REF PH1 NPH1 VDD33 VSS gf180_tg_lowq
XDP243 CDRP43 INP PH2 NPH2 VDD33 VSS gf180_tg_lowq
XDN143 CDRN43 VCM_REF PH1 NPH1 VDD33 VSS gf180_tg_lowq
XDN243 CDRN43 INN PH2 NPH2 VDD33 VSS gf180_tg_lowq
BGPP43 GPP43 VSS I=(v(GPP43)-v(PH2)*v(S2P43)/v(VDD33))/1k
BGPN43 GPN43 VSS I=(v(GPN43)-v(PH2)*(v(VDD33)-v(S2P43))/v(VDD33))/1k
BGNP43 GNP43 VSS I=(v(GNP43)-v(PH2)*v(S2N43)/v(VDD33))/1k
BGNN43 GNN43 VSS I=(v(GNN43)-v(PH2)*(v(VDD33)-v(S2N43))/v(VDD33))/1k
BNOPP43 NGPP43 0 V=v(VDD33)-v(GPP43)
BNOPN43 NGPN43 0 V=v(VDD33)-v(GPN43)
BNONP43 NGNP43 0 V=v(VDD33)-v(GNP43)
BNONN43 NGNN43 0 V=v(VDD33)-v(GNN43)
CGPP43 GPP43 VSS 2p
CGPN43 GPN43 VSS 2p
CGNP43 GNP43 VSS 2p
CGNN43 GNN43 VSS 2p
CNGPP43 NGPP43 VSS 0.2p
CNGPN43 NGPN43 VSS 0.2p
CNGNP43 NGNP43 VSS 0.2p
CNGNN43 NGNN43 VSS 0.2p
XPVP43 CDLP43 VP GPP43 NGPP43 VDD33 VSS gf180_tg_lowq
XPVN43 CDLP43 VN GPN43 NGPN43 VDD33 VSS gf180_tg_lowq
XNVP43 CDLN43 VP GNP43 NGNP43 VDD33 VSS gf180_tg_lowq
XNVN43 CDLN43 VN GNN43 NGNN43 VDD33 VSS gf180_tg_lowq
XDPC43 CDLP43 VCM_REF PH1 NPH1 VDD33 VSS gf180_tg_lowq
XDNC43 CDLN43 VCM_REF PH1 NPH1 VDD33 VSS gf180_tg_lowq
* DAC unit 44
CDP44 CDLP44 CDRP44 {CU}
CDN44 CDLN44 CDRN44 {CU}
XDP144 CDRP44 VCM_REF PH1 NPH1 VDD33 VSS gf180_tg_lowq
XDP244 CDRP44 INP PH2 NPH2 VDD33 VSS gf180_tg_lowq
XDN144 CDRN44 VCM_REF PH1 NPH1 VDD33 VSS gf180_tg_lowq
XDN244 CDRN44 INN PH2 NPH2 VDD33 VSS gf180_tg_lowq
BGPP44 GPP44 VSS I=(v(GPP44)-v(PH2)*v(S2P44)/v(VDD33))/1k
BGPN44 GPN44 VSS I=(v(GPN44)-v(PH2)*(v(VDD33)-v(S2P44))/v(VDD33))/1k
BGNP44 GNP44 VSS I=(v(GNP44)-v(PH2)*v(S2N44)/v(VDD33))/1k
BGNN44 GNN44 VSS I=(v(GNN44)-v(PH2)*(v(VDD33)-v(S2N44))/v(VDD33))/1k
BNOPP44 NGPP44 0 V=v(VDD33)-v(GPP44)
BNOPN44 NGPN44 0 V=v(VDD33)-v(GPN44)
BNONP44 NGNP44 0 V=v(VDD33)-v(GNP44)
BNONN44 NGNN44 0 V=v(VDD33)-v(GNN44)
CGPP44 GPP44 VSS 2p
CGPN44 GPN44 VSS 2p
CGNP44 GNP44 VSS 2p
CGNN44 GNN44 VSS 2p
CNGPP44 NGPP44 VSS 0.2p
CNGPN44 NGPN44 VSS 0.2p
CNGNP44 NGNP44 VSS 0.2p
CNGNN44 NGNN44 VSS 0.2p
XPVP44 CDLP44 VP GPP44 NGPP44 VDD33 VSS gf180_tg_lowq
XPVN44 CDLP44 VN GPN44 NGPN44 VDD33 VSS gf180_tg_lowq
XNVP44 CDLN44 VP GNP44 NGNP44 VDD33 VSS gf180_tg_lowq
XNVN44 CDLN44 VN GNN44 NGNN44 VDD33 VSS gf180_tg_lowq
XDPC44 CDLP44 VCM_REF PH1 NPH1 VDD33 VSS gf180_tg_lowq
XDNC44 CDLN44 VCM_REF PH1 NPH1 VDD33 VSS gf180_tg_lowq
* DAC unit 45
CDP45 CDLP45 CDRP45 {CU}
CDN45 CDLN45 CDRN45 {CU}
XDP145 CDRP45 VCM_REF PH1 NPH1 VDD33 VSS gf180_tg_lowq
XDP245 CDRP45 INP PH2 NPH2 VDD33 VSS gf180_tg_lowq
XDN145 CDRN45 VCM_REF PH1 NPH1 VDD33 VSS gf180_tg_lowq
XDN245 CDRN45 INN PH2 NPH2 VDD33 VSS gf180_tg_lowq
BGPP45 GPP45 VSS I=(v(GPP45)-v(PH2)*v(S2P45)/v(VDD33))/1k
BGPN45 GPN45 VSS I=(v(GPN45)-v(PH2)*(v(VDD33)-v(S2P45))/v(VDD33))/1k
BGNP45 GNP45 VSS I=(v(GNP45)-v(PH2)*v(S2N45)/v(VDD33))/1k
BGNN45 GNN45 VSS I=(v(GNN45)-v(PH2)*(v(VDD33)-v(S2N45))/v(VDD33))/1k
BNOPP45 NGPP45 0 V=v(VDD33)-v(GPP45)
BNOPN45 NGPN45 0 V=v(VDD33)-v(GPN45)
BNONP45 NGNP45 0 V=v(VDD33)-v(GNP45)
BNONN45 NGNN45 0 V=v(VDD33)-v(GNN45)
CGPP45 GPP45 VSS 2p
CGPN45 GPN45 VSS 2p
CGNP45 GNP45 VSS 2p
CGNN45 GNN45 VSS 2p
CNGPP45 NGPP45 VSS 0.2p
CNGPN45 NGPN45 VSS 0.2p
CNGNP45 NGNP45 VSS 0.2p
CNGNN45 NGNN45 VSS 0.2p
XPVP45 CDLP45 VP GPP45 NGPP45 VDD33 VSS gf180_tg_lowq
XPVN45 CDLP45 VN GPN45 NGPN45 VDD33 VSS gf180_tg_lowq
XNVP45 CDLN45 VP GNP45 NGNP45 VDD33 VSS gf180_tg_lowq
XNVN45 CDLN45 VN GNN45 NGNN45 VDD33 VSS gf180_tg_lowq
XDPC45 CDLP45 VCM_REF PH1 NPH1 VDD33 VSS gf180_tg_lowq
XDNC45 CDLN45 VCM_REF PH1 NPH1 VDD33 VSS gf180_tg_lowq
* DAC unit 46
CDP46 CDLP46 CDRP46 {CU}
CDN46 CDLN46 CDRN46 {CU}
XDP146 CDRP46 VCM_REF PH1 NPH1 VDD33 VSS gf180_tg_lowq
XDP246 CDRP46 INP PH2 NPH2 VDD33 VSS gf180_tg_lowq
XDN146 CDRN46 VCM_REF PH1 NPH1 VDD33 VSS gf180_tg_lowq
XDN246 CDRN46 INN PH2 NPH2 VDD33 VSS gf180_tg_lowq
BGPP46 GPP46 VSS I=(v(GPP46)-v(PH2)*v(S2P46)/v(VDD33))/1k
BGPN46 GPN46 VSS I=(v(GPN46)-v(PH2)*(v(VDD33)-v(S2P46))/v(VDD33))/1k
BGNP46 GNP46 VSS I=(v(GNP46)-v(PH2)*v(S2N46)/v(VDD33))/1k
BGNN46 GNN46 VSS I=(v(GNN46)-v(PH2)*(v(VDD33)-v(S2N46))/v(VDD33))/1k
BNOPP46 NGPP46 0 V=v(VDD33)-v(GPP46)
BNOPN46 NGPN46 0 V=v(VDD33)-v(GPN46)
BNONP46 NGNP46 0 V=v(VDD33)-v(GNP46)
BNONN46 NGNN46 0 V=v(VDD33)-v(GNN46)
CGPP46 GPP46 VSS 2p
CGPN46 GPN46 VSS 2p
CGNP46 GNP46 VSS 2p
CGNN46 GNN46 VSS 2p
CNGPP46 NGPP46 VSS 0.2p
CNGPN46 NGPN46 VSS 0.2p
CNGNP46 NGNP46 VSS 0.2p
CNGNN46 NGNN46 VSS 0.2p
XPVP46 CDLP46 VP GPP46 NGPP46 VDD33 VSS gf180_tg_lowq
XPVN46 CDLP46 VN GPN46 NGPN46 VDD33 VSS gf180_tg_lowq
XNVP46 CDLN46 VP GNP46 NGNP46 VDD33 VSS gf180_tg_lowq
XNVN46 CDLN46 VN GNN46 NGNN46 VDD33 VSS gf180_tg_lowq
XDPC46 CDLP46 VCM_REF PH1 NPH1 VDD33 VSS gf180_tg_lowq
XDNC46 CDLN46 VCM_REF PH1 NPH1 VDD33 VSS gf180_tg_lowq
* DAC unit 47
CDP47 CDLP47 CDRP47 {CU}
CDN47 CDLN47 CDRN47 {CU}
XDP147 CDRP47 VCM_REF PH1 NPH1 VDD33 VSS gf180_tg_lowq
XDP247 CDRP47 INP PH2 NPH2 VDD33 VSS gf180_tg_lowq
XDN147 CDRN47 VCM_REF PH1 NPH1 VDD33 VSS gf180_tg_lowq
XDN247 CDRN47 INN PH2 NPH2 VDD33 VSS gf180_tg_lowq
BGPP47 GPP47 VSS I=(v(GPP47)-v(PH2)*v(S2P47)/v(VDD33))/1k
BGPN47 GPN47 VSS I=(v(GPN47)-v(PH2)*(v(VDD33)-v(S2P47))/v(VDD33))/1k
BGNP47 GNP47 VSS I=(v(GNP47)-v(PH2)*v(S2N47)/v(VDD33))/1k
BGNN47 GNN47 VSS I=(v(GNN47)-v(PH2)*(v(VDD33)-v(S2N47))/v(VDD33))/1k
BNOPP47 NGPP47 0 V=v(VDD33)-v(GPP47)
BNOPN47 NGPN47 0 V=v(VDD33)-v(GPN47)
BNONP47 NGNP47 0 V=v(VDD33)-v(GNP47)
BNONN47 NGNN47 0 V=v(VDD33)-v(GNN47)
CGPP47 GPP47 VSS 2p
CGPN47 GPN47 VSS 2p
CGNP47 GNP47 VSS 2p
CGNN47 GNN47 VSS 2p
CNGPP47 NGPP47 VSS 0.2p
CNGPN47 NGPN47 VSS 0.2p
CNGNP47 NGNP47 VSS 0.2p
CNGNN47 NGNN47 VSS 0.2p
XPVP47 CDLP47 VP GPP47 NGPP47 VDD33 VSS gf180_tg_lowq
XPVN47 CDLP47 VN GPN47 NGPN47 VDD33 VSS gf180_tg_lowq
XNVP47 CDLN47 VP GNP47 NGNP47 VDD33 VSS gf180_tg_lowq
XNVN47 CDLN47 VN GNN47 NGNN47 VDD33 VSS gf180_tg_lowq
XDPC47 CDLP47 VCM_REF PH1 NPH1 VDD33 VSS gf180_tg_lowq
XDNC47 CDLN47 VCM_REF PH1 NPH1 VDD33 VSS gf180_tg_lowq
* DAC unit 48
CDP48 CDLP48 CDRP48 {CU}
CDN48 CDLN48 CDRN48 {CU}
XDP148 CDRP48 VCM_REF PH1 NPH1 VDD33 VSS gf180_tg_lowq
XDP248 CDRP48 INP PH2 NPH2 VDD33 VSS gf180_tg_lowq
XDN148 CDRN48 VCM_REF PH1 NPH1 VDD33 VSS gf180_tg_lowq
XDN248 CDRN48 INN PH2 NPH2 VDD33 VSS gf180_tg_lowq
BGPP48 GPP48 VSS I=(v(GPP48)-v(PH2)*v(S2P48)/v(VDD33))/1k
BGPN48 GPN48 VSS I=(v(GPN48)-v(PH2)*(v(VDD33)-v(S2P48))/v(VDD33))/1k
BGNP48 GNP48 VSS I=(v(GNP48)-v(PH2)*v(S2N48)/v(VDD33))/1k
BGNN48 GNN48 VSS I=(v(GNN48)-v(PH2)*(v(VDD33)-v(S2N48))/v(VDD33))/1k
BNOPP48 NGPP48 0 V=v(VDD33)-v(GPP48)
BNOPN48 NGPN48 0 V=v(VDD33)-v(GPN48)
BNONP48 NGNP48 0 V=v(VDD33)-v(GNP48)
BNONN48 NGNN48 0 V=v(VDD33)-v(GNN48)
CGPP48 GPP48 VSS 2p
CGPN48 GPN48 VSS 2p
CGNP48 GNP48 VSS 2p
CGNN48 GNN48 VSS 2p
CNGPP48 NGPP48 VSS 0.2p
CNGPN48 NGPN48 VSS 0.2p
CNGNP48 NGNP48 VSS 0.2p
CNGNN48 NGNN48 VSS 0.2p
XPVP48 CDLP48 VP GPP48 NGPP48 VDD33 VSS gf180_tg_lowq
XPVN48 CDLP48 VN GPN48 NGPN48 VDD33 VSS gf180_tg_lowq
XNVP48 CDLN48 VP GNP48 NGNP48 VDD33 VSS gf180_tg_lowq
XNVN48 CDLN48 VN GNN48 NGNN48 VDD33 VSS gf180_tg_lowq
XDPC48 CDLP48 VCM_REF PH1 NPH1 VDD33 VSS gf180_tg_lowq
XDNC48 CDLN48 VCM_REF PH1 NPH1 VDD33 VSS gf180_tg_lowq
* DAC unit 49
CDP49 CDLP49 CDRP49 {CU}
CDN49 CDLN49 CDRN49 {CU}
XDP149 CDRP49 VCM_REF PH1 NPH1 VDD33 VSS gf180_tg_lowq
XDP249 CDRP49 INP PH2 NPH2 VDD33 VSS gf180_tg_lowq
XDN149 CDRN49 VCM_REF PH1 NPH1 VDD33 VSS gf180_tg_lowq
XDN249 CDRN49 INN PH2 NPH2 VDD33 VSS gf180_tg_lowq
BGPP49 GPP49 VSS I=(v(GPP49)-v(PH2)*v(S2P49)/v(VDD33))/1k
BGPN49 GPN49 VSS I=(v(GPN49)-v(PH2)*(v(VDD33)-v(S2P49))/v(VDD33))/1k
BGNP49 GNP49 VSS I=(v(GNP49)-v(PH2)*v(S2N49)/v(VDD33))/1k
BGNN49 GNN49 VSS I=(v(GNN49)-v(PH2)*(v(VDD33)-v(S2N49))/v(VDD33))/1k
BNOPP49 NGPP49 0 V=v(VDD33)-v(GPP49)
BNOPN49 NGPN49 0 V=v(VDD33)-v(GPN49)
BNONP49 NGNP49 0 V=v(VDD33)-v(GNP49)
BNONN49 NGNN49 0 V=v(VDD33)-v(GNN49)
CGPP49 GPP49 VSS 2p
CGPN49 GPN49 VSS 2p
CGNP49 GNP49 VSS 2p
CGNN49 GNN49 VSS 2p
CNGPP49 NGPP49 VSS 0.2p
CNGPN49 NGPN49 VSS 0.2p
CNGNP49 NGNP49 VSS 0.2p
CNGNN49 NGNN49 VSS 0.2p
XPVP49 CDLP49 VP GPP49 NGPP49 VDD33 VSS gf180_tg_lowq
XPVN49 CDLP49 VN GPN49 NGPN49 VDD33 VSS gf180_tg_lowq
XNVP49 CDLN49 VP GNP49 NGNP49 VDD33 VSS gf180_tg_lowq
XNVN49 CDLN49 VN GNN49 NGNN49 VDD33 VSS gf180_tg_lowq
XDPC49 CDLP49 VCM_REF PH1 NPH1 VDD33 VSS gf180_tg_lowq
XDNC49 CDLN49 VCM_REF PH1 NPH1 VDD33 VSS gf180_tg_lowq
* DAC unit 50
CDP50 CDLP50 CDRP50 {CU}
CDN50 CDLN50 CDRN50 {CU}
XDP150 CDRP50 VCM_REF PH1 NPH1 VDD33 VSS gf180_tg_lowq
XDP250 CDRP50 INP PH2 NPH2 VDD33 VSS gf180_tg_lowq
XDN150 CDRN50 VCM_REF PH1 NPH1 VDD33 VSS gf180_tg_lowq
XDN250 CDRN50 INN PH2 NPH2 VDD33 VSS gf180_tg_lowq
BGPP50 GPP50 VSS I=(v(GPP50)-v(PH2)*v(S2P50)/v(VDD33))/1k
BGPN50 GPN50 VSS I=(v(GPN50)-v(PH2)*(v(VDD33)-v(S2P50))/v(VDD33))/1k
BGNP50 GNP50 VSS I=(v(GNP50)-v(PH2)*v(S2N50)/v(VDD33))/1k
BGNN50 GNN50 VSS I=(v(GNN50)-v(PH2)*(v(VDD33)-v(S2N50))/v(VDD33))/1k
BNOPP50 NGPP50 0 V=v(VDD33)-v(GPP50)
BNOPN50 NGPN50 0 V=v(VDD33)-v(GPN50)
BNONP50 NGNP50 0 V=v(VDD33)-v(GNP50)
BNONN50 NGNN50 0 V=v(VDD33)-v(GNN50)
CGPP50 GPP50 VSS 2p
CGPN50 GPN50 VSS 2p
CGNP50 GNP50 VSS 2p
CGNN50 GNN50 VSS 2p
CNGPP50 NGPP50 VSS 0.2p
CNGPN50 NGPN50 VSS 0.2p
CNGNP50 NGNP50 VSS 0.2p
CNGNN50 NGNN50 VSS 0.2p
XPVP50 CDLP50 VP GPP50 NGPP50 VDD33 VSS gf180_tg_lowq
XPVN50 CDLP50 VN GPN50 NGPN50 VDD33 VSS gf180_tg_lowq
XNVP50 CDLN50 VP GNP50 NGNP50 VDD33 VSS gf180_tg_lowq
XNVN50 CDLN50 VN GNN50 NGNN50 VDD33 VSS gf180_tg_lowq
XDPC50 CDLP50 VCM_REF PH1 NPH1 VDD33 VSS gf180_tg_lowq
XDNC50 CDLN50 VCM_REF PH1 NPH1 VDD33 VSS gf180_tg_lowq
* DAC unit 51
CDP51 CDLP51 CDRP51 {CU}
CDN51 CDLN51 CDRN51 {CU}
XDP151 CDRP51 VCM_REF PH1 NPH1 VDD33 VSS gf180_tg_lowq
XDP251 CDRP51 INP PH2 NPH2 VDD33 VSS gf180_tg_lowq
XDN151 CDRN51 VCM_REF PH1 NPH1 VDD33 VSS gf180_tg_lowq
XDN251 CDRN51 INN PH2 NPH2 VDD33 VSS gf180_tg_lowq
BGPP51 GPP51 VSS I=(v(GPP51)-v(PH2)*v(S2P51)/v(VDD33))/1k
BGPN51 GPN51 VSS I=(v(GPN51)-v(PH2)*(v(VDD33)-v(S2P51))/v(VDD33))/1k
BGNP51 GNP51 VSS I=(v(GNP51)-v(PH2)*v(S2N51)/v(VDD33))/1k
BGNN51 GNN51 VSS I=(v(GNN51)-v(PH2)*(v(VDD33)-v(S2N51))/v(VDD33))/1k
BNOPP51 NGPP51 0 V=v(VDD33)-v(GPP51)
BNOPN51 NGPN51 0 V=v(VDD33)-v(GPN51)
BNONP51 NGNP51 0 V=v(VDD33)-v(GNP51)
BNONN51 NGNN51 0 V=v(VDD33)-v(GNN51)
CGPP51 GPP51 VSS 2p
CGPN51 GPN51 VSS 2p
CGNP51 GNP51 VSS 2p
CGNN51 GNN51 VSS 2p
CNGPP51 NGPP51 VSS 0.2p
CNGPN51 NGPN51 VSS 0.2p
CNGNP51 NGNP51 VSS 0.2p
CNGNN51 NGNN51 VSS 0.2p
XPVP51 CDLP51 VP GPP51 NGPP51 VDD33 VSS gf180_tg_lowq
XPVN51 CDLP51 VN GPN51 NGPN51 VDD33 VSS gf180_tg_lowq
XNVP51 CDLN51 VP GNP51 NGNP51 VDD33 VSS gf180_tg_lowq
XNVN51 CDLN51 VN GNN51 NGNN51 VDD33 VSS gf180_tg_lowq
XDPC51 CDLP51 VCM_REF PH1 NPH1 VDD33 VSS gf180_tg_lowq
XDNC51 CDLN51 VCM_REF PH1 NPH1 VDD33 VSS gf180_tg_lowq
* DAC unit 52
CDP52 CDLP52 CDRP52 {CU}
CDN52 CDLN52 CDRN52 {CU}
XDP152 CDRP52 VCM_REF PH1 NPH1 VDD33 VSS gf180_tg_lowq
XDP252 CDRP52 INP PH2 NPH2 VDD33 VSS gf180_tg_lowq
XDN152 CDRN52 VCM_REF PH1 NPH1 VDD33 VSS gf180_tg_lowq
XDN252 CDRN52 INN PH2 NPH2 VDD33 VSS gf180_tg_lowq
BGPP52 GPP52 VSS I=(v(GPP52)-v(PH2)*v(S2P52)/v(VDD33))/1k
BGPN52 GPN52 VSS I=(v(GPN52)-v(PH2)*(v(VDD33)-v(S2P52))/v(VDD33))/1k
BGNP52 GNP52 VSS I=(v(GNP52)-v(PH2)*v(S2N52)/v(VDD33))/1k
BGNN52 GNN52 VSS I=(v(GNN52)-v(PH2)*(v(VDD33)-v(S2N52))/v(VDD33))/1k
BNOPP52 NGPP52 0 V=v(VDD33)-v(GPP52)
BNOPN52 NGPN52 0 V=v(VDD33)-v(GPN52)
BNONP52 NGNP52 0 V=v(VDD33)-v(GNP52)
BNONN52 NGNN52 0 V=v(VDD33)-v(GNN52)
CGPP52 GPP52 VSS 2p
CGPN52 GPN52 VSS 2p
CGNP52 GNP52 VSS 2p
CGNN52 GNN52 VSS 2p
CNGPP52 NGPP52 VSS 0.2p
CNGPN52 NGPN52 VSS 0.2p
CNGNP52 NGNP52 VSS 0.2p
CNGNN52 NGNN52 VSS 0.2p
XPVP52 CDLP52 VP GPP52 NGPP52 VDD33 VSS gf180_tg_lowq
XPVN52 CDLP52 VN GPN52 NGPN52 VDD33 VSS gf180_tg_lowq
XNVP52 CDLN52 VP GNP52 NGNP52 VDD33 VSS gf180_tg_lowq
XNVN52 CDLN52 VN GNN52 NGNN52 VDD33 VSS gf180_tg_lowq
XDPC52 CDLP52 VCM_REF PH1 NPH1 VDD33 VSS gf180_tg_lowq
XDNC52 CDLN52 VCM_REF PH1 NPH1 VDD33 VSS gf180_tg_lowq
* DAC unit 53
CDP53 CDLP53 CDRP53 {CU}
CDN53 CDLN53 CDRN53 {CU}
XDP153 CDRP53 VCM_REF PH1 NPH1 VDD33 VSS gf180_tg_lowq
XDP253 CDRP53 INP PH2 NPH2 VDD33 VSS gf180_tg_lowq
XDN153 CDRN53 VCM_REF PH1 NPH1 VDD33 VSS gf180_tg_lowq
XDN253 CDRN53 INN PH2 NPH2 VDD33 VSS gf180_tg_lowq
BGPP53 GPP53 VSS I=(v(GPP53)-v(PH2)*v(S2P53)/v(VDD33))/1k
BGPN53 GPN53 VSS I=(v(GPN53)-v(PH2)*(v(VDD33)-v(S2P53))/v(VDD33))/1k
BGNP53 GNP53 VSS I=(v(GNP53)-v(PH2)*v(S2N53)/v(VDD33))/1k
BGNN53 GNN53 VSS I=(v(GNN53)-v(PH2)*(v(VDD33)-v(S2N53))/v(VDD33))/1k
BNOPP53 NGPP53 0 V=v(VDD33)-v(GPP53)
BNOPN53 NGPN53 0 V=v(VDD33)-v(GPN53)
BNONP53 NGNP53 0 V=v(VDD33)-v(GNP53)
BNONN53 NGNN53 0 V=v(VDD33)-v(GNN53)
CGPP53 GPP53 VSS 2p
CGPN53 GPN53 VSS 2p
CGNP53 GNP53 VSS 2p
CGNN53 GNN53 VSS 2p
CNGPP53 NGPP53 VSS 0.2p
CNGPN53 NGPN53 VSS 0.2p
CNGNP53 NGNP53 VSS 0.2p
CNGNN53 NGNN53 VSS 0.2p
XPVP53 CDLP53 VP GPP53 NGPP53 VDD33 VSS gf180_tg_lowq
XPVN53 CDLP53 VN GPN53 NGPN53 VDD33 VSS gf180_tg_lowq
XNVP53 CDLN53 VP GNP53 NGNP53 VDD33 VSS gf180_tg_lowq
XNVN53 CDLN53 VN GNN53 NGNN53 VDD33 VSS gf180_tg_lowq
XDPC53 CDLP53 VCM_REF PH1 NPH1 VDD33 VSS gf180_tg_lowq
XDNC53 CDLN53 VCM_REF PH1 NPH1 VDD33 VSS gf180_tg_lowq
* DAC unit 54
CDP54 CDLP54 CDRP54 {CU}
CDN54 CDLN54 CDRN54 {CU}
XDP154 CDRP54 VCM_REF PH1 NPH1 VDD33 VSS gf180_tg_lowq
XDP254 CDRP54 INP PH2 NPH2 VDD33 VSS gf180_tg_lowq
XDN154 CDRN54 VCM_REF PH1 NPH1 VDD33 VSS gf180_tg_lowq
XDN254 CDRN54 INN PH2 NPH2 VDD33 VSS gf180_tg_lowq
BGPP54 GPP54 VSS I=(v(GPP54)-v(PH2)*v(S2P54)/v(VDD33))/1k
BGPN54 GPN54 VSS I=(v(GPN54)-v(PH2)*(v(VDD33)-v(S2P54))/v(VDD33))/1k
BGNP54 GNP54 VSS I=(v(GNP54)-v(PH2)*v(S2N54)/v(VDD33))/1k
BGNN54 GNN54 VSS I=(v(GNN54)-v(PH2)*(v(VDD33)-v(S2N54))/v(VDD33))/1k
BNOPP54 NGPP54 0 V=v(VDD33)-v(GPP54)
BNOPN54 NGPN54 0 V=v(VDD33)-v(GPN54)
BNONP54 NGNP54 0 V=v(VDD33)-v(GNP54)
BNONN54 NGNN54 0 V=v(VDD33)-v(GNN54)
CGPP54 GPP54 VSS 2p
CGPN54 GPN54 VSS 2p
CGNP54 GNP54 VSS 2p
CGNN54 GNN54 VSS 2p
CNGPP54 NGPP54 VSS 0.2p
CNGPN54 NGPN54 VSS 0.2p
CNGNP54 NGNP54 VSS 0.2p
CNGNN54 NGNN54 VSS 0.2p
XPVP54 CDLP54 VP GPP54 NGPP54 VDD33 VSS gf180_tg_lowq
XPVN54 CDLP54 VN GPN54 NGPN54 VDD33 VSS gf180_tg_lowq
XNVP54 CDLN54 VP GNP54 NGNP54 VDD33 VSS gf180_tg_lowq
XNVN54 CDLN54 VN GNN54 NGNN54 VDD33 VSS gf180_tg_lowq
XDPC54 CDLP54 VCM_REF PH1 NPH1 VDD33 VSS gf180_tg_lowq
XDNC54 CDLN54 VCM_REF PH1 NPH1 VDD33 VSS gf180_tg_lowq
* DAC unit 55
CDP55 CDLP55 CDRP55 {CU}
CDN55 CDLN55 CDRN55 {CU}
XDP155 CDRP55 VCM_REF PH1 NPH1 VDD33 VSS gf180_tg_lowq
XDP255 CDRP55 INP PH2 NPH2 VDD33 VSS gf180_tg_lowq
XDN155 CDRN55 VCM_REF PH1 NPH1 VDD33 VSS gf180_tg_lowq
XDN255 CDRN55 INN PH2 NPH2 VDD33 VSS gf180_tg_lowq
BGPP55 GPP55 VSS I=(v(GPP55)-v(PH2)*v(S2P55)/v(VDD33))/1k
BGPN55 GPN55 VSS I=(v(GPN55)-v(PH2)*(v(VDD33)-v(S2P55))/v(VDD33))/1k
BGNP55 GNP55 VSS I=(v(GNP55)-v(PH2)*v(S2N55)/v(VDD33))/1k
BGNN55 GNN55 VSS I=(v(GNN55)-v(PH2)*(v(VDD33)-v(S2N55))/v(VDD33))/1k
BNOPP55 NGPP55 0 V=v(VDD33)-v(GPP55)
BNOPN55 NGPN55 0 V=v(VDD33)-v(GPN55)
BNONP55 NGNP55 0 V=v(VDD33)-v(GNP55)
BNONN55 NGNN55 0 V=v(VDD33)-v(GNN55)
CGPP55 GPP55 VSS 2p
CGPN55 GPN55 VSS 2p
CGNP55 GNP55 VSS 2p
CGNN55 GNN55 VSS 2p
CNGPP55 NGPP55 VSS 0.2p
CNGPN55 NGPN55 VSS 0.2p
CNGNP55 NGNP55 VSS 0.2p
CNGNN55 NGNN55 VSS 0.2p
XPVP55 CDLP55 VP GPP55 NGPP55 VDD33 VSS gf180_tg_lowq
XPVN55 CDLP55 VN GPN55 NGPN55 VDD33 VSS gf180_tg_lowq
XNVP55 CDLN55 VP GNP55 NGNP55 VDD33 VSS gf180_tg_lowq
XNVN55 CDLN55 VN GNN55 NGNN55 VDD33 VSS gf180_tg_lowq
XDPC55 CDLP55 VCM_REF PH1 NPH1 VDD33 VSS gf180_tg_lowq
XDNC55 CDLN55 VCM_REF PH1 NPH1 VDD33 VSS gf180_tg_lowq
* DAC unit 56
CDP56 CDLP56 CDRP56 {CU}
CDN56 CDLN56 CDRN56 {CU}
XDP156 CDRP56 VCM_REF PH1 NPH1 VDD33 VSS gf180_tg_lowq
XDP256 CDRP56 INP PH2 NPH2 VDD33 VSS gf180_tg_lowq
XDN156 CDRN56 VCM_REF PH1 NPH1 VDD33 VSS gf180_tg_lowq
XDN256 CDRN56 INN PH2 NPH2 VDD33 VSS gf180_tg_lowq
BGPP56 GPP56 VSS I=(v(GPP56)-v(PH2)*v(S2P56)/v(VDD33))/1k
BGPN56 GPN56 VSS I=(v(GPN56)-v(PH2)*(v(VDD33)-v(S2P56))/v(VDD33))/1k
BGNP56 GNP56 VSS I=(v(GNP56)-v(PH2)*v(S2N56)/v(VDD33))/1k
BGNN56 GNN56 VSS I=(v(GNN56)-v(PH2)*(v(VDD33)-v(S2N56))/v(VDD33))/1k
BNOPP56 NGPP56 0 V=v(VDD33)-v(GPP56)
BNOPN56 NGPN56 0 V=v(VDD33)-v(GPN56)
BNONP56 NGNP56 0 V=v(VDD33)-v(GNP56)
BNONN56 NGNN56 0 V=v(VDD33)-v(GNN56)
CGPP56 GPP56 VSS 2p
CGPN56 GPN56 VSS 2p
CGNP56 GNP56 VSS 2p
CGNN56 GNN56 VSS 2p
CNGPP56 NGPP56 VSS 0.2p
CNGPN56 NGPN56 VSS 0.2p
CNGNP56 NGNP56 VSS 0.2p
CNGNN56 NGNN56 VSS 0.2p
XPVP56 CDLP56 VP GPP56 NGPP56 VDD33 VSS gf180_tg_lowq
XPVN56 CDLP56 VN GPN56 NGPN56 VDD33 VSS gf180_tg_lowq
XNVP56 CDLN56 VP GNP56 NGNP56 VDD33 VSS gf180_tg_lowq
XNVN56 CDLN56 VN GNN56 NGNN56 VDD33 VSS gf180_tg_lowq
XDPC56 CDLP56 VCM_REF PH1 NPH1 VDD33 VSS gf180_tg_lowq
XDNC56 CDLN56 VCM_REF PH1 NPH1 VDD33 VSS gf180_tg_lowq
* DAC unit 57
CDP57 CDLP57 CDRP57 {CU}
CDN57 CDLN57 CDRN57 {CU}
XDP157 CDRP57 VCM_REF PH1 NPH1 VDD33 VSS gf180_tg_lowq
XDP257 CDRP57 INP PH2 NPH2 VDD33 VSS gf180_tg_lowq
XDN157 CDRN57 VCM_REF PH1 NPH1 VDD33 VSS gf180_tg_lowq
XDN257 CDRN57 INN PH2 NPH2 VDD33 VSS gf180_tg_lowq
BGPP57 GPP57 VSS I=(v(GPP57)-v(PH2)*v(S2P57)/v(VDD33))/1k
BGPN57 GPN57 VSS I=(v(GPN57)-v(PH2)*(v(VDD33)-v(S2P57))/v(VDD33))/1k
BGNP57 GNP57 VSS I=(v(GNP57)-v(PH2)*v(S2N57)/v(VDD33))/1k
BGNN57 GNN57 VSS I=(v(GNN57)-v(PH2)*(v(VDD33)-v(S2N57))/v(VDD33))/1k
BNOPP57 NGPP57 0 V=v(VDD33)-v(GPP57)
BNOPN57 NGPN57 0 V=v(VDD33)-v(GPN57)
BNONP57 NGNP57 0 V=v(VDD33)-v(GNP57)
BNONN57 NGNN57 0 V=v(VDD33)-v(GNN57)
CGPP57 GPP57 VSS 2p
CGPN57 GPN57 VSS 2p
CGNP57 GNP57 VSS 2p
CGNN57 GNN57 VSS 2p
CNGPP57 NGPP57 VSS 0.2p
CNGPN57 NGPN57 VSS 0.2p
CNGNP57 NGNP57 VSS 0.2p
CNGNN57 NGNN57 VSS 0.2p
XPVP57 CDLP57 VP GPP57 NGPP57 VDD33 VSS gf180_tg_lowq
XPVN57 CDLP57 VN GPN57 NGPN57 VDD33 VSS gf180_tg_lowq
XNVP57 CDLN57 VP GNP57 NGNP57 VDD33 VSS gf180_tg_lowq
XNVN57 CDLN57 VN GNN57 NGNN57 VDD33 VSS gf180_tg_lowq
XDPC57 CDLP57 VCM_REF PH1 NPH1 VDD33 VSS gf180_tg_lowq
XDNC57 CDLN57 VCM_REF PH1 NPH1 VDD33 VSS gf180_tg_lowq
* DAC unit 58
CDP58 CDLP58 CDRP58 {CU}
CDN58 CDLN58 CDRN58 {CU}
XDP158 CDRP58 VCM_REF PH1 NPH1 VDD33 VSS gf180_tg_lowq
XDP258 CDRP58 INP PH2 NPH2 VDD33 VSS gf180_tg_lowq
XDN158 CDRN58 VCM_REF PH1 NPH1 VDD33 VSS gf180_tg_lowq
XDN258 CDRN58 INN PH2 NPH2 VDD33 VSS gf180_tg_lowq
BGPP58 GPP58 VSS I=(v(GPP58)-v(PH2)*v(S2P58)/v(VDD33))/1k
BGPN58 GPN58 VSS I=(v(GPN58)-v(PH2)*(v(VDD33)-v(S2P58))/v(VDD33))/1k
BGNP58 GNP58 VSS I=(v(GNP58)-v(PH2)*v(S2N58)/v(VDD33))/1k
BGNN58 GNN58 VSS I=(v(GNN58)-v(PH2)*(v(VDD33)-v(S2N58))/v(VDD33))/1k
BNOPP58 NGPP58 0 V=v(VDD33)-v(GPP58)
BNOPN58 NGPN58 0 V=v(VDD33)-v(GPN58)
BNONP58 NGNP58 0 V=v(VDD33)-v(GNP58)
BNONN58 NGNN58 0 V=v(VDD33)-v(GNN58)
CGPP58 GPP58 VSS 2p
CGPN58 GPN58 VSS 2p
CGNP58 GNP58 VSS 2p
CGNN58 GNN58 VSS 2p
CNGPP58 NGPP58 VSS 0.2p
CNGPN58 NGPN58 VSS 0.2p
CNGNP58 NGNP58 VSS 0.2p
CNGNN58 NGNN58 VSS 0.2p
XPVP58 CDLP58 VP GPP58 NGPP58 VDD33 VSS gf180_tg_lowq
XPVN58 CDLP58 VN GPN58 NGPN58 VDD33 VSS gf180_tg_lowq
XNVP58 CDLN58 VP GNP58 NGNP58 VDD33 VSS gf180_tg_lowq
XNVN58 CDLN58 VN GNN58 NGNN58 VDD33 VSS gf180_tg_lowq
XDPC58 CDLP58 VCM_REF PH1 NPH1 VDD33 VSS gf180_tg_lowq
XDNC58 CDLN58 VCM_REF PH1 NPH1 VDD33 VSS gf180_tg_lowq
* DAC unit 59
CDP59 CDLP59 CDRP59 {CU}
CDN59 CDLN59 CDRN59 {CU}
XDP159 CDRP59 VCM_REF PH1 NPH1 VDD33 VSS gf180_tg_lowq
XDP259 CDRP59 INP PH2 NPH2 VDD33 VSS gf180_tg_lowq
XDN159 CDRN59 VCM_REF PH1 NPH1 VDD33 VSS gf180_tg_lowq
XDN259 CDRN59 INN PH2 NPH2 VDD33 VSS gf180_tg_lowq
BGPP59 GPP59 VSS I=(v(GPP59)-v(PH2)*v(S2P59)/v(VDD33))/1k
BGPN59 GPN59 VSS I=(v(GPN59)-v(PH2)*(v(VDD33)-v(S2P59))/v(VDD33))/1k
BGNP59 GNP59 VSS I=(v(GNP59)-v(PH2)*v(S2N59)/v(VDD33))/1k
BGNN59 GNN59 VSS I=(v(GNN59)-v(PH2)*(v(VDD33)-v(S2N59))/v(VDD33))/1k
BNOPP59 NGPP59 0 V=v(VDD33)-v(GPP59)
BNOPN59 NGPN59 0 V=v(VDD33)-v(GPN59)
BNONP59 NGNP59 0 V=v(VDD33)-v(GNP59)
BNONN59 NGNN59 0 V=v(VDD33)-v(GNN59)
CGPP59 GPP59 VSS 2p
CGPN59 GPN59 VSS 2p
CGNP59 GNP59 VSS 2p
CGNN59 GNN59 VSS 2p
CNGPP59 NGPP59 VSS 0.2p
CNGPN59 NGPN59 VSS 0.2p
CNGNP59 NGNP59 VSS 0.2p
CNGNN59 NGNN59 VSS 0.2p
XPVP59 CDLP59 VP GPP59 NGPP59 VDD33 VSS gf180_tg_lowq
XPVN59 CDLP59 VN GPN59 NGPN59 VDD33 VSS gf180_tg_lowq
XNVP59 CDLN59 VP GNP59 NGNP59 VDD33 VSS gf180_tg_lowq
XNVN59 CDLN59 VN GNN59 NGNN59 VDD33 VSS gf180_tg_lowq
XDPC59 CDLP59 VCM_REF PH1 NPH1 VDD33 VSS gf180_tg_lowq
XDNC59 CDLN59 VCM_REF PH1 NPH1 VDD33 VSS gf180_tg_lowq
* DAC unit 60
CDP60 CDLP60 CDRP60 {CU}
CDN60 CDLN60 CDRN60 {CU}
XDP160 CDRP60 VCM_REF PH1 NPH1 VDD33 VSS gf180_tg_lowq
XDP260 CDRP60 INP PH2 NPH2 VDD33 VSS gf180_tg_lowq
XDN160 CDRN60 VCM_REF PH1 NPH1 VDD33 VSS gf180_tg_lowq
XDN260 CDRN60 INN PH2 NPH2 VDD33 VSS gf180_tg_lowq
BGPP60 GPP60 VSS I=(v(GPP60)-v(PH2)*v(S2P60)/v(VDD33))/1k
BGPN60 GPN60 VSS I=(v(GPN60)-v(PH2)*(v(VDD33)-v(S2P60))/v(VDD33))/1k
BGNP60 GNP60 VSS I=(v(GNP60)-v(PH2)*v(S2N60)/v(VDD33))/1k
BGNN60 GNN60 VSS I=(v(GNN60)-v(PH2)*(v(VDD33)-v(S2N60))/v(VDD33))/1k
BNOPP60 NGPP60 0 V=v(VDD33)-v(GPP60)
BNOPN60 NGPN60 0 V=v(VDD33)-v(GPN60)
BNONP60 NGNP60 0 V=v(VDD33)-v(GNP60)
BNONN60 NGNN60 0 V=v(VDD33)-v(GNN60)
CGPP60 GPP60 VSS 2p
CGPN60 GPN60 VSS 2p
CGNP60 GNP60 VSS 2p
CGNN60 GNN60 VSS 2p
CNGPP60 NGPP60 VSS 0.2p
CNGPN60 NGPN60 VSS 0.2p
CNGNP60 NGNP60 VSS 0.2p
CNGNN60 NGNN60 VSS 0.2p
XPVP60 CDLP60 VP GPP60 NGPP60 VDD33 VSS gf180_tg_lowq
XPVN60 CDLP60 VN GPN60 NGPN60 VDD33 VSS gf180_tg_lowq
XNVP60 CDLN60 VP GNP60 NGNP60 VDD33 VSS gf180_tg_lowq
XNVN60 CDLN60 VN GNN60 NGNN60 VDD33 VSS gf180_tg_lowq
XDPC60 CDLP60 VCM_REF PH1 NPH1 VDD33 VSS gf180_tg_lowq
XDNC60 CDLN60 VCM_REF PH1 NPH1 VDD33 VSS gf180_tg_lowq
* DAC unit 61
CDP61 CDLP61 CDRP61 {CU}
CDN61 CDLN61 CDRN61 {CU}
XDP161 CDRP61 VCM_REF PH1 NPH1 VDD33 VSS gf180_tg_lowq
XDP261 CDRP61 INP PH2 NPH2 VDD33 VSS gf180_tg_lowq
XDN161 CDRN61 VCM_REF PH1 NPH1 VDD33 VSS gf180_tg_lowq
XDN261 CDRN61 INN PH2 NPH2 VDD33 VSS gf180_tg_lowq
BGPP61 GPP61 VSS I=(v(GPP61)-v(PH2)*v(S2P61)/v(VDD33))/1k
BGPN61 GPN61 VSS I=(v(GPN61)-v(PH2)*(v(VDD33)-v(S2P61))/v(VDD33))/1k
BGNP61 GNP61 VSS I=(v(GNP61)-v(PH2)*v(S2N61)/v(VDD33))/1k
BGNN61 GNN61 VSS I=(v(GNN61)-v(PH2)*(v(VDD33)-v(S2N61))/v(VDD33))/1k
BNOPP61 NGPP61 0 V=v(VDD33)-v(GPP61)
BNOPN61 NGPN61 0 V=v(VDD33)-v(GPN61)
BNONP61 NGNP61 0 V=v(VDD33)-v(GNP61)
BNONN61 NGNN61 0 V=v(VDD33)-v(GNN61)
CGPP61 GPP61 VSS 2p
CGPN61 GPN61 VSS 2p
CGNP61 GNP61 VSS 2p
CGNN61 GNN61 VSS 2p
CNGPP61 NGPP61 VSS 0.2p
CNGPN61 NGPN61 VSS 0.2p
CNGNP61 NGNP61 VSS 0.2p
CNGNN61 NGNN61 VSS 0.2p
XPVP61 CDLP61 VP GPP61 NGPP61 VDD33 VSS gf180_tg_lowq
XPVN61 CDLP61 VN GPN61 NGPN61 VDD33 VSS gf180_tg_lowq
XNVP61 CDLN61 VP GNP61 NGNP61 VDD33 VSS gf180_tg_lowq
XNVN61 CDLN61 VN GNN61 NGNN61 VDD33 VSS gf180_tg_lowq
XDPC61 CDLP61 VCM_REF PH1 NPH1 VDD33 VSS gf180_tg_lowq
XDNC61 CDLN61 VCM_REF PH1 NPH1 VDD33 VSS gf180_tg_lowq
* DAC unit 62
CDP62 CDLP62 CDRP62 {CU}
CDN62 CDLN62 CDRN62 {CU}
XDP162 CDRP62 VCM_REF PH1 NPH1 VDD33 VSS gf180_tg_lowq
XDP262 CDRP62 INP PH2 NPH2 VDD33 VSS gf180_tg_lowq
XDN162 CDRN62 VCM_REF PH1 NPH1 VDD33 VSS gf180_tg_lowq
XDN262 CDRN62 INN PH2 NPH2 VDD33 VSS gf180_tg_lowq
BGPP62 GPP62 VSS I=(v(GPP62)-v(PH2)*v(S2P62)/v(VDD33))/1k
BGPN62 GPN62 VSS I=(v(GPN62)-v(PH2)*(v(VDD33)-v(S2P62))/v(VDD33))/1k
BGNP62 GNP62 VSS I=(v(GNP62)-v(PH2)*v(S2N62)/v(VDD33))/1k
BGNN62 GNN62 VSS I=(v(GNN62)-v(PH2)*(v(VDD33)-v(S2N62))/v(VDD33))/1k
BNOPP62 NGPP62 0 V=v(VDD33)-v(GPP62)
BNOPN62 NGPN62 0 V=v(VDD33)-v(GPN62)
BNONP62 NGNP62 0 V=v(VDD33)-v(GNP62)
BNONN62 NGNN62 0 V=v(VDD33)-v(GNN62)
CGPP62 GPP62 VSS 2p
CGPN62 GPN62 VSS 2p
CGNP62 GNP62 VSS 2p
CGNN62 GNN62 VSS 2p
CNGPP62 NGPP62 VSS 0.2p
CNGPN62 NGPN62 VSS 0.2p
CNGNP62 NGNP62 VSS 0.2p
CNGNN62 NGNN62 VSS 0.2p
XPVP62 CDLP62 VP GPP62 NGPP62 VDD33 VSS gf180_tg_lowq
XPVN62 CDLP62 VN GPN62 NGPN62 VDD33 VSS gf180_tg_lowq
XNVP62 CDLN62 VP GNP62 NGNP62 VDD33 VSS gf180_tg_lowq
XNVN62 CDLN62 VN GNN62 NGNN62 VDD33 VSS gf180_tg_lowq
XDPC62 CDLP62 VCM_REF PH1 NPH1 VDD33 VSS gf180_tg_lowq
XDNC62 CDLN62 VCM_REF PH1 NPH1 VDD33 VSS gf180_tg_lowq
CIP OUTN INP {CI}
CIN OUTP INN {CI}
RBIASP INP VCM_REF 10G
RBIASN INN VCM_REF 10G
.ends gf180_sdm3_int2_mb

* ---- modulator top: sdm3 timing, 4-bit flash + behavioral DWA ----
* Nodes: TH0..TH14 = thermometer lines (H_i). External PUP clock (narrow
* pulse at PH1 rising edge) advances the DWA master register.
.subckt gf180_sdm3_mod_mb VINP VINN VCM_REF VP VN PH1 NPH1 PH2 NPH2 CMPCK PUP VDD33 VSS TH0 TH1 TH2 TH3 TH4 TH5 TH6 TH7 TH8 TH9 TH10 TH11 TH12 TH13 TH14 TH15 TH16 TH17 TH18 TH19 TH20 TH21 TH22 TH23 TH24 TH25 TH26 TH27 TH28 TH29 TH30 TH31 TH32 TH33 TH34 TH35 TH36 TH37 TH38 TH39 TH40 TH41 TH42 TH43 TH44 TH45 TH46 TH47 TH48 TH49 TH50 TH51 TH52 TH53 TH54 TH55 TH56 TH57 TH58 TH59 TH60 TH61 TH62 params: RSET=25k CC=10p
XINT1 VINN VINP VCM_REF VP VN O1P O1N PH1 NPH1 PH2 NPH2 VDD33 VSS SEL0 SEL1 SEL2 SEL3 SEL4 SEL5 SEL6 SEL7 SEL8 SEL9 SEL10 SEL11 SEL12 SEL13 SEL14 SEL15 SEL16 SEL17 SEL18 SEL19 SEL20 SEL21 SEL22 SEL23 SEL24 SEL25 SEL26 SEL27 SEL28 SEL29 SEL30 SEL31 SEL32 SEL33 SEL34 SEL35 SEL36 SEL37 SEL38 SEL39 SEL40 SEL41 SEL42 SEL43 SEL44 SEL45 SEL46 SEL47 SEL48 SEL49 SEL50 SEL51 SEL52 SEL53 SEL54 SEL55 SEL56 SEL57 SEL58 SEL59 SEL60 SEL61 SEL62 SELN0 SELN1 SELN2 SELN3 SELN4 SELN5 SELN6 SELN7 SELN8 SELN9 SELN10 SELN11 SELN12 SELN13 SELN14 SELN15 SELN16 SELN17 SELN18 SELN19 SELN20 SELN21 SELN22 SELN23 SELN24 SELN25 SELN26 SELN27 SELN28 SELN29 SELN30 SELN31 SELN32 SELN33 SELN34 SELN35 SELN36 SELN37 SELN38 SELN39 SELN40 SELN41 SELN42 SELN43 SELN44 SELN45 SELN46 SELN47 SELN48 SELN49 SELN50 SELN51 SELN52 SELN53 SELN54 SELN55 SELN56 SELN57 SELN58 SELN59 SELN60 SELN61 SELN62 gf180_sdm3_int1_mb RSET={RSET} CC={CC}
* int2 with swapped clock pins (samples PH2 / integrates PH1)
XINT2 O1N O1P VCM_REF VP VN O2P O2N PH2 NPH2 PH1 NPH1 VDD33 VSS S2L0 S2L1 S2L2 S2L3 S2L4 S2L5 S2L6 S2L7 S2L8 S2L9 S2L10 S2L11 S2L12 S2L13 S2L14 S2L15 S2L16 S2L17 S2L18 S2L19 S2L20 S2L21 S2L22 S2L23 S2L24 S2L25 S2L26 S2L27 S2L28 S2L29 S2L30 S2L31 S2L32 S2L33 S2L34 S2L35 S2L36 S2L37 S2L38 S2L39 S2L40 S2L41 S2L42 S2L43 S2L44 S2L45 S2L46 S2L47 S2L48 S2L49 S2L50 S2L51 S2L52 S2L53 S2L54 S2L55 S2L56 S2L57 S2L58 S2L59 S2L60 S2L61 S2L62 S2LN0 S2LN1 S2LN2 S2LN3 S2LN4 S2LN5 S2LN6 S2LN7 S2LN8 S2LN9 S2LN10 S2LN11 S2LN12 S2LN13 S2LN14 S2LN15 S2LN16 S2LN17 S2LN18 S2LN19 S2LN20 S2LN21 S2LN22 S2LN23 S2LN24 S2LN25 S2LN26 S2LN27 S2LN28 S2LN29 S2LN30 S2LN31 S2LN32 S2LN33 S2LN34 S2LN35 S2LN36 S2LN37 S2LN38 S2LN39 S2LN40 S2LN41 S2LN42 S2LN43 S2LN44 S2LN45 S2LN46 S2LN47 S2LN48 S2LN49 S2LN50 S2LN51 S2LN52 S2LN53 S2LN54 S2LN55 S2LN56 S2LN57 S2LN58 S2LN59 S2LN60 S2LN61 S2LN62 gf180_sdm3_int2_mb RSET={RSET} CC={CC}
XFLASH O2P O2N CMPCK VDD33 VSS TH0 TH1 TH2 TH3 TH4 TH5 TH6 TH7 TH8 TH9 TH10 TH11 TH12 TH13 TH14 TH15 TH16 TH17 TH18 TH19 TH20 TH21 TH22 TH23 TH24 TH25 TH26 TH27 TH28 TH29 TH30 TH31 TH32 TH33 TH34 TH35 TH36 TH37 TH38 TH39 TH40 TH41 TH42 TH43 TH44 TH45 TH46 TH47 TH48 TH49 TH50 TH51 TH52 TH53 TH54 TH55 TH56 TH57 TH58 TH59 TH60 TH61 TH62 gf180_sdm3_flash63
* thermometer count as voltage (1 V per count), RC-filtered (tau ~4 ns)
RTHF0 TH0 THF0 2k
CTHF0 THF0 VSS 2p
RTHF1 TH1 THF1 2k
CTHF1 THF1 VSS 2p
RTHF2 TH2 THF2 2k
CTHF2 THF2 VSS 2p
RTHF3 TH3 THF3 2k
CTHF3 THF3 VSS 2p
RTHF4 TH4 THF4 2k
CTHF4 THF4 VSS 2p
RTHF5 TH5 THF5 2k
CTHF5 THF5 VSS 2p
RTHF6 TH6 THF6 2k
CTHF6 THF6 VSS 2p
RTHF7 TH7 THF7 2k
CTHF7 THF7 VSS 2p
RTHF8 TH8 THF8 2k
CTHF8 THF8 VSS 2p
RTHF9 TH9 THF9 2k
CTHF9 THF9 VSS 2p
RTHF10 TH10 THF10 2k
CTHF10 THF10 VSS 2p
RTHF11 TH11 THF11 2k
CTHF11 THF11 VSS 2p
RTHF12 TH12 THF12 2k
CTHF12 THF12 VSS 2p
RTHF13 TH13 THF13 2k
CTHF13 THF13 VSS 2p
RTHF14 TH14 THF14 2k
CTHF14 THF14 VSS 2p
RTHF15 TH15 THF15 2k
CTHF15 THF15 VSS 2p
RTHF16 TH16 THF16 2k
CTHF16 THF16 VSS 2p
RTHF17 TH17 THF17 2k
CTHF17 THF17 VSS 2p
RTHF18 TH18 THF18 2k
CTHF18 THF18 VSS 2p
RTHF19 TH19 THF19 2k
CTHF19 THF19 VSS 2p
RTHF20 TH20 THF20 2k
CTHF20 THF20 VSS 2p
RTHF21 TH21 THF21 2k
CTHF21 THF21 VSS 2p
RTHF22 TH22 THF22 2k
CTHF22 THF22 VSS 2p
RTHF23 TH23 THF23 2k
CTHF23 THF23 VSS 2p
RTHF24 TH24 THF24 2k
CTHF24 THF24 VSS 2p
RTHF25 TH25 THF25 2k
CTHF25 THF25 VSS 2p
RTHF26 TH26 THF26 2k
CTHF26 THF26 VSS 2p
RTHF27 TH27 THF27 2k
CTHF27 THF27 VSS 2p
RTHF28 TH28 THF28 2k
CTHF28 THF28 VSS 2p
RTHF29 TH29 THF29 2k
CTHF29 THF29 VSS 2p
RTHF30 TH30 THF30 2k
CTHF30 THF30 VSS 2p
RTHF31 TH31 THF31 2k
CTHF31 THF31 VSS 2p
RTHF32 TH32 THF32 2k
CTHF32 THF32 VSS 2p
RTHF33 TH33 THF33 2k
CTHF33 THF33 VSS 2p
RTHF34 TH34 THF34 2k
CTHF34 THF34 VSS 2p
RTHF35 TH35 THF35 2k
CTHF35 THF35 VSS 2p
RTHF36 TH36 THF36 2k
CTHF36 THF36 VSS 2p
RTHF37 TH37 THF37 2k
CTHF37 THF37 VSS 2p
RTHF38 TH38 THF38 2k
CTHF38 THF38 VSS 2p
RTHF39 TH39 THF39 2k
CTHF39 THF39 VSS 2p
RTHF40 TH40 THF40 2k
CTHF40 THF40 VSS 2p
RTHF41 TH41 THF41 2k
CTHF41 THF41 VSS 2p
RTHF42 TH42 THF42 2k
CTHF42 THF42 VSS 2p
RTHF43 TH43 THF43 2k
CTHF43 THF43 VSS 2p
RTHF44 TH44 THF44 2k
CTHF44 THF44 VSS 2p
RTHF45 TH45 THF45 2k
CTHF45 THF45 VSS 2p
RTHF46 TH46 THF46 2k
CTHF46 THF46 VSS 2p
RTHF47 TH47 THF47 2k
CTHF47 THF47 VSS 2p
RTHF48 TH48 THF48 2k
CTHF48 THF48 VSS 2p
RTHF49 TH49 THF49 2k
CTHF49 THF49 VSS 2p
RTHF50 TH50 THF50 2k
CTHF50 THF50 VSS 2p
RTHF51 TH51 THF51 2k
CTHF51 THF51 VSS 2p
RTHF52 TH52 THF52 2k
CTHF52 THF52 VSS 2p
RTHF53 TH53 THF53 2k
CTHF53 THF53 VSS 2p
RTHF54 TH54 THF54 2k
CTHF54 THF54 VSS 2p
RTHF55 TH55 THF55 2k
CTHF55 THF55 VSS 2p
RTHF56 TH56 THF56 2k
CTHF56 THF56 VSS 2p
RTHF57 TH57 THF57 2k
CTHF57 THF57 VSS 2p
RTHF58 TH58 THF58 2k
CTHF58 THF58 VSS 2p
RTHF59 TH59 THF59 2k
CTHF59 THF59 VSS 2p
RTHF60 TH60 THF60 2k
CTHF60 THF60 VSS 2p
RTHF61 TH61 THF61 2k
CTHF61 THF61 VSS 2p
RTHF62 TH62 THF62 2k
CTHF62 THF62 VSS 2p
BCSUM CSUM 0 V=(v(THF0)+v(THF1)+v(THF2)+v(THF3)+v(THF4)+v(THF5)+v(THF6)+v(THF7)+v(THF8)+v(THF9)+v(THF10)+v(THF11)+v(THF12)+v(THF13)+v(THF14)+v(THF15)+v(THF16)+v(THF17)+v(THF18)+v(THF19)+v(THF20)+v(THF21)+v(THF22)+v(THF23)+v(THF24)+v(THF25)+v(THF26)+v(THF27)+v(THF28)+v(THF29)+v(THF30)+v(THF31)+v(THF32)+v(THF33)+v(THF34)+v(THF35)+v(THF36)+v(THF37)+v(THF38)+v(THF39)+v(THF40)+v(THF41)+v(THF42)+v(THF43)+v(THF44)+v(THF45)+v(THF46)+v(THF47)+v(THF48)+v(THF49)+v(THF50)+v(THF51)+v(THF52)+v(THF53)+v(THF54)+v(THF55)+v(THF56)+v(THF57)+v(THF58)+v(THF59)+v(THF60)+v(THF61)+v(THF62))/v(VDD33)
* (nodwa: no pointer logic)
*
* B-source current sample/hold (idsw SW broke transient OP; RC form is OP-clean)
*
* int1 unit selects (straight thermometer): P-side unit j -> VP if j < 63-c.
* RC-smoothed current-source form (tau ~2 ns); sigmoid boundary errors
* cancel pairwise in the summed DAC charge.
BSEL0 SEL0 VSS I=(v(SEL0)-v(VDD33)/(1+exp((0+0.5-(63-v(CSUM)))/0.15)))/1k
BSELN0 SELN0 VSS I=(v(SELN0)-(v(VDD33)-v(SEL0)))/1k
BSEL1 SEL1 VSS I=(v(SEL1)-v(VDD33)/(1+exp((1+0.5-(63-v(CSUM)))/0.15)))/1k
BSELN1 SELN1 VSS I=(v(SELN1)-(v(VDD33)-v(SEL1)))/1k
BSEL2 SEL2 VSS I=(v(SEL2)-v(VDD33)/(1+exp((2+0.5-(63-v(CSUM)))/0.15)))/1k
BSELN2 SELN2 VSS I=(v(SELN2)-(v(VDD33)-v(SEL2)))/1k
BSEL3 SEL3 VSS I=(v(SEL3)-v(VDD33)/(1+exp((3+0.5-(63-v(CSUM)))/0.15)))/1k
BSELN3 SELN3 VSS I=(v(SELN3)-(v(VDD33)-v(SEL3)))/1k
BSEL4 SEL4 VSS I=(v(SEL4)-v(VDD33)/(1+exp((4+0.5-(63-v(CSUM)))/0.15)))/1k
BSELN4 SELN4 VSS I=(v(SELN4)-(v(VDD33)-v(SEL4)))/1k
BSEL5 SEL5 VSS I=(v(SEL5)-v(VDD33)/(1+exp((5+0.5-(63-v(CSUM)))/0.15)))/1k
BSELN5 SELN5 VSS I=(v(SELN5)-(v(VDD33)-v(SEL5)))/1k
BSEL6 SEL6 VSS I=(v(SEL6)-v(VDD33)/(1+exp((6+0.5-(63-v(CSUM)))/0.15)))/1k
BSELN6 SELN6 VSS I=(v(SELN6)-(v(VDD33)-v(SEL6)))/1k
BSEL7 SEL7 VSS I=(v(SEL7)-v(VDD33)/(1+exp((7+0.5-(63-v(CSUM)))/0.15)))/1k
BSELN7 SELN7 VSS I=(v(SELN7)-(v(VDD33)-v(SEL7)))/1k
BSEL8 SEL8 VSS I=(v(SEL8)-v(VDD33)/(1+exp((8+0.5-(63-v(CSUM)))/0.15)))/1k
BSELN8 SELN8 VSS I=(v(SELN8)-(v(VDD33)-v(SEL8)))/1k
BSEL9 SEL9 VSS I=(v(SEL9)-v(VDD33)/(1+exp((9+0.5-(63-v(CSUM)))/0.15)))/1k
BSELN9 SELN9 VSS I=(v(SELN9)-(v(VDD33)-v(SEL9)))/1k
BSEL10 SEL10 VSS I=(v(SEL10)-v(VDD33)/(1+exp((10+0.5-(63-v(CSUM)))/0.15)))/1k
BSELN10 SELN10 VSS I=(v(SELN10)-(v(VDD33)-v(SEL10)))/1k
BSEL11 SEL11 VSS I=(v(SEL11)-v(VDD33)/(1+exp((11+0.5-(63-v(CSUM)))/0.15)))/1k
BSELN11 SELN11 VSS I=(v(SELN11)-(v(VDD33)-v(SEL11)))/1k
BSEL12 SEL12 VSS I=(v(SEL12)-v(VDD33)/(1+exp((12+0.5-(63-v(CSUM)))/0.15)))/1k
BSELN12 SELN12 VSS I=(v(SELN12)-(v(VDD33)-v(SEL12)))/1k
BSEL13 SEL13 VSS I=(v(SEL13)-v(VDD33)/(1+exp((13+0.5-(63-v(CSUM)))/0.15)))/1k
BSELN13 SELN13 VSS I=(v(SELN13)-(v(VDD33)-v(SEL13)))/1k
BSEL14 SEL14 VSS I=(v(SEL14)-v(VDD33)/(1+exp((14+0.5-(63-v(CSUM)))/0.15)))/1k
BSELN14 SELN14 VSS I=(v(SELN14)-(v(VDD33)-v(SEL14)))/1k
BSEL15 SEL15 VSS I=(v(SEL15)-v(VDD33)/(1+exp((15+0.5-(63-v(CSUM)))/0.15)))/1k
BSELN15 SELN15 VSS I=(v(SELN15)-(v(VDD33)-v(SEL15)))/1k
BSEL16 SEL16 VSS I=(v(SEL16)-v(VDD33)/(1+exp((16+0.5-(63-v(CSUM)))/0.15)))/1k
BSELN16 SELN16 VSS I=(v(SELN16)-(v(VDD33)-v(SEL16)))/1k
BSEL17 SEL17 VSS I=(v(SEL17)-v(VDD33)/(1+exp((17+0.5-(63-v(CSUM)))/0.15)))/1k
BSELN17 SELN17 VSS I=(v(SELN17)-(v(VDD33)-v(SEL17)))/1k
BSEL18 SEL18 VSS I=(v(SEL18)-v(VDD33)/(1+exp((18+0.5-(63-v(CSUM)))/0.15)))/1k
BSELN18 SELN18 VSS I=(v(SELN18)-(v(VDD33)-v(SEL18)))/1k
BSEL19 SEL19 VSS I=(v(SEL19)-v(VDD33)/(1+exp((19+0.5-(63-v(CSUM)))/0.15)))/1k
BSELN19 SELN19 VSS I=(v(SELN19)-(v(VDD33)-v(SEL19)))/1k
BSEL20 SEL20 VSS I=(v(SEL20)-v(VDD33)/(1+exp((20+0.5-(63-v(CSUM)))/0.15)))/1k
BSELN20 SELN20 VSS I=(v(SELN20)-(v(VDD33)-v(SEL20)))/1k
BSEL21 SEL21 VSS I=(v(SEL21)-v(VDD33)/(1+exp((21+0.5-(63-v(CSUM)))/0.15)))/1k
BSELN21 SELN21 VSS I=(v(SELN21)-(v(VDD33)-v(SEL21)))/1k
BSEL22 SEL22 VSS I=(v(SEL22)-v(VDD33)/(1+exp((22+0.5-(63-v(CSUM)))/0.15)))/1k
BSELN22 SELN22 VSS I=(v(SELN22)-(v(VDD33)-v(SEL22)))/1k
BSEL23 SEL23 VSS I=(v(SEL23)-v(VDD33)/(1+exp((23+0.5-(63-v(CSUM)))/0.15)))/1k
BSELN23 SELN23 VSS I=(v(SELN23)-(v(VDD33)-v(SEL23)))/1k
BSEL24 SEL24 VSS I=(v(SEL24)-v(VDD33)/(1+exp((24+0.5-(63-v(CSUM)))/0.15)))/1k
BSELN24 SELN24 VSS I=(v(SELN24)-(v(VDD33)-v(SEL24)))/1k
BSEL25 SEL25 VSS I=(v(SEL25)-v(VDD33)/(1+exp((25+0.5-(63-v(CSUM)))/0.15)))/1k
BSELN25 SELN25 VSS I=(v(SELN25)-(v(VDD33)-v(SEL25)))/1k
BSEL26 SEL26 VSS I=(v(SEL26)-v(VDD33)/(1+exp((26+0.5-(63-v(CSUM)))/0.15)))/1k
BSELN26 SELN26 VSS I=(v(SELN26)-(v(VDD33)-v(SEL26)))/1k
BSEL27 SEL27 VSS I=(v(SEL27)-v(VDD33)/(1+exp((27+0.5-(63-v(CSUM)))/0.15)))/1k
BSELN27 SELN27 VSS I=(v(SELN27)-(v(VDD33)-v(SEL27)))/1k
BSEL28 SEL28 VSS I=(v(SEL28)-v(VDD33)/(1+exp((28+0.5-(63-v(CSUM)))/0.15)))/1k
BSELN28 SELN28 VSS I=(v(SELN28)-(v(VDD33)-v(SEL28)))/1k
BSEL29 SEL29 VSS I=(v(SEL29)-v(VDD33)/(1+exp((29+0.5-(63-v(CSUM)))/0.15)))/1k
BSELN29 SELN29 VSS I=(v(SELN29)-(v(VDD33)-v(SEL29)))/1k
BSEL30 SEL30 VSS I=(v(SEL30)-v(VDD33)/(1+exp((30+0.5-(63-v(CSUM)))/0.15)))/1k
BSELN30 SELN30 VSS I=(v(SELN30)-(v(VDD33)-v(SEL30)))/1k
BSEL31 SEL31 VSS I=(v(SEL31)-v(VDD33)/(1+exp((31+0.5-(63-v(CSUM)))/0.15)))/1k
BSELN31 SELN31 VSS I=(v(SELN31)-(v(VDD33)-v(SEL31)))/1k
BSEL32 SEL32 VSS I=(v(SEL32)-v(VDD33)/(1+exp((32+0.5-(63-v(CSUM)))/0.15)))/1k
BSELN32 SELN32 VSS I=(v(SELN32)-(v(VDD33)-v(SEL32)))/1k
BSEL33 SEL33 VSS I=(v(SEL33)-v(VDD33)/(1+exp((33+0.5-(63-v(CSUM)))/0.15)))/1k
BSELN33 SELN33 VSS I=(v(SELN33)-(v(VDD33)-v(SEL33)))/1k
BSEL34 SEL34 VSS I=(v(SEL34)-v(VDD33)/(1+exp((34+0.5-(63-v(CSUM)))/0.15)))/1k
BSELN34 SELN34 VSS I=(v(SELN34)-(v(VDD33)-v(SEL34)))/1k
BSEL35 SEL35 VSS I=(v(SEL35)-v(VDD33)/(1+exp((35+0.5-(63-v(CSUM)))/0.15)))/1k
BSELN35 SELN35 VSS I=(v(SELN35)-(v(VDD33)-v(SEL35)))/1k
BSEL36 SEL36 VSS I=(v(SEL36)-v(VDD33)/(1+exp((36+0.5-(63-v(CSUM)))/0.15)))/1k
BSELN36 SELN36 VSS I=(v(SELN36)-(v(VDD33)-v(SEL36)))/1k
BSEL37 SEL37 VSS I=(v(SEL37)-v(VDD33)/(1+exp((37+0.5-(63-v(CSUM)))/0.15)))/1k
BSELN37 SELN37 VSS I=(v(SELN37)-(v(VDD33)-v(SEL37)))/1k
BSEL38 SEL38 VSS I=(v(SEL38)-v(VDD33)/(1+exp((38+0.5-(63-v(CSUM)))/0.15)))/1k
BSELN38 SELN38 VSS I=(v(SELN38)-(v(VDD33)-v(SEL38)))/1k
BSEL39 SEL39 VSS I=(v(SEL39)-v(VDD33)/(1+exp((39+0.5-(63-v(CSUM)))/0.15)))/1k
BSELN39 SELN39 VSS I=(v(SELN39)-(v(VDD33)-v(SEL39)))/1k
BSEL40 SEL40 VSS I=(v(SEL40)-v(VDD33)/(1+exp((40+0.5-(63-v(CSUM)))/0.15)))/1k
BSELN40 SELN40 VSS I=(v(SELN40)-(v(VDD33)-v(SEL40)))/1k
BSEL41 SEL41 VSS I=(v(SEL41)-v(VDD33)/(1+exp((41+0.5-(63-v(CSUM)))/0.15)))/1k
BSELN41 SELN41 VSS I=(v(SELN41)-(v(VDD33)-v(SEL41)))/1k
BSEL42 SEL42 VSS I=(v(SEL42)-v(VDD33)/(1+exp((42+0.5-(63-v(CSUM)))/0.15)))/1k
BSELN42 SELN42 VSS I=(v(SELN42)-(v(VDD33)-v(SEL42)))/1k
BSEL43 SEL43 VSS I=(v(SEL43)-v(VDD33)/(1+exp((43+0.5-(63-v(CSUM)))/0.15)))/1k
BSELN43 SELN43 VSS I=(v(SELN43)-(v(VDD33)-v(SEL43)))/1k
BSEL44 SEL44 VSS I=(v(SEL44)-v(VDD33)/(1+exp((44+0.5-(63-v(CSUM)))/0.15)))/1k
BSELN44 SELN44 VSS I=(v(SELN44)-(v(VDD33)-v(SEL44)))/1k
BSEL45 SEL45 VSS I=(v(SEL45)-v(VDD33)/(1+exp((45+0.5-(63-v(CSUM)))/0.15)))/1k
BSELN45 SELN45 VSS I=(v(SELN45)-(v(VDD33)-v(SEL45)))/1k
BSEL46 SEL46 VSS I=(v(SEL46)-v(VDD33)/(1+exp((46+0.5-(63-v(CSUM)))/0.15)))/1k
BSELN46 SELN46 VSS I=(v(SELN46)-(v(VDD33)-v(SEL46)))/1k
BSEL47 SEL47 VSS I=(v(SEL47)-v(VDD33)/(1+exp((47+0.5-(63-v(CSUM)))/0.15)))/1k
BSELN47 SELN47 VSS I=(v(SELN47)-(v(VDD33)-v(SEL47)))/1k
BSEL48 SEL48 VSS I=(v(SEL48)-v(VDD33)/(1+exp((48+0.5-(63-v(CSUM)))/0.15)))/1k
BSELN48 SELN48 VSS I=(v(SELN48)-(v(VDD33)-v(SEL48)))/1k
BSEL49 SEL49 VSS I=(v(SEL49)-v(VDD33)/(1+exp((49+0.5-(63-v(CSUM)))/0.15)))/1k
BSELN49 SELN49 VSS I=(v(SELN49)-(v(VDD33)-v(SEL49)))/1k
BSEL50 SEL50 VSS I=(v(SEL50)-v(VDD33)/(1+exp((50+0.5-(63-v(CSUM)))/0.15)))/1k
BSELN50 SELN50 VSS I=(v(SELN50)-(v(VDD33)-v(SEL50)))/1k
BSEL51 SEL51 VSS I=(v(SEL51)-v(VDD33)/(1+exp((51+0.5-(63-v(CSUM)))/0.15)))/1k
BSELN51 SELN51 VSS I=(v(SELN51)-(v(VDD33)-v(SEL51)))/1k
BSEL52 SEL52 VSS I=(v(SEL52)-v(VDD33)/(1+exp((52+0.5-(63-v(CSUM)))/0.15)))/1k
BSELN52 SELN52 VSS I=(v(SELN52)-(v(VDD33)-v(SEL52)))/1k
BSEL53 SEL53 VSS I=(v(SEL53)-v(VDD33)/(1+exp((53+0.5-(63-v(CSUM)))/0.15)))/1k
BSELN53 SELN53 VSS I=(v(SELN53)-(v(VDD33)-v(SEL53)))/1k
BSEL54 SEL54 VSS I=(v(SEL54)-v(VDD33)/(1+exp((54+0.5-(63-v(CSUM)))/0.15)))/1k
BSELN54 SELN54 VSS I=(v(SELN54)-(v(VDD33)-v(SEL54)))/1k
BSEL55 SEL55 VSS I=(v(SEL55)-v(VDD33)/(1+exp((55+0.5-(63-v(CSUM)))/0.15)))/1k
BSELN55 SELN55 VSS I=(v(SELN55)-(v(VDD33)-v(SEL55)))/1k
BSEL56 SEL56 VSS I=(v(SEL56)-v(VDD33)/(1+exp((56+0.5-(63-v(CSUM)))/0.15)))/1k
BSELN56 SELN56 VSS I=(v(SELN56)-(v(VDD33)-v(SEL56)))/1k
BSEL57 SEL57 VSS I=(v(SEL57)-v(VDD33)/(1+exp((57+0.5-(63-v(CSUM)))/0.15)))/1k
BSELN57 SELN57 VSS I=(v(SELN57)-(v(VDD33)-v(SEL57)))/1k
BSEL58 SEL58 VSS I=(v(SEL58)-v(VDD33)/(1+exp((58+0.5-(63-v(CSUM)))/0.15)))/1k
BSELN58 SELN58 VSS I=(v(SELN58)-(v(VDD33)-v(SEL58)))/1k
BSEL59 SEL59 VSS I=(v(SEL59)-v(VDD33)/(1+exp((59+0.5-(63-v(CSUM)))/0.15)))/1k
BSELN59 SELN59 VSS I=(v(SELN59)-(v(VDD33)-v(SEL59)))/1k
BSEL60 SEL60 VSS I=(v(SEL60)-v(VDD33)/(1+exp((60+0.5-(63-v(CSUM)))/0.15)))/1k
BSELN60 SELN60 VSS I=(v(SELN60)-(v(VDD33)-v(SEL60)))/1k
BSEL61 SEL61 VSS I=(v(SEL61)-v(VDD33)/(1+exp((61+0.5-(63-v(CSUM)))/0.15)))/1k
BSELN61 SELN61 VSS I=(v(SELN61)-(v(VDD33)-v(SEL61)))/1k
BSEL62 SEL62 VSS I=(v(SEL62)-v(VDD33)/(1+exp((62+0.5-(63-v(CSUM)))/0.15)))/1k
BSELN62 SELN62 VSS I=(v(SELN62)-(v(VDD33)-v(SEL62)))/1k
* int2 code register: tracks CSUM during PH2, holds through PH1
* (smoothed B-source sample/hold; idsw SW broke transient OP)
BC2R C2R VSS I=(v(C2R)-v(CSUM))/1k/(1+exp((2.0-v(PH2))/0.05))
CC2R C2R VSS 0.5p
RC2R C2R VSS 1G
* int2 unit selects (straight thermometer from registered code)
BS2L0 S2L0 VSS I=(v(S2L0)-v(VDD33)/(1+exp((0+0.5-(63-v(C2R)))/0.15)))/1k
BS2LN0 S2LN0 VSS I=(v(S2LN0)-(v(VDD33)-v(S2L0)))/1k
BS2L1 S2L1 VSS I=(v(S2L1)-v(VDD33)/(1+exp((1+0.5-(63-v(C2R)))/0.15)))/1k
BS2LN1 S2LN1 VSS I=(v(S2LN1)-(v(VDD33)-v(S2L1)))/1k
BS2L2 S2L2 VSS I=(v(S2L2)-v(VDD33)/(1+exp((2+0.5-(63-v(C2R)))/0.15)))/1k
BS2LN2 S2LN2 VSS I=(v(S2LN2)-(v(VDD33)-v(S2L2)))/1k
BS2L3 S2L3 VSS I=(v(S2L3)-v(VDD33)/(1+exp((3+0.5-(63-v(C2R)))/0.15)))/1k
BS2LN3 S2LN3 VSS I=(v(S2LN3)-(v(VDD33)-v(S2L3)))/1k
BS2L4 S2L4 VSS I=(v(S2L4)-v(VDD33)/(1+exp((4+0.5-(63-v(C2R)))/0.15)))/1k
BS2LN4 S2LN4 VSS I=(v(S2LN4)-(v(VDD33)-v(S2L4)))/1k
BS2L5 S2L5 VSS I=(v(S2L5)-v(VDD33)/(1+exp((5+0.5-(63-v(C2R)))/0.15)))/1k
BS2LN5 S2LN5 VSS I=(v(S2LN5)-(v(VDD33)-v(S2L5)))/1k
BS2L6 S2L6 VSS I=(v(S2L6)-v(VDD33)/(1+exp((6+0.5-(63-v(C2R)))/0.15)))/1k
BS2LN6 S2LN6 VSS I=(v(S2LN6)-(v(VDD33)-v(S2L6)))/1k
BS2L7 S2L7 VSS I=(v(S2L7)-v(VDD33)/(1+exp((7+0.5-(63-v(C2R)))/0.15)))/1k
BS2LN7 S2LN7 VSS I=(v(S2LN7)-(v(VDD33)-v(S2L7)))/1k
BS2L8 S2L8 VSS I=(v(S2L8)-v(VDD33)/(1+exp((8+0.5-(63-v(C2R)))/0.15)))/1k
BS2LN8 S2LN8 VSS I=(v(S2LN8)-(v(VDD33)-v(S2L8)))/1k
BS2L9 S2L9 VSS I=(v(S2L9)-v(VDD33)/(1+exp((9+0.5-(63-v(C2R)))/0.15)))/1k
BS2LN9 S2LN9 VSS I=(v(S2LN9)-(v(VDD33)-v(S2L9)))/1k
BS2L10 S2L10 VSS I=(v(S2L10)-v(VDD33)/(1+exp((10+0.5-(63-v(C2R)))/0.15)))/1k
BS2LN10 S2LN10 VSS I=(v(S2LN10)-(v(VDD33)-v(S2L10)))/1k
BS2L11 S2L11 VSS I=(v(S2L11)-v(VDD33)/(1+exp((11+0.5-(63-v(C2R)))/0.15)))/1k
BS2LN11 S2LN11 VSS I=(v(S2LN11)-(v(VDD33)-v(S2L11)))/1k
BS2L12 S2L12 VSS I=(v(S2L12)-v(VDD33)/(1+exp((12+0.5-(63-v(C2R)))/0.15)))/1k
BS2LN12 S2LN12 VSS I=(v(S2LN12)-(v(VDD33)-v(S2L12)))/1k
BS2L13 S2L13 VSS I=(v(S2L13)-v(VDD33)/(1+exp((13+0.5-(63-v(C2R)))/0.15)))/1k
BS2LN13 S2LN13 VSS I=(v(S2LN13)-(v(VDD33)-v(S2L13)))/1k
BS2L14 S2L14 VSS I=(v(S2L14)-v(VDD33)/(1+exp((14+0.5-(63-v(C2R)))/0.15)))/1k
BS2LN14 S2LN14 VSS I=(v(S2LN14)-(v(VDD33)-v(S2L14)))/1k
BS2L15 S2L15 VSS I=(v(S2L15)-v(VDD33)/(1+exp((15+0.5-(63-v(C2R)))/0.15)))/1k
BS2LN15 S2LN15 VSS I=(v(S2LN15)-(v(VDD33)-v(S2L15)))/1k
BS2L16 S2L16 VSS I=(v(S2L16)-v(VDD33)/(1+exp((16+0.5-(63-v(C2R)))/0.15)))/1k
BS2LN16 S2LN16 VSS I=(v(S2LN16)-(v(VDD33)-v(S2L16)))/1k
BS2L17 S2L17 VSS I=(v(S2L17)-v(VDD33)/(1+exp((17+0.5-(63-v(C2R)))/0.15)))/1k
BS2LN17 S2LN17 VSS I=(v(S2LN17)-(v(VDD33)-v(S2L17)))/1k
BS2L18 S2L18 VSS I=(v(S2L18)-v(VDD33)/(1+exp((18+0.5-(63-v(C2R)))/0.15)))/1k
BS2LN18 S2LN18 VSS I=(v(S2LN18)-(v(VDD33)-v(S2L18)))/1k
BS2L19 S2L19 VSS I=(v(S2L19)-v(VDD33)/(1+exp((19+0.5-(63-v(C2R)))/0.15)))/1k
BS2LN19 S2LN19 VSS I=(v(S2LN19)-(v(VDD33)-v(S2L19)))/1k
BS2L20 S2L20 VSS I=(v(S2L20)-v(VDD33)/(1+exp((20+0.5-(63-v(C2R)))/0.15)))/1k
BS2LN20 S2LN20 VSS I=(v(S2LN20)-(v(VDD33)-v(S2L20)))/1k
BS2L21 S2L21 VSS I=(v(S2L21)-v(VDD33)/(1+exp((21+0.5-(63-v(C2R)))/0.15)))/1k
BS2LN21 S2LN21 VSS I=(v(S2LN21)-(v(VDD33)-v(S2L21)))/1k
BS2L22 S2L22 VSS I=(v(S2L22)-v(VDD33)/(1+exp((22+0.5-(63-v(C2R)))/0.15)))/1k
BS2LN22 S2LN22 VSS I=(v(S2LN22)-(v(VDD33)-v(S2L22)))/1k
BS2L23 S2L23 VSS I=(v(S2L23)-v(VDD33)/(1+exp((23+0.5-(63-v(C2R)))/0.15)))/1k
BS2LN23 S2LN23 VSS I=(v(S2LN23)-(v(VDD33)-v(S2L23)))/1k
BS2L24 S2L24 VSS I=(v(S2L24)-v(VDD33)/(1+exp((24+0.5-(63-v(C2R)))/0.15)))/1k
BS2LN24 S2LN24 VSS I=(v(S2LN24)-(v(VDD33)-v(S2L24)))/1k
BS2L25 S2L25 VSS I=(v(S2L25)-v(VDD33)/(1+exp((25+0.5-(63-v(C2R)))/0.15)))/1k
BS2LN25 S2LN25 VSS I=(v(S2LN25)-(v(VDD33)-v(S2L25)))/1k
BS2L26 S2L26 VSS I=(v(S2L26)-v(VDD33)/(1+exp((26+0.5-(63-v(C2R)))/0.15)))/1k
BS2LN26 S2LN26 VSS I=(v(S2LN26)-(v(VDD33)-v(S2L26)))/1k
BS2L27 S2L27 VSS I=(v(S2L27)-v(VDD33)/(1+exp((27+0.5-(63-v(C2R)))/0.15)))/1k
BS2LN27 S2LN27 VSS I=(v(S2LN27)-(v(VDD33)-v(S2L27)))/1k
BS2L28 S2L28 VSS I=(v(S2L28)-v(VDD33)/(1+exp((28+0.5-(63-v(C2R)))/0.15)))/1k
BS2LN28 S2LN28 VSS I=(v(S2LN28)-(v(VDD33)-v(S2L28)))/1k
BS2L29 S2L29 VSS I=(v(S2L29)-v(VDD33)/(1+exp((29+0.5-(63-v(C2R)))/0.15)))/1k
BS2LN29 S2LN29 VSS I=(v(S2LN29)-(v(VDD33)-v(S2L29)))/1k
BS2L30 S2L30 VSS I=(v(S2L30)-v(VDD33)/(1+exp((30+0.5-(63-v(C2R)))/0.15)))/1k
BS2LN30 S2LN30 VSS I=(v(S2LN30)-(v(VDD33)-v(S2L30)))/1k
BS2L31 S2L31 VSS I=(v(S2L31)-v(VDD33)/(1+exp((31+0.5-(63-v(C2R)))/0.15)))/1k
BS2LN31 S2LN31 VSS I=(v(S2LN31)-(v(VDD33)-v(S2L31)))/1k
BS2L32 S2L32 VSS I=(v(S2L32)-v(VDD33)/(1+exp((32+0.5-(63-v(C2R)))/0.15)))/1k
BS2LN32 S2LN32 VSS I=(v(S2LN32)-(v(VDD33)-v(S2L32)))/1k
BS2L33 S2L33 VSS I=(v(S2L33)-v(VDD33)/(1+exp((33+0.5-(63-v(C2R)))/0.15)))/1k
BS2LN33 S2LN33 VSS I=(v(S2LN33)-(v(VDD33)-v(S2L33)))/1k
BS2L34 S2L34 VSS I=(v(S2L34)-v(VDD33)/(1+exp((34+0.5-(63-v(C2R)))/0.15)))/1k
BS2LN34 S2LN34 VSS I=(v(S2LN34)-(v(VDD33)-v(S2L34)))/1k
BS2L35 S2L35 VSS I=(v(S2L35)-v(VDD33)/(1+exp((35+0.5-(63-v(C2R)))/0.15)))/1k
BS2LN35 S2LN35 VSS I=(v(S2LN35)-(v(VDD33)-v(S2L35)))/1k
BS2L36 S2L36 VSS I=(v(S2L36)-v(VDD33)/(1+exp((36+0.5-(63-v(C2R)))/0.15)))/1k
BS2LN36 S2LN36 VSS I=(v(S2LN36)-(v(VDD33)-v(S2L36)))/1k
BS2L37 S2L37 VSS I=(v(S2L37)-v(VDD33)/(1+exp((37+0.5-(63-v(C2R)))/0.15)))/1k
BS2LN37 S2LN37 VSS I=(v(S2LN37)-(v(VDD33)-v(S2L37)))/1k
BS2L38 S2L38 VSS I=(v(S2L38)-v(VDD33)/(1+exp((38+0.5-(63-v(C2R)))/0.15)))/1k
BS2LN38 S2LN38 VSS I=(v(S2LN38)-(v(VDD33)-v(S2L38)))/1k
BS2L39 S2L39 VSS I=(v(S2L39)-v(VDD33)/(1+exp((39+0.5-(63-v(C2R)))/0.15)))/1k
BS2LN39 S2LN39 VSS I=(v(S2LN39)-(v(VDD33)-v(S2L39)))/1k
BS2L40 S2L40 VSS I=(v(S2L40)-v(VDD33)/(1+exp((40+0.5-(63-v(C2R)))/0.15)))/1k
BS2LN40 S2LN40 VSS I=(v(S2LN40)-(v(VDD33)-v(S2L40)))/1k
BS2L41 S2L41 VSS I=(v(S2L41)-v(VDD33)/(1+exp((41+0.5-(63-v(C2R)))/0.15)))/1k
BS2LN41 S2LN41 VSS I=(v(S2LN41)-(v(VDD33)-v(S2L41)))/1k
BS2L42 S2L42 VSS I=(v(S2L42)-v(VDD33)/(1+exp((42+0.5-(63-v(C2R)))/0.15)))/1k
BS2LN42 S2LN42 VSS I=(v(S2LN42)-(v(VDD33)-v(S2L42)))/1k
BS2L43 S2L43 VSS I=(v(S2L43)-v(VDD33)/(1+exp((43+0.5-(63-v(C2R)))/0.15)))/1k
BS2LN43 S2LN43 VSS I=(v(S2LN43)-(v(VDD33)-v(S2L43)))/1k
BS2L44 S2L44 VSS I=(v(S2L44)-v(VDD33)/(1+exp((44+0.5-(63-v(C2R)))/0.15)))/1k
BS2LN44 S2LN44 VSS I=(v(S2LN44)-(v(VDD33)-v(S2L44)))/1k
BS2L45 S2L45 VSS I=(v(S2L45)-v(VDD33)/(1+exp((45+0.5-(63-v(C2R)))/0.15)))/1k
BS2LN45 S2LN45 VSS I=(v(S2LN45)-(v(VDD33)-v(S2L45)))/1k
BS2L46 S2L46 VSS I=(v(S2L46)-v(VDD33)/(1+exp((46+0.5-(63-v(C2R)))/0.15)))/1k
BS2LN46 S2LN46 VSS I=(v(S2LN46)-(v(VDD33)-v(S2L46)))/1k
BS2L47 S2L47 VSS I=(v(S2L47)-v(VDD33)/(1+exp((47+0.5-(63-v(C2R)))/0.15)))/1k
BS2LN47 S2LN47 VSS I=(v(S2LN47)-(v(VDD33)-v(S2L47)))/1k
BS2L48 S2L48 VSS I=(v(S2L48)-v(VDD33)/(1+exp((48+0.5-(63-v(C2R)))/0.15)))/1k
BS2LN48 S2LN48 VSS I=(v(S2LN48)-(v(VDD33)-v(S2L48)))/1k
BS2L49 S2L49 VSS I=(v(S2L49)-v(VDD33)/(1+exp((49+0.5-(63-v(C2R)))/0.15)))/1k
BS2LN49 S2LN49 VSS I=(v(S2LN49)-(v(VDD33)-v(S2L49)))/1k
BS2L50 S2L50 VSS I=(v(S2L50)-v(VDD33)/(1+exp((50+0.5-(63-v(C2R)))/0.15)))/1k
BS2LN50 S2LN50 VSS I=(v(S2LN50)-(v(VDD33)-v(S2L50)))/1k
BS2L51 S2L51 VSS I=(v(S2L51)-v(VDD33)/(1+exp((51+0.5-(63-v(C2R)))/0.15)))/1k
BS2LN51 S2LN51 VSS I=(v(S2LN51)-(v(VDD33)-v(S2L51)))/1k
BS2L52 S2L52 VSS I=(v(S2L52)-v(VDD33)/(1+exp((52+0.5-(63-v(C2R)))/0.15)))/1k
BS2LN52 S2LN52 VSS I=(v(S2LN52)-(v(VDD33)-v(S2L52)))/1k
BS2L53 S2L53 VSS I=(v(S2L53)-v(VDD33)/(1+exp((53+0.5-(63-v(C2R)))/0.15)))/1k
BS2LN53 S2LN53 VSS I=(v(S2LN53)-(v(VDD33)-v(S2L53)))/1k
BS2L54 S2L54 VSS I=(v(S2L54)-v(VDD33)/(1+exp((54+0.5-(63-v(C2R)))/0.15)))/1k
BS2LN54 S2LN54 VSS I=(v(S2LN54)-(v(VDD33)-v(S2L54)))/1k
BS2L55 S2L55 VSS I=(v(S2L55)-v(VDD33)/(1+exp((55+0.5-(63-v(C2R)))/0.15)))/1k
BS2LN55 S2LN55 VSS I=(v(S2LN55)-(v(VDD33)-v(S2L55)))/1k
BS2L56 S2L56 VSS I=(v(S2L56)-v(VDD33)/(1+exp((56+0.5-(63-v(C2R)))/0.15)))/1k
BS2LN56 S2LN56 VSS I=(v(S2LN56)-(v(VDD33)-v(S2L56)))/1k
BS2L57 S2L57 VSS I=(v(S2L57)-v(VDD33)/(1+exp((57+0.5-(63-v(C2R)))/0.15)))/1k
BS2LN57 S2LN57 VSS I=(v(S2LN57)-(v(VDD33)-v(S2L57)))/1k
BS2L58 S2L58 VSS I=(v(S2L58)-v(VDD33)/(1+exp((58+0.5-(63-v(C2R)))/0.15)))/1k
BS2LN58 S2LN58 VSS I=(v(S2LN58)-(v(VDD33)-v(S2L58)))/1k
BS2L59 S2L59 VSS I=(v(S2L59)-v(VDD33)/(1+exp((59+0.5-(63-v(C2R)))/0.15)))/1k
BS2LN59 S2LN59 VSS I=(v(S2LN59)-(v(VDD33)-v(S2L59)))/1k
BS2L60 S2L60 VSS I=(v(S2L60)-v(VDD33)/(1+exp((60+0.5-(63-v(C2R)))/0.15)))/1k
BS2LN60 S2LN60 VSS I=(v(S2LN60)-(v(VDD33)-v(S2L60)))/1k
BS2L61 S2L61 VSS I=(v(S2L61)-v(VDD33)/(1+exp((61+0.5-(63-v(C2R)))/0.15)))/1k
BS2LN61 S2LN61 VSS I=(v(S2LN61)-(v(VDD33)-v(S2L61)))/1k
BS2L62 S2L62 VSS I=(v(S2L62)-v(VDD33)/(1+exp((62+0.5-(63-v(C2R)))/0.15)))/1k
BS2LN62 S2LN62 VSS I=(v(S2LN62)-(v(VDD33)-v(S2L62)))/1k
CSEL0 SEL0 VSS 2p
CSELN0 SELN0 VSS 2p
CS2L0 S2L0 VSS 2p
CS2LN0 S2LN0 VSS 2p
CSEL1 SEL1 VSS 2p
CSELN1 SELN1 VSS 2p
CS2L1 S2L1 VSS 2p
CS2LN1 S2LN1 VSS 2p
CSEL2 SEL2 VSS 2p
CSELN2 SELN2 VSS 2p
CS2L2 S2L2 VSS 2p
CS2LN2 S2LN2 VSS 2p
CSEL3 SEL3 VSS 2p
CSELN3 SELN3 VSS 2p
CS2L3 S2L3 VSS 2p
CS2LN3 S2LN3 VSS 2p
CSEL4 SEL4 VSS 2p
CSELN4 SELN4 VSS 2p
CS2L4 S2L4 VSS 2p
CS2LN4 S2LN4 VSS 2p
CSEL5 SEL5 VSS 2p
CSELN5 SELN5 VSS 2p
CS2L5 S2L5 VSS 2p
CS2LN5 S2LN5 VSS 2p
CSEL6 SEL6 VSS 2p
CSELN6 SELN6 VSS 2p
CS2L6 S2L6 VSS 2p
CS2LN6 S2LN6 VSS 2p
CSEL7 SEL7 VSS 2p
CSELN7 SELN7 VSS 2p
CS2L7 S2L7 VSS 2p
CS2LN7 S2LN7 VSS 2p
CSEL8 SEL8 VSS 2p
CSELN8 SELN8 VSS 2p
CS2L8 S2L8 VSS 2p
CS2LN8 S2LN8 VSS 2p
CSEL9 SEL9 VSS 2p
CSELN9 SELN9 VSS 2p
CS2L9 S2L9 VSS 2p
CS2LN9 S2LN9 VSS 2p
CSEL10 SEL10 VSS 2p
CSELN10 SELN10 VSS 2p
CS2L10 S2L10 VSS 2p
CS2LN10 S2LN10 VSS 2p
CSEL11 SEL11 VSS 2p
CSELN11 SELN11 VSS 2p
CS2L11 S2L11 VSS 2p
CS2LN11 S2LN11 VSS 2p
CSEL12 SEL12 VSS 2p
CSELN12 SELN12 VSS 2p
CS2L12 S2L12 VSS 2p
CS2LN12 S2LN12 VSS 2p
CSEL13 SEL13 VSS 2p
CSELN13 SELN13 VSS 2p
CS2L13 S2L13 VSS 2p
CS2LN13 S2LN13 VSS 2p
CSEL14 SEL14 VSS 2p
CSELN14 SELN14 VSS 2p
CS2L14 S2L14 VSS 2p
CS2LN14 S2LN14 VSS 2p
CSEL15 SEL15 VSS 2p
CSELN15 SELN15 VSS 2p
CS2L15 S2L15 VSS 2p
CS2LN15 S2LN15 VSS 2p
CSEL16 SEL16 VSS 2p
CSELN16 SELN16 VSS 2p
CS2L16 S2L16 VSS 2p
CS2LN16 S2LN16 VSS 2p
CSEL17 SEL17 VSS 2p
CSELN17 SELN17 VSS 2p
CS2L17 S2L17 VSS 2p
CS2LN17 S2LN17 VSS 2p
CSEL18 SEL18 VSS 2p
CSELN18 SELN18 VSS 2p
CS2L18 S2L18 VSS 2p
CS2LN18 S2LN18 VSS 2p
CSEL19 SEL19 VSS 2p
CSELN19 SELN19 VSS 2p
CS2L19 S2L19 VSS 2p
CS2LN19 S2LN19 VSS 2p
CSEL20 SEL20 VSS 2p
CSELN20 SELN20 VSS 2p
CS2L20 S2L20 VSS 2p
CS2LN20 S2LN20 VSS 2p
CSEL21 SEL21 VSS 2p
CSELN21 SELN21 VSS 2p
CS2L21 S2L21 VSS 2p
CS2LN21 S2LN21 VSS 2p
CSEL22 SEL22 VSS 2p
CSELN22 SELN22 VSS 2p
CS2L22 S2L22 VSS 2p
CS2LN22 S2LN22 VSS 2p
CSEL23 SEL23 VSS 2p
CSELN23 SELN23 VSS 2p
CS2L23 S2L23 VSS 2p
CS2LN23 S2LN23 VSS 2p
CSEL24 SEL24 VSS 2p
CSELN24 SELN24 VSS 2p
CS2L24 S2L24 VSS 2p
CS2LN24 S2LN24 VSS 2p
CSEL25 SEL25 VSS 2p
CSELN25 SELN25 VSS 2p
CS2L25 S2L25 VSS 2p
CS2LN25 S2LN25 VSS 2p
CSEL26 SEL26 VSS 2p
CSELN26 SELN26 VSS 2p
CS2L26 S2L26 VSS 2p
CS2LN26 S2LN26 VSS 2p
CSEL27 SEL27 VSS 2p
CSELN27 SELN27 VSS 2p
CS2L27 S2L27 VSS 2p
CS2LN27 S2LN27 VSS 2p
CSEL28 SEL28 VSS 2p
CSELN28 SELN28 VSS 2p
CS2L28 S2L28 VSS 2p
CS2LN28 S2LN28 VSS 2p
CSEL29 SEL29 VSS 2p
CSELN29 SELN29 VSS 2p
CS2L29 S2L29 VSS 2p
CS2LN29 S2LN29 VSS 2p
CSEL30 SEL30 VSS 2p
CSELN30 SELN30 VSS 2p
CS2L30 S2L30 VSS 2p
CS2LN30 S2LN30 VSS 2p
CSEL31 SEL31 VSS 2p
CSELN31 SELN31 VSS 2p
CS2L31 S2L31 VSS 2p
CS2LN31 S2LN31 VSS 2p
CSEL32 SEL32 VSS 2p
CSELN32 SELN32 VSS 2p
CS2L32 S2L32 VSS 2p
CS2LN32 S2LN32 VSS 2p
CSEL33 SEL33 VSS 2p
CSELN33 SELN33 VSS 2p
CS2L33 S2L33 VSS 2p
CS2LN33 S2LN33 VSS 2p
CSEL34 SEL34 VSS 2p
CSELN34 SELN34 VSS 2p
CS2L34 S2L34 VSS 2p
CS2LN34 S2LN34 VSS 2p
CSEL35 SEL35 VSS 2p
CSELN35 SELN35 VSS 2p
CS2L35 S2L35 VSS 2p
CS2LN35 S2LN35 VSS 2p
CSEL36 SEL36 VSS 2p
CSELN36 SELN36 VSS 2p
CS2L36 S2L36 VSS 2p
CS2LN36 S2LN36 VSS 2p
CSEL37 SEL37 VSS 2p
CSELN37 SELN37 VSS 2p
CS2L37 S2L37 VSS 2p
CS2LN37 S2LN37 VSS 2p
CSEL38 SEL38 VSS 2p
CSELN38 SELN38 VSS 2p
CS2L38 S2L38 VSS 2p
CS2LN38 S2LN38 VSS 2p
CSEL39 SEL39 VSS 2p
CSELN39 SELN39 VSS 2p
CS2L39 S2L39 VSS 2p
CS2LN39 S2LN39 VSS 2p
CSEL40 SEL40 VSS 2p
CSELN40 SELN40 VSS 2p
CS2L40 S2L40 VSS 2p
CS2LN40 S2LN40 VSS 2p
CSEL41 SEL41 VSS 2p
CSELN41 SELN41 VSS 2p
CS2L41 S2L41 VSS 2p
CS2LN41 S2LN41 VSS 2p
CSEL42 SEL42 VSS 2p
CSELN42 SELN42 VSS 2p
CS2L42 S2L42 VSS 2p
CS2LN42 S2LN42 VSS 2p
CSEL43 SEL43 VSS 2p
CSELN43 SELN43 VSS 2p
CS2L43 S2L43 VSS 2p
CS2LN43 S2LN43 VSS 2p
CSEL44 SEL44 VSS 2p
CSELN44 SELN44 VSS 2p
CS2L44 S2L44 VSS 2p
CS2LN44 S2LN44 VSS 2p
CSEL45 SEL45 VSS 2p
CSELN45 SELN45 VSS 2p
CS2L45 S2L45 VSS 2p
CS2LN45 S2LN45 VSS 2p
CSEL46 SEL46 VSS 2p
CSELN46 SELN46 VSS 2p
CS2L46 S2L46 VSS 2p
CS2LN46 S2LN46 VSS 2p
CSEL47 SEL47 VSS 2p
CSELN47 SELN47 VSS 2p
CS2L47 S2L47 VSS 2p
CS2LN47 S2LN47 VSS 2p
CSEL48 SEL48 VSS 2p
CSELN48 SELN48 VSS 2p
CS2L48 S2L48 VSS 2p
CS2LN48 S2LN48 VSS 2p
CSEL49 SEL49 VSS 2p
CSELN49 SELN49 VSS 2p
CS2L49 S2L49 VSS 2p
CS2LN49 S2LN49 VSS 2p
CSEL50 SEL50 VSS 2p
CSELN50 SELN50 VSS 2p
CS2L50 S2L50 VSS 2p
CS2LN50 S2LN50 VSS 2p
CSEL51 SEL51 VSS 2p
CSELN51 SELN51 VSS 2p
CS2L51 S2L51 VSS 2p
CS2LN51 S2LN51 VSS 2p
CSEL52 SEL52 VSS 2p
CSELN52 SELN52 VSS 2p
CS2L52 S2L52 VSS 2p
CS2LN52 S2LN52 VSS 2p
CSEL53 SEL53 VSS 2p
CSELN53 SELN53 VSS 2p
CS2L53 S2L53 VSS 2p
CS2LN53 S2LN53 VSS 2p
CSEL54 SEL54 VSS 2p
CSELN54 SELN54 VSS 2p
CS2L54 S2L54 VSS 2p
CS2LN54 S2LN54 VSS 2p
CSEL55 SEL55 VSS 2p
CSELN55 SELN55 VSS 2p
CS2L55 S2L55 VSS 2p
CS2LN55 S2LN55 VSS 2p
CSEL56 SEL56 VSS 2p
CSELN56 SELN56 VSS 2p
CS2L56 S2L56 VSS 2p
CS2LN56 S2LN56 VSS 2p
CSEL57 SEL57 VSS 2p
CSELN57 SELN57 VSS 2p
CS2L57 S2L57 VSS 2p
CS2LN57 S2LN57 VSS 2p
CSEL58 SEL58 VSS 2p
CSELN58 SELN58 VSS 2p
CS2L58 S2L58 VSS 2p
CS2LN58 S2LN58 VSS 2p
CSEL59 SEL59 VSS 2p
CSELN59 SELN59 VSS 2p
CS2L59 S2L59 VSS 2p
CS2LN59 S2LN59 VSS 2p
CSEL60 SEL60 VSS 2p
CSELN60 SELN60 VSS 2p
CS2L60 S2L60 VSS 2p
CS2LN60 S2LN60 VSS 2p
CSEL61 SEL61 VSS 2p
CSELN61 SELN61 VSS 2p
CS2L61 S2L61 VSS 2p
CS2LN61 S2LN61 VSS 2p
CSEL62 SEL62 VSS 2p
CSELN62 SELN62 VSS 2p
CS2L62 S2L62 VSS 2p
CS2LN62 S2LN62 VSS 2p
CCSUM CSUM VSS 0.5p
.ends gf180_sdm3_mod_mb
