* gf180_sdm3_mb.spice - 4-bit (15-level) sdm3 variant for fs=512 kHz
* GENERATED by gen_sdm3_mb.py - do not edit by hand.
* Requires: gf180_afe_cells.spice (OTA/TG/bias) + gf180_sdm3.spice
* (strongarm, nand2, inv). Loop timing/coefficients identical to sdm3.
* Flash thresholds and DWA/thermometer logic are BEHAVIORAL (ideal
* sources / B-sources) - silicon needs a ladder + DWA RTL.

* ---- 15-level flash: strongarm + SR latch per slice ----
* H_i=1 <=> O2D > theta_i, theta_i=(i-7)*6.25mV; H_i is the latch's NBIT
* terminal (BIT_i=1 <=> O2D<theta_i, same convention as 1-bit sdm3).
.subckt gf180_sdm3_flash15 O2P O2N CMPCK VDD33 VSS H0 H1 H2 H3 H4 H5 H6 H7 H8 H9 H10 H11 H12 H13 H14
* slice 0: theta=-43.75 mV diff
VOFFP0 O2P INPP0 2.187500e-02
VOFFN0 O2N INNN0 -2.187500e-02
XCMP0 INPP0 INNN0 QP0 QN0 CMPCK VDD33 VSS gf180_strongarm
CQP0 QP0 VSS 0.5p
CQN0 QN0 VSS 0.5p
XND10 QP0 H0 BIT0 VDD33 VSS gf180_sdm3_nand2
XND20 QN0 BIT0 H0 VDD33 VSS gf180_sdm3_nand2
* slice 1: theta=-37.50 mV diff
VOFFP1 O2P INPP1 1.875000e-02
VOFFN1 O2N INNN1 -1.875000e-02
XCMP1 INPP1 INNN1 QP1 QN1 CMPCK VDD33 VSS gf180_strongarm
CQP1 QP1 VSS 0.5p
CQN1 QN1 VSS 0.5p
XND11 QP1 H1 BIT1 VDD33 VSS gf180_sdm3_nand2
XND21 QN1 BIT1 H1 VDD33 VSS gf180_sdm3_nand2
* slice 2: theta=-31.25 mV diff
VOFFP2 O2P INPP2 1.562500e-02
VOFFN2 O2N INNN2 -1.562500e-02
XCMP2 INPP2 INNN2 QP2 QN2 CMPCK VDD33 VSS gf180_strongarm
CQP2 QP2 VSS 0.5p
CQN2 QN2 VSS 0.5p
XND12 QP2 H2 BIT2 VDD33 VSS gf180_sdm3_nand2
XND22 QN2 BIT2 H2 VDD33 VSS gf180_sdm3_nand2
* slice 3: theta=-25.00 mV diff
VOFFP3 O2P INPP3 1.250000e-02
VOFFN3 O2N INNN3 -1.250000e-02
XCMP3 INPP3 INNN3 QP3 QN3 CMPCK VDD33 VSS gf180_strongarm
CQP3 QP3 VSS 0.5p
CQN3 QN3 VSS 0.5p
XND13 QP3 H3 BIT3 VDD33 VSS gf180_sdm3_nand2
XND23 QN3 BIT3 H3 VDD33 VSS gf180_sdm3_nand2
* slice 4: theta=-18.75 mV diff
VOFFP4 O2P INPP4 9.375000e-03
VOFFN4 O2N INNN4 -9.375000e-03
XCMP4 INPP4 INNN4 QP4 QN4 CMPCK VDD33 VSS gf180_strongarm
CQP4 QP4 VSS 0.5p
CQN4 QN4 VSS 0.5p
XND14 QP4 H4 BIT4 VDD33 VSS gf180_sdm3_nand2
XND24 QN4 BIT4 H4 VDD33 VSS gf180_sdm3_nand2
* slice 5: theta=-12.50 mV diff
VOFFP5 O2P INPP5 6.250000e-03
VOFFN5 O2N INNN5 -6.250000e-03
XCMP5 INPP5 INNN5 QP5 QN5 CMPCK VDD33 VSS gf180_strongarm
CQP5 QP5 VSS 0.5p
CQN5 QN5 VSS 0.5p
XND15 QP5 H5 BIT5 VDD33 VSS gf180_sdm3_nand2
XND25 QN5 BIT5 H5 VDD33 VSS gf180_sdm3_nand2
* slice 6: theta=-6.25 mV diff
VOFFP6 O2P INPP6 3.125000e-03
VOFFN6 O2N INNN6 -3.125000e-03
XCMP6 INPP6 INNN6 QP6 QN6 CMPCK VDD33 VSS gf180_strongarm
CQP6 QP6 VSS 0.5p
CQN6 QN6 VSS 0.5p
XND16 QP6 H6 BIT6 VDD33 VSS gf180_sdm3_nand2
XND26 QN6 BIT6 H6 VDD33 VSS gf180_sdm3_nand2
* slice 7: theta=+0.00 mV diff
VOFFP7 O2P INPP7 -0.000000e+00
VOFFN7 O2N INNN7 0.000000e+00
XCMP7 INPP7 INNN7 QP7 QN7 CMPCK VDD33 VSS gf180_strongarm
CQP7 QP7 VSS 0.5p
CQN7 QN7 VSS 0.5p
XND17 QP7 H7 BIT7 VDD33 VSS gf180_sdm3_nand2
XND27 QN7 BIT7 H7 VDD33 VSS gf180_sdm3_nand2
* slice 8: theta=+6.25 mV diff
VOFFP8 O2P INPP8 -3.125000e-03
VOFFN8 O2N INNN8 3.125000e-03
XCMP8 INPP8 INNN8 QP8 QN8 CMPCK VDD33 VSS gf180_strongarm
CQP8 QP8 VSS 0.5p
CQN8 QN8 VSS 0.5p
XND18 QP8 H8 BIT8 VDD33 VSS gf180_sdm3_nand2
XND28 QN8 BIT8 H8 VDD33 VSS gf180_sdm3_nand2
* slice 9: theta=+12.50 mV diff
VOFFP9 O2P INPP9 -6.250000e-03
VOFFN9 O2N INNN9 6.250000e-03
XCMP9 INPP9 INNN9 QP9 QN9 CMPCK VDD33 VSS gf180_strongarm
CQP9 QP9 VSS 0.5p
CQN9 QN9 VSS 0.5p
XND19 QP9 H9 BIT9 VDD33 VSS gf180_sdm3_nand2
XND29 QN9 BIT9 H9 VDD33 VSS gf180_sdm3_nand2
* slice 10: theta=+18.75 mV diff
VOFFP10 O2P INPP10 -9.375000e-03
VOFFN10 O2N INNN10 9.375000e-03
XCMP10 INPP10 INNN10 QP10 QN10 CMPCK VDD33 VSS gf180_strongarm
CQP10 QP10 VSS 0.5p
CQN10 QN10 VSS 0.5p
XND110 QP10 H10 BIT10 VDD33 VSS gf180_sdm3_nand2
XND210 QN10 BIT10 H10 VDD33 VSS gf180_sdm3_nand2
* slice 11: theta=+25.00 mV diff
VOFFP11 O2P INPP11 -1.250000e-02
VOFFN11 O2N INNN11 1.250000e-02
XCMP11 INPP11 INNN11 QP11 QN11 CMPCK VDD33 VSS gf180_strongarm
CQP11 QP11 VSS 0.5p
CQN11 QN11 VSS 0.5p
XND111 QP11 H11 BIT11 VDD33 VSS gf180_sdm3_nand2
XND211 QN11 BIT11 H11 VDD33 VSS gf180_sdm3_nand2
* slice 12: theta=+31.25 mV diff
VOFFP12 O2P INPP12 -1.562500e-02
VOFFN12 O2N INNN12 1.562500e-02
XCMP12 INPP12 INNN12 QP12 QN12 CMPCK VDD33 VSS gf180_strongarm
CQP12 QP12 VSS 0.5p
CQN12 QN12 VSS 0.5p
XND112 QP12 H12 BIT12 VDD33 VSS gf180_sdm3_nand2
XND212 QN12 BIT12 H12 VDD33 VSS gf180_sdm3_nand2
* slice 13: theta=+37.50 mV diff
VOFFP13 O2P INPP13 -1.875000e-02
VOFFN13 O2N INNN13 1.875000e-02
XCMP13 INPP13 INNN13 QP13 QN13 CMPCK VDD33 VSS gf180_strongarm
CQP13 QP13 VSS 0.5p
CQN13 QN13 VSS 0.5p
XND113 QP13 H13 BIT13 VDD33 VSS gf180_sdm3_nand2
XND213 QN13 BIT13 H13 VDD33 VSS gf180_sdm3_nand2
* slice 14: theta=+43.75 mV diff
VOFFP14 O2P INPP14 -2.187500e-02
VOFFN14 O2N INNN14 2.187500e-02
XCMP14 INPP14 INNN14 QP14 QN14 CMPCK VDD33 VSS gf180_strongarm
CQP14 QP14 VSS 0.5p
CQN14 QN14 VSS 0.5p
XND114 QP14 H14 BIT14 VDD33 VSS gf180_sdm3_nand2
XND214 QN14 BIT14 H14 VDD33 VSS gf180_sdm3_nand2
.ends gf180_sdm3_flash15

* ---- int1 mb: CS=16p sampled input + 15x1p/side direct DAC, CI=8p ----
* SELP_j/SELN_j: 0/VDD level, unit j P-side left plate -> VP if SELP_j,
* else VN during PH2 (complement on N side: SELN_j=1 -> NP side to VP).
.subckt gf180_sdm3_int1_mb INP_S INN_S VCM_REF VP VN OUTP OUTN PH1 NPH1 PH2 NPH2 VDD33 VSS SP0 SP1 SP2 SP3 SP4 SP5 SP6 SP7 SP8 SP9 SP10 SP11 SP12 SP13 SP14 SN0 SN1 SN2 SN3 SN4 SN5 SN6 SN7 SN8 SN9 SN10 SN11 SN12 SN13 SN14 params: CS=16p CU=1p CI=8p W91=11u L91=2u W92=6u L92=2u W10=12u RSET=25k CC=10p
XOTA INP INN VCM_REF OUTP OUTN VDD33 VSS gf180_fd_ota_full2_nc W91={W91} L91={L91} W92={W92} L92={L92} W10={W10} RSET={RSET} CC={CC}
CSP CSLP CSRP {CS}
CSN CSLN CSRN {CS}
XS1A CSLP INP_S PH1 NPH1 VDD33 VSS gf180_tg_lowq
XS1B CSRP VCM_REF PH1 NPH1 VDD33 VSS gf180_tg_lowq
XS1C CSLN INN_S PH1 NPH1 VDD33 VSS gf180_tg_lowq
XS1D CSRN VCM_REF PH1 NPH1 VDD33 VSS gf180_tg_lowq
XS2A CSLP VCM_REF PH2 NPH2 VDD33 VSS gf180_tg_lowq
XS2B CSRP INP PH2 NPH2 VDD33 VSS gf180_tg_lowq
XS2C CSLN VCM_REF PH2 NPH2 VDD33 VSS gf180_tg_lowq
XS2D CSRN INN PH2 NPH2 VDD33 VSS gf180_tg_lowq
* DAC unit 0 (P side DP0, N side DN0)
CDP0 CDLP0 CDRP0 {CU}
CDN0 CDLN0 CDRN0 {CU}
XDPA0 CDLP0 VCM_REF PH1 NPH1 VDD33 VSS gf180_tg_lowq
XDPB0 CDRP0 VCM_REF PH1 NPH1 VDD33 VSS gf180_tg_lowq
XDNA0 CDLN0 VCM_REF PH1 NPH1 VDD33 VSS gf180_tg_lowq
XDNB0 CDRN0 VCM_REF PH1 NPH1 VDD33 VSS gf180_tg_lowq
XDP20 CDRP0 INP PH2 NPH2 VDD33 VSS gf180_tg_lowq
XDN20 CDRN0 INN PH2 NPH2 VDD33 VSS gf180_tg_lowq
BGPP0 GPP0 0 V=v(PH2)*v(SP0)/v(VDD33)
BGPN0 GPN0 0 V=v(PH2)*(v(VDD33)-v(SP0))/v(VDD33)
BGNP0 GNP0 0 V=v(PH2)*v(SN0)/v(VDD33)
BGNN0 GNN0 0 V=v(PH2)*(v(VDD33)-v(SN0))/v(VDD33)
BNOPP0 NGPP0 0 V=v(VDD33)-v(GPP0)
BNOPN0 NGPN0 0 V=v(VDD33)-v(GPN0)
BNONP0 NGNP0 0 V=v(VDD33)-v(GNP0)
BNONN0 NGNN0 0 V=v(VDD33)-v(GNN0)
XPVP0 CDLP0 VP GPP0 NGPP0 VDD33 VSS gf180_tg_lowq
XPVN0 CDLP0 VN GPN0 NGPN0 VDD33 VSS gf180_tg_lowq
XNVP0 CDLN0 VP GNP0 NGNP0 VDD33 VSS gf180_tg_lowq
XNVN0 CDLN0 VN GNN0 NGNN0 VDD33 VSS gf180_tg_lowq
* DAC unit 1 (P side DP1, N side DN1)
CDP1 CDLP1 CDRP1 {CU}
CDN1 CDLN1 CDRN1 {CU}
XDPA1 CDLP1 VCM_REF PH1 NPH1 VDD33 VSS gf180_tg_lowq
XDPB1 CDRP1 VCM_REF PH1 NPH1 VDD33 VSS gf180_tg_lowq
XDNA1 CDLN1 VCM_REF PH1 NPH1 VDD33 VSS gf180_tg_lowq
XDNB1 CDRN1 VCM_REF PH1 NPH1 VDD33 VSS gf180_tg_lowq
XDP21 CDRP1 INP PH2 NPH2 VDD33 VSS gf180_tg_lowq
XDN21 CDRN1 INN PH2 NPH2 VDD33 VSS gf180_tg_lowq
BGPP1 GPP1 0 V=v(PH2)*v(SP1)/v(VDD33)
BGPN1 GPN1 0 V=v(PH2)*(v(VDD33)-v(SP1))/v(VDD33)
BGNP1 GNP1 0 V=v(PH2)*v(SN1)/v(VDD33)
BGNN1 GNN1 0 V=v(PH2)*(v(VDD33)-v(SN1))/v(VDD33)
BNOPP1 NGPP1 0 V=v(VDD33)-v(GPP1)
BNOPN1 NGPN1 0 V=v(VDD33)-v(GPN1)
BNONP1 NGNP1 0 V=v(VDD33)-v(GNP1)
BNONN1 NGNN1 0 V=v(VDD33)-v(GNN1)
XPVP1 CDLP1 VP GPP1 NGPP1 VDD33 VSS gf180_tg_lowq
XPVN1 CDLP1 VN GPN1 NGPN1 VDD33 VSS gf180_tg_lowq
XNVP1 CDLN1 VP GNP1 NGNP1 VDD33 VSS gf180_tg_lowq
XNVN1 CDLN1 VN GNN1 NGNN1 VDD33 VSS gf180_tg_lowq
* DAC unit 2 (P side DP2, N side DN2)
CDP2 CDLP2 CDRP2 {CU}
CDN2 CDLN2 CDRN2 {CU}
XDPA2 CDLP2 VCM_REF PH1 NPH1 VDD33 VSS gf180_tg_lowq
XDPB2 CDRP2 VCM_REF PH1 NPH1 VDD33 VSS gf180_tg_lowq
XDNA2 CDLN2 VCM_REF PH1 NPH1 VDD33 VSS gf180_tg_lowq
XDNB2 CDRN2 VCM_REF PH1 NPH1 VDD33 VSS gf180_tg_lowq
XDP22 CDRP2 INP PH2 NPH2 VDD33 VSS gf180_tg_lowq
XDN22 CDRN2 INN PH2 NPH2 VDD33 VSS gf180_tg_lowq
BGPP2 GPP2 0 V=v(PH2)*v(SP2)/v(VDD33)
BGPN2 GPN2 0 V=v(PH2)*(v(VDD33)-v(SP2))/v(VDD33)
BGNP2 GNP2 0 V=v(PH2)*v(SN2)/v(VDD33)
BGNN2 GNN2 0 V=v(PH2)*(v(VDD33)-v(SN2))/v(VDD33)
BNOPP2 NGPP2 0 V=v(VDD33)-v(GPP2)
BNOPN2 NGPN2 0 V=v(VDD33)-v(GPN2)
BNONP2 NGNP2 0 V=v(VDD33)-v(GNP2)
BNONN2 NGNN2 0 V=v(VDD33)-v(GNN2)
XPVP2 CDLP2 VP GPP2 NGPP2 VDD33 VSS gf180_tg_lowq
XPVN2 CDLP2 VN GPN2 NGPN2 VDD33 VSS gf180_tg_lowq
XNVP2 CDLN2 VP GNP2 NGNP2 VDD33 VSS gf180_tg_lowq
XNVN2 CDLN2 VN GNN2 NGNN2 VDD33 VSS gf180_tg_lowq
* DAC unit 3 (P side DP3, N side DN3)
CDP3 CDLP3 CDRP3 {CU}
CDN3 CDLN3 CDRN3 {CU}
XDPA3 CDLP3 VCM_REF PH1 NPH1 VDD33 VSS gf180_tg_lowq
XDPB3 CDRP3 VCM_REF PH1 NPH1 VDD33 VSS gf180_tg_lowq
XDNA3 CDLN3 VCM_REF PH1 NPH1 VDD33 VSS gf180_tg_lowq
XDNB3 CDRN3 VCM_REF PH1 NPH1 VDD33 VSS gf180_tg_lowq
XDP23 CDRP3 INP PH2 NPH2 VDD33 VSS gf180_tg_lowq
XDN23 CDRN3 INN PH2 NPH2 VDD33 VSS gf180_tg_lowq
BGPP3 GPP3 0 V=v(PH2)*v(SP3)/v(VDD33)
BGPN3 GPN3 0 V=v(PH2)*(v(VDD33)-v(SP3))/v(VDD33)
BGNP3 GNP3 0 V=v(PH2)*v(SN3)/v(VDD33)
BGNN3 GNN3 0 V=v(PH2)*(v(VDD33)-v(SN3))/v(VDD33)
BNOPP3 NGPP3 0 V=v(VDD33)-v(GPP3)
BNOPN3 NGPN3 0 V=v(VDD33)-v(GPN3)
BNONP3 NGNP3 0 V=v(VDD33)-v(GNP3)
BNONN3 NGNN3 0 V=v(VDD33)-v(GNN3)
XPVP3 CDLP3 VP GPP3 NGPP3 VDD33 VSS gf180_tg_lowq
XPVN3 CDLP3 VN GPN3 NGPN3 VDD33 VSS gf180_tg_lowq
XNVP3 CDLN3 VP GNP3 NGNP3 VDD33 VSS gf180_tg_lowq
XNVN3 CDLN3 VN GNN3 NGNN3 VDD33 VSS gf180_tg_lowq
* DAC unit 4 (P side DP4, N side DN4)
CDP4 CDLP4 CDRP4 {CU}
CDN4 CDLN4 CDRN4 {CU}
XDPA4 CDLP4 VCM_REF PH1 NPH1 VDD33 VSS gf180_tg_lowq
XDPB4 CDRP4 VCM_REF PH1 NPH1 VDD33 VSS gf180_tg_lowq
XDNA4 CDLN4 VCM_REF PH1 NPH1 VDD33 VSS gf180_tg_lowq
XDNB4 CDRN4 VCM_REF PH1 NPH1 VDD33 VSS gf180_tg_lowq
XDP24 CDRP4 INP PH2 NPH2 VDD33 VSS gf180_tg_lowq
XDN24 CDRN4 INN PH2 NPH2 VDD33 VSS gf180_tg_lowq
BGPP4 GPP4 0 V=v(PH2)*v(SP4)/v(VDD33)
BGPN4 GPN4 0 V=v(PH2)*(v(VDD33)-v(SP4))/v(VDD33)
BGNP4 GNP4 0 V=v(PH2)*v(SN4)/v(VDD33)
BGNN4 GNN4 0 V=v(PH2)*(v(VDD33)-v(SN4))/v(VDD33)
BNOPP4 NGPP4 0 V=v(VDD33)-v(GPP4)
BNOPN4 NGPN4 0 V=v(VDD33)-v(GPN4)
BNONP4 NGNP4 0 V=v(VDD33)-v(GNP4)
BNONN4 NGNN4 0 V=v(VDD33)-v(GNN4)
XPVP4 CDLP4 VP GPP4 NGPP4 VDD33 VSS gf180_tg_lowq
XPVN4 CDLP4 VN GPN4 NGPN4 VDD33 VSS gf180_tg_lowq
XNVP4 CDLN4 VP GNP4 NGNP4 VDD33 VSS gf180_tg_lowq
XNVN4 CDLN4 VN GNN4 NGNN4 VDD33 VSS gf180_tg_lowq
* DAC unit 5 (P side DP5, N side DN5)
CDP5 CDLP5 CDRP5 {CU}
CDN5 CDLN5 CDRN5 {CU}
XDPA5 CDLP5 VCM_REF PH1 NPH1 VDD33 VSS gf180_tg_lowq
XDPB5 CDRP5 VCM_REF PH1 NPH1 VDD33 VSS gf180_tg_lowq
XDNA5 CDLN5 VCM_REF PH1 NPH1 VDD33 VSS gf180_tg_lowq
XDNB5 CDRN5 VCM_REF PH1 NPH1 VDD33 VSS gf180_tg_lowq
XDP25 CDRP5 INP PH2 NPH2 VDD33 VSS gf180_tg_lowq
XDN25 CDRN5 INN PH2 NPH2 VDD33 VSS gf180_tg_lowq
BGPP5 GPP5 0 V=v(PH2)*v(SP5)/v(VDD33)
BGPN5 GPN5 0 V=v(PH2)*(v(VDD33)-v(SP5))/v(VDD33)
BGNP5 GNP5 0 V=v(PH2)*v(SN5)/v(VDD33)
BGNN5 GNN5 0 V=v(PH2)*(v(VDD33)-v(SN5))/v(VDD33)
BNOPP5 NGPP5 0 V=v(VDD33)-v(GPP5)
BNOPN5 NGPN5 0 V=v(VDD33)-v(GPN5)
BNONP5 NGNP5 0 V=v(VDD33)-v(GNP5)
BNONN5 NGNN5 0 V=v(VDD33)-v(GNN5)
XPVP5 CDLP5 VP GPP5 NGPP5 VDD33 VSS gf180_tg_lowq
XPVN5 CDLP5 VN GPN5 NGPN5 VDD33 VSS gf180_tg_lowq
XNVP5 CDLN5 VP GNP5 NGNP5 VDD33 VSS gf180_tg_lowq
XNVN5 CDLN5 VN GNN5 NGNN5 VDD33 VSS gf180_tg_lowq
* DAC unit 6 (P side DP6, N side DN6)
CDP6 CDLP6 CDRP6 {CU}
CDN6 CDLN6 CDRN6 {CU}
XDPA6 CDLP6 VCM_REF PH1 NPH1 VDD33 VSS gf180_tg_lowq
XDPB6 CDRP6 VCM_REF PH1 NPH1 VDD33 VSS gf180_tg_lowq
XDNA6 CDLN6 VCM_REF PH1 NPH1 VDD33 VSS gf180_tg_lowq
XDNB6 CDRN6 VCM_REF PH1 NPH1 VDD33 VSS gf180_tg_lowq
XDP26 CDRP6 INP PH2 NPH2 VDD33 VSS gf180_tg_lowq
XDN26 CDRN6 INN PH2 NPH2 VDD33 VSS gf180_tg_lowq
BGPP6 GPP6 0 V=v(PH2)*v(SP6)/v(VDD33)
BGPN6 GPN6 0 V=v(PH2)*(v(VDD33)-v(SP6))/v(VDD33)
BGNP6 GNP6 0 V=v(PH2)*v(SN6)/v(VDD33)
BGNN6 GNN6 0 V=v(PH2)*(v(VDD33)-v(SN6))/v(VDD33)
BNOPP6 NGPP6 0 V=v(VDD33)-v(GPP6)
BNOPN6 NGPN6 0 V=v(VDD33)-v(GPN6)
BNONP6 NGNP6 0 V=v(VDD33)-v(GNP6)
BNONN6 NGNN6 0 V=v(VDD33)-v(GNN6)
XPVP6 CDLP6 VP GPP6 NGPP6 VDD33 VSS gf180_tg_lowq
XPVN6 CDLP6 VN GPN6 NGPN6 VDD33 VSS gf180_tg_lowq
XNVP6 CDLN6 VP GNP6 NGNP6 VDD33 VSS gf180_tg_lowq
XNVN6 CDLN6 VN GNN6 NGNN6 VDD33 VSS gf180_tg_lowq
* DAC unit 7 (P side DP7, N side DN7)
CDP7 CDLP7 CDRP7 {CU}
CDN7 CDLN7 CDRN7 {CU}
XDPA7 CDLP7 VCM_REF PH1 NPH1 VDD33 VSS gf180_tg_lowq
XDPB7 CDRP7 VCM_REF PH1 NPH1 VDD33 VSS gf180_tg_lowq
XDNA7 CDLN7 VCM_REF PH1 NPH1 VDD33 VSS gf180_tg_lowq
XDNB7 CDRN7 VCM_REF PH1 NPH1 VDD33 VSS gf180_tg_lowq
XDP27 CDRP7 INP PH2 NPH2 VDD33 VSS gf180_tg_lowq
XDN27 CDRN7 INN PH2 NPH2 VDD33 VSS gf180_tg_lowq
BGPP7 GPP7 0 V=v(PH2)*v(SP7)/v(VDD33)
BGPN7 GPN7 0 V=v(PH2)*(v(VDD33)-v(SP7))/v(VDD33)
BGNP7 GNP7 0 V=v(PH2)*v(SN7)/v(VDD33)
BGNN7 GNN7 0 V=v(PH2)*(v(VDD33)-v(SN7))/v(VDD33)
BNOPP7 NGPP7 0 V=v(VDD33)-v(GPP7)
BNOPN7 NGPN7 0 V=v(VDD33)-v(GPN7)
BNONP7 NGNP7 0 V=v(VDD33)-v(GNP7)
BNONN7 NGNN7 0 V=v(VDD33)-v(GNN7)
XPVP7 CDLP7 VP GPP7 NGPP7 VDD33 VSS gf180_tg_lowq
XPVN7 CDLP7 VN GPN7 NGPN7 VDD33 VSS gf180_tg_lowq
XNVP7 CDLN7 VP GNP7 NGNP7 VDD33 VSS gf180_tg_lowq
XNVN7 CDLN7 VN GNN7 NGNN7 VDD33 VSS gf180_tg_lowq
* DAC unit 8 (P side DP8, N side DN8)
CDP8 CDLP8 CDRP8 {CU}
CDN8 CDLN8 CDRN8 {CU}
XDPA8 CDLP8 VCM_REF PH1 NPH1 VDD33 VSS gf180_tg_lowq
XDPB8 CDRP8 VCM_REF PH1 NPH1 VDD33 VSS gf180_tg_lowq
XDNA8 CDLN8 VCM_REF PH1 NPH1 VDD33 VSS gf180_tg_lowq
XDNB8 CDRN8 VCM_REF PH1 NPH1 VDD33 VSS gf180_tg_lowq
XDP28 CDRP8 INP PH2 NPH2 VDD33 VSS gf180_tg_lowq
XDN28 CDRN8 INN PH2 NPH2 VDD33 VSS gf180_tg_lowq
BGPP8 GPP8 0 V=v(PH2)*v(SP8)/v(VDD33)
BGPN8 GPN8 0 V=v(PH2)*(v(VDD33)-v(SP8))/v(VDD33)
BGNP8 GNP8 0 V=v(PH2)*v(SN8)/v(VDD33)
BGNN8 GNN8 0 V=v(PH2)*(v(VDD33)-v(SN8))/v(VDD33)
BNOPP8 NGPP8 0 V=v(VDD33)-v(GPP8)
BNOPN8 NGPN8 0 V=v(VDD33)-v(GPN8)
BNONP8 NGNP8 0 V=v(VDD33)-v(GNP8)
BNONN8 NGNN8 0 V=v(VDD33)-v(GNN8)
XPVP8 CDLP8 VP GPP8 NGPP8 VDD33 VSS gf180_tg_lowq
XPVN8 CDLP8 VN GPN8 NGPN8 VDD33 VSS gf180_tg_lowq
XNVP8 CDLN8 VP GNP8 NGNP8 VDD33 VSS gf180_tg_lowq
XNVN8 CDLN8 VN GNN8 NGNN8 VDD33 VSS gf180_tg_lowq
* DAC unit 9 (P side DP9, N side DN9)
CDP9 CDLP9 CDRP9 {CU}
CDN9 CDLN9 CDRN9 {CU}
XDPA9 CDLP9 VCM_REF PH1 NPH1 VDD33 VSS gf180_tg_lowq
XDPB9 CDRP9 VCM_REF PH1 NPH1 VDD33 VSS gf180_tg_lowq
XDNA9 CDLN9 VCM_REF PH1 NPH1 VDD33 VSS gf180_tg_lowq
XDNB9 CDRN9 VCM_REF PH1 NPH1 VDD33 VSS gf180_tg_lowq
XDP29 CDRP9 INP PH2 NPH2 VDD33 VSS gf180_tg_lowq
XDN29 CDRN9 INN PH2 NPH2 VDD33 VSS gf180_tg_lowq
BGPP9 GPP9 0 V=v(PH2)*v(SP9)/v(VDD33)
BGPN9 GPN9 0 V=v(PH2)*(v(VDD33)-v(SP9))/v(VDD33)
BGNP9 GNP9 0 V=v(PH2)*v(SN9)/v(VDD33)
BGNN9 GNN9 0 V=v(PH2)*(v(VDD33)-v(SN9))/v(VDD33)
BNOPP9 NGPP9 0 V=v(VDD33)-v(GPP9)
BNOPN9 NGPN9 0 V=v(VDD33)-v(GPN9)
BNONP9 NGNP9 0 V=v(VDD33)-v(GNP9)
BNONN9 NGNN9 0 V=v(VDD33)-v(GNN9)
XPVP9 CDLP9 VP GPP9 NGPP9 VDD33 VSS gf180_tg_lowq
XPVN9 CDLP9 VN GPN9 NGPN9 VDD33 VSS gf180_tg_lowq
XNVP9 CDLN9 VP GNP9 NGNP9 VDD33 VSS gf180_tg_lowq
XNVN9 CDLN9 VN GNN9 NGNN9 VDD33 VSS gf180_tg_lowq
* DAC unit 10 (P side DP10, N side DN10)
CDP10 CDLP10 CDRP10 {CU}
CDN10 CDLN10 CDRN10 {CU}
XDPA10 CDLP10 VCM_REF PH1 NPH1 VDD33 VSS gf180_tg_lowq
XDPB10 CDRP10 VCM_REF PH1 NPH1 VDD33 VSS gf180_tg_lowq
XDNA10 CDLN10 VCM_REF PH1 NPH1 VDD33 VSS gf180_tg_lowq
XDNB10 CDRN10 VCM_REF PH1 NPH1 VDD33 VSS gf180_tg_lowq
XDP210 CDRP10 INP PH2 NPH2 VDD33 VSS gf180_tg_lowq
XDN210 CDRN10 INN PH2 NPH2 VDD33 VSS gf180_tg_lowq
BGPP10 GPP10 0 V=v(PH2)*v(SP10)/v(VDD33)
BGPN10 GPN10 0 V=v(PH2)*(v(VDD33)-v(SP10))/v(VDD33)
BGNP10 GNP10 0 V=v(PH2)*v(SN10)/v(VDD33)
BGNN10 GNN10 0 V=v(PH2)*(v(VDD33)-v(SN10))/v(VDD33)
BNOPP10 NGPP10 0 V=v(VDD33)-v(GPP10)
BNOPN10 NGPN10 0 V=v(VDD33)-v(GPN10)
BNONP10 NGNP10 0 V=v(VDD33)-v(GNP10)
BNONN10 NGNN10 0 V=v(VDD33)-v(GNN10)
XPVP10 CDLP10 VP GPP10 NGPP10 VDD33 VSS gf180_tg_lowq
XPVN10 CDLP10 VN GPN10 NGPN10 VDD33 VSS gf180_tg_lowq
XNVP10 CDLN10 VP GNP10 NGNP10 VDD33 VSS gf180_tg_lowq
XNVN10 CDLN10 VN GNN10 NGNN10 VDD33 VSS gf180_tg_lowq
* DAC unit 11 (P side DP11, N side DN11)
CDP11 CDLP11 CDRP11 {CU}
CDN11 CDLN11 CDRN11 {CU}
XDPA11 CDLP11 VCM_REF PH1 NPH1 VDD33 VSS gf180_tg_lowq
XDPB11 CDRP11 VCM_REF PH1 NPH1 VDD33 VSS gf180_tg_lowq
XDNA11 CDLN11 VCM_REF PH1 NPH1 VDD33 VSS gf180_tg_lowq
XDNB11 CDRN11 VCM_REF PH1 NPH1 VDD33 VSS gf180_tg_lowq
XDP211 CDRP11 INP PH2 NPH2 VDD33 VSS gf180_tg_lowq
XDN211 CDRN11 INN PH2 NPH2 VDD33 VSS gf180_tg_lowq
BGPP11 GPP11 0 V=v(PH2)*v(SP11)/v(VDD33)
BGPN11 GPN11 0 V=v(PH2)*(v(VDD33)-v(SP11))/v(VDD33)
BGNP11 GNP11 0 V=v(PH2)*v(SN11)/v(VDD33)
BGNN11 GNN11 0 V=v(PH2)*(v(VDD33)-v(SN11))/v(VDD33)
BNOPP11 NGPP11 0 V=v(VDD33)-v(GPP11)
BNOPN11 NGPN11 0 V=v(VDD33)-v(GPN11)
BNONP11 NGNP11 0 V=v(VDD33)-v(GNP11)
BNONN11 NGNN11 0 V=v(VDD33)-v(GNN11)
XPVP11 CDLP11 VP GPP11 NGPP11 VDD33 VSS gf180_tg_lowq
XPVN11 CDLP11 VN GPN11 NGPN11 VDD33 VSS gf180_tg_lowq
XNVP11 CDLN11 VP GNP11 NGNP11 VDD33 VSS gf180_tg_lowq
XNVN11 CDLN11 VN GNN11 NGNN11 VDD33 VSS gf180_tg_lowq
* DAC unit 12 (P side DP12, N side DN12)
CDP12 CDLP12 CDRP12 {CU}
CDN12 CDLN12 CDRN12 {CU}
XDPA12 CDLP12 VCM_REF PH1 NPH1 VDD33 VSS gf180_tg_lowq
XDPB12 CDRP12 VCM_REF PH1 NPH1 VDD33 VSS gf180_tg_lowq
XDNA12 CDLN12 VCM_REF PH1 NPH1 VDD33 VSS gf180_tg_lowq
XDNB12 CDRN12 VCM_REF PH1 NPH1 VDD33 VSS gf180_tg_lowq
XDP212 CDRP12 INP PH2 NPH2 VDD33 VSS gf180_tg_lowq
XDN212 CDRN12 INN PH2 NPH2 VDD33 VSS gf180_tg_lowq
BGPP12 GPP12 0 V=v(PH2)*v(SP12)/v(VDD33)
BGPN12 GPN12 0 V=v(PH2)*(v(VDD33)-v(SP12))/v(VDD33)
BGNP12 GNP12 0 V=v(PH2)*v(SN12)/v(VDD33)
BGNN12 GNN12 0 V=v(PH2)*(v(VDD33)-v(SN12))/v(VDD33)
BNOPP12 NGPP12 0 V=v(VDD33)-v(GPP12)
BNOPN12 NGPN12 0 V=v(VDD33)-v(GPN12)
BNONP12 NGNP12 0 V=v(VDD33)-v(GNP12)
BNONN12 NGNN12 0 V=v(VDD33)-v(GNN12)
XPVP12 CDLP12 VP GPP12 NGPP12 VDD33 VSS gf180_tg_lowq
XPVN12 CDLP12 VN GPN12 NGPN12 VDD33 VSS gf180_tg_lowq
XNVP12 CDLN12 VP GNP12 NGNP12 VDD33 VSS gf180_tg_lowq
XNVN12 CDLN12 VN GNN12 NGNN12 VDD33 VSS gf180_tg_lowq
* DAC unit 13 (P side DP13, N side DN13)
CDP13 CDLP13 CDRP13 {CU}
CDN13 CDLN13 CDRN13 {CU}
XDPA13 CDLP13 VCM_REF PH1 NPH1 VDD33 VSS gf180_tg_lowq
XDPB13 CDRP13 VCM_REF PH1 NPH1 VDD33 VSS gf180_tg_lowq
XDNA13 CDLN13 VCM_REF PH1 NPH1 VDD33 VSS gf180_tg_lowq
XDNB13 CDRN13 VCM_REF PH1 NPH1 VDD33 VSS gf180_tg_lowq
XDP213 CDRP13 INP PH2 NPH2 VDD33 VSS gf180_tg_lowq
XDN213 CDRN13 INN PH2 NPH2 VDD33 VSS gf180_tg_lowq
BGPP13 GPP13 0 V=v(PH2)*v(SP13)/v(VDD33)
BGPN13 GPN13 0 V=v(PH2)*(v(VDD33)-v(SP13))/v(VDD33)
BGNP13 GNP13 0 V=v(PH2)*v(SN13)/v(VDD33)
BGNN13 GNN13 0 V=v(PH2)*(v(VDD33)-v(SN13))/v(VDD33)
BNOPP13 NGPP13 0 V=v(VDD33)-v(GPP13)
BNOPN13 NGPN13 0 V=v(VDD33)-v(GPN13)
BNONP13 NGNP13 0 V=v(VDD33)-v(GNP13)
BNONN13 NGNN13 0 V=v(VDD33)-v(GNN13)
XPVP13 CDLP13 VP GPP13 NGPP13 VDD33 VSS gf180_tg_lowq
XPVN13 CDLP13 VN GPN13 NGPN13 VDD33 VSS gf180_tg_lowq
XNVP13 CDLN13 VP GNP13 NGNP13 VDD33 VSS gf180_tg_lowq
XNVN13 CDLN13 VN GNN13 NGNN13 VDD33 VSS gf180_tg_lowq
* DAC unit 14 (P side DP14, N side DN14)
CDP14 CDLP14 CDRP14 {CU}
CDN14 CDLN14 CDRN14 {CU}
XDPA14 CDLP14 VCM_REF PH1 NPH1 VDD33 VSS gf180_tg_lowq
XDPB14 CDRP14 VCM_REF PH1 NPH1 VDD33 VSS gf180_tg_lowq
XDNA14 CDLN14 VCM_REF PH1 NPH1 VDD33 VSS gf180_tg_lowq
XDNB14 CDRN14 VCM_REF PH1 NPH1 VDD33 VSS gf180_tg_lowq
XDP214 CDRP14 INP PH2 NPH2 VDD33 VSS gf180_tg_lowq
XDN214 CDRN14 INN PH2 NPH2 VDD33 VSS gf180_tg_lowq
BGPP14 GPP14 0 V=v(PH2)*v(SP14)/v(VDD33)
BGPN14 GPN14 0 V=v(PH2)*(v(VDD33)-v(SP14))/v(VDD33)
BGNP14 GNP14 0 V=v(PH2)*v(SN14)/v(VDD33)
BGNN14 GNN14 0 V=v(PH2)*(v(VDD33)-v(SN14))/v(VDD33)
BNOPP14 NGPP14 0 V=v(VDD33)-v(GPP14)
BNOPN14 NGPN14 0 V=v(VDD33)-v(GPN14)
BNONP14 NGNP14 0 V=v(VDD33)-v(GNP14)
BNONN14 NGNN14 0 V=v(VDD33)-v(GNN14)
XPVP14 CDLP14 VP GPP14 NGPP14 VDD33 VSS gf180_tg_lowq
XPVN14 CDLP14 VN GPN14 NGPN14 VDD33 VSS gf180_tg_lowq
XNVP14 CDLN14 VP GNP14 NGNP14 VDD33 VSS gf180_tg_lowq
XNVN14 CDLN14 VN GNN14 NGNN14 VDD33 VSS gf180_tg_lowq
CIP OUTN INP {CI}
CIN OUTP INN {CI}
RBIASP INP VCM_REF 10G
RBIASN INN VCM_REF 10G
.ends gf180_sdm3_int1_mb

* ---- int2 mb: CS=2p, CI=4p, 15x0.25p/side DAC (S2P/S2N selects, PH1 int)
* int2 integrates during PH1 with the REGISTERED code (applied via S2*).
.subckt gf180_sdm3_int2_mb INP_S INN_S VCM_REF VP VN OUTP OUTN PH1 NPH1 PH2 NPH2 VDD33 VSS S2P0 S2P1 S2P2 S2P3 S2P4 S2P5 S2P6 S2P7 S2P8 S2P9 S2P10 S2P11 S2P12 S2P13 S2P14 S2N0 S2N1 S2N2 S2N3 S2N4 S2N5 S2N6 S2N7 S2N8 S2N9 S2N10 S2N11 S2N12 S2N13 S2N14 params: CS=2p CU=0.25p CI=4p W91=11u L91=2u W92=6u L92=2u W10=12u RSET=25k CC=10p
XOTA INP INN VCM_REF OUTP OUTN VDD33 VSS gf180_fd_ota_full2_nc W91={W91} L91={L91} W92={W92} L92={L92} W10={W10} RSET={RSET} CC={CC}
CSP CSLP CSRP {CS}
CSN CSLN CSRN {CS}
XS1A CSLP INP_S PH1 NPH1 VDD33 VSS gf180_tg_lowq
XS1B CSRP VCM_REF PH1 NPH1 VDD33 VSS gf180_tg_lowq
XS1C CSLN INN_S PH1 NPH1 VDD33 VSS gf180_tg_lowq
XS1D CSRN VCM_REF PH1 NPH1 VDD33 VSS gf180_tg_lowq
XS2A CSLP VCM_REF PH2 NPH2 VDD33 VSS gf180_tg_lowq
XS2B CSRP INP PH2 NPH2 VDD33 VSS gf180_tg_lowq
XS2C CSLN VCM_REF PH2 NPH2 VDD33 VSS gf180_tg_lowq
XS2D CSRN INN PH2 NPH2 VDD33 VSS gf180_tg_lowq
* DAC unit 0
CDP0 CDLP0 CDRP0 {CU}
CDN0 CDLN0 CDRN0 {CU}
XDP10 CDRP0 VCM_REF PH1 NPH1 VDD33 VSS gf180_tg_lowq
XDP20 CDRP0 INP PH2 NPH2 VDD33 VSS gf180_tg_lowq
XDN10 CDRN0 VCM_REF PH1 NPH1 VDD33 VSS gf180_tg_lowq
XDN20 CDRN0 INN PH2 NPH2 VDD33 VSS gf180_tg_lowq
BGPP0 GPP0 0 V=v(PH2)*v(S2P0)/v(VDD33)
BGPN0 GPN0 0 V=v(PH2)*(v(VDD33)-v(S2P0))/v(VDD33)
BGNP0 GNP0 0 V=v(PH2)*v(S2N0)/v(VDD33)
BGNN0 GNN0 0 V=v(PH2)*(v(VDD33)-v(S2N0))/v(VDD33)
BNOPP0 NGPP0 0 V=v(VDD33)-v(GPP0)
BNOPN0 NGPN0 0 V=v(VDD33)-v(GPN0)
BNONP0 NGNP0 0 V=v(VDD33)-v(GNP0)
BNONN0 NGNN0 0 V=v(VDD33)-v(GNN0)
XPVP0 CDLP0 VP GPP0 NGPP0 VDD33 VSS gf180_tg_lowq
XPVN0 CDLP0 VN GPN0 NGPN0 VDD33 VSS gf180_tg_lowq
XNVP0 CDLN0 VP GNP0 NGNP0 VDD33 VSS gf180_tg_lowq
XNVN0 CDLN0 VN GNN0 NGNN0 VDD33 VSS gf180_tg_lowq
XDPC0 CDLP0 VCM_REF PH1 NPH1 VDD33 VSS gf180_tg_lowq
XDNC0 CDLN0 VCM_REF PH1 NPH1 VDD33 VSS gf180_tg_lowq
* DAC unit 1
CDP1 CDLP1 CDRP1 {CU}
CDN1 CDLN1 CDRN1 {CU}
XDP11 CDRP1 VCM_REF PH1 NPH1 VDD33 VSS gf180_tg_lowq
XDP21 CDRP1 INP PH2 NPH2 VDD33 VSS gf180_tg_lowq
XDN11 CDRN1 VCM_REF PH1 NPH1 VDD33 VSS gf180_tg_lowq
XDN21 CDRN1 INN PH2 NPH2 VDD33 VSS gf180_tg_lowq
BGPP1 GPP1 0 V=v(PH2)*v(S2P1)/v(VDD33)
BGPN1 GPN1 0 V=v(PH2)*(v(VDD33)-v(S2P1))/v(VDD33)
BGNP1 GNP1 0 V=v(PH2)*v(S2N1)/v(VDD33)
BGNN1 GNN1 0 V=v(PH2)*(v(VDD33)-v(S2N1))/v(VDD33)
BNOPP1 NGPP1 0 V=v(VDD33)-v(GPP1)
BNOPN1 NGPN1 0 V=v(VDD33)-v(GPN1)
BNONP1 NGNP1 0 V=v(VDD33)-v(GNP1)
BNONN1 NGNN1 0 V=v(VDD33)-v(GNN1)
XPVP1 CDLP1 VP GPP1 NGPP1 VDD33 VSS gf180_tg_lowq
XPVN1 CDLP1 VN GPN1 NGPN1 VDD33 VSS gf180_tg_lowq
XNVP1 CDLN1 VP GNP1 NGNP1 VDD33 VSS gf180_tg_lowq
XNVN1 CDLN1 VN GNN1 NGNN1 VDD33 VSS gf180_tg_lowq
XDPC1 CDLP1 VCM_REF PH1 NPH1 VDD33 VSS gf180_tg_lowq
XDNC1 CDLN1 VCM_REF PH1 NPH1 VDD33 VSS gf180_tg_lowq
* DAC unit 2
CDP2 CDLP2 CDRP2 {CU}
CDN2 CDLN2 CDRN2 {CU}
XDP12 CDRP2 VCM_REF PH1 NPH1 VDD33 VSS gf180_tg_lowq
XDP22 CDRP2 INP PH2 NPH2 VDD33 VSS gf180_tg_lowq
XDN12 CDRN2 VCM_REF PH1 NPH1 VDD33 VSS gf180_tg_lowq
XDN22 CDRN2 INN PH2 NPH2 VDD33 VSS gf180_tg_lowq
BGPP2 GPP2 0 V=v(PH2)*v(S2P2)/v(VDD33)
BGPN2 GPN2 0 V=v(PH2)*(v(VDD33)-v(S2P2))/v(VDD33)
BGNP2 GNP2 0 V=v(PH2)*v(S2N2)/v(VDD33)
BGNN2 GNN2 0 V=v(PH2)*(v(VDD33)-v(S2N2))/v(VDD33)
BNOPP2 NGPP2 0 V=v(VDD33)-v(GPP2)
BNOPN2 NGPN2 0 V=v(VDD33)-v(GPN2)
BNONP2 NGNP2 0 V=v(VDD33)-v(GNP2)
BNONN2 NGNN2 0 V=v(VDD33)-v(GNN2)
XPVP2 CDLP2 VP GPP2 NGPP2 VDD33 VSS gf180_tg_lowq
XPVN2 CDLP2 VN GPN2 NGPN2 VDD33 VSS gf180_tg_lowq
XNVP2 CDLN2 VP GNP2 NGNP2 VDD33 VSS gf180_tg_lowq
XNVN2 CDLN2 VN GNN2 NGNN2 VDD33 VSS gf180_tg_lowq
XDPC2 CDLP2 VCM_REF PH1 NPH1 VDD33 VSS gf180_tg_lowq
XDNC2 CDLN2 VCM_REF PH1 NPH1 VDD33 VSS gf180_tg_lowq
* DAC unit 3
CDP3 CDLP3 CDRP3 {CU}
CDN3 CDLN3 CDRN3 {CU}
XDP13 CDRP3 VCM_REF PH1 NPH1 VDD33 VSS gf180_tg_lowq
XDP23 CDRP3 INP PH2 NPH2 VDD33 VSS gf180_tg_lowq
XDN13 CDRN3 VCM_REF PH1 NPH1 VDD33 VSS gf180_tg_lowq
XDN23 CDRN3 INN PH2 NPH2 VDD33 VSS gf180_tg_lowq
BGPP3 GPP3 0 V=v(PH2)*v(S2P3)/v(VDD33)
BGPN3 GPN3 0 V=v(PH2)*(v(VDD33)-v(S2P3))/v(VDD33)
BGNP3 GNP3 0 V=v(PH2)*v(S2N3)/v(VDD33)
BGNN3 GNN3 0 V=v(PH2)*(v(VDD33)-v(S2N3))/v(VDD33)
BNOPP3 NGPP3 0 V=v(VDD33)-v(GPP3)
BNOPN3 NGPN3 0 V=v(VDD33)-v(GPN3)
BNONP3 NGNP3 0 V=v(VDD33)-v(GNP3)
BNONN3 NGNN3 0 V=v(VDD33)-v(GNN3)
XPVP3 CDLP3 VP GPP3 NGPP3 VDD33 VSS gf180_tg_lowq
XPVN3 CDLP3 VN GPN3 NGPN3 VDD33 VSS gf180_tg_lowq
XNVP3 CDLN3 VP GNP3 NGNP3 VDD33 VSS gf180_tg_lowq
XNVN3 CDLN3 VN GNN3 NGNN3 VDD33 VSS gf180_tg_lowq
XDPC3 CDLP3 VCM_REF PH1 NPH1 VDD33 VSS gf180_tg_lowq
XDNC3 CDLN3 VCM_REF PH1 NPH1 VDD33 VSS gf180_tg_lowq
* DAC unit 4
CDP4 CDLP4 CDRP4 {CU}
CDN4 CDLN4 CDRN4 {CU}
XDP14 CDRP4 VCM_REF PH1 NPH1 VDD33 VSS gf180_tg_lowq
XDP24 CDRP4 INP PH2 NPH2 VDD33 VSS gf180_tg_lowq
XDN14 CDRN4 VCM_REF PH1 NPH1 VDD33 VSS gf180_tg_lowq
XDN24 CDRN4 INN PH2 NPH2 VDD33 VSS gf180_tg_lowq
BGPP4 GPP4 0 V=v(PH2)*v(S2P4)/v(VDD33)
BGPN4 GPN4 0 V=v(PH2)*(v(VDD33)-v(S2P4))/v(VDD33)
BGNP4 GNP4 0 V=v(PH2)*v(S2N4)/v(VDD33)
BGNN4 GNN4 0 V=v(PH2)*(v(VDD33)-v(S2N4))/v(VDD33)
BNOPP4 NGPP4 0 V=v(VDD33)-v(GPP4)
BNOPN4 NGPN4 0 V=v(VDD33)-v(GPN4)
BNONP4 NGNP4 0 V=v(VDD33)-v(GNP4)
BNONN4 NGNN4 0 V=v(VDD33)-v(GNN4)
XPVP4 CDLP4 VP GPP4 NGPP4 VDD33 VSS gf180_tg_lowq
XPVN4 CDLP4 VN GPN4 NGPN4 VDD33 VSS gf180_tg_lowq
XNVP4 CDLN4 VP GNP4 NGNP4 VDD33 VSS gf180_tg_lowq
XNVN4 CDLN4 VN GNN4 NGNN4 VDD33 VSS gf180_tg_lowq
XDPC4 CDLP4 VCM_REF PH1 NPH1 VDD33 VSS gf180_tg_lowq
XDNC4 CDLN4 VCM_REF PH1 NPH1 VDD33 VSS gf180_tg_lowq
* DAC unit 5
CDP5 CDLP5 CDRP5 {CU}
CDN5 CDLN5 CDRN5 {CU}
XDP15 CDRP5 VCM_REF PH1 NPH1 VDD33 VSS gf180_tg_lowq
XDP25 CDRP5 INP PH2 NPH2 VDD33 VSS gf180_tg_lowq
XDN15 CDRN5 VCM_REF PH1 NPH1 VDD33 VSS gf180_tg_lowq
XDN25 CDRN5 INN PH2 NPH2 VDD33 VSS gf180_tg_lowq
BGPP5 GPP5 0 V=v(PH2)*v(S2P5)/v(VDD33)
BGPN5 GPN5 0 V=v(PH2)*(v(VDD33)-v(S2P5))/v(VDD33)
BGNP5 GNP5 0 V=v(PH2)*v(S2N5)/v(VDD33)
BGNN5 GNN5 0 V=v(PH2)*(v(VDD33)-v(S2N5))/v(VDD33)
BNOPP5 NGPP5 0 V=v(VDD33)-v(GPP5)
BNOPN5 NGPN5 0 V=v(VDD33)-v(GPN5)
BNONP5 NGNP5 0 V=v(VDD33)-v(GNP5)
BNONN5 NGNN5 0 V=v(VDD33)-v(GNN5)
XPVP5 CDLP5 VP GPP5 NGPP5 VDD33 VSS gf180_tg_lowq
XPVN5 CDLP5 VN GPN5 NGPN5 VDD33 VSS gf180_tg_lowq
XNVP5 CDLN5 VP GNP5 NGNP5 VDD33 VSS gf180_tg_lowq
XNVN5 CDLN5 VN GNN5 NGNN5 VDD33 VSS gf180_tg_lowq
XDPC5 CDLP5 VCM_REF PH1 NPH1 VDD33 VSS gf180_tg_lowq
XDNC5 CDLN5 VCM_REF PH1 NPH1 VDD33 VSS gf180_tg_lowq
* DAC unit 6
CDP6 CDLP6 CDRP6 {CU}
CDN6 CDLN6 CDRN6 {CU}
XDP16 CDRP6 VCM_REF PH1 NPH1 VDD33 VSS gf180_tg_lowq
XDP26 CDRP6 INP PH2 NPH2 VDD33 VSS gf180_tg_lowq
XDN16 CDRN6 VCM_REF PH1 NPH1 VDD33 VSS gf180_tg_lowq
XDN26 CDRN6 INN PH2 NPH2 VDD33 VSS gf180_tg_lowq
BGPP6 GPP6 0 V=v(PH2)*v(S2P6)/v(VDD33)
BGPN6 GPN6 0 V=v(PH2)*(v(VDD33)-v(S2P6))/v(VDD33)
BGNP6 GNP6 0 V=v(PH2)*v(S2N6)/v(VDD33)
BGNN6 GNN6 0 V=v(PH2)*(v(VDD33)-v(S2N6))/v(VDD33)
BNOPP6 NGPP6 0 V=v(VDD33)-v(GPP6)
BNOPN6 NGPN6 0 V=v(VDD33)-v(GPN6)
BNONP6 NGNP6 0 V=v(VDD33)-v(GNP6)
BNONN6 NGNN6 0 V=v(VDD33)-v(GNN6)
XPVP6 CDLP6 VP GPP6 NGPP6 VDD33 VSS gf180_tg_lowq
XPVN6 CDLP6 VN GPN6 NGPN6 VDD33 VSS gf180_tg_lowq
XNVP6 CDLN6 VP GNP6 NGNP6 VDD33 VSS gf180_tg_lowq
XNVN6 CDLN6 VN GNN6 NGNN6 VDD33 VSS gf180_tg_lowq
XDPC6 CDLP6 VCM_REF PH1 NPH1 VDD33 VSS gf180_tg_lowq
XDNC6 CDLN6 VCM_REF PH1 NPH1 VDD33 VSS gf180_tg_lowq
* DAC unit 7
CDP7 CDLP7 CDRP7 {CU}
CDN7 CDLN7 CDRN7 {CU}
XDP17 CDRP7 VCM_REF PH1 NPH1 VDD33 VSS gf180_tg_lowq
XDP27 CDRP7 INP PH2 NPH2 VDD33 VSS gf180_tg_lowq
XDN17 CDRN7 VCM_REF PH1 NPH1 VDD33 VSS gf180_tg_lowq
XDN27 CDRN7 INN PH2 NPH2 VDD33 VSS gf180_tg_lowq
BGPP7 GPP7 0 V=v(PH2)*v(S2P7)/v(VDD33)
BGPN7 GPN7 0 V=v(PH2)*(v(VDD33)-v(S2P7))/v(VDD33)
BGNP7 GNP7 0 V=v(PH2)*v(S2N7)/v(VDD33)
BGNN7 GNN7 0 V=v(PH2)*(v(VDD33)-v(S2N7))/v(VDD33)
BNOPP7 NGPP7 0 V=v(VDD33)-v(GPP7)
BNOPN7 NGPN7 0 V=v(VDD33)-v(GPN7)
BNONP7 NGNP7 0 V=v(VDD33)-v(GNP7)
BNONN7 NGNN7 0 V=v(VDD33)-v(GNN7)
XPVP7 CDLP7 VP GPP7 NGPP7 VDD33 VSS gf180_tg_lowq
XPVN7 CDLP7 VN GPN7 NGPN7 VDD33 VSS gf180_tg_lowq
XNVP7 CDLN7 VP GNP7 NGNP7 VDD33 VSS gf180_tg_lowq
XNVN7 CDLN7 VN GNN7 NGNN7 VDD33 VSS gf180_tg_lowq
XDPC7 CDLP7 VCM_REF PH1 NPH1 VDD33 VSS gf180_tg_lowq
XDNC7 CDLN7 VCM_REF PH1 NPH1 VDD33 VSS gf180_tg_lowq
* DAC unit 8
CDP8 CDLP8 CDRP8 {CU}
CDN8 CDLN8 CDRN8 {CU}
XDP18 CDRP8 VCM_REF PH1 NPH1 VDD33 VSS gf180_tg_lowq
XDP28 CDRP8 INP PH2 NPH2 VDD33 VSS gf180_tg_lowq
XDN18 CDRN8 VCM_REF PH1 NPH1 VDD33 VSS gf180_tg_lowq
XDN28 CDRN8 INN PH2 NPH2 VDD33 VSS gf180_tg_lowq
BGPP8 GPP8 0 V=v(PH2)*v(S2P8)/v(VDD33)
BGPN8 GPN8 0 V=v(PH2)*(v(VDD33)-v(S2P8))/v(VDD33)
BGNP8 GNP8 0 V=v(PH2)*v(S2N8)/v(VDD33)
BGNN8 GNN8 0 V=v(PH2)*(v(VDD33)-v(S2N8))/v(VDD33)
BNOPP8 NGPP8 0 V=v(VDD33)-v(GPP8)
BNOPN8 NGPN8 0 V=v(VDD33)-v(GPN8)
BNONP8 NGNP8 0 V=v(VDD33)-v(GNP8)
BNONN8 NGNN8 0 V=v(VDD33)-v(GNN8)
XPVP8 CDLP8 VP GPP8 NGPP8 VDD33 VSS gf180_tg_lowq
XPVN8 CDLP8 VN GPN8 NGPN8 VDD33 VSS gf180_tg_lowq
XNVP8 CDLN8 VP GNP8 NGNP8 VDD33 VSS gf180_tg_lowq
XNVN8 CDLN8 VN GNN8 NGNN8 VDD33 VSS gf180_tg_lowq
XDPC8 CDLP8 VCM_REF PH1 NPH1 VDD33 VSS gf180_tg_lowq
XDNC8 CDLN8 VCM_REF PH1 NPH1 VDD33 VSS gf180_tg_lowq
* DAC unit 9
CDP9 CDLP9 CDRP9 {CU}
CDN9 CDLN9 CDRN9 {CU}
XDP19 CDRP9 VCM_REF PH1 NPH1 VDD33 VSS gf180_tg_lowq
XDP29 CDRP9 INP PH2 NPH2 VDD33 VSS gf180_tg_lowq
XDN19 CDRN9 VCM_REF PH1 NPH1 VDD33 VSS gf180_tg_lowq
XDN29 CDRN9 INN PH2 NPH2 VDD33 VSS gf180_tg_lowq
BGPP9 GPP9 0 V=v(PH2)*v(S2P9)/v(VDD33)
BGPN9 GPN9 0 V=v(PH2)*(v(VDD33)-v(S2P9))/v(VDD33)
BGNP9 GNP9 0 V=v(PH2)*v(S2N9)/v(VDD33)
BGNN9 GNN9 0 V=v(PH2)*(v(VDD33)-v(S2N9))/v(VDD33)
BNOPP9 NGPP9 0 V=v(VDD33)-v(GPP9)
BNOPN9 NGPN9 0 V=v(VDD33)-v(GPN9)
BNONP9 NGNP9 0 V=v(VDD33)-v(GNP9)
BNONN9 NGNN9 0 V=v(VDD33)-v(GNN9)
XPVP9 CDLP9 VP GPP9 NGPP9 VDD33 VSS gf180_tg_lowq
XPVN9 CDLP9 VN GPN9 NGPN9 VDD33 VSS gf180_tg_lowq
XNVP9 CDLN9 VP GNP9 NGNP9 VDD33 VSS gf180_tg_lowq
XNVN9 CDLN9 VN GNN9 NGNN9 VDD33 VSS gf180_tg_lowq
XDPC9 CDLP9 VCM_REF PH1 NPH1 VDD33 VSS gf180_tg_lowq
XDNC9 CDLN9 VCM_REF PH1 NPH1 VDD33 VSS gf180_tg_lowq
* DAC unit 10
CDP10 CDLP10 CDRP10 {CU}
CDN10 CDLN10 CDRN10 {CU}
XDP110 CDRP10 VCM_REF PH1 NPH1 VDD33 VSS gf180_tg_lowq
XDP210 CDRP10 INP PH2 NPH2 VDD33 VSS gf180_tg_lowq
XDN110 CDRN10 VCM_REF PH1 NPH1 VDD33 VSS gf180_tg_lowq
XDN210 CDRN10 INN PH2 NPH2 VDD33 VSS gf180_tg_lowq
BGPP10 GPP10 0 V=v(PH2)*v(S2P10)/v(VDD33)
BGPN10 GPN10 0 V=v(PH2)*(v(VDD33)-v(S2P10))/v(VDD33)
BGNP10 GNP10 0 V=v(PH2)*v(S2N10)/v(VDD33)
BGNN10 GNN10 0 V=v(PH2)*(v(VDD33)-v(S2N10))/v(VDD33)
BNOPP10 NGPP10 0 V=v(VDD33)-v(GPP10)
BNOPN10 NGPN10 0 V=v(VDD33)-v(GPN10)
BNONP10 NGNP10 0 V=v(VDD33)-v(GNP10)
BNONN10 NGNN10 0 V=v(VDD33)-v(GNN10)
XPVP10 CDLP10 VP GPP10 NGPP10 VDD33 VSS gf180_tg_lowq
XPVN10 CDLP10 VN GPN10 NGPN10 VDD33 VSS gf180_tg_lowq
XNVP10 CDLN10 VP GNP10 NGNP10 VDD33 VSS gf180_tg_lowq
XNVN10 CDLN10 VN GNN10 NGNN10 VDD33 VSS gf180_tg_lowq
XDPC10 CDLP10 VCM_REF PH1 NPH1 VDD33 VSS gf180_tg_lowq
XDNC10 CDLN10 VCM_REF PH1 NPH1 VDD33 VSS gf180_tg_lowq
* DAC unit 11
CDP11 CDLP11 CDRP11 {CU}
CDN11 CDLN11 CDRN11 {CU}
XDP111 CDRP11 VCM_REF PH1 NPH1 VDD33 VSS gf180_tg_lowq
XDP211 CDRP11 INP PH2 NPH2 VDD33 VSS gf180_tg_lowq
XDN111 CDRN11 VCM_REF PH1 NPH1 VDD33 VSS gf180_tg_lowq
XDN211 CDRN11 INN PH2 NPH2 VDD33 VSS gf180_tg_lowq
BGPP11 GPP11 0 V=v(PH2)*v(S2P11)/v(VDD33)
BGPN11 GPN11 0 V=v(PH2)*(v(VDD33)-v(S2P11))/v(VDD33)
BGNP11 GNP11 0 V=v(PH2)*v(S2N11)/v(VDD33)
BGNN11 GNN11 0 V=v(PH2)*(v(VDD33)-v(S2N11))/v(VDD33)
BNOPP11 NGPP11 0 V=v(VDD33)-v(GPP11)
BNOPN11 NGPN11 0 V=v(VDD33)-v(GPN11)
BNONP11 NGNP11 0 V=v(VDD33)-v(GNP11)
BNONN11 NGNN11 0 V=v(VDD33)-v(GNN11)
XPVP11 CDLP11 VP GPP11 NGPP11 VDD33 VSS gf180_tg_lowq
XPVN11 CDLP11 VN GPN11 NGPN11 VDD33 VSS gf180_tg_lowq
XNVP11 CDLN11 VP GNP11 NGNP11 VDD33 VSS gf180_tg_lowq
XNVN11 CDLN11 VN GNN11 NGNN11 VDD33 VSS gf180_tg_lowq
XDPC11 CDLP11 VCM_REF PH1 NPH1 VDD33 VSS gf180_tg_lowq
XDNC11 CDLN11 VCM_REF PH1 NPH1 VDD33 VSS gf180_tg_lowq
* DAC unit 12
CDP12 CDLP12 CDRP12 {CU}
CDN12 CDLN12 CDRN12 {CU}
XDP112 CDRP12 VCM_REF PH1 NPH1 VDD33 VSS gf180_tg_lowq
XDP212 CDRP12 INP PH2 NPH2 VDD33 VSS gf180_tg_lowq
XDN112 CDRN12 VCM_REF PH1 NPH1 VDD33 VSS gf180_tg_lowq
XDN212 CDRN12 INN PH2 NPH2 VDD33 VSS gf180_tg_lowq
BGPP12 GPP12 0 V=v(PH2)*v(S2P12)/v(VDD33)
BGPN12 GPN12 0 V=v(PH2)*(v(VDD33)-v(S2P12))/v(VDD33)
BGNP12 GNP12 0 V=v(PH2)*v(S2N12)/v(VDD33)
BGNN12 GNN12 0 V=v(PH2)*(v(VDD33)-v(S2N12))/v(VDD33)
BNOPP12 NGPP12 0 V=v(VDD33)-v(GPP12)
BNOPN12 NGPN12 0 V=v(VDD33)-v(GPN12)
BNONP12 NGNP12 0 V=v(VDD33)-v(GNP12)
BNONN12 NGNN12 0 V=v(VDD33)-v(GNN12)
XPVP12 CDLP12 VP GPP12 NGPP12 VDD33 VSS gf180_tg_lowq
XPVN12 CDLP12 VN GPN12 NGPN12 VDD33 VSS gf180_tg_lowq
XNVP12 CDLN12 VP GNP12 NGNP12 VDD33 VSS gf180_tg_lowq
XNVN12 CDLN12 VN GNN12 NGNN12 VDD33 VSS gf180_tg_lowq
XDPC12 CDLP12 VCM_REF PH1 NPH1 VDD33 VSS gf180_tg_lowq
XDNC12 CDLN12 VCM_REF PH1 NPH1 VDD33 VSS gf180_tg_lowq
* DAC unit 13
CDP13 CDLP13 CDRP13 {CU}
CDN13 CDLN13 CDRN13 {CU}
XDP113 CDRP13 VCM_REF PH1 NPH1 VDD33 VSS gf180_tg_lowq
XDP213 CDRP13 INP PH2 NPH2 VDD33 VSS gf180_tg_lowq
XDN113 CDRN13 VCM_REF PH1 NPH1 VDD33 VSS gf180_tg_lowq
XDN213 CDRN13 INN PH2 NPH2 VDD33 VSS gf180_tg_lowq
BGPP13 GPP13 0 V=v(PH2)*v(S2P13)/v(VDD33)
BGPN13 GPN13 0 V=v(PH2)*(v(VDD33)-v(S2P13))/v(VDD33)
BGNP13 GNP13 0 V=v(PH2)*v(S2N13)/v(VDD33)
BGNN13 GNN13 0 V=v(PH2)*(v(VDD33)-v(S2N13))/v(VDD33)
BNOPP13 NGPP13 0 V=v(VDD33)-v(GPP13)
BNOPN13 NGPN13 0 V=v(VDD33)-v(GPN13)
BNONP13 NGNP13 0 V=v(VDD33)-v(GNP13)
BNONN13 NGNN13 0 V=v(VDD33)-v(GNN13)
XPVP13 CDLP13 VP GPP13 NGPP13 VDD33 VSS gf180_tg_lowq
XPVN13 CDLP13 VN GPN13 NGPN13 VDD33 VSS gf180_tg_lowq
XNVP13 CDLN13 VP GNP13 NGNP13 VDD33 VSS gf180_tg_lowq
XNVN13 CDLN13 VN GNN13 NGNN13 VDD33 VSS gf180_tg_lowq
XDPC13 CDLP13 VCM_REF PH1 NPH1 VDD33 VSS gf180_tg_lowq
XDNC13 CDLN13 VCM_REF PH1 NPH1 VDD33 VSS gf180_tg_lowq
* DAC unit 14
CDP14 CDLP14 CDRP14 {CU}
CDN14 CDLN14 CDRN14 {CU}
XDP114 CDRP14 VCM_REF PH1 NPH1 VDD33 VSS gf180_tg_lowq
XDP214 CDRP14 INP PH2 NPH2 VDD33 VSS gf180_tg_lowq
XDN114 CDRN14 VCM_REF PH1 NPH1 VDD33 VSS gf180_tg_lowq
XDN214 CDRN14 INN PH2 NPH2 VDD33 VSS gf180_tg_lowq
BGPP14 GPP14 0 V=v(PH2)*v(S2P14)/v(VDD33)
BGPN14 GPN14 0 V=v(PH2)*(v(VDD33)-v(S2P14))/v(VDD33)
BGNP14 GNP14 0 V=v(PH2)*v(S2N14)/v(VDD33)
BGNN14 GNN14 0 V=v(PH2)*(v(VDD33)-v(S2N14))/v(VDD33)
BNOPP14 NGPP14 0 V=v(VDD33)-v(GPP14)
BNOPN14 NGPN14 0 V=v(VDD33)-v(GPN14)
BNONP14 NGNP14 0 V=v(VDD33)-v(GNP14)
BNONN14 NGNN14 0 V=v(VDD33)-v(GNN14)
XPVP14 CDLP14 VP GPP14 NGPP14 VDD33 VSS gf180_tg_lowq
XPVN14 CDLP14 VN GPN14 NGPN14 VDD33 VSS gf180_tg_lowq
XNVP14 CDLN14 VP GNP14 NGNP14 VDD33 VSS gf180_tg_lowq
XNVN14 CDLN14 VN GNN14 NGNN14 VDD33 VSS gf180_tg_lowq
XDPC14 CDLP14 VCM_REF PH1 NPH1 VDD33 VSS gf180_tg_lowq
XDNC14 CDLN14 VCM_REF PH1 NPH1 VDD33 VSS gf180_tg_lowq
CIP OUTN INP {CI}
CIN OUTP INN {CI}
RBIASP INP VCM_REF 10G
RBIASN INN VCM_REF 10G
.ends gf180_sdm3_int2_mb

* ---- modulator top: sdm3 timing, 4-bit flash + behavioral DWA ----
* Nodes: TH0..TH14 = thermometer lines (H_i). External PUP clock (narrow
* pulse at PH1 rising edge) advances the DWA master register.
.subckt gf180_sdm3_mod_mb VINP VINN VCM_REF VP VN PH1 NPH1 PH2 NPH2 CMPCK PUP VDD33 VSS TH0 TH1 TH2 TH3 TH4 TH5 TH6 TH7 TH8 TH9 TH10 TH11 TH12 TH13 TH14 params: RSET=25k CC=10p
XINT1 VINN VINP VCM_REF VP VN O1P O1N PH1 NPH1 PH2 NPH2 VDD33 VSS SEL0 SEL1 SEL2 SEL3 SEL4 SEL5 SEL6 SEL7 SEL8 SEL9 SEL10 SEL11 SEL12 SEL13 SEL14 SELN0 SELN1 SELN2 SELN3 SELN4 SELN5 SELN6 SELN7 SELN8 SELN9 SELN10 SELN11 SELN12 SELN13 SELN14 gf180_sdm3_int1_mb RSET={RSET} CC={CC}
* int2 with swapped clock pins (samples PH2 / integrates PH1)
XINT2 O1N O1P VCM_REF VP VN O2P O2N PH2 NPH2 PH1 NPH1 VDD33 VSS SEL20 SEL21 SEL22 SEL23 SEL24 SEL25 SEL26 SEL27 SEL28 SEL29 SEL210 SEL211 SEL212 SEL213 SEL214 SEL2N0 SEL2N1 SEL2N2 SEL2N3 SEL2N4 SEL2N5 SEL2N6 SEL2N7 SEL2N8 SEL2N9 SEL2N10 SEL2N11 SEL2N12 SEL2N13 SEL2N14 gf180_sdm3_int2_mb RSET={RSET} CC={CC}
XFLASH O2P O2N CMPCK VDD33 VSS TH0 TH1 TH2 TH3 TH4 TH5 TH6 TH7 TH8 TH9 TH10 TH11 TH12 TH13 TH14 gf180_sdm3_flash15
* thermometer count as voltage (1 V per count)
BCSUM CSUM 0 V=(v(TH0)+v(TH1)+v(TH2)+v(TH3)+v(TH4)+v(TH5)+v(TH6)+v(TH7)+v(TH8)+v(TH9)+v(TH10)+v(TH11)+v(TH12)+v(TH13)+v(TH14))/v(VDD33)
* DWA pointer: master samples mod(p_slave - c + 15) during PUP,
* slave tracks master during PH2. p[n+1]=(p[n]-c[n]) mod 15.
BNEXT PNEXT 0 V=v(PTRS)-v(CSUM)+15
BNEXTM PNEXTM 0 V=v(PNEXT)-15*floor(v(PNEXT)/15)
BPTRM0 PTRM 0 V=0
CPTRM PTRM VSS 0.5p
RPTRM PTRM VSS 1G
BPTRS0 PTRS 0 V=0
CPTRS PTRS VSS 0.5p
RPTRS PTRS VSS 1G
*
* int1 unit selects (DWA): P-side unit j -> VP if rot(j-p) < 15-c
BSEL0 SEL0 0 V=(((15-v(PTRS))-15*floor((15-v(PTRS))/15)) < (15-v(CSUM)) ? v(VDD33) : 0)
BSELN0 SELN0 0 V=(((15-v(PTRS))-15*floor((15-v(PTRS))/15)) >= (15-v(CSUM)) ? v(VDD33) : 0)
BSEL1 SEL1 0 V=(((16-v(PTRS))-15*floor((16-v(PTRS))/15)) < (15-v(CSUM)) ? v(VDD33) : 0)
BSELN1 SELN1 0 V=(((16-v(PTRS))-15*floor((16-v(PTRS))/15)) >= (15-v(CSUM)) ? v(VDD33) : 0)
BSEL2 SEL2 0 V=(((17-v(PTRS))-15*floor((17-v(PTRS))/15)) < (15-v(CSUM)) ? v(VDD33) : 0)
BSELN2 SELN2 0 V=(((17-v(PTRS))-15*floor((17-v(PTRS))/15)) >= (15-v(CSUM)) ? v(VDD33) : 0)
BSEL3 SEL3 0 V=(((18-v(PTRS))-15*floor((18-v(PTRS))/15)) < (15-v(CSUM)) ? v(VDD33) : 0)
BSELN3 SELN3 0 V=(((18-v(PTRS))-15*floor((18-v(PTRS))/15)) >= (15-v(CSUM)) ? v(VDD33) : 0)
BSEL4 SEL4 0 V=(((19-v(PTRS))-15*floor((19-v(PTRS))/15)) < (15-v(CSUM)) ? v(VDD33) : 0)
BSELN4 SELN4 0 V=(((19-v(PTRS))-15*floor((19-v(PTRS))/15)) >= (15-v(CSUM)) ? v(VDD33) : 0)
BSEL5 SEL5 0 V=(((20-v(PTRS))-15*floor((20-v(PTRS))/15)) < (15-v(CSUM)) ? v(VDD33) : 0)
BSELN5 SELN5 0 V=(((20-v(PTRS))-15*floor((20-v(PTRS))/15)) >= (15-v(CSUM)) ? v(VDD33) : 0)
BSEL6 SEL6 0 V=(((21-v(PTRS))-15*floor((21-v(PTRS))/15)) < (15-v(CSUM)) ? v(VDD33) : 0)
BSELN6 SELN6 0 V=(((21-v(PTRS))-15*floor((21-v(PTRS))/15)) >= (15-v(CSUM)) ? v(VDD33) : 0)
BSEL7 SEL7 0 V=(((22-v(PTRS))-15*floor((22-v(PTRS))/15)) < (15-v(CSUM)) ? v(VDD33) : 0)
BSELN7 SELN7 0 V=(((22-v(PTRS))-15*floor((22-v(PTRS))/15)) >= (15-v(CSUM)) ? v(VDD33) : 0)
BSEL8 SEL8 0 V=(((23-v(PTRS))-15*floor((23-v(PTRS))/15)) < (15-v(CSUM)) ? v(VDD33) : 0)
BSELN8 SELN8 0 V=(((23-v(PTRS))-15*floor((23-v(PTRS))/15)) >= (15-v(CSUM)) ? v(VDD33) : 0)
BSEL9 SEL9 0 V=(((24-v(PTRS))-15*floor((24-v(PTRS))/15)) < (15-v(CSUM)) ? v(VDD33) : 0)
BSELN9 SELN9 0 V=(((24-v(PTRS))-15*floor((24-v(PTRS))/15)) >= (15-v(CSUM)) ? v(VDD33) : 0)
BSEL10 SEL10 0 V=(((25-v(PTRS))-15*floor((25-v(PTRS))/15)) < (15-v(CSUM)) ? v(VDD33) : 0)
BSELN10 SELN10 0 V=(((25-v(PTRS))-15*floor((25-v(PTRS))/15)) >= (15-v(CSUM)) ? v(VDD33) : 0)
BSEL11 SEL11 0 V=(((26-v(PTRS))-15*floor((26-v(PTRS))/15)) < (15-v(CSUM)) ? v(VDD33) : 0)
BSELN11 SELN11 0 V=(((26-v(PTRS))-15*floor((26-v(PTRS))/15)) >= (15-v(CSUM)) ? v(VDD33) : 0)
BSEL12 SEL12 0 V=(((27-v(PTRS))-15*floor((27-v(PTRS))/15)) < (15-v(CSUM)) ? v(VDD33) : 0)
BSELN12 SELN12 0 V=(((27-v(PTRS))-15*floor((27-v(PTRS))/15)) >= (15-v(CSUM)) ? v(VDD33) : 0)
BSEL13 SEL13 0 V=(((28-v(PTRS))-15*floor((28-v(PTRS))/15)) < (15-v(CSUM)) ? v(VDD33) : 0)
BSELN13 SELN13 0 V=(((28-v(PTRS))-15*floor((28-v(PTRS))/15)) >= (15-v(CSUM)) ? v(VDD33) : 0)
BSEL14 SEL14 0 V=(((29-v(PTRS))-15*floor((29-v(PTRS))/15)) < (15-v(CSUM)) ? v(VDD33) : 0)
BSELN14 SELN14 0 V=(((29-v(PTRS))-15*floor((29-v(PTRS))/15)) >= (15-v(CSUM)) ? v(VDD33) : 0)
* int2 code register: tracks CSUM during PH2, holds through PH1
SC2 CSUM C2R PH2 VSS idsw
CC2R C2R VSS 0.5p
RC2R C2R VSS 1G
* int2 unit selects (straight thermometer from registered code)
BSEL20 SEL20 0 V=((0 < (15-v(C2R))) ? v(VDD33) : 0)
BSEL2N0 SEL2N0 0 V=((0 >= (15-v(C2R))) ? v(VDD33) : 0)
BSEL21 SEL21 0 V=((1 < (15-v(C2R))) ? v(VDD33) : 0)
BSEL2N1 SEL2N1 0 V=((1 >= (15-v(C2R))) ? v(VDD33) : 0)
BSEL22 SEL22 0 V=((2 < (15-v(C2R))) ? v(VDD33) : 0)
BSEL2N2 SEL2N2 0 V=((2 >= (15-v(C2R))) ? v(VDD33) : 0)
BSEL23 SEL23 0 V=((3 < (15-v(C2R))) ? v(VDD33) : 0)
BSEL2N3 SEL2N3 0 V=((3 >= (15-v(C2R))) ? v(VDD33) : 0)
BSEL24 SEL24 0 V=((4 < (15-v(C2R))) ? v(VDD33) : 0)
BSEL2N4 SEL2N4 0 V=((4 >= (15-v(C2R))) ? v(VDD33) : 0)
BSEL25 SEL25 0 V=((5 < (15-v(C2R))) ? v(VDD33) : 0)
BSEL2N5 SEL2N5 0 V=((5 >= (15-v(C2R))) ? v(VDD33) : 0)
BSEL26 SEL26 0 V=((6 < (15-v(C2R))) ? v(VDD33) : 0)
BSEL2N6 SEL2N6 0 V=((6 >= (15-v(C2R))) ? v(VDD33) : 0)
BSEL27 SEL27 0 V=((7 < (15-v(C2R))) ? v(VDD33) : 0)
BSEL2N7 SEL2N7 0 V=((7 >= (15-v(C2R))) ? v(VDD33) : 0)
BSEL28 SEL28 0 V=((8 < (15-v(C2R))) ? v(VDD33) : 0)
BSEL2N8 SEL2N8 0 V=((8 >= (15-v(C2R))) ? v(VDD33) : 0)
BSEL29 SEL29 0 V=((9 < (15-v(C2R))) ? v(VDD33) : 0)
BSEL2N9 SEL2N9 0 V=((9 >= (15-v(C2R))) ? v(VDD33) : 0)
BSEL210 SEL210 0 V=((10 < (15-v(C2R))) ? v(VDD33) : 0)
BSEL2N10 SEL2N10 0 V=((10 >= (15-v(C2R))) ? v(VDD33) : 0)
BSEL211 SEL211 0 V=((11 < (15-v(C2R))) ? v(VDD33) : 0)
BSEL2N11 SEL2N11 0 V=((11 >= (15-v(C2R))) ? v(VDD33) : 0)
BSEL212 SEL212 0 V=((12 < (15-v(C2R))) ? v(VDD33) : 0)
BSEL2N12 SEL2N12 0 V=((12 >= (15-v(C2R))) ? v(VDD33) : 0)
BSEL213 SEL213 0 V=((13 < (15-v(C2R))) ? v(VDD33) : 0)
BSEL2N13 SEL2N13 0 V=((13 >= (15-v(C2R))) ? v(VDD33) : 0)
BSEL214 SEL214 0 V=((14 < (15-v(C2R))) ? v(VDD33) : 0)
BSEL2N14 SEL2N14 0 V=((14 >= (15-v(C2R))) ? v(VDD33) : 0)
.model idsw SW(RON=1 ROFF=1T VON=2.2 VOFF=1.0)
.ends gf180_sdm3_mod_mb
