* gf180_sdm3_mb_tl.spice - 4-bit sdm3, ALL-TRANSISTOR select logic
* GENERATED by gen_sdm3_mb_tl.py - do not edit by hand.
* No behavioral B-sources anywhere (ngspice 62.502 ms artifact avoidance).
* Requires gf180_afe_cells.spice + gf180_sdm3.spice (cells).

.subckt gf180_sdm3_flash15 O2P O2N CMPCK VDD33 VSS H0 H1 H2 H3 H4 H5 H6 H7 H8 H9 H10 H11 H12 H13 H14
* slice 0: theta=-43.75 mV diff
VOFFP0 O2P INPP0 2.187500e-02
VOFFN0 O2N INNN0 -2.187500e-02
XCMP0 INPP0 INNN0 QP0 QN0 CMPCK VDD33 VSS gf180_strongarm
CQP0 QP0 VSS 0.5p
CQN0 QN0 VSS 0.5p
XND10 QP0 H0 BIT0 VDD33 VSS gf180_sdm3_nand2
XND20 QN0 BIT0 H0 VDD33 VSS gf180_sdm3_nand2
* slice 1: theta=-37.50 mV diff
VOFFP1 O2P INPP1 1.875000e-02
VOFFN1 O2N INNN1 -1.875000e-02
XCMP1 INPP1 INNN1 QP1 QN1 CMPCK VDD33 VSS gf180_strongarm
CQP1 QP1 VSS 0.5p
CQN1 QN1 VSS 0.5p
XND11 QP1 H1 BIT1 VDD33 VSS gf180_sdm3_nand2
XND21 QN1 BIT1 H1 VDD33 VSS gf180_sdm3_nand2
* slice 2: theta=-31.25 mV diff
VOFFP2 O2P INPP2 1.562500e-02
VOFFN2 O2N INNN2 -1.562500e-02
XCMP2 INPP2 INNN2 QP2 QN2 CMPCK VDD33 VSS gf180_strongarm
CQP2 QP2 VSS 0.5p
CQN2 QN2 VSS 0.5p
XND12 QP2 H2 BIT2 VDD33 VSS gf180_sdm3_nand2
XND22 QN2 BIT2 H2 VDD33 VSS gf180_sdm3_nand2
* slice 3: theta=-25.00 mV diff
VOFFP3 O2P INPP3 1.250000e-02
VOFFN3 O2N INNN3 -1.250000e-02
XCMP3 INPP3 INNN3 QP3 QN3 CMPCK VDD33 VSS gf180_strongarm
CQP3 QP3 VSS 0.5p
CQN3 QN3 VSS 0.5p
XND13 QP3 H3 BIT3 VDD33 VSS gf180_sdm3_nand2
XND23 QN3 BIT3 H3 VDD33 VSS gf180_sdm3_nand2
* slice 4: theta=-18.75 mV diff
VOFFP4 O2P INPP4 9.375000e-03
VOFFN4 O2N INNN4 -9.375000e-03
XCMP4 INPP4 INNN4 QP4 QN4 CMPCK VDD33 VSS gf180_strongarm
CQP4 QP4 VSS 0.5p
CQN4 QN4 VSS 0.5p
XND14 QP4 H4 BIT4 VDD33 VSS gf180_sdm3_nand2
XND24 QN4 BIT4 H4 VDD33 VSS gf180_sdm3_nand2
* slice 5: theta=-12.50 mV diff
VOFFP5 O2P INPP5 6.250000e-03
VOFFN5 O2N INNN5 -6.250000e-03
XCMP5 INPP5 INNN5 QP5 QN5 CMPCK VDD33 VSS gf180_strongarm
CQP5 QP5 VSS 0.5p
CQN5 QN5 VSS 0.5p
XND15 QP5 H5 BIT5 VDD33 VSS gf180_sdm3_nand2
XND25 QN5 BIT5 H5 VDD33 VSS gf180_sdm3_nand2
* slice 6: theta=-6.25 mV diff
VOFFP6 O2P INPP6 3.125000e-03
VOFFN6 O2N INNN6 -3.125000e-03
XCMP6 INPP6 INNN6 QP6 QN6 CMPCK VDD33 VSS gf180_strongarm
CQP6 QP6 VSS 0.5p
CQN6 QN6 VSS 0.5p
XND16 QP6 H6 BIT6 VDD33 VSS gf180_sdm3_nand2
XND26 QN6 BIT6 H6 VDD33 VSS gf180_sdm3_nand2
* slice 7: theta=+0.00 mV diff
VOFFP7 O2P INPP7 -0.000000e+00
VOFFN7 O2N INNN7 0.000000e+00
XCMP7 INPP7 INNN7 QP7 QN7 CMPCK VDD33 VSS gf180_strongarm
CQP7 QP7 VSS 0.5p
CQN7 QN7 VSS 0.5p
XND17 QP7 H7 BIT7 VDD33 VSS gf180_sdm3_nand2
XND27 QN7 BIT7 H7 VDD33 VSS gf180_sdm3_nand2
* slice 8: theta=+6.25 mV diff
VOFFP8 O2P INPP8 -3.125000e-03
VOFFN8 O2N INNN8 3.125000e-03
XCMP8 INPP8 INNN8 QP8 QN8 CMPCK VDD33 VSS gf180_strongarm
CQP8 QP8 VSS 0.5p
CQN8 QN8 VSS 0.5p
XND18 QP8 H8 BIT8 VDD33 VSS gf180_sdm3_nand2
XND28 QN8 BIT8 H8 VDD33 VSS gf180_sdm3_nand2
* slice 9: theta=+12.50 mV diff
VOFFP9 O2P INPP9 -6.250000e-03
VOFFN9 O2N INNN9 6.250000e-03
XCMP9 INPP9 INNN9 QP9 QN9 CMPCK VDD33 VSS gf180_strongarm
CQP9 QP9 VSS 0.5p
CQN9 QN9 VSS 0.5p
XND19 QP9 H9 BIT9 VDD33 VSS gf180_sdm3_nand2
XND29 QN9 BIT9 H9 VDD33 VSS gf180_sdm3_nand2
* slice 10: theta=+18.75 mV diff
VOFFP10 O2P INPP10 -9.375000e-03
VOFFN10 O2N INNN10 9.375000e-03
XCMP10 INPP10 INNN10 QP10 QN10 CMPCK VDD33 VSS gf180_strongarm
CQP10 QP10 VSS 0.5p
CQN10 QN10 VSS 0.5p
XND110 QP10 H10 BIT10 VDD33 VSS gf180_sdm3_nand2
XND210 QN10 BIT10 H10 VDD33 VSS gf180_sdm3_nand2
* slice 11: theta=+25.00 mV diff
VOFFP11 O2P INPP11 -1.250000e-02
VOFFN11 O2N INNN11 1.250000e-02
XCMP11 INPP11 INNN11 QP11 QN11 CMPCK VDD33 VSS gf180_strongarm
CQP11 QP11 VSS 0.5p
CQN11 QN11 VSS 0.5p
XND111 QP11 H11 BIT11 VDD33 VSS gf180_sdm3_nand2
XND211 QN11 BIT11 H11 VDD33 VSS gf180_sdm3_nand2
* slice 12: theta=+31.25 mV diff
VOFFP12 O2P INPP12 -1.562500e-02
VOFFN12 O2N INNN12 1.562500e-02
XCMP12 INPP12 INNN12 QP12 QN12 CMPCK VDD33 VSS gf180_strongarm
CQP12 QP12 VSS 0.5p
CQN12 QN12 VSS 0.5p
XND112 QP12 H12 BIT12 VDD33 VSS gf180_sdm3_nand2
XND212 QN12 BIT12 H12 VDD33 VSS gf180_sdm3_nand2
* slice 13: theta=+37.50 mV diff
VOFFP13 O2P INPP13 -1.875000e-02
VOFFN13 O2N INNN13 1.875000e-02
XCMP13 INPP13 INNN13 QP13 QN13 CMPCK VDD33 VSS gf180_strongarm
CQP13 QP13 VSS 0.5p
CQN13 QN13 VSS 0.5p
XND113 QP13 H13 BIT13 VDD33 VSS gf180_sdm3_nand2
XND213 QN13 BIT13 H13 VDD33 VSS gf180_sdm3_nand2
* slice 14: theta=+43.75 mV diff
VOFFP14 O2P INPP14 -2.187500e-02
VOFFN14 O2N INNN14 2.187500e-02
XCMP14 INPP14 INNN14 QP14 QN14 CMPCK VDD33 VSS gf180_strongarm
CQP14 QP14 VSS 0.5p
CQN14 QN14 VSS 0.5p
XND114 QP14 H14 BIT14 VDD33 VSS gf180_sdm3_nand2
XND214 QN14 BIT14 H14 VDD33 VSS gf180_sdm3_nand2
.ends gf180_sdm3_flash15

.subckt gf180_sdm3_int1_mb INP_S INN_S VCM_REF VP VN OUTP OUTN PH1 NPH1 PH2 NPH2 VDD33 VSS SP0 SP1 SP2 SP3 SP4 SP5 SP6 SP7 SP8 SP9 SP10 SP11 SP12 SP13 SP14 SN0 SN1 SN2 SN3 SN4 SN5 SN6 SN7 SN8 SN9 SN10 SN11 SN12 SN13 SN14 params: CS=16p CU=1p CI=8p W91=11u L91=2u W92=6u L92=2u W10=12u RSET=25k CC=10p
XOTA INP INN VCM_REF OUTP OUTN VDD33 VSS gf180_fd_ota_full2_nc W91={W91} L91={L91} W92={W92} L92={L92} W10={W10} RSET={RSET} CC={CC}
CSP CSLP CSRP {CS}
CSN CSLN CSRN {CS}
XS1A CSLP INP_S PH1 NPH1 VDD33 VSS gf180_tg_lowq
XS1B CSRP VCM_REF PH1 NPH1 VDD33 VSS gf180_tg_lowq
XS1C CSLN INN_S PH1 NPH1 VDD33 VSS gf180_tg_lowq
XS1D CSRN VCM_REF PH1 NPH1 VDD33 VSS gf180_tg_lowq
XS2A CSLP VCM_REF PH2 NPH2 VDD33 VSS gf180_tg_lowq
XS2B CSRP INP PH2 NPH2 VDD33 VSS gf180_tg_lowq
XS2C CSLN VCM_REF PH2 NPH2 VDD33 VSS gf180_tg_lowq
XS2D CSRN INN PH2 NPH2 VDD33 VSS gf180_tg_lowq
* DAC unit 0 (P side DP0, N side DN0); SP/SN are logic levels
CDP0 CDLP0 CDRP0 {CU}
CDN0 CDLN0 CDRN0 {CU}
XDPA0 CDLP0 VCM_REF PH1 NPH1 VDD33 VSS gf180_tg_lowq
XDPB0 CDRP0 VCM_REF PH1 NPH1 VDD33 VSS gf180_tg_lowq
XDNA0 CDLN0 VCM_REF PH1 NPH1 VDD33 VSS gf180_tg_lowq
XDNB0 CDRN0 VCM_REF PH1 NPH1 VDD33 VSS gf180_tg_lowq
XDP20 CDRP0 INP PH2 NPH2 VDD33 VSS gf180_tg_lowq
XDN20 CDRN0 INN PH2 NPH2 VDD33 VSS gf180_tg_lowq
XNDGPP0 PH2 SP0 NGPP0 VDD33 VSS gf180_sdm3_nand2
XIGPP0 NGPP0 GPP0 VDD33 VSS gf180_sdm3_inv
XNDGPN0 PH2 SN0 NGPN0 VDD33 VSS gf180_sdm3_nand2
XIGPN0 NGPN0 GPN0 VDD33 VSS gf180_sdm3_inv
XPVP0 CDLP0 VP GPP0 NGPP0 VDD33 VSS gf180_tg_lowq
XPVN0 CDLP0 VN GPN0 NGPN0 VDD33 VSS gf180_tg_lowq
XNDGNP0 PH2 SN0 NGNP0 VDD33 VSS gf180_sdm3_nand2
XIGNP0 NGNP0 GNP0 VDD33 VSS gf180_sdm3_inv
XNDGNN0 PH2 SP0 NGNN0 VDD33 VSS gf180_sdm3_nand2
XIGNN0 NGNN0 GNN0 VDD33 VSS gf180_sdm3_inv
XNVP0 CDLN0 VP GNP0 NGNP0 VDD33 VSS gf180_tg_lowq
XNVN0 CDLN0 VN GNN0 NGNN0 VDD33 VSS gf180_tg_lowq
* DAC unit 1 (P side DP1, N side DN1); SP/SN are logic levels
CDP1 CDLP1 CDRP1 {CU}
CDN1 CDLN1 CDRN1 {CU}
XDPA1 CDLP1 VCM_REF PH1 NPH1 VDD33 VSS gf180_tg_lowq
XDPB1 CDRP1 VCM_REF PH1 NPH1 VDD33 VSS gf180_tg_lowq
XDNA1 CDLN1 VCM_REF PH1 NPH1 VDD33 VSS gf180_tg_lowq
XDNB1 CDRN1 VCM_REF PH1 NPH1 VDD33 VSS gf180_tg_lowq
XDP21 CDRP1 INP PH2 NPH2 VDD33 VSS gf180_tg_lowq
XDN21 CDRN1 INN PH2 NPH2 VDD33 VSS gf180_tg_lowq
XNDGPP1 PH2 SP1 NGPP1 VDD33 VSS gf180_sdm3_nand2
XIGPP1 NGPP1 GPP1 VDD33 VSS gf180_sdm3_inv
XNDGPN1 PH2 SN1 NGPN1 VDD33 VSS gf180_sdm3_nand2
XIGPN1 NGPN1 GPN1 VDD33 VSS gf180_sdm3_inv
XPVP1 CDLP1 VP GPP1 NGPP1 VDD33 VSS gf180_tg_lowq
XPVN1 CDLP1 VN GPN1 NGPN1 VDD33 VSS gf180_tg_lowq
XNDGNP1 PH2 SN1 NGNP1 VDD33 VSS gf180_sdm3_nand2
XIGNP1 NGNP1 GNP1 VDD33 VSS gf180_sdm3_inv
XNDGNN1 PH2 SP1 NGNN1 VDD33 VSS gf180_sdm3_nand2
XIGNN1 NGNN1 GNN1 VDD33 VSS gf180_sdm3_inv
XNVP1 CDLN1 VP GNP1 NGNP1 VDD33 VSS gf180_tg_lowq
XNVN1 CDLN1 VN GNN1 NGNN1 VDD33 VSS gf180_tg_lowq
* DAC unit 2 (P side DP2, N side DN2); SP/SN are logic levels
CDP2 CDLP2 CDRP2 {CU}
CDN2 CDLN2 CDRN2 {CU}
XDPA2 CDLP2 VCM_REF PH1 NPH1 VDD33 VSS gf180_tg_lowq
XDPB2 CDRP2 VCM_REF PH1 NPH1 VDD33 VSS gf180_tg_lowq
XDNA2 CDLN2 VCM_REF PH1 NPH1 VDD33 VSS gf180_tg_lowq
XDNB2 CDRN2 VCM_REF PH1 NPH1 VDD33 VSS gf180_tg_lowq
XDP22 CDRP2 INP PH2 NPH2 VDD33 VSS gf180_tg_lowq
XDN22 CDRN2 INN PH2 NPH2 VDD33 VSS gf180_tg_lowq
XNDGPP2 PH2 SP2 NGPP2 VDD33 VSS gf180_sdm3_nand2
XIGPP2 NGPP2 GPP2 VDD33 VSS gf180_sdm3_inv
XNDGPN2 PH2 SN2 NGPN2 VDD33 VSS gf180_sdm3_nand2
XIGPN2 NGPN2 GPN2 VDD33 VSS gf180_sdm3_inv
XPVP2 CDLP2 VP GPP2 NGPP2 VDD33 VSS gf180_tg_lowq
XPVN2 CDLP2 VN GPN2 NGPN2 VDD33 VSS gf180_tg_lowq
XNDGNP2 PH2 SN2 NGNP2 VDD33 VSS gf180_sdm3_nand2
XIGNP2 NGNP2 GNP2 VDD33 VSS gf180_sdm3_inv
XNDGNN2 PH2 SP2 NGNN2 VDD33 VSS gf180_sdm3_nand2
XIGNN2 NGNN2 GNN2 VDD33 VSS gf180_sdm3_inv
XNVP2 CDLN2 VP GNP2 NGNP2 VDD33 VSS gf180_tg_lowq
XNVN2 CDLN2 VN GNN2 NGNN2 VDD33 VSS gf180_tg_lowq
* DAC unit 3 (P side DP3, N side DN3); SP/SN are logic levels
CDP3 CDLP3 CDRP3 {CU}
CDN3 CDLN3 CDRN3 {CU}
XDPA3 CDLP3 VCM_REF PH1 NPH1 VDD33 VSS gf180_tg_lowq
XDPB3 CDRP3 VCM_REF PH1 NPH1 VDD33 VSS gf180_tg_lowq
XDNA3 CDLN3 VCM_REF PH1 NPH1 VDD33 VSS gf180_tg_lowq
XDNB3 CDRN3 VCM_REF PH1 NPH1 VDD33 VSS gf180_tg_lowq
XDP23 CDRP3 INP PH2 NPH2 VDD33 VSS gf180_tg_lowq
XDN23 CDRN3 INN PH2 NPH2 VDD33 VSS gf180_tg_lowq
XNDGPP3 PH2 SP3 NGPP3 VDD33 VSS gf180_sdm3_nand2
XIGPP3 NGPP3 GPP3 VDD33 VSS gf180_sdm3_inv
XNDGPN3 PH2 SN3 NGPN3 VDD33 VSS gf180_sdm3_nand2
XIGPN3 NGPN3 GPN3 VDD33 VSS gf180_sdm3_inv
XPVP3 CDLP3 VP GPP3 NGPP3 VDD33 VSS gf180_tg_lowq
XPVN3 CDLP3 VN GPN3 NGPN3 VDD33 VSS gf180_tg_lowq
XNDGNP3 PH2 SN3 NGNP3 VDD33 VSS gf180_sdm3_nand2
XIGNP3 NGNP3 GNP3 VDD33 VSS gf180_sdm3_inv
XNDGNN3 PH2 SP3 NGNN3 VDD33 VSS gf180_sdm3_nand2
XIGNN3 NGNN3 GNN3 VDD33 VSS gf180_sdm3_inv
XNVP3 CDLN3 VP GNP3 NGNP3 VDD33 VSS gf180_tg_lowq
XNVN3 CDLN3 VN GNN3 NGNN3 VDD33 VSS gf180_tg_lowq
* DAC unit 4 (P side DP4, N side DN4); SP/SN are logic levels
CDP4 CDLP4 CDRP4 {CU}
CDN4 CDLN4 CDRN4 {CU}
XDPA4 CDLP4 VCM_REF PH1 NPH1 VDD33 VSS gf180_tg_lowq
XDPB4 CDRP4 VCM_REF PH1 NPH1 VDD33 VSS gf180_tg_lowq
XDNA4 CDLN4 VCM_REF PH1 NPH1 VDD33 VSS gf180_tg_lowq
XDNB4 CDRN4 VCM_REF PH1 NPH1 VDD33 VSS gf180_tg_lowq
XDP24 CDRP4 INP PH2 NPH2 VDD33 VSS gf180_tg_lowq
XDN24 CDRN4 INN PH2 NPH2 VDD33 VSS gf180_tg_lowq
XNDGPP4 PH2 SP4 NGPP4 VDD33 VSS gf180_sdm3_nand2
XIGPP4 NGPP4 GPP4 VDD33 VSS gf180_sdm3_inv
XNDGPN4 PH2 SN4 NGPN4 VDD33 VSS gf180_sdm3_nand2
XIGPN4 NGPN4 GPN4 VDD33 VSS gf180_sdm3_inv
XPVP4 CDLP4 VP GPP4 NGPP4 VDD33 VSS gf180_tg_lowq
XPVN4 CDLP4 VN GPN4 NGPN4 VDD33 VSS gf180_tg_lowq
XNDGNP4 PH2 SN4 NGNP4 VDD33 VSS gf180_sdm3_nand2
XIGNP4 NGNP4 GNP4 VDD33 VSS gf180_sdm3_inv
XNDGNN4 PH2 SP4 NGNN4 VDD33 VSS gf180_sdm3_nand2
XIGNN4 NGNN4 GNN4 VDD33 VSS gf180_sdm3_inv
XNVP4 CDLN4 VP GNP4 NGNP4 VDD33 VSS gf180_tg_lowq
XNVN4 CDLN4 VN GNN4 NGNN4 VDD33 VSS gf180_tg_lowq
* DAC unit 5 (P side DP5, N side DN5); SP/SN are logic levels
CDP5 CDLP5 CDRP5 {CU}
CDN5 CDLN5 CDRN5 {CU}
XDPA5 CDLP5 VCM_REF PH1 NPH1 VDD33 VSS gf180_tg_lowq
XDPB5 CDRP5 VCM_REF PH1 NPH1 VDD33 VSS gf180_tg_lowq
XDNA5 CDLN5 VCM_REF PH1 NPH1 VDD33 VSS gf180_tg_lowq
XDNB5 CDRN5 VCM_REF PH1 NPH1 VDD33 VSS gf180_tg_lowq
XDP25 CDRP5 INP PH2 NPH2 VDD33 VSS gf180_tg_lowq
XDN25 CDRN5 INN PH2 NPH2 VDD33 VSS gf180_tg_lowq
XNDGPP5 PH2 SP5 NGPP5 VDD33 VSS gf180_sdm3_nand2
XIGPP5 NGPP5 GPP5 VDD33 VSS gf180_sdm3_inv
XNDGPN5 PH2 SN5 NGPN5 VDD33 VSS gf180_sdm3_nand2
XIGPN5 NGPN5 GPN5 VDD33 VSS gf180_sdm3_inv
XPVP5 CDLP5 VP GPP5 NGPP5 VDD33 VSS gf180_tg_lowq
XPVN5 CDLP5 VN GPN5 NGPN5 VDD33 VSS gf180_tg_lowq
XNDGNP5 PH2 SN5 NGNP5 VDD33 VSS gf180_sdm3_nand2
XIGNP5 NGNP5 GNP5 VDD33 VSS gf180_sdm3_inv
XNDGNN5 PH2 SP5 NGNN5 VDD33 VSS gf180_sdm3_nand2
XIGNN5 NGNN5 GNN5 VDD33 VSS gf180_sdm3_inv
XNVP5 CDLN5 VP GNP5 NGNP5 VDD33 VSS gf180_tg_lowq
XNVN5 CDLN5 VN GNN5 NGNN5 VDD33 VSS gf180_tg_lowq
* DAC unit 6 (P side DP6, N side DN6); SP/SN are logic levels
CDP6 CDLP6 CDRP6 {CU}
CDN6 CDLN6 CDRN6 {CU}
XDPA6 CDLP6 VCM_REF PH1 NPH1 VDD33 VSS gf180_tg_lowq
XDPB6 CDRP6 VCM_REF PH1 NPH1 VDD33 VSS gf180_tg_lowq
XDNA6 CDLN6 VCM_REF PH1 NPH1 VDD33 VSS gf180_tg_lowq
XDNB6 CDRN6 VCM_REF PH1 NPH1 VDD33 VSS gf180_tg_lowq
XDP26 CDRP6 INP PH2 NPH2 VDD33 VSS gf180_tg_lowq
XDN26 CDRN6 INN PH2 NPH2 VDD33 VSS gf180_tg_lowq
XNDGPP6 PH2 SP6 NGPP6 VDD33 VSS gf180_sdm3_nand2
XIGPP6 NGPP6 GPP6 VDD33 VSS gf180_sdm3_inv
XNDGPN6 PH2 SN6 NGPN6 VDD33 VSS gf180_sdm3_nand2
XIGPN6 NGPN6 GPN6 VDD33 VSS gf180_sdm3_inv
XPVP6 CDLP6 VP GPP6 NGPP6 VDD33 VSS gf180_tg_lowq
XPVN6 CDLP6 VN GPN6 NGPN6 VDD33 VSS gf180_tg_lowq
XNDGNP6 PH2 SN6 NGNP6 VDD33 VSS gf180_sdm3_nand2
XIGNP6 NGNP6 GNP6 VDD33 VSS gf180_sdm3_inv
XNDGNN6 PH2 SP6 NGNN6 VDD33 VSS gf180_sdm3_nand2
XIGNN6 NGNN6 GNN6 VDD33 VSS gf180_sdm3_inv
XNVP6 CDLN6 VP GNP6 NGNP6 VDD33 VSS gf180_tg_lowq
XNVN6 CDLN6 VN GNN6 NGNN6 VDD33 VSS gf180_tg_lowq
* DAC unit 7 (P side DP7, N side DN7); SP/SN are logic levels
CDP7 CDLP7 CDRP7 {CU}
CDN7 CDLN7 CDRN7 {CU}
XDPA7 CDLP7 VCM_REF PH1 NPH1 VDD33 VSS gf180_tg_lowq
XDPB7 CDRP7 VCM_REF PH1 NPH1 VDD33 VSS gf180_tg_lowq
XDNA7 CDLN7 VCM_REF PH1 NPH1 VDD33 VSS gf180_tg_lowq
XDNB7 CDRN7 VCM_REF PH1 NPH1 VDD33 VSS gf180_tg_lowq
XDP27 CDRP7 INP PH2 NPH2 VDD33 VSS gf180_tg_lowq
XDN27 CDRN7 INN PH2 NPH2 VDD33 VSS gf180_tg_lowq
XNDGPP7 PH2 SP7 NGPP7 VDD33 VSS gf180_sdm3_nand2
XIGPP7 NGPP7 GPP7 VDD33 VSS gf180_sdm3_inv
XNDGPN7 PH2 SN7 NGPN7 VDD33 VSS gf180_sdm3_nand2
XIGPN7 NGPN7 GPN7 VDD33 VSS gf180_sdm3_inv
XPVP7 CDLP7 VP GPP7 NGPP7 VDD33 VSS gf180_tg_lowq
XPVN7 CDLP7 VN GPN7 NGPN7 VDD33 VSS gf180_tg_lowq
XNDGNP7 PH2 SN7 NGNP7 VDD33 VSS gf180_sdm3_nand2
XIGNP7 NGNP7 GNP7 VDD33 VSS gf180_sdm3_inv
XNDGNN7 PH2 SP7 NGNN7 VDD33 VSS gf180_sdm3_nand2
XIGNN7 NGNN7 GNN7 VDD33 VSS gf180_sdm3_inv
XNVP7 CDLN7 VP GNP7 NGNP7 VDD33 VSS gf180_tg_lowq
XNVN7 CDLN7 VN GNN7 NGNN7 VDD33 VSS gf180_tg_lowq
* DAC unit 8 (P side DP8, N side DN8); SP/SN are logic levels
CDP8 CDLP8 CDRP8 {CU}
CDN8 CDLN8 CDRN8 {CU}
XDPA8 CDLP8 VCM_REF PH1 NPH1 VDD33 VSS gf180_tg_lowq
XDPB8 CDRP8 VCM_REF PH1 NPH1 VDD33 VSS gf180_tg_lowq
XDNA8 CDLN8 VCM_REF PH1 NPH1 VDD33 VSS gf180_tg_lowq
XDNB8 CDRN8 VCM_REF PH1 NPH1 VDD33 VSS gf180_tg_lowq
XDP28 CDRP8 INP PH2 NPH2 VDD33 VSS gf180_tg_lowq
XDN28 CDRN8 INN PH2 NPH2 VDD33 VSS gf180_tg_lowq
XNDGPP8 PH2 SP8 NGPP8 VDD33 VSS gf180_sdm3_nand2
XIGPP8 NGPP8 GPP8 VDD33 VSS gf180_sdm3_inv
XNDGPN8 PH2 SN8 NGPN8 VDD33 VSS gf180_sdm3_nand2
XIGPN8 NGPN8 GPN8 VDD33 VSS gf180_sdm3_inv
XPVP8 CDLP8 VP GPP8 NGPP8 VDD33 VSS gf180_tg_lowq
XPVN8 CDLP8 VN GPN8 NGPN8 VDD33 VSS gf180_tg_lowq
XNDGNP8 PH2 SN8 NGNP8 VDD33 VSS gf180_sdm3_nand2
XIGNP8 NGNP8 GNP8 VDD33 VSS gf180_sdm3_inv
XNDGNN8 PH2 SP8 NGNN8 VDD33 VSS gf180_sdm3_nand2
XIGNN8 NGNN8 GNN8 VDD33 VSS gf180_sdm3_inv
XNVP8 CDLN8 VP GNP8 NGNP8 VDD33 VSS gf180_tg_lowq
XNVN8 CDLN8 VN GNN8 NGNN8 VDD33 VSS gf180_tg_lowq
* DAC unit 9 (P side DP9, N side DN9); SP/SN are logic levels
CDP9 CDLP9 CDRP9 {CU}
CDN9 CDLN9 CDRN9 {CU}
XDPA9 CDLP9 VCM_REF PH1 NPH1 VDD33 VSS gf180_tg_lowq
XDPB9 CDRP9 VCM_REF PH1 NPH1 VDD33 VSS gf180_tg_lowq
XDNA9 CDLN9 VCM_REF PH1 NPH1 VDD33 VSS gf180_tg_lowq
XDNB9 CDRN9 VCM_REF PH1 NPH1 VDD33 VSS gf180_tg_lowq
XDP29 CDRP9 INP PH2 NPH2 VDD33 VSS gf180_tg_lowq
XDN29 CDRN9 INN PH2 NPH2 VDD33 VSS gf180_tg_lowq
XNDGPP9 PH2 SP9 NGPP9 VDD33 VSS gf180_sdm3_nand2
XIGPP9 NGPP9 GPP9 VDD33 VSS gf180_sdm3_inv
XNDGPN9 PH2 SN9 NGPN9 VDD33 VSS gf180_sdm3_nand2
XIGPN9 NGPN9 GPN9 VDD33 VSS gf180_sdm3_inv
XPVP9 CDLP9 VP GPP9 NGPP9 VDD33 VSS gf180_tg_lowq
XPVN9 CDLP9 VN GPN9 NGPN9 VDD33 VSS gf180_tg_lowq
XNDGNP9 PH2 SN9 NGNP9 VDD33 VSS gf180_sdm3_nand2
XIGNP9 NGNP9 GNP9 VDD33 VSS gf180_sdm3_inv
XNDGNN9 PH2 SP9 NGNN9 VDD33 VSS gf180_sdm3_nand2
XIGNN9 NGNN9 GNN9 VDD33 VSS gf180_sdm3_inv
XNVP9 CDLN9 VP GNP9 NGNP9 VDD33 VSS gf180_tg_lowq
XNVN9 CDLN9 VN GNN9 NGNN9 VDD33 VSS gf180_tg_lowq
* DAC unit 10 (P side DP10, N side DN10); SP/SN are logic levels
CDP10 CDLP10 CDRP10 {CU}
CDN10 CDLN10 CDRN10 {CU}
XDPA10 CDLP10 VCM_REF PH1 NPH1 VDD33 VSS gf180_tg_lowq
XDPB10 CDRP10 VCM_REF PH1 NPH1 VDD33 VSS gf180_tg_lowq
XDNA10 CDLN10 VCM_REF PH1 NPH1 VDD33 VSS gf180_tg_lowq
XDNB10 CDRN10 VCM_REF PH1 NPH1 VDD33 VSS gf180_tg_lowq
XDP210 CDRP10 INP PH2 NPH2 VDD33 VSS gf180_tg_lowq
XDN210 CDRN10 INN PH2 NPH2 VDD33 VSS gf180_tg_lowq
XNDGPP10 PH2 SP10 NGPP10 VDD33 VSS gf180_sdm3_nand2
XIGPP10 NGPP10 GPP10 VDD33 VSS gf180_sdm3_inv
XNDGPN10 PH2 SN10 NGPN10 VDD33 VSS gf180_sdm3_nand2
XIGPN10 NGPN10 GPN10 VDD33 VSS gf180_sdm3_inv
XPVP10 CDLP10 VP GPP10 NGPP10 VDD33 VSS gf180_tg_lowq
XPVN10 CDLP10 VN GPN10 NGPN10 VDD33 VSS gf180_tg_lowq
XNDGNP10 PH2 SN10 NGNP10 VDD33 VSS gf180_sdm3_nand2
XIGNP10 NGNP10 GNP10 VDD33 VSS gf180_sdm3_inv
XNDGNN10 PH2 SP10 NGNN10 VDD33 VSS gf180_sdm3_nand2
XIGNN10 NGNN10 GNN10 VDD33 VSS gf180_sdm3_inv
XNVP10 CDLN10 VP GNP10 NGNP10 VDD33 VSS gf180_tg_lowq
XNVN10 CDLN10 VN GNN10 NGNN10 VDD33 VSS gf180_tg_lowq
* DAC unit 11 (P side DP11, N side DN11); SP/SN are logic levels
CDP11 CDLP11 CDRP11 {CU}
CDN11 CDLN11 CDRN11 {CU}
XDPA11 CDLP11 VCM_REF PH1 NPH1 VDD33 VSS gf180_tg_lowq
XDPB11 CDRP11 VCM_REF PH1 NPH1 VDD33 VSS gf180_tg_lowq
XDNA11 CDLN11 VCM_REF PH1 NPH1 VDD33 VSS gf180_tg_lowq
XDNB11 CDRN11 VCM_REF PH1 NPH1 VDD33 VSS gf180_tg_lowq
XDP211 CDRP11 INP PH2 NPH2 VDD33 VSS gf180_tg_lowq
XDN211 CDRN11 INN PH2 NPH2 VDD33 VSS gf180_tg_lowq
XNDGPP11 PH2 SP11 NGPP11 VDD33 VSS gf180_sdm3_nand2
XIGPP11 NGPP11 GPP11 VDD33 VSS gf180_sdm3_inv
XNDGPN11 PH2 SN11 NGPN11 VDD33 VSS gf180_sdm3_nand2
XIGPN11 NGPN11 GPN11 VDD33 VSS gf180_sdm3_inv
XPVP11 CDLP11 VP GPP11 NGPP11 VDD33 VSS gf180_tg_lowq
XPVN11 CDLP11 VN GPN11 NGPN11 VDD33 VSS gf180_tg_lowq
XNDGNP11 PH2 SN11 NGNP11 VDD33 VSS gf180_sdm3_nand2
XIGNP11 NGNP11 GNP11 VDD33 VSS gf180_sdm3_inv
XNDGNN11 PH2 SP11 NGNN11 VDD33 VSS gf180_sdm3_nand2
XIGNN11 NGNN11 GNN11 VDD33 VSS gf180_sdm3_inv
XNVP11 CDLN11 VP GNP11 NGNP11 VDD33 VSS gf180_tg_lowq
XNVN11 CDLN11 VN GNN11 NGNN11 VDD33 VSS gf180_tg_lowq
* DAC unit 12 (P side DP12, N side DN12); SP/SN are logic levels
CDP12 CDLP12 CDRP12 {CU}
CDN12 CDLN12 CDRN12 {CU}
XDPA12 CDLP12 VCM_REF PH1 NPH1 VDD33 VSS gf180_tg_lowq
XDPB12 CDRP12 VCM_REF PH1 NPH1 VDD33 VSS gf180_tg_lowq
XDNA12 CDLN12 VCM_REF PH1 NPH1 VDD33 VSS gf180_tg_lowq
XDNB12 CDRN12 VCM_REF PH1 NPH1 VDD33 VSS gf180_tg_lowq
XDP212 CDRP12 INP PH2 NPH2 VDD33 VSS gf180_tg_lowq
XDN212 CDRN12 INN PH2 NPH2 VDD33 VSS gf180_tg_lowq
XNDGPP12 PH2 SP12 NGPP12 VDD33 VSS gf180_sdm3_nand2
XIGPP12 NGPP12 GPP12 VDD33 VSS gf180_sdm3_inv
XNDGPN12 PH2 SN12 NGPN12 VDD33 VSS gf180_sdm3_nand2
XIGPN12 NGPN12 GPN12 VDD33 VSS gf180_sdm3_inv
XPVP12 CDLP12 VP GPP12 NGPP12 VDD33 VSS gf180_tg_lowq
XPVN12 CDLP12 VN GPN12 NGPN12 VDD33 VSS gf180_tg_lowq
XNDGNP12 PH2 SN12 NGNP12 VDD33 VSS gf180_sdm3_nand2
XIGNP12 NGNP12 GNP12 VDD33 VSS gf180_sdm3_inv
XNDGNN12 PH2 SP12 NGNN12 VDD33 VSS gf180_sdm3_nand2
XIGNN12 NGNN12 GNN12 VDD33 VSS gf180_sdm3_inv
XNVP12 CDLN12 VP GNP12 NGNP12 VDD33 VSS gf180_tg_lowq
XNVN12 CDLN12 VN GNN12 NGNN12 VDD33 VSS gf180_tg_lowq
* DAC unit 13 (P side DP13, N side DN13); SP/SN are logic levels
CDP13 CDLP13 CDRP13 {CU}
CDN13 CDLN13 CDRN13 {CU}
XDPA13 CDLP13 VCM_REF PH1 NPH1 VDD33 VSS gf180_tg_lowq
XDPB13 CDRP13 VCM_REF PH1 NPH1 VDD33 VSS gf180_tg_lowq
XDNA13 CDLN13 VCM_REF PH1 NPH1 VDD33 VSS gf180_tg_lowq
XDNB13 CDRN13 VCM_REF PH1 NPH1 VDD33 VSS gf180_tg_lowq
XDP213 CDRP13 INP PH2 NPH2 VDD33 VSS gf180_tg_lowq
XDN213 CDRN13 INN PH2 NPH2 VDD33 VSS gf180_tg_lowq
XNDGPP13 PH2 SP13 NGPP13 VDD33 VSS gf180_sdm3_nand2
XIGPP13 NGPP13 GPP13 VDD33 VSS gf180_sdm3_inv
XNDGPN13 PH2 SN13 NGPN13 VDD33 VSS gf180_sdm3_nand2
XIGPN13 NGPN13 GPN13 VDD33 VSS gf180_sdm3_inv
XPVP13 CDLP13 VP GPP13 NGPP13 VDD33 VSS gf180_tg_lowq
XPVN13 CDLP13 VN GPN13 NGPN13 VDD33 VSS gf180_tg_lowq
XNDGNP13 PH2 SN13 NGNP13 VDD33 VSS gf180_sdm3_nand2
XIGNP13 NGNP13 GNP13 VDD33 VSS gf180_sdm3_inv
XNDGNN13 PH2 SP13 NGNN13 VDD33 VSS gf180_sdm3_nand2
XIGNN13 NGNN13 GNN13 VDD33 VSS gf180_sdm3_inv
XNVP13 CDLN13 VP GNP13 NGNP13 VDD33 VSS gf180_tg_lowq
XNVN13 CDLN13 VN GNN13 NGNN13 VDD33 VSS gf180_tg_lowq
* DAC unit 14 (P side DP14, N side DN14); SP/SN are logic levels
CDP14 CDLP14 CDRP14 {CU}
CDN14 CDLN14 CDRN14 {CU}
XDPA14 CDLP14 VCM_REF PH1 NPH1 VDD33 VSS gf180_tg_lowq
XDPB14 CDRP14 VCM_REF PH1 NPH1 VDD33 VSS gf180_tg_lowq
XDNA14 CDLN14 VCM_REF PH1 NPH1 VDD33 VSS gf180_tg_lowq
XDNB14 CDRN14 VCM_REF PH1 NPH1 VDD33 VSS gf180_tg_lowq
XDP214 CDRP14 INP PH2 NPH2 VDD33 VSS gf180_tg_lowq
XDN214 CDRN14 INN PH2 NPH2 VDD33 VSS gf180_tg_lowq
XNDGPP14 PH2 SP14 NGPP14 VDD33 VSS gf180_sdm3_nand2
XIGPP14 NGPP14 GPP14 VDD33 VSS gf180_sdm3_inv
XNDGPN14 PH2 SN14 NGPN14 VDD33 VSS gf180_sdm3_nand2
XIGPN14 NGPN14 GPN14 VDD33 VSS gf180_sdm3_inv
XPVP14 CDLP14 VP GPP14 NGPP14 VDD33 VSS gf180_tg_lowq
XPVN14 CDLP14 VN GPN14 NGPN14 VDD33 VSS gf180_tg_lowq
XNDGNP14 PH2 SN14 NGNP14 VDD33 VSS gf180_sdm3_nand2
XIGNP14 NGNP14 GNP14 VDD33 VSS gf180_sdm3_inv
XNDGNN14 PH2 SP14 NGNN14 VDD33 VSS gf180_sdm3_nand2
XIGNN14 NGNN14 GNN14 VDD33 VSS gf180_sdm3_inv
XNVP14 CDLN14 VP GNP14 NGNP14 VDD33 VSS gf180_tg_lowq
XNVN14 CDLN14 VN GNN14 NGNN14 VDD33 VSS gf180_tg_lowq
CIP OUTN INP {CI}
CIN OUTP INN {CI}
RBIASP INP VCM_REF 10G
RBIASN INN VCM_REF 10G
.ends gf180_sdm3_int1_mb

.subckt gf180_sdm3_int2_mb INP_S INN_S VCM_REF VP VN OUTP OUTN PH1 NPH1 PH2 NPH2 VDD33 VSS S2P0 S2P1 S2P2 S2P3 S2P4 S2P5 S2P6 S2P7 S2P8 S2P9 S2P10 S2P11 S2P12 S2P13 S2P14 S2N0 S2N1 S2N2 S2N3 S2N4 S2N5 S2N6 S2N7 S2N8 S2N9 S2N10 S2N11 S2N12 S2N13 S2N14 params: CS=2p CU=0.25p CI=4p W91=11u L91=2u W92=6u L92=2u W10=12u RSET=25k CC=10p
XOTA INP INN VCM_REF OUTP OUTN VDD33 VSS gf180_fd_ota_full2_nc W91={W91} L91={L91} W92={W92} L92={L92} W10={W10} RSET={RSET} CC={CC}
CSP CSLP CSRP {CS}
CSN CSLN CSRN {CS}
XS1A CSLP INP_S PH1 NPH1 VDD33 VSS gf180_tg_lowq
XS1B CSRP VCM_REF PH1 NPH1 VDD33 VSS gf180_tg_lowq
XS1C CSLN INN_S PH1 NPH1 VDD33 VSS gf180_tg_lowq
XS1D CSRN VCM_REF PH1 NPH1 VDD33 VSS gf180_tg_lowq
XS2A CSLP VCM_REF PH2 NPH2 VDD33 VSS gf180_tg_lowq
XS2B CSRP INP PH2 NPH2 VDD33 VSS gf180_tg_lowq
XS2C CSLN VCM_REF PH2 NPH2 VDD33 VSS gf180_tg_lowq
XS2D CSRN INN PH2 NPH2 VDD33 VSS gf180_tg_lowq
* DAC unit 0
CDP0 CDLP0 CDRP0 {CU}
CDN0 CDLN0 CDRN0 {CU}
XDP10 CDRP0 VCM_REF PH1 NPH1 VDD33 VSS gf180_tg_lowq
XDP20 CDRP0 INP PH2 NPH2 VDD33 VSS gf180_tg_lowq
XDN10 CDRN0 VCM_REF PH1 NPH1 VDD33 VSS gf180_tg_lowq
XDN20 CDRN0 INN PH2 NPH2 VDD33 VSS gf180_tg_lowq
XDPC0 CDLP0 VCM_REF PH1 NPH1 VDD33 VSS gf180_tg_lowq
XDNC0 CDLN0 VCM_REF PH1 NPH1 VDD33 VSS gf180_tg_lowq
XNDGPP0 PH2 S2P0 NGPP0 VDD33 VSS gf180_sdm3_nand2
XIGPP0 NGPP0 GPP0 VDD33 VSS gf180_sdm3_inv
XNDGPN0 PH2 S2N0 NGPN0 VDD33 VSS gf180_sdm3_nand2
XIGPN0 NGPN0 GPN0 VDD33 VSS gf180_sdm3_inv
XPVP0 CDLP0 VP GPP0 NGPP0 VDD33 VSS gf180_tg_lowq
XPVN0 CDLP0 VN GPN0 NGPN0 VDD33 VSS gf180_tg_lowq
XNDGNP0 PH2 S2N0 NGNP0 VDD33 VSS gf180_sdm3_nand2
XIGNP0 NGNP0 GNP0 VDD33 VSS gf180_sdm3_inv
XNDGNN0 PH2 S2P0 NGNN0 VDD33 VSS gf180_sdm3_nand2
XIGNN0 NGNN0 GNN0 VDD33 VSS gf180_sdm3_inv
XNVP0 CDLN0 VP GNP0 NGNP0 VDD33 VSS gf180_tg_lowq
XNVN0 CDLN0 VN GNN0 NGNN0 VDD33 VSS gf180_tg_lowq
* DAC unit 1
CDP1 CDLP1 CDRP1 {CU}
CDN1 CDLN1 CDRN1 {CU}
XDP11 CDRP1 VCM_REF PH1 NPH1 VDD33 VSS gf180_tg_lowq
XDP21 CDRP1 INP PH2 NPH2 VDD33 VSS gf180_tg_lowq
XDN11 CDRN1 VCM_REF PH1 NPH1 VDD33 VSS gf180_tg_lowq
XDN21 CDRN1 INN PH2 NPH2 VDD33 VSS gf180_tg_lowq
XDPC1 CDLP1 VCM_REF PH1 NPH1 VDD33 VSS gf180_tg_lowq
XDNC1 CDLN1 VCM_REF PH1 NPH1 VDD33 VSS gf180_tg_lowq
XNDGPP1 PH2 S2P1 NGPP1 VDD33 VSS gf180_sdm3_nand2
XIGPP1 NGPP1 GPP1 VDD33 VSS gf180_sdm3_inv
XNDGPN1 PH2 S2N1 NGPN1 VDD33 VSS gf180_sdm3_nand2
XIGPN1 NGPN1 GPN1 VDD33 VSS gf180_sdm3_inv
XPVP1 CDLP1 VP GPP1 NGPP1 VDD33 VSS gf180_tg_lowq
XPVN1 CDLP1 VN GPN1 NGPN1 VDD33 VSS gf180_tg_lowq
XNDGNP1 PH2 S2N1 NGNP1 VDD33 VSS gf180_sdm3_nand2
XIGNP1 NGNP1 GNP1 VDD33 VSS gf180_sdm3_inv
XNDGNN1 PH2 S2P1 NGNN1 VDD33 VSS gf180_sdm3_nand2
XIGNN1 NGNN1 GNN1 VDD33 VSS gf180_sdm3_inv
XNVP1 CDLN1 VP GNP1 NGNP1 VDD33 VSS gf180_tg_lowq
XNVN1 CDLN1 VN GNN1 NGNN1 VDD33 VSS gf180_tg_lowq
* DAC unit 2
CDP2 CDLP2 CDRP2 {CU}
CDN2 CDLN2 CDRN2 {CU}
XDP12 CDRP2 VCM_REF PH1 NPH1 VDD33 VSS gf180_tg_lowq
XDP22 CDRP2 INP PH2 NPH2 VDD33 VSS gf180_tg_lowq
XDN12 CDRN2 VCM_REF PH1 NPH1 VDD33 VSS gf180_tg_lowq
XDN22 CDRN2 INN PH2 NPH2 VDD33 VSS gf180_tg_lowq
XDPC2 CDLP2 VCM_REF PH1 NPH1 VDD33 VSS gf180_tg_lowq
XDNC2 CDLN2 VCM_REF PH1 NPH1 VDD33 VSS gf180_tg_lowq
XNDGPP2 PH2 S2P2 NGPP2 VDD33 VSS gf180_sdm3_nand2
XIGPP2 NGPP2 GPP2 VDD33 VSS gf180_sdm3_inv
XNDGPN2 PH2 S2N2 NGPN2 VDD33 VSS gf180_sdm3_nand2
XIGPN2 NGPN2 GPN2 VDD33 VSS gf180_sdm3_inv
XPVP2 CDLP2 VP GPP2 NGPP2 VDD33 VSS gf180_tg_lowq
XPVN2 CDLP2 VN GPN2 NGPN2 VDD33 VSS gf180_tg_lowq
XNDGNP2 PH2 S2N2 NGNP2 VDD33 VSS gf180_sdm3_nand2
XIGNP2 NGNP2 GNP2 VDD33 VSS gf180_sdm3_inv
XNDGNN2 PH2 S2P2 NGNN2 VDD33 VSS gf180_sdm3_nand2
XIGNN2 NGNN2 GNN2 VDD33 VSS gf180_sdm3_inv
XNVP2 CDLN2 VP GNP2 NGNP2 VDD33 VSS gf180_tg_lowq
XNVN2 CDLN2 VN GNN2 NGNN2 VDD33 VSS gf180_tg_lowq
* DAC unit 3
CDP3 CDLP3 CDRP3 {CU}
CDN3 CDLN3 CDRN3 {CU}
XDP13 CDRP3 VCM_REF PH1 NPH1 VDD33 VSS gf180_tg_lowq
XDP23 CDRP3 INP PH2 NPH2 VDD33 VSS gf180_tg_lowq
XDN13 CDRN3 VCM_REF PH1 NPH1 VDD33 VSS gf180_tg_lowq
XDN23 CDRN3 INN PH2 NPH2 VDD33 VSS gf180_tg_lowq
XDPC3 CDLP3 VCM_REF PH1 NPH1 VDD33 VSS gf180_tg_lowq
XDNC3 CDLN3 VCM_REF PH1 NPH1 VDD33 VSS gf180_tg_lowq
XNDGPP3 PH2 S2P3 NGPP3 VDD33 VSS gf180_sdm3_nand2
XIGPP3 NGPP3 GPP3 VDD33 VSS gf180_sdm3_inv
XNDGPN3 PH2 S2N3 NGPN3 VDD33 VSS gf180_sdm3_nand2
XIGPN3 NGPN3 GPN3 VDD33 VSS gf180_sdm3_inv
XPVP3 CDLP3 VP GPP3 NGPP3 VDD33 VSS gf180_tg_lowq
XPVN3 CDLP3 VN GPN3 NGPN3 VDD33 VSS gf180_tg_lowq
XNDGNP3 PH2 S2N3 NGNP3 VDD33 VSS gf180_sdm3_nand2
XIGNP3 NGNP3 GNP3 VDD33 VSS gf180_sdm3_inv
XNDGNN3 PH2 S2P3 NGNN3 VDD33 VSS gf180_sdm3_nand2
XIGNN3 NGNN3 GNN3 VDD33 VSS gf180_sdm3_inv
XNVP3 CDLN3 VP GNP3 NGNP3 VDD33 VSS gf180_tg_lowq
XNVN3 CDLN3 VN GNN3 NGNN3 VDD33 VSS gf180_tg_lowq
* DAC unit 4
CDP4 CDLP4 CDRP4 {CU}
CDN4 CDLN4 CDRN4 {CU}
XDP14 CDRP4 VCM_REF PH1 NPH1 VDD33 VSS gf180_tg_lowq
XDP24 CDRP4 INP PH2 NPH2 VDD33 VSS gf180_tg_lowq
XDN14 CDRN4 VCM_REF PH1 NPH1 VDD33 VSS gf180_tg_lowq
XDN24 CDRN4 INN PH2 NPH2 VDD33 VSS gf180_tg_lowq
XDPC4 CDLP4 VCM_REF PH1 NPH1 VDD33 VSS gf180_tg_lowq
XDNC4 CDLN4 VCM_REF PH1 NPH1 VDD33 VSS gf180_tg_lowq
XNDGPP4 PH2 S2P4 NGPP4 VDD33 VSS gf180_sdm3_nand2
XIGPP4 NGPP4 GPP4 VDD33 VSS gf180_sdm3_inv
XNDGPN4 PH2 S2N4 NGPN4 VDD33 VSS gf180_sdm3_nand2
XIGPN4 NGPN4 GPN4 VDD33 VSS gf180_sdm3_inv
XPVP4 CDLP4 VP GPP4 NGPP4 VDD33 VSS gf180_tg_lowq
XPVN4 CDLP4 VN GPN4 NGPN4 VDD33 VSS gf180_tg_lowq
XNDGNP4 PH2 S2N4 NGNP4 VDD33 VSS gf180_sdm3_nand2
XIGNP4 NGNP4 GNP4 VDD33 VSS gf180_sdm3_inv
XNDGNN4 PH2 S2P4 NGNN4 VDD33 VSS gf180_sdm3_nand2
XIGNN4 NGNN4 GNN4 VDD33 VSS gf180_sdm3_inv
XNVP4 CDLN4 VP GNP4 NGNP4 VDD33 VSS gf180_tg_lowq
XNVN4 CDLN4 VN GNN4 NGNN4 VDD33 VSS gf180_tg_lowq
* DAC unit 5
CDP5 CDLP5 CDRP5 {CU}
CDN5 CDLN5 CDRN5 {CU}
XDP15 CDRP5 VCM_REF PH1 NPH1 VDD33 VSS gf180_tg_lowq
XDP25 CDRP5 INP PH2 NPH2 VDD33 VSS gf180_tg_lowq
XDN15 CDRN5 VCM_REF PH1 NPH1 VDD33 VSS gf180_tg_lowq
XDN25 CDRN5 INN PH2 NPH2 VDD33 VSS gf180_tg_lowq
XDPC5 CDLP5 VCM_REF PH1 NPH1 VDD33 VSS gf180_tg_lowq
XDNC5 CDLN5 VCM_REF PH1 NPH1 VDD33 VSS gf180_tg_lowq
XNDGPP5 PH2 S2P5 NGPP5 VDD33 VSS gf180_sdm3_nand2
XIGPP5 NGPP5 GPP5 VDD33 VSS gf180_sdm3_inv
XNDGPN5 PH2 S2N5 NGPN5 VDD33 VSS gf180_sdm3_nand2
XIGPN5 NGPN5 GPN5 VDD33 VSS gf180_sdm3_inv
XPVP5 CDLP5 VP GPP5 NGPP5 VDD33 VSS gf180_tg_lowq
XPVN5 CDLP5 VN GPN5 NGPN5 VDD33 VSS gf180_tg_lowq
XNDGNP5 PH2 S2N5 NGNP5 VDD33 VSS gf180_sdm3_nand2
XIGNP5 NGNP5 GNP5 VDD33 VSS gf180_sdm3_inv
XNDGNN5 PH2 S2P5 NGNN5 VDD33 VSS gf180_sdm3_nand2
XIGNN5 NGNN5 GNN5 VDD33 VSS gf180_sdm3_inv
XNVP5 CDLN5 VP GNP5 NGNP5 VDD33 VSS gf180_tg_lowq
XNVN5 CDLN5 VN GNN5 NGNN5 VDD33 VSS gf180_tg_lowq
* DAC unit 6
CDP6 CDLP6 CDRP6 {CU}
CDN6 CDLN6 CDRN6 {CU}
XDP16 CDRP6 VCM_REF PH1 NPH1 VDD33 VSS gf180_tg_lowq
XDP26 CDRP6 INP PH2 NPH2 VDD33 VSS gf180_tg_lowq
XDN16 CDRN6 VCM_REF PH1 NPH1 VDD33 VSS gf180_tg_lowq
XDN26 CDRN6 INN PH2 NPH2 VDD33 VSS gf180_tg_lowq
XDPC6 CDLP6 VCM_REF PH1 NPH1 VDD33 VSS gf180_tg_lowq
XDNC6 CDLN6 VCM_REF PH1 NPH1 VDD33 VSS gf180_tg_lowq
XNDGPP6 PH2 S2P6 NGPP6 VDD33 VSS gf180_sdm3_nand2
XIGPP6 NGPP6 GPP6 VDD33 VSS gf180_sdm3_inv
XNDGPN6 PH2 S2N6 NGPN6 VDD33 VSS gf180_sdm3_nand2
XIGPN6 NGPN6 GPN6 VDD33 VSS gf180_sdm3_inv
XPVP6 CDLP6 VP GPP6 NGPP6 VDD33 VSS gf180_tg_lowq
XPVN6 CDLP6 VN GPN6 NGPN6 VDD33 VSS gf180_tg_lowq
XNDGNP6 PH2 S2N6 NGNP6 VDD33 VSS gf180_sdm3_nand2
XIGNP6 NGNP6 GNP6 VDD33 VSS gf180_sdm3_inv
XNDGNN6 PH2 S2P6 NGNN6 VDD33 VSS gf180_sdm3_nand2
XIGNN6 NGNN6 GNN6 VDD33 VSS gf180_sdm3_inv
XNVP6 CDLN6 VP GNP6 NGNP6 VDD33 VSS gf180_tg_lowq
XNVN6 CDLN6 VN GNN6 NGNN6 VDD33 VSS gf180_tg_lowq
* DAC unit 7
CDP7 CDLP7 CDRP7 {CU}
CDN7 CDLN7 CDRN7 {CU}
XDP17 CDRP7 VCM_REF PH1 NPH1 VDD33 VSS gf180_tg_lowq
XDP27 CDRP7 INP PH2 NPH2 VDD33 VSS gf180_tg_lowq
XDN17 CDRN7 VCM_REF PH1 NPH1 VDD33 VSS gf180_tg_lowq
XDN27 CDRN7 INN PH2 NPH2 VDD33 VSS gf180_tg_lowq
XDPC7 CDLP7 VCM_REF PH1 NPH1 VDD33 VSS gf180_tg_lowq
XDNC7 CDLN7 VCM_REF PH1 NPH1 VDD33 VSS gf180_tg_lowq
XNDGPP7 PH2 S2P7 NGPP7 VDD33 VSS gf180_sdm3_nand2
XIGPP7 NGPP7 GPP7 VDD33 VSS gf180_sdm3_inv
XNDGPN7 PH2 S2N7 NGPN7 VDD33 VSS gf180_sdm3_nand2
XIGPN7 NGPN7 GPN7 VDD33 VSS gf180_sdm3_inv
XPVP7 CDLP7 VP GPP7 NGPP7 VDD33 VSS gf180_tg_lowq
XPVN7 CDLP7 VN GPN7 NGPN7 VDD33 VSS gf180_tg_lowq
XNDGNP7 PH2 S2N7 NGNP7 VDD33 VSS gf180_sdm3_nand2
XIGNP7 NGNP7 GNP7 VDD33 VSS gf180_sdm3_inv
XNDGNN7 PH2 S2P7 NGNN7 VDD33 VSS gf180_sdm3_nand2
XIGNN7 NGNN7 GNN7 VDD33 VSS gf180_sdm3_inv
XNVP7 CDLN7 VP GNP7 NGNP7 VDD33 VSS gf180_tg_lowq
XNVN7 CDLN7 VN GNN7 NGNN7 VDD33 VSS gf180_tg_lowq
* DAC unit 8
CDP8 CDLP8 CDRP8 {CU}
CDN8 CDLN8 CDRN8 {CU}
XDP18 CDRP8 VCM_REF PH1 NPH1 VDD33 VSS gf180_tg_lowq
XDP28 CDRP8 INP PH2 NPH2 VDD33 VSS gf180_tg_lowq
XDN18 CDRN8 VCM_REF PH1 NPH1 VDD33 VSS gf180_tg_lowq
XDN28 CDRN8 INN PH2 NPH2 VDD33 VSS gf180_tg_lowq
XDPC8 CDLP8 VCM_REF PH1 NPH1 VDD33 VSS gf180_tg_lowq
XDNC8 CDLN8 VCM_REF PH1 NPH1 VDD33 VSS gf180_tg_lowq
XNDGPP8 PH2 S2P8 NGPP8 VDD33 VSS gf180_sdm3_nand2
XIGPP8 NGPP8 GPP8 VDD33 VSS gf180_sdm3_inv
XNDGPN8 PH2 S2N8 NGPN8 VDD33 VSS gf180_sdm3_nand2
XIGPN8 NGPN8 GPN8 VDD33 VSS gf180_sdm3_inv
XPVP8 CDLP8 VP GPP8 NGPP8 VDD33 VSS gf180_tg_lowq
XPVN8 CDLP8 VN GPN8 NGPN8 VDD33 VSS gf180_tg_lowq
XNDGNP8 PH2 S2N8 NGNP8 VDD33 VSS gf180_sdm3_nand2
XIGNP8 NGNP8 GNP8 VDD33 VSS gf180_sdm3_inv
XNDGNN8 PH2 S2P8 NGNN8 VDD33 VSS gf180_sdm3_nand2
XIGNN8 NGNN8 GNN8 VDD33 VSS gf180_sdm3_inv
XNVP8 CDLN8 VP GNP8 NGNP8 VDD33 VSS gf180_tg_lowq
XNVN8 CDLN8 VN GNN8 NGNN8 VDD33 VSS gf180_tg_lowq
* DAC unit 9
CDP9 CDLP9 CDRP9 {CU}
CDN9 CDLN9 CDRN9 {CU}
XDP19 CDRP9 VCM_REF PH1 NPH1 VDD33 VSS gf180_tg_lowq
XDP29 CDRP9 INP PH2 NPH2 VDD33 VSS gf180_tg_lowq
XDN19 CDRN9 VCM_REF PH1 NPH1 VDD33 VSS gf180_tg_lowq
XDN29 CDRN9 INN PH2 NPH2 VDD33 VSS gf180_tg_lowq
XDPC9 CDLP9 VCM_REF PH1 NPH1 VDD33 VSS gf180_tg_lowq
XDNC9 CDLN9 VCM_REF PH1 NPH1 VDD33 VSS gf180_tg_lowq
XNDGPP9 PH2 S2P9 NGPP9 VDD33 VSS gf180_sdm3_nand2
XIGPP9 NGPP9 GPP9 VDD33 VSS gf180_sdm3_inv
XNDGPN9 PH2 S2N9 NGPN9 VDD33 VSS gf180_sdm3_nand2
XIGPN9 NGPN9 GPN9 VDD33 VSS gf180_sdm3_inv
XPVP9 CDLP9 VP GPP9 NGPP9 VDD33 VSS gf180_tg_lowq
XPVN9 CDLP9 VN GPN9 NGPN9 VDD33 VSS gf180_tg_lowq
XNDGNP9 PH2 S2N9 NGNP9 VDD33 VSS gf180_sdm3_nand2
XIGNP9 NGNP9 GNP9 VDD33 VSS gf180_sdm3_inv
XNDGNN9 PH2 S2P9 NGNN9 VDD33 VSS gf180_sdm3_nand2
XIGNN9 NGNN9 GNN9 VDD33 VSS gf180_sdm3_inv
XNVP9 CDLN9 VP GNP9 NGNP9 VDD33 VSS gf180_tg_lowq
XNVN9 CDLN9 VN GNN9 NGNN9 VDD33 VSS gf180_tg_lowq
* DAC unit 10
CDP10 CDLP10 CDRP10 {CU}
CDN10 CDLN10 CDRN10 {CU}
XDP110 CDRP10 VCM_REF PH1 NPH1 VDD33 VSS gf180_tg_lowq
XDP210 CDRP10 INP PH2 NPH2 VDD33 VSS gf180_tg_lowq
XDN110 CDRN10 VCM_REF PH1 NPH1 VDD33 VSS gf180_tg_lowq
XDN210 CDRN10 INN PH2 NPH2 VDD33 VSS gf180_tg_lowq
XDPC10 CDLP10 VCM_REF PH1 NPH1 VDD33 VSS gf180_tg_lowq
XDNC10 CDLN10 VCM_REF PH1 NPH1 VDD33 VSS gf180_tg_lowq
XNDGPP10 PH2 S2P10 NGPP10 VDD33 VSS gf180_sdm3_nand2
XIGPP10 NGPP10 GPP10 VDD33 VSS gf180_sdm3_inv
XNDGPN10 PH2 S2N10 NGPN10 VDD33 VSS gf180_sdm3_nand2
XIGPN10 NGPN10 GPN10 VDD33 VSS gf180_sdm3_inv
XPVP10 CDLP10 VP GPP10 NGPP10 VDD33 VSS gf180_tg_lowq
XPVN10 CDLP10 VN GPN10 NGPN10 VDD33 VSS gf180_tg_lowq
XNDGNP10 PH2 S2N10 NGNP10 VDD33 VSS gf180_sdm3_nand2
XIGNP10 NGNP10 GNP10 VDD33 VSS gf180_sdm3_inv
XNDGNN10 PH2 S2P10 NGNN10 VDD33 VSS gf180_sdm3_nand2
XIGNN10 NGNN10 GNN10 VDD33 VSS gf180_sdm3_inv
XNVP10 CDLN10 VP GNP10 NGNP10 VDD33 VSS gf180_tg_lowq
XNVN10 CDLN10 VN GNN10 NGNN10 VDD33 VSS gf180_tg_lowq
* DAC unit 11
CDP11 CDLP11 CDRP11 {CU}
CDN11 CDLN11 CDRN11 {CU}
XDP111 CDRP11 VCM_REF PH1 NPH1 VDD33 VSS gf180_tg_lowq
XDP211 CDRP11 INP PH2 NPH2 VDD33 VSS gf180_tg_lowq
XDN111 CDRN11 VCM_REF PH1 NPH1 VDD33 VSS gf180_tg_lowq
XDN211 CDRN11 INN PH2 NPH2 VDD33 VSS gf180_tg_lowq
XDPC11 CDLP11 VCM_REF PH1 NPH1 VDD33 VSS gf180_tg_lowq
XDNC11 CDLN11 VCM_REF PH1 NPH1 VDD33 VSS gf180_tg_lowq
XNDGPP11 PH2 S2P11 NGPP11 VDD33 VSS gf180_sdm3_nand2
XIGPP11 NGPP11 GPP11 VDD33 VSS gf180_sdm3_inv
XNDGPN11 PH2 S2N11 NGPN11 VDD33 VSS gf180_sdm3_nand2
XIGPN11 NGPN11 GPN11 VDD33 VSS gf180_sdm3_inv
XPVP11 CDLP11 VP GPP11 NGPP11 VDD33 VSS gf180_tg_lowq
XPVN11 CDLP11 VN GPN11 NGPN11 VDD33 VSS gf180_tg_lowq
XNDGNP11 PH2 S2N11 NGNP11 VDD33 VSS gf180_sdm3_nand2
XIGNP11 NGNP11 GNP11 VDD33 VSS gf180_sdm3_inv
XNDGNN11 PH2 S2P11 NGNN11 VDD33 VSS gf180_sdm3_nand2
XIGNN11 NGNN11 GNN11 VDD33 VSS gf180_sdm3_inv
XNVP11 CDLN11 VP GNP11 NGNP11 VDD33 VSS gf180_tg_lowq
XNVN11 CDLN11 VN GNN11 NGNN11 VDD33 VSS gf180_tg_lowq
* DAC unit 12
CDP12 CDLP12 CDRP12 {CU}
CDN12 CDLN12 CDRN12 {CU}
XDP112 CDRP12 VCM_REF PH1 NPH1 VDD33 VSS gf180_tg_lowq
XDP212 CDRP12 INP PH2 NPH2 VDD33 VSS gf180_tg_lowq
XDN112 CDRN12 VCM_REF PH1 NPH1 VDD33 VSS gf180_tg_lowq
XDN212 CDRN12 INN PH2 NPH2 VDD33 VSS gf180_tg_lowq
XDPC12 CDLP12 VCM_REF PH1 NPH1 VDD33 VSS gf180_tg_lowq
XDNC12 CDLN12 VCM_REF PH1 NPH1 VDD33 VSS gf180_tg_lowq
XNDGPP12 PH2 S2P12 NGPP12 VDD33 VSS gf180_sdm3_nand2
XIGPP12 NGPP12 GPP12 VDD33 VSS gf180_sdm3_inv
XNDGPN12 PH2 S2N12 NGPN12 VDD33 VSS gf180_sdm3_nand2
XIGPN12 NGPN12 GPN12 VDD33 VSS gf180_sdm3_inv
XPVP12 CDLP12 VP GPP12 NGPP12 VDD33 VSS gf180_tg_lowq
XPVN12 CDLP12 VN GPN12 NGPN12 VDD33 VSS gf180_tg_lowq
XNDGNP12 PH2 S2N12 NGNP12 VDD33 VSS gf180_sdm3_nand2
XIGNP12 NGNP12 GNP12 VDD33 VSS gf180_sdm3_inv
XNDGNN12 PH2 S2P12 NGNN12 VDD33 VSS gf180_sdm3_nand2
XIGNN12 NGNN12 GNN12 VDD33 VSS gf180_sdm3_inv
XNVP12 CDLN12 VP GNP12 NGNP12 VDD33 VSS gf180_tg_lowq
XNVN12 CDLN12 VN GNN12 NGNN12 VDD33 VSS gf180_tg_lowq
* DAC unit 13
CDP13 CDLP13 CDRP13 {CU}
CDN13 CDLN13 CDRN13 {CU}
XDP113 CDRP13 VCM_REF PH1 NPH1 VDD33 VSS gf180_tg_lowq
XDP213 CDRP13 INP PH2 NPH2 VDD33 VSS gf180_tg_lowq
XDN113 CDRN13 VCM_REF PH1 NPH1 VDD33 VSS gf180_tg_lowq
XDN213 CDRN13 INN PH2 NPH2 VDD33 VSS gf180_tg_lowq
XDPC13 CDLP13 VCM_REF PH1 NPH1 VDD33 VSS gf180_tg_lowq
XDNC13 CDLN13 VCM_REF PH1 NPH1 VDD33 VSS gf180_tg_lowq
XNDGPP13 PH2 S2P13 NGPP13 VDD33 VSS gf180_sdm3_nand2
XIGPP13 NGPP13 GPP13 VDD33 VSS gf180_sdm3_inv
XNDGPN13 PH2 S2N13 NGPN13 VDD33 VSS gf180_sdm3_nand2
XIGPN13 NGPN13 GPN13 VDD33 VSS gf180_sdm3_inv
XPVP13 CDLP13 VP GPP13 NGPP13 VDD33 VSS gf180_tg_lowq
XPVN13 CDLP13 VN GPN13 NGPN13 VDD33 VSS gf180_tg_lowq
XNDGNP13 PH2 S2N13 NGNP13 VDD33 VSS gf180_sdm3_nand2
XIGNP13 NGNP13 GNP13 VDD33 VSS gf180_sdm3_inv
XNDGNN13 PH2 S2P13 NGNN13 VDD33 VSS gf180_sdm3_nand2
XIGNN13 NGNN13 GNN13 VDD33 VSS gf180_sdm3_inv
XNVP13 CDLN13 VP GNP13 NGNP13 VDD33 VSS gf180_tg_lowq
XNVN13 CDLN13 VN GNN13 NGNN13 VDD33 VSS gf180_tg_lowq
* DAC unit 14
CDP14 CDLP14 CDRP14 {CU}
CDN14 CDLN14 CDRN14 {CU}
XDP114 CDRP14 VCM_REF PH1 NPH1 VDD33 VSS gf180_tg_lowq
XDP214 CDRP14 INP PH2 NPH2 VDD33 VSS gf180_tg_lowq
XDN114 CDRN14 VCM_REF PH1 NPH1 VDD33 VSS gf180_tg_lowq
XDN214 CDRN14 INN PH2 NPH2 VDD33 VSS gf180_tg_lowq
XDPC14 CDLP14 VCM_REF PH1 NPH1 VDD33 VSS gf180_tg_lowq
XDNC14 CDLN14 VCM_REF PH1 NPH1 VDD33 VSS gf180_tg_lowq
XNDGPP14 PH2 S2P14 NGPP14 VDD33 VSS gf180_sdm3_nand2
XIGPP14 NGPP14 GPP14 VDD33 VSS gf180_sdm3_inv
XNDGPN14 PH2 S2N14 NGPN14 VDD33 VSS gf180_sdm3_nand2
XIGPN14 NGPN14 GPN14 VDD33 VSS gf180_sdm3_inv
XPVP14 CDLP14 VP GPP14 NGPP14 VDD33 VSS gf180_tg_lowq
XPVN14 CDLP14 VN GPN14 NGPN14 VDD33 VSS gf180_tg_lowq
XNDGNP14 PH2 S2N14 NGNP14 VDD33 VSS gf180_sdm3_nand2
XIGNP14 NGNP14 GNP14 VDD33 VSS gf180_sdm3_inv
XNDGNN14 PH2 S2P14 NGNN14 VDD33 VSS gf180_sdm3_nand2
XIGNN14 NGNN14 GNN14 VDD33 VSS gf180_sdm3_inv
XNVP14 CDLN14 VP GNP14 NGNP14 VDD33 VSS gf180_tg_lowq
XNVN14 CDLN14 VN GNN14 NGNN14 VDD33 VSS gf180_tg_lowq
CIP OUTN INP {CI}
CIN OUTP INN {CI}
RBIASP INP VCM_REF 10G
RBIASN INN VCM_REF 10G
.ends gf180_sdm3_int2_mb

.subckt gf180_sdm3_mod_mb VINP VINN VCM_REF VP VN PH1 NPH1 PH2 NPH2 CMPCK PUP VDD33 VSS TH0 TH1 TH2 TH3 TH4 TH5 TH6 TH7 TH8 TH9 TH10 TH11 TH12 TH13 TH14 params: RSET=25k CC=10p
XINT1 VINN VINP VCM_REF VP VN O1P O1N PH1 NPH1 PH2 NPH2 VDD33 VSS THN14 THN13 THN12 THN11 THN10 THN9 THN8 THN7 THN6 THN5 THN4 THN3 THN2 THN1 THN0 TH14 TH13 TH12 TH11 TH10 TH9 TH8 TH7 TH6 TH5 TH4 TH3 TH2 TH1 TH0 gf180_sdm3_int1_mb RSET={RSET} CC={CC}
XINT2 O1N O1P VCM_REF VP VN O2P O2N PH2 NPH2 PH1 NPH1 VDD33 VSS H2N14 H2N13 H2N12 H2N11 H2N10 H2N9 H2N8 H2N7 H2N6 H2N5 H2N4 H2N3 H2N2 H2N1 H2N0 H214 H213 H212 H211 H210 H29 H28 H27 H26 H25 H24 H23 H22 H21 H20 gf180_sdm3_int2_mb RSET={RSET} CC={CC}
XFLASH O2P O2N CMPCK VDD33 VSS TH0 TH1 TH2 TH3 TH4 TH5 TH6 TH7 TH8 TH9 TH10 TH11 TH12 TH13 TH14 gf180_sdm3_flash15
XITHN0 TH0 THN0 VDD33 VSS gf180_sdm3_inv
XITHN1 TH1 THN1 VDD33 VSS gf180_sdm3_inv
XITHN2 TH2 THN2 VDD33 VSS gf180_sdm3_inv
XITHN3 TH3 THN3 VDD33 VSS gf180_sdm3_inv
XITHN4 TH4 THN4 VDD33 VSS gf180_sdm3_inv
XITHN5 TH5 THN5 VDD33 VSS gf180_sdm3_inv
XITHN6 TH6 THN6 VDD33 VSS gf180_sdm3_inv
XITHN7 TH7 THN7 VDD33 VSS gf180_sdm3_inv
XITHN8 TH8 THN8 VDD33 VSS gf180_sdm3_inv
XITHN9 TH9 THN9 VDD33 VSS gf180_sdm3_inv
XITHN10 TH10 THN10 VDD33 VSS gf180_sdm3_inv
XITHN11 TH11 THN11 VDD33 VSS gf180_sdm3_inv
XITHN12 TH12 THN12 VDD33 VSS gf180_sdm3_inv
XITHN13 TH13 THN13 VDD33 VSS gf180_sdm3_inv
XITHN14 TH14 THN14 VDD33 VSS gf180_sdm3_inv
XH2D0 TH0 H20 PH2 NPH2 VDD33 VSS gf180_sdm3_dff
XH2D1 TH1 H21 PH2 NPH2 VDD33 VSS gf180_sdm3_dff
XH2D2 TH2 H22 PH2 NPH2 VDD33 VSS gf180_sdm3_dff
XH2D3 TH3 H23 PH2 NPH2 VDD33 VSS gf180_sdm3_dff
XH2D4 TH4 H24 PH2 NPH2 VDD33 VSS gf180_sdm3_dff
XH2D5 TH5 H25 PH2 NPH2 VDD33 VSS gf180_sdm3_dff
XH2D6 TH6 H26 PH2 NPH2 VDD33 VSS gf180_sdm3_dff
XH2D7 TH7 H27 PH2 NPH2 VDD33 VSS gf180_sdm3_dff
XH2D8 TH8 H28 PH2 NPH2 VDD33 VSS gf180_sdm3_dff
XH2D9 TH9 H29 PH2 NPH2 VDD33 VSS gf180_sdm3_dff
XH2D10 TH10 H210 PH2 NPH2 VDD33 VSS gf180_sdm3_dff
XH2D11 TH11 H211 PH2 NPH2 VDD33 VSS gf180_sdm3_dff
XH2D12 TH12 H212 PH2 NPH2 VDD33 VSS gf180_sdm3_dff
XH2D13 TH13 H213 PH2 NPH2 VDD33 VSS gf180_sdm3_dff
XH2D14 TH14 H214 PH2 NPH2 VDD33 VSS gf180_sdm3_dff
XIH2N0 H20 H2N0 VDD33 VSS gf180_sdm3_inv
XIH2N1 H21 H2N1 VDD33 VSS gf180_sdm3_inv
XIH2N2 H22 H2N2 VDD33 VSS gf180_sdm3_inv
XIH2N3 H23 H2N3 VDD33 VSS gf180_sdm3_inv
XIH2N4 H24 H2N4 VDD33 VSS gf180_sdm3_inv
XIH2N5 H25 H2N5 VDD33 VSS gf180_sdm3_inv
XIH2N6 H26 H2N6 VDD33 VSS gf180_sdm3_inv
XIH2N7 H27 H2N7 VDD33 VSS gf180_sdm3_inv
XIH2N8 H28 H2N8 VDD33 VSS gf180_sdm3_inv
XIH2N9 H29 H2N9 VDD33 VSS gf180_sdm3_inv
XIH2N10 H210 H2N10 VDD33 VSS gf180_sdm3_inv
XIH2N11 H211 H2N11 VDD33 VSS gf180_sdm3_inv
XIH2N12 H212 H2N12 VDD33 VSS gf180_sdm3_inv
XIH2N13 H213 H2N13 VDD33 VSS gf180_sdm3_inv
XIH2N14 H214 H2N14 VDD33 VSS gf180_sdm3_inv
.ends gf180_sdm3_mod_mb
