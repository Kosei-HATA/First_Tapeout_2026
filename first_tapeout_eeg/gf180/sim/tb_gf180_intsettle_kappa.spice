* GF180 sdm3 int1 state-dependent gain (kappa) measurement bench.
* DC input + BIT fixed -> constant charge packet per cycle; the integrator
* output ramps linearly, and the per-cycle increment's dependence on the
* output amplitude gives kappa directly: inc(x) = inc0*(1 + kappa*x),
* kappa_phys = slope/inc0 [1/V], kappa_model = kappa_phys * 50mV.
* @TOKENS@ are filled by fit runner (all timing literals precomputed).
.include /Users/noah/.ciel/ciel/gf180mcu/versions/f6eeac7dad085ffcc829ccfd721f7b4ce39edcf7/gf180mcuD/libs.tech/ngspice/design.ngspice
.lib /Users/noah/.ciel/ciel/gf180mcu/versions/f6eeac7dad085ffcc829ccfd721f7b4ce39edcf7/gf180mcuD/libs.tech/ngspice/sm141064.ngspice typical
.temp 27
.include gf180_afe_cells.spice
.include gf180_sdm3.spice
.param VDD=3.3 VCM=1.65
VDD_SRC VDD33 0 {VDD}
VREF VCM_REF 0 {VCM}
VVP VP 0 {VCM+25m}
VVN VN 0 {VCM-25m}
VPH1 PH1 0 PULSE(0 {VDD} @PH1D@ 15n 15n @PHW@ @TCLK@)
VPH2 PH2 0 PULSE(0 {VDD} @PH2D@ 15n 15n @PHW@ @TCLK@)
BNPH1 NPH1 0 V={VDD}-v(PH1)
BNPH2 NPH2 0 V={VDD}-v(PH2)
* ramp down (@RAMP@=-1): BIT=0 (DAC negative), input +10 mV diff
* ramp up   (@RAMP@=+1): BIT=VDD (DAC positive), input -10 mV diff
VINP VINP 0 @VINPV@
VINN VINN 0 @VINNV@
VBIT BIT 0 @VBITV@
XINT1 VINN VINP VCM_REF BIT VP VN O1P O1N PH1 NPH1 PH2 NPH2 VDD33 0 gf180_sdm3_int1 W91=11u W92=6u RSET=@RSETP@ CC=@CCP@
.nodeset v(O1P)=1.65 v(O1N)=1.65 v(XINT1.INP)=1.65 v(XINT1.INN)=1.65
.control
set noaskquit
save time v(O1P) v(O1N) i(VDD_SRC)
tran 5n @TTOT@
wrdata ../results/sdm3_kappa.csv time v(O1P) v(O1N)
let idd=-i(VDD_SRC)
meas tran idd_avg avg idd from=@TMEAS0@ to=@TTOT@
quit
.endc
.end
