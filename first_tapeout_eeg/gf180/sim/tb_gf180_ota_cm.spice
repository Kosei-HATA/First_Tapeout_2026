* GF180 sdm3 int1 SC settle, parameterized CMFB diode sizes (W91/W92 sweep).
* Same stimulus as tb_gf180_sdm3_intsettle.spice; measures plateau output CM
* and stage-1 internal CM over the last cycle.
.include /Users/noah/.ciel/ciel/gf180mcu/versions/f6eeac7dad085ffcc829ccfd721f7b4ce39edcf7/gf180mcuD/libs.tech/ngspice/design.ngspice
.lib /Users/noah/.ciel/ciel/gf180mcu/versions/f6eeac7dad085ffcc829ccfd721f7b4ce39edcf7/gf180mcuD/libs.tech/ngspice/sm141064.ngspice typical
.temp 27
.include gf180_afe_cells.spice
.include gf180_sdm3.spice
.param VDD=3.3 VCM=1.65 TCLK=3.90625u W91P=4u W92P=0.5u
VDD_SRC VDD33 0 {VDD}
VREF VCM_REF 0 {VCM}
VVP VP 0 {VCM+25m}
VVN VN 0 {VCM-25m}
VPH1 PH1 0 PULSE(0 {VDD} 0.1u 30n 30n 1.62u {TCLK})
VPH2 PH2 0 PULSE(0 {VDD} 2.053u 30n 30n 1.62u {TCLK})
BNPH1 NPH1 0 V={VDD}-v(PH1)
BNPH2 NPH2 0 V={VDD}-v(PH2)
VINP VINP 0 {VCM+5m}
VINN VINN 0 {VCM-5m}
VBIT BIT 0 0
XINT1 VINN VINP VCM_REF BIT VP VN O1P O1N PH1 NPH1 PH2 NPH2 VDD33 0 gf180_sdm3_int1 W91={W91P} W92={W92P}
.nodeset v(O1P)=1.65 v(O1N)=1.65 v(XINT1.INP)=1.65 v(XINT1.INN)=1.65
.control
set noaskquit
save time v(O1P) v(O1N) v(XINT1.XOTA.N1P) v(XINT1.XOTA.N1N)
tran 5n 31.25u
let cm_out = (v(O1P)+v(O1N))/2
let cm_s1  = (v(XINT1.XOTA.N1P)+v(XINT1.XOTA.N1N))/2
meas tran cm_o avg cm_out from=29u to=31.25u
meas tran cm_1 avg cm_s1 from=29u to=31.25u
meas tran o1p_v avg v(O1P) from=29u to=31.25u
meas tran o1n_v avg v(O1N) from=29u to=31.25u
quit
.endc
.end
