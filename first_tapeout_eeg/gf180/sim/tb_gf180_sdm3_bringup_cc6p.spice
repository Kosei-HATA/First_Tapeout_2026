* GF180 sdm3 bring-up (step B): 6 ms, 32 Hz 0.6 FS input, fs=256 kHz.
* Checks: loop lock, duty tracking, integrator swings. Mirrors sky130
* tb_sdm3_256k.spice clocking exactly; save-limited.
.include /Users/noah/.ciel/ciel/gf180mcu/versions/f6eeac7dad085ffcc829ccfd721f7b4ce39edcf7/gf180mcuD/libs.tech/ngspice/design.ngspice
.lib /Users/noah/.ciel/ciel/gf180mcu/versions/f6eeac7dad085ffcc829ccfd721f7b4ce39edcf7/gf180mcuD/libs.tech/ngspice/sm141064.ngspice typical
.temp 27
.include gf180_afe_cells.spice
.include gf180_sdm3.spice
.param VDD=3.3 VCM=1.65 TCLK=3.90625u
VDD_SRC VDD33 0 {VDD}
VREF VCM_REF 0 {VCM}
VVP VP 0 {VCM+25m}
VVN VN 0 {VCM-25m}
VPH1 PH1 0 PULSE(0 {VDD} 0.1u 30n 30n 1.62u {TCLK})
VPH2 PH2 0 PULSE(0 {VDD} 2.053u 30n 30n 1.62u {TCLK})
VCMPCK CMPCK 0 PULSE(0 {VDD} 1.30u 20n 20n 0.36u {TCLK})
BNPH1 NPH1 0 V={VDD}-v(PH1)
BNPH2 NPH2 0 V={VDD}-v(PH2)
VINP VINP 0 SIN({VCM} 15m 32)
VINN VINN 0 SIN({VCM} 15m 32 0 0 180)
XSDM VINP VINN VCM_REF VP VN BIT NBIT O1P O1N O2P O2N PH1 NPH1 PH2 NPH2 CMPCK VDD33 0 gf180_sdm3_mod CC=6p
.nodeset v(BIT)=3.3 v(NBIT)=0 v(O1P)=1.65 v(O1N)=1.65 v(O2P)=1.65 v(O2N)=1.65
.nodeset v(XSDM.XINT1.INP)=1.65 v(XSDM.XINT1.INN)=1.65 v(XSDM.XINT2.INP)=1.65 v(XSDM.XINT2.INN)=1.65
.control
set noaskquit
save time v(BIT) v(O1P) v(O1N) v(O2P) v(O2N) i(VDD_SRC)
tran 50n 6m
wrdata ../results/sdm3_bringup_cc6p.csv time v(BIT) v(O1P) v(O1N) v(O2P) v(O2N)
let idd=-i(VDD_SRC)
meas tran idd_avg avg idd from=5m to=6m
quit
.endc
.end
