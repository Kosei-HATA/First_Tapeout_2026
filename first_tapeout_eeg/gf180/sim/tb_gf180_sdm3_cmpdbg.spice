* GF180 sdm3 in-loop comparator diagnostic (CMFB fix, CC=10p):
* 300 cycles at DC input (vin=+6 mV, mid limit-cycle regime), saving the
* comparator input O2D, latch nodes QP/QN, CMPCK and BIT.
* Checks: does the decision match sign(settled x2)? How settled is x2 at
* the CMPCK edge? Any metastable (both-mid) latch events?
.include /Users/noah/.ciel/ciel/gf180mcu/versions/f6eeac7dad085ffcc829ccfd721f7b4ce39edcf7/gf180mcuD/libs.tech/ngspice/design.ngspice
.lib /Users/noah/.ciel/ciel/gf180mcu/versions/f6eeac7dad085ffcc829ccfd721f7b4ce39edcf7/gf180mcuD/libs.tech/ngspice/sm141064.ngspice typical
.temp 27
.include gf180_afe_cells.spice
.include gf180_sdm3.spice
.param VDD=3.3 VCM=1.65 TCLK=3.90625u
VDD_SRC VDD33 0 {VDD}
VREF VCM_REF 0 {VCM}
VVP VP 0 {VCM+25m}
VVN VN 0 {VCM-25m}
VPH1 PH1 0 PULSE(0 {VDD} 0.1u 30n 30n 1.62u {TCLK})
VPH2 PH2 0 PULSE(0 {VDD} 2.053u 30n 30n 1.62u {TCLK})
VCMPCK CMPCK 0 PULSE(0 {VDD} 1.30u 20n 20n 0.36u {TCLK})
BNPH1 NPH1 0 V={VDD}-v(PH1)
BNPH2 NPH2 0 V={VDD}-v(PH2)
VINP VINP 0 {VCM+3m}
VINN VINN 0 {VCM-3m}
XSDM VINP VINN VCM_REF VP VN BIT NBIT O1P O1N O2P O2N PH1 NPH1 PH2 NPH2 CMPCK VDD33 0 gf180_sdm3_mod
.nodeset v(BIT)=3.3 v(NBIT)=0 v(O1P)=1.65 v(O1N)=1.65 v(O2P)=1.65 v(O2N)=1.65
.nodeset v(XSDM.XINT1.INP)=1.65 v(XSDM.XINT1.INN)=1.65 v(XSDM.XINT2.INP)=1.65 v(XSDM.XINT2.INN)=1.65
.control
set noaskquit
save time v(BIT) v(O2P) v(O2N) v(XSDM.QP) v(XSDM.QN) v(CMPCK)
tran 10n 1.25m
wrdata ../results/sdm3_cmpdbg.csv time v(BIT) v(O2P) v(O2N) v(XSDM.QP) v(XSDM.QN) v(CMPCK)
quit
.endc
.end
