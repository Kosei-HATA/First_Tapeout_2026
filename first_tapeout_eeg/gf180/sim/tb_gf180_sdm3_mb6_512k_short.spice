* GF180 sdm3_mb (6-bit, 63-level flash (nodwa)) bring-up at fs=512 kHz.
* short SNDR run (35m screen), all 63 thermometer lines saved.
* GENERATED from tb_gf180_sdm3_mb5_512k_short.spice - do not edit by hand.
.include /Users/noah/.ciel/ciel/gf180mcu/versions/f6eeac7dad085ffcc829ccfd721f7b4ce39edcf7/gf180mcuD/libs.tech/ngspice/design.ngspice
.lib /Users/noah/.ciel/ciel/gf180mcu/versions/f6eeac7dad085ffcc829ccfd721f7b4ce39edcf7/gf180mcuD/libs.tech/ngspice/sm141064.ngspice typical
.temp 27
.include gf180_afe_cells.spice
.include gf180_sdm3.spice
.include gf180_sdm3_mb6_nodwa.spice
.param VDD=3.3 VCM=1.65 TCLK=1.953125u
VDD_SRC VDD33 0 {VDD}
VREF VCM_REF 0 {VCM}
VVP VP 0 {VCM+25m}
VVN VN 0 {VCM-25m}
VPH1 PH1 0 PULSE(0 {VDD} 0.661u 15n 15n 0.81u {TCLK})
VPH2 PH2 0 PULSE(0 {VDD} 1.6375u 15n 15n 0.81u {TCLK})
VCMPCK CMPCK 0 PULSE(0 {VDD} 1.261u 10n 10n 0.18u {TCLK})
VPUP PUP 0 PULSE(0 {VDD} 0.671u 5n 5n 0.05u {TCLK})
BNPH1 NPH1 0 V={VDD}-v(PH1)
BNPH2 NPH2 0 V={VDD}-v(PH2)
VINP VINP 0 SIN({VCM} 15m 32)
VINN VINN 0 SIN({VCM} 15m 32 0 0 180)
XSDM VINP VINN VCM_REF VP VN PH1 NPH1 PH2 NPH2 CMPCK PUP VDD33 0
+ TH0 TH1 TH2 TH3 TH4 TH5 TH6 TH7 TH8 TH9 TH10 TH11 TH12 TH13 TH14 TH15 TH16 TH17 TH18 TH19 TH20 TH21 TH22 TH23 TH24 TH25 TH26 TH27 TH28 TH29 TH30 TH31 TH32 TH33 TH34 TH35 TH36 TH37 TH38 TH39 TH40 TH41 TH42 TH43 TH44 TH45 TH46 TH47 TH48 TH49 TH50 TH51 TH52 TH53 TH54 TH55 TH56 TH57 TH58 TH59 TH60 TH61 TH62
+ gf180_sdm3_mod_mb RSET=25k CC=10p
.nodeset v(XSDM.O1P)=1.65 v(XSDM.O1N)=1.65 v(XSDM.O2P)=1.65 v(XSDM.O2N)=1.65
.nodeset v(XSDM.XINT1.INP)=1.65 v(XSDM.XINT1.INN)=1.65 v(XSDM.XINT2.INP)=1.65 v(XSDM.XINT2.INN)=1.65
* flash latch initial state: mid-code (H0..H30=3.3, H31..H62=0 -> c=31 at t=0)
.nodeset v(XSDM.XFLASH.BIT0)=0 v(TH0)=3.3
.nodeset v(XSDM.XFLASH.BIT1)=0 v(TH1)=3.3
.nodeset v(XSDM.XFLASH.BIT2)=0 v(TH2)=3.3
.nodeset v(XSDM.XFLASH.BIT3)=0 v(TH3)=3.3
.nodeset v(XSDM.XFLASH.BIT4)=0 v(TH4)=3.3
.nodeset v(XSDM.XFLASH.BIT5)=0 v(TH5)=3.3
.nodeset v(XSDM.XFLASH.BIT6)=0 v(TH6)=3.3
.nodeset v(XSDM.XFLASH.BIT7)=0 v(TH7)=3.3
.nodeset v(XSDM.XFLASH.BIT8)=0 v(TH8)=3.3
.nodeset v(XSDM.XFLASH.BIT9)=0 v(TH9)=3.3
.nodeset v(XSDM.XFLASH.BIT10)=0 v(TH10)=3.3
.nodeset v(XSDM.XFLASH.BIT11)=0 v(TH11)=3.3
.nodeset v(XSDM.XFLASH.BIT12)=0 v(TH12)=3.3
.nodeset v(XSDM.XFLASH.BIT13)=0 v(TH13)=3.3
.nodeset v(XSDM.XFLASH.BIT14)=0 v(TH14)=3.3
.nodeset v(XSDM.XFLASH.BIT15)=0 v(TH15)=3.3
.nodeset v(XSDM.XFLASH.BIT16)=0 v(TH16)=3.3
.nodeset v(XSDM.XFLASH.BIT17)=0 v(TH17)=3.3
.nodeset v(XSDM.XFLASH.BIT18)=0 v(TH18)=3.3
.nodeset v(XSDM.XFLASH.BIT19)=0 v(TH19)=3.3
.nodeset v(XSDM.XFLASH.BIT20)=0 v(TH20)=3.3
.nodeset v(XSDM.XFLASH.BIT21)=0 v(TH21)=3.3
.nodeset v(XSDM.XFLASH.BIT22)=0 v(TH22)=3.3
.nodeset v(XSDM.XFLASH.BIT23)=0 v(TH23)=3.3
.nodeset v(XSDM.XFLASH.BIT24)=0 v(TH24)=3.3
.nodeset v(XSDM.XFLASH.BIT25)=0 v(TH25)=3.3
.nodeset v(XSDM.XFLASH.BIT26)=0 v(TH26)=3.3
.nodeset v(XSDM.XFLASH.BIT27)=0 v(TH27)=3.3
.nodeset v(XSDM.XFLASH.BIT28)=0 v(TH28)=3.3
.nodeset v(XSDM.XFLASH.BIT29)=0 v(TH29)=3.3
.nodeset v(XSDM.XFLASH.BIT30)=0 v(TH30)=3.3
.nodeset v(XSDM.XFLASH.BIT31)=3.3 v(TH31)=0
.nodeset v(XSDM.XFLASH.BIT32)=3.3 v(TH32)=0
.nodeset v(XSDM.XFLASH.BIT33)=3.3 v(TH33)=0
.nodeset v(XSDM.XFLASH.BIT34)=3.3 v(TH34)=0
.nodeset v(XSDM.XFLASH.BIT35)=3.3 v(TH35)=0
.nodeset v(XSDM.XFLASH.BIT36)=3.3 v(TH36)=0
.nodeset v(XSDM.XFLASH.BIT37)=3.3 v(TH37)=0
.nodeset v(XSDM.XFLASH.BIT38)=3.3 v(TH38)=0
.nodeset v(XSDM.XFLASH.BIT39)=3.3 v(TH39)=0
.nodeset v(XSDM.XFLASH.BIT40)=3.3 v(TH40)=0
.nodeset v(XSDM.XFLASH.BIT41)=3.3 v(TH41)=0
.nodeset v(XSDM.XFLASH.BIT42)=3.3 v(TH42)=0
.nodeset v(XSDM.XFLASH.BIT43)=3.3 v(TH43)=0
.nodeset v(XSDM.XFLASH.BIT44)=3.3 v(TH44)=0
.nodeset v(XSDM.XFLASH.BIT45)=3.3 v(TH45)=0
.nodeset v(XSDM.XFLASH.BIT46)=3.3 v(TH46)=0
.nodeset v(XSDM.XFLASH.BIT47)=3.3 v(TH47)=0
.nodeset v(XSDM.XFLASH.BIT48)=3.3 v(TH48)=0
.nodeset v(XSDM.XFLASH.BIT49)=3.3 v(TH49)=0
.nodeset v(XSDM.XFLASH.BIT50)=3.3 v(TH50)=0
.nodeset v(XSDM.XFLASH.BIT51)=3.3 v(TH51)=0
.nodeset v(XSDM.XFLASH.BIT52)=3.3 v(TH52)=0
.nodeset v(XSDM.XFLASH.BIT53)=3.3 v(TH53)=0
.nodeset v(XSDM.XFLASH.BIT54)=3.3 v(TH54)=0
.nodeset v(XSDM.XFLASH.BIT55)=3.3 v(TH55)=0
.nodeset v(XSDM.XFLASH.BIT56)=3.3 v(TH56)=0
.nodeset v(XSDM.XFLASH.BIT57)=3.3 v(TH57)=0
.nodeset v(XSDM.XFLASH.BIT58)=3.3 v(TH58)=0
.nodeset v(XSDM.XFLASH.BIT59)=3.3 v(TH59)=0
.nodeset v(XSDM.XFLASH.BIT60)=3.3 v(TH60)=0
.nodeset v(XSDM.XFLASH.BIT61)=3.3 v(TH61)=0
.nodeset v(XSDM.XFLASH.BIT62)=3.3 v(TH62)=0
.nodeset v(XSDM.PTRS)=0 v(XSDM.PTRM)=0 v(XSDM.C2R)=31.5
.control
set noaskquit
options itl4=1000
save time v(TH0) v(TH1) v(TH2) v(TH3) v(TH4) v(TH5) v(TH6) v(TH7) v(TH8) v(TH9) v(TH10) v(TH11) v(TH12) v(TH13) v(TH14) v(TH15) v(TH16) v(TH17) v(TH18) v(TH19) v(TH20) v(TH21) v(TH22) v(TH23) v(TH24) v(TH25) v(TH26) v(TH27) v(TH28) v(TH29) v(TH30) v(TH31) v(TH32) v(TH33) v(TH34) v(TH35) v(TH36) v(TH37) v(TH38) v(TH39) v(TH40) v(TH41) v(TH42) v(TH43) v(TH44) v(TH45) v(TH46) v(TH47) v(TH48) v(TH49) v(TH50) v(TH51) v(TH52) v(TH53) v(TH54) v(TH55) v(TH56) v(TH57) v(TH58) v(TH59) v(TH60) v(TH61) v(TH62)
tran 50n 35m
wrdata ../results/sdm3_mb6_512k_short.csv time v(TH0) v(TH1) v(TH2) v(TH3) v(TH4) v(TH5) v(TH6) v(TH7) v(TH8) v(TH9) v(TH10) v(TH11) v(TH12) v(TH13) v(TH14) v(TH15) v(TH16) v(TH17) v(TH18) v(TH19) v(TH20) v(TH21) v(TH22) v(TH23) v(TH24) v(TH25) v(TH26) v(TH27) v(TH28) v(TH29) v(TH30) v(TH31) v(TH32) v(TH33) v(TH34) v(TH35) v(TH36) v(TH37) v(TH38) v(TH39) v(TH40) v(TH41) v(TH42) v(TH43) v(TH44) v(TH45) v(TH46) v(TH47) v(TH48) v(TH49) v(TH50) v(TH51) v(TH52) v(TH53) v(TH54) v(TH55) v(TH56) v(TH57) v(TH58) v(TH59) v(TH60) v(TH61) v(TH62)
quit
.endc
.end
