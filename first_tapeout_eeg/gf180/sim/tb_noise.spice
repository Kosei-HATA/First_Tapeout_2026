* GF180 rev2-style frozen-chopper noise + gain check (mirrors rev2_tb_noise.spice).
* Closed loop x32 (CIN=32p, CFB=1p), choppers frozen straight.
* Input-referred noise density = onoise_spectrum / closed-loop gain at f.
.include /Users/noah/.ciel/ciel/gf180mcu/versions/f6eeac7dad085ffcc829ccfd721f7b4ce39edcf7/gf180mcuD/libs.tech/ngspice/design.ngspice
.lib /Users/noah/.ciel/ciel/gf180mcu/versions/f6eeac7dad085ffcc829ccfd721f7b4ce39edcf7/gf180mcuD/libs.tech/ngspice/sm141064.ngspice typical
.include gf180_afe_cells.spice
.param VDD=3.3 VCM=1.65
VDD_SRC VDD33 0 {VDD}
VREF VCM_REF 0 {VCM}
VPHI PHI 0 {VDD}
VPHIB PHIB 0 0
BNPHI NPHI 0 V={VDD}-v(PHI)
BNPHIB NPHIB 0 V={VDD}-v(PHIB)
VSIGP SIGP 0 DC {VCM} AC 0.5 0
VSIGN SRCN 0 DC {VCM} AC 0.5 180
CINP SIGP INP 32p
CINN SRCN INN 32p
CFP OUTN INP 1p
CFN OUTP INN 1p
RBIASP INP VCM_REF 1T
RBIASN INN VCM_REF 1T
XAFE INP INN VCM_REF OUTP OUTN PHI NPHI PHIB NPHIB PHI NPHI PHIB NPHIB VDD33 0 gf180_fd_ota_chopped_full2
CLOADP OUTP 0 5p
CLOADN OUTN 0 5p
.control
set noaskquit
noise v(OUTP,OUTN) VSIGP dec 25 0.1 1Meg 1
setplot noise1
wrdata ../results/noise.csv onoise_spectrum inoise_spectrum
ac dec 10 1 1k
let g = mag(v(OUTP)-v(OUTN))
wrdata ../results/noise_gain.csv g
let idd = -i(VDD_SRC)
op
print idd
quit
.endc
.temp 27
.end
