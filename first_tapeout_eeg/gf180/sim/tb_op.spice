* GF180 OTA op-point check (frozen choppers, open loop)
.include /Users/noah/.ciel/ciel/gf180mcu/versions/f6eeac7dad085ffcc829ccfd721f7b4ce39edcf7/gf180mcuD/libs.tech/ngspice/design.ngspice
.lib /Users/noah/.ciel/ciel/gf180mcu/versions/f6eeac7dad085ffcc829ccfd721f7b4ce39edcf7/gf180mcuD/libs.tech/ngspice/sm141064.ngspice typical
.temp 27
.include gf180_afe_cells.spice
.param VDD=3.3 VCM=1.65
VDD_SRC VDD33 0 {VDD}
VREF VCM_REF 0 {VCM}
VPHI PHI 0 {VDD}
VPHIB PHIB 0 0
BNPHI NPHI 0 V={VDD}-v(PHI)
BNPHIB NPHIB 0 V={VDD}-v(PHIB)
VSIGP SIGP 0 DC {VCM} AC 0.5 0
VSIGN SIGN 0 DC {VCM} AC 0.5 180
CINP SIGP INP 32p
CINN SIGN INN 32p
RBIASP INP VCM_REF 1T
RBIASN INN VCM_REF 1T
XAFE INP INN VCM_REF OUTP OUTN PHI NPHI PHIB NPHIB PHI NPHI PHIB NPHIB VDD33 0 gf180_fd_ota_chopped_full2
CLOADP OUTP 0 5p
CLOADN OUTN 0 5p
.control
set noaskquit
op
let idd = -i(VDD_SRC)
print idd v(OUTP) v(OUTN) v(XAFE.N1P)
quit
.endc
.end
