* eeg_adc: the CT 2nd-order 5-bit sigma-delta modulator of the EEG chip (GF180, this
* rev), from the independent-environment gain-10 loop (import_20261021/adc_gain10_loop)
* with the changes of tracker B2-B8:
*   stage 1  RIN 18750 ohm = 16 parallel 300 kohm unit resistors (since r11 each two
*            ppolyf_u strips of 320.48 x 0.8 um in series, the 16 middle nodes joined;
*            through r10 one ppolyf_u_1k strip of 291.28 x 1 um), so RIN/RD1 = 31/32 by
*            construction (a DAC1 element is two units in series); OTA1
*            (gf180_inside_cascode_ota, input pair L 1 um m 1024, eeg_adc_otas.spice)
*            chopped by CHOP1 through eeg_adc_clk; C1 425.4 pF per side; DAC1
*            eeg_dac1 (steered cells, common-break drive from DAC_CLK)
*   stage 2  scaled x10: R21 100 kohm = 3 parallel 300 kohm unit resistors (since r11
*            each three ppolyf_u strips of 213.54 x 0.8 um in series, middle nodes
*            joined, so that the stage-2 resistors follow RIN and DAC1 over corners and
*            temperature); OTA2
*            (gf180_ct_ota_tel16_cmfb); C2 24.41 pF per side; DAC2 eeg_dac2 (current
*            steering, SEL2 at e3)
*   quantizer eeg_quantizer on O2P/O2N (31 comparators, ladder from VREFP/VREFN)
*   reset    TGs across C1 and C2 while RST = 1 (the integrators start from zero)
*   ADC_ZERO a TG from INP to INN (TEST_CFG[5], gate 1 10/23): with the AFE output
*            chopper held open (CHOP_BLANK forced high by the RTL) the ADC converts
*            zero through its own RIN, for an ADC-only noise and idle-tone test
* C1 halved (10/23, area fallback 2 of documentation/gf180_gate1_20261023.md): C1
* 680.5 -> 340.3 pF per side with RIN and the DAC1 elements doubled, so the stage-1 time
* constants stay; the RIN noise rises by sqrt(2) (0.91 -> 1.29 nVrms input-referred).
* C1 and C2 x1.25 (10/29, documentation/gf180_realistic_eval_20261028.md): C1 340.3 -> 425.4
* pF and C2 19.53 -> 24.41 pF per side, the resistors and DAC currents unchanged, so every
* time constant of the loop grows by 1.25 and the RIN noise stays. With the fast poly
* resistor and the fast MIM together (RC 0.72 of typical) the extracted loop swung its
* quantizer input to -75 .. +92 mV with no input at all (range +-46.9 mV; adc_loop_mc.py,
* the behavioral model agrees); after the change that corner runs at 0.90 of the typical
* time constants.
* C1 and C2 are MIM arrays of the layout (gf180/tapeout/layout/mim_arrays_lay.py, adc_lay.py):
* C1 = eeg_c1a (20 cap_mim_2f0ff, 5 x 4) + eeg_c1x (4 smaller ones in the ADC's band), C2 two
* units, sized with the area and perimeter terms of the model; the integrator input (high
* impedance) is on the top plate. 2 pF per integrator output stands for the wiring until PEX.
*
* Ports: INP INN (from the AFE output), CHOP1, DAC_CLK, CMP_STROBE, RST (AFE_RST; its complement
* for the reset TGs is made here), ADC_ZERO
* (TEST_CFG[5]), SEL1_0..30, SEL2_0..30 (eeg_adc_dig SEL1/SEL2), TH0..TH30 (to eeg_adc_dig),
* VREFP VREFN (filtered, eeg_ref), VCM (CM reference), VBN1 VNC1 VPC1 VBCM1 VBPC2 VBNC2
* IDP IDN IQ (eeg_bias), O2P O2N (the stage-2 outputs, to the test multiplexer, 10/23), AVDD
* AVSS, DVDD (quantizer latches), DVSS (unused inside since r10, kept for the port order: the
* latches' ground is AVSS, see the quantizer below).
* Needs: eeg_adc_otas.spice, eeg_adc_clk.spice, eeg_dac1.spice, eeg_dac2.spice,
* eeg_quantizer.spice (all in gf180/tapeout/adc/).

.subckt eeg_adc INP INN CHOP1 DAC_CLK CMP_STROBE RST ADC_ZERO
+ SEL1_0 SEL1_1 SEL1_2 SEL1_3 SEL1_4 SEL1_5 SEL1_6 SEL1_7 SEL1_8 SEL1_9 SEL1_10 SEL1_11 SEL1_12 SEL1_13 SEL1_14 SEL1_15 SEL1_16 SEL1_17 SEL1_18 SEL1_19 SEL1_20 SEL1_21 SEL1_22 SEL1_23 SEL1_24 SEL1_25 SEL1_26 SEL1_27 SEL1_28 SEL1_29 SEL1_30
+ SEL2_0 SEL2_1 SEL2_2 SEL2_3 SEL2_4 SEL2_5 SEL2_6 SEL2_7 SEL2_8 SEL2_9 SEL2_10 SEL2_11 SEL2_12 SEL2_13 SEL2_14 SEL2_15 SEL2_16 SEL2_17 SEL2_18 SEL2_19 SEL2_20 SEL2_21 SEL2_22 SEL2_23 SEL2_24 SEL2_25 SEL2_26 SEL2_27 SEL2_28 SEL2_29 SEL2_30
+ TH0 TH1 TH2 TH3 TH4 TH5 TH6 TH7 TH8 TH9 TH10 TH11 TH12 TH13 TH14 TH15 TH16 TH17 TH18 TH19 TH20 TH21 TH22 TH23 TH24 TH25 TH26 TH27 TH28 TH29 TH30
+ VREFP VREFN VCM VBN1 VNC1 VPC1 VBCM1 VBPC2 VBNC2 IDP IDN IQ O2P O2N AVDD AVSS DVDD DVSS
* ---- ADC-only test: INP-INN short (open in normal operation)
XZERO INP INN ADC_ZERO AVDD AVSS eeg_adc_zero
* ---- stage 1
XRINPA INP RINPM AVSS ppolyf_u r_length=320.48u r_width=0.8u m=16
XRINPB RINPM I1P AVSS ppolyf_u r_length=320.48u r_width=0.8u m=16
XRINNA INN RINNM AVSS ppolyf_u r_length=320.48u r_width=0.8u m=16
XRINNB RINNM I1N AVSS ppolyf_u r_length=320.48u r_width=0.8u m=16
XCLK1 CHOP1 CIA NCIA CIB NCIB CDA NCDA CDB NCDB AVDD AVSS eeg_adc_clk
XOTA1 I1P I1N O1P O1N VCM VBN1 VNC1 VPC1 VBCM1 CIA NCIA CIB NCIB CDA NCDA CDB NCDB AVDD AVSS
+ gf180_inside_cascode_ota
XC1P I1P O1N eeg_c1
XC1N I1N O1P eeg_c1
XDAC1 I1P I1N VREFP VREFN SEL1_0 SEL1_1 SEL1_2 SEL1_3 SEL1_4 SEL1_5 SEL1_6 SEL1_7 SEL1_8 SEL1_9 SEL1_10 SEL1_11 SEL1_12 SEL1_13 SEL1_14 SEL1_15 SEL1_16 SEL1_17 SEL1_18 SEL1_19 SEL1_20 SEL1_21 SEL1_22 SEL1_23 SEL1_24 SEL1_25 SEL1_26 SEL1_27 SEL1_28 SEL1_29 SEL1_30 DAC_CLK AVDD AVSS eeg_dac1
XRSTB NRST RST AVDD AVSS eeg_adc_inv
XR1P O1N I1P RST NRST AVDD AVSS eeg_adc_rst
XR1N O1P I1N RST NRST AVDD AVSS eeg_adc_rst
* ---- stage 2
XR21P1 O1P R21PA AVSS ppolyf_u r_length=213.54u r_width=0.8u m=3
XR21P2 R21PA R21PB AVSS ppolyf_u r_length=213.54u r_width=0.8u m=3
XR21P3 R21PB I2P AVSS ppolyf_u r_length=213.54u r_width=0.8u m=3
XR21N1 O1N R21NA AVSS ppolyf_u r_length=213.54u r_width=0.8u m=3
XR21N2 R21NA R21NB AVSS ppolyf_u r_length=213.54u r_width=0.8u m=3
XR21N3 R21NB I2N AVSS ppolyf_u r_length=213.54u r_width=0.8u m=3
XOTA2 I2P I2N O2P O2N VCM VBN1 VNC1 VPC1 VBCM1 AVDD AVSS gf180_ct_ota_tel16_cmfb
XC2P I2P O2N eeg_c2
XC2N I2N O2P eeg_c2
XDAC2 I2P I2N SEL2_0 SEL2_1 SEL2_2 SEL2_3 SEL2_4 SEL2_5 SEL2_6 SEL2_7 SEL2_8 SEL2_9 SEL2_10 SEL2_11 SEL2_12 SEL2_13 SEL2_14 SEL2_15 SEL2_16 SEL2_17 SEL2_18 SEL2_19 SEL2_20 SEL2_21 SEL2_22 SEL2_23 SEL2_24 SEL2_25 SEL2_26 SEL2_27 SEL2_28 SEL2_29 SEL2_30 IDP IDN VBPC2 VBNC2 AVDD AVSS eeg_dac2
XR2P O2N I2P RST NRST AVDD AVSS eeg_adc_rst
XR2N O2P I2N RST NRST AVDD AVSS eeg_adc_rst
* ---- wiring estimates on the integrator outputs (before layout; for simulation only,
* gf180lay.to_cdl leaves CW* out of the LVS netlist)
CW1P O1P AVSS 2p
CW1N O1N AVSS 2p
CW2P O2P AVSS 2p
CW2N O2N AVSS 2p
* ---- quantizer
* The latches' ground (the quantizer's DVSS pin: StrongARM, SR latch, TH inverters, strobe
* buffer, the DVSS shields) on AVSS since r10 (11/9, tracker E4): the latches sit in the ADC's
* analog band and their 313 substrate taps hold the substrate there; on DVSS they would put
* eeg_adc_dig's ground bounce into it. Their supply stays DVDD, so the strobe current is not
* on AVDD. Through r9 that pin was wired to nothing in the layout (adc_lay.py).
XQ O2P O2N VREFP VREFN CMP_STROBE TH0 TH1 TH2 TH3 TH4 TH5 TH6 TH7 TH8 TH9 TH10 TH11 TH12 TH13 TH14 TH15 TH16 TH17 TH18 TH19 TH20 TH21 TH22 TH23 TH24 TH25 TH26 TH27 TH28 TH29 TH30 IQ AVDD AVSS DVDD AVSS eeg_quantizer
.ends eeg_adc

* ADC_ZERO switch: TG of about 100 ohm (NMOS 10 um, PMOS 20 um; RIN is 9375 ohm per
* side), with its own inverter for the PMOS gate. Off, it adds about 20 fF per input
* node (the AFE hold capacitors are 30 pF).
.subckt eeg_adc_zero A B Z VDD VSS
XIP ZB Z VDD VDD pfet_03v3 W=2u L=0.28u nf=1
XIN ZB Z VSS VSS nfet_03v3 W=1u L=0.28u nf=1
XN A Z B VSS nfet_03v3 W=10u L=0.28u nf=2
XP A ZB B VDD pfet_03v3 W=20u L=0.28u nf=4
.ends eeg_adc_zero

* NRST for the reset TGs (10/23: the decks had an ideal inverter outside the ADC)
.subckt eeg_adc_inv Y A VDD VSS
XP Y A VDD VDD pfet_03v3 W=2u L=0.28u nf=1
XN Y A VSS VSS nfet_03v3 W=1u L=0.28u nf=1
.ends eeg_adc_inv

* integrator reset switch (as rst_tg of the imported deck)
.subckt eeg_adc_rst A B G GN VDD VSS
XN A G B VSS nfet_03v3 W=1u L=0.28u nf=1
XP A GN B VDD pfet_03v3 W=2u L=0.28u nf=1
.ends eeg_adc_rst

* C1, one side (425.37 pF since 10/29, x1.25: see the header): the main array eeg_c1a and the
* rest, eeg_c1x, in the ADC's band, in parallel. TOP: OTA1 input, BOT: OTA1 output.
.subckt eeg_c1 TOP BOT
XA TOP BOT eeg_c1a
XX TOP BOT eeg_c1x
.ends eeg_c1

* C1's main array: 20 cap_mim_2f0ff of 98.33 um square in parallel (386.69 pF).
.subckt eeg_c1a TOP BOT
XC0 TOP BOT cap_mim_2f0ff c_length=98.33u c_width=98.33u
XC1 TOP BOT cap_mim_2f0ff c_length=98.33u c_width=98.33u
XC2 TOP BOT cap_mim_2f0ff c_length=98.33u c_width=98.33u
XC3 TOP BOT cap_mim_2f0ff c_length=98.33u c_width=98.33u
XC4 TOP BOT cap_mim_2f0ff c_length=98.33u c_width=98.33u
XC5 TOP BOT cap_mim_2f0ff c_length=98.33u c_width=98.33u
XC6 TOP BOT cap_mim_2f0ff c_length=98.33u c_width=98.33u
XC7 TOP BOT cap_mim_2f0ff c_length=98.33u c_width=98.33u
XC8 TOP BOT cap_mim_2f0ff c_length=98.33u c_width=98.33u
XC9 TOP BOT cap_mim_2f0ff c_length=98.33u c_width=98.33u
XC10 TOP BOT cap_mim_2f0ff c_length=98.33u c_width=98.33u
XC11 TOP BOT cap_mim_2f0ff c_length=98.33u c_width=98.33u
XC12 TOP BOT cap_mim_2f0ff c_length=98.33u c_width=98.33u
XC13 TOP BOT cap_mim_2f0ff c_length=98.33u c_width=98.33u
XC14 TOP BOT cap_mim_2f0ff c_length=98.33u c_width=98.33u
XC15 TOP BOT cap_mim_2f0ff c_length=98.33u c_width=98.33u
XC16 TOP BOT cap_mim_2f0ff c_length=98.33u c_width=98.33u
XC17 TOP BOT cap_mim_2f0ff c_length=98.33u c_width=98.33u
XC18 TOP BOT cap_mim_2f0ff c_length=98.33u c_width=98.33u
XC19 TOP BOT cap_mim_2f0ff c_length=98.33u c_width=98.33u
.ends eeg_c1a

* C1's extension: 4 cap_mim_2f0ff of 69.47 um square in parallel (38.68 pF).
.subckt eeg_c1x TOP BOT
XC0 TOP BOT cap_mim_2f0ff c_length=69.47u c_width=69.47u
XC1 TOP BOT cap_mim_2f0ff c_length=69.47u c_width=69.47u
XC2 TOP BOT cap_mim_2f0ff c_length=69.47u c_width=69.47u
XC3 TOP BOT cap_mim_2f0ff c_length=69.47u c_width=69.47u
.ends eeg_c1x

* C2, one side: two cap_mim_2f0ff of 61.68 x 98.83 um (24.41 pF since 10/29, x1.25). TOP: OTA2
* input, BOT: OTA2 output.
.subckt eeg_c2 TOP BOT
XC0 TOP BOT cap_mim_2f0ff c_length=98.83u c_width=61.68u
XC1 TOP BOT cap_mim_2f0ff c_length=98.83u c_width=61.68u
.ends eeg_c2
