* eeg_adc: the CT 2nd-order 5-bit sigma-delta modulator of the EEG chip (GF180, this
* rev), from the independent-environment gain-10 loop (import_20261021/adc_gain10_loop)
* with the changes of tracker B2-B8:
*   stage 1  RIN 18750 ohm = 16 parallel 300 kohm unit resistors (ppolyf_u_1k,
*            291.28 x 1 um), so RIN/RD1 = 31/32 by construction (a DAC1 element is two
*            units in series); OTA1
*            (gf180_inside_cascode_ota, input pair L 1 um m 1024, eeg_adc_otas.spice)
*            chopped by CHOP1 through eeg_adc_clk; C1 340.3 pF per side; DAC1
*            eeg_dac1 (steered cells, common-break drive from DAC_CLK)
*   stage 2  scaled x10: R21 100 kohm = 3 parallel 300 kohm unit resistors; OTA2
*            (gf180_ct_ota_tel16_cmfb); C2 19.53 pF per side; DAC2 eeg_dac2 (current
*            steering, SEL2 at e3)
*   quantizer eeg_quantizer on O2P/O2N (31 comparators, ladder from VREFP/VREFN)
*   reset    TGs across C1 and C2 while RST = 1 (the integrators start from zero)
*   ADC_ZERO a TG from INP to INN (TEST_CFG[5], gate 1 10/23): with the AFE output
*            chopper held open (CHOP_BLANK forced high by the RTL) the ADC converts
*            zero through its own RIN, for an ADC-only noise and idle-tone test
* C1 halved (10/23, area fallback 2 of documentation/gf180_gate1_20261023.md): C1
* 680.5 -> 340.3 pF per side with RIN and the DAC1 elements doubled, so the stage-1 time
* constants stay; the RIN noise rises by sqrt(2) (0.91 -> 1.29 nVrms input-referred).
* C1 and C2 are the MIM arrays of the layout (gf180/tapeout/layout/mim_arrays_lay.py):
* eeg_c1 18 and eeg_c2 one cap_mim_2f0ff, sized with the area and perimeter terms of the
* model; the integrator input (high impedance) is on the top plate. 2 pF per integrator
* output stands for the wiring until PEX.
*
* Ports: INP INN (from the AFE output), CHOP1, DAC_CLK, CMP_STROBE, RST (AFE_RST; its complement
* for the reset TGs is made here), ADC_ZERO
* (TEST_CFG[5]), SEL1_0..30, SEL2_0..30 (eeg_adc_dig SEL1/SEL2), TH0..TH30 (to eeg_adc_dig),
* VREFP VREFN (filtered, eeg_ref), VCM (CM reference), VBN1 VNC1 VPC1 VBCM1 VBPC2 VBNC2
* IDP IDN IQ (eeg_bias), O2P O2N (the stage-2 outputs, to the test multiplexer, 10/23), AVDD
* AVSS, DVDD DVSS (quantizer latches).
* Needs: eeg_adc_otas.spice, eeg_adc_clk.spice, eeg_dac1.spice, eeg_dac2.spice,
* eeg_quantizer.spice (all in gf180/tapeout/adc/).

.subckt eeg_adc INP INN CHOP1 DAC_CLK CMP_STROBE RST ADC_ZERO
+ SEL1_0 SEL1_1 SEL1_2 SEL1_3 SEL1_4 SEL1_5 SEL1_6 SEL1_7 SEL1_8 SEL1_9 SEL1_10 SEL1_11 SEL1_12 SEL1_13 SEL1_14 SEL1_15 SEL1_16 SEL1_17 SEL1_18 SEL1_19 SEL1_20 SEL1_21 SEL1_22 SEL1_23 SEL1_24 SEL1_25 SEL1_26 SEL1_27 SEL1_28 SEL1_29 SEL1_30
+ SEL2_0 SEL2_1 SEL2_2 SEL2_3 SEL2_4 SEL2_5 SEL2_6 SEL2_7 SEL2_8 SEL2_9 SEL2_10 SEL2_11 SEL2_12 SEL2_13 SEL2_14 SEL2_15 SEL2_16 SEL2_17 SEL2_18 SEL2_19 SEL2_20 SEL2_21 SEL2_22 SEL2_23 SEL2_24 SEL2_25 SEL2_26 SEL2_27 SEL2_28 SEL2_29 SEL2_30
+ TH0 TH1 TH2 TH3 TH4 TH5 TH6 TH7 TH8 TH9 TH10 TH11 TH12 TH13 TH14 TH15 TH16 TH17 TH18 TH19 TH20 TH21 TH22 TH23 TH24 TH25 TH26 TH27 TH28 TH29 TH30
+ VREFP VREFN VCM VBN1 VNC1 VPC1 VBCM1 VBPC2 VBNC2 IDP IDN IQ O2P O2N AVDD AVSS DVDD DVSS
* ---- ADC-only test: INP-INN short (open in normal operation)
XZERO INP INN ADC_ZERO AVDD AVSS eeg_adc_zero
* ---- stage 1
XRINP INP I1P AVSS ppolyf_u_1k r_length=291.28u r_width=1u m=16
XRINN INN I1N AVSS ppolyf_u_1k r_length=291.28u r_width=1u m=16
XCLK1 CHOP1 CIA NCIA CIB NCIB CDA NCDA CDB NCDB AVDD AVSS eeg_adc_clk
XOTA1 I1P I1N O1P O1N VCM VBN1 VNC1 VPC1 VBCM1 CIA NCIA CIB NCIB CDA NCDA CDB NCDB AVDD AVSS
+ gf180_inside_cascode_ota
XC1P I1P O1N eeg_c1
XC1N I1N O1P eeg_c1
XDAC1 I1P I1N VREFP VREFN SEL1_0 SEL1_1 SEL1_2 SEL1_3 SEL1_4 SEL1_5 SEL1_6 SEL1_7 SEL1_8 SEL1_9 SEL1_10 SEL1_11 SEL1_12 SEL1_13 SEL1_14 SEL1_15 SEL1_16 SEL1_17 SEL1_18 SEL1_19 SEL1_20 SEL1_21 SEL1_22 SEL1_23 SEL1_24 SEL1_25 SEL1_26 SEL1_27 SEL1_28 SEL1_29 SEL1_30 DAC_CLK AVDD AVSS eeg_dac1
XRSTB NRST RST AVDD AVSS eeg_adc_inv
XR1P O1N I1P RST NRST AVDD AVSS eeg_adc_rst
XR1N O1P I1N RST NRST AVDD AVSS eeg_adc_rst
* ---- stage 2
XR21P O1P I2P AVSS ppolyf_u_1k r_length=291.28u r_width=1u m=3
XR21N O1N I2N AVSS ppolyf_u_1k r_length=291.28u r_width=1u m=3
XOTA2 I2P I2N O2P O2N VCM VBN1 VNC1 VPC1 VBCM1 AVDD AVSS gf180_ct_ota_tel16_cmfb
XC2P I2P O2N eeg_c2
XC2N I2N O2P eeg_c2
XDAC2 I2P I2N SEL2_0 SEL2_1 SEL2_2 SEL2_3 SEL2_4 SEL2_5 SEL2_6 SEL2_7 SEL2_8 SEL2_9 SEL2_10 SEL2_11 SEL2_12 SEL2_13 SEL2_14 SEL2_15 SEL2_16 SEL2_17 SEL2_18 SEL2_19 SEL2_20 SEL2_21 SEL2_22 SEL2_23 SEL2_24 SEL2_25 SEL2_26 SEL2_27 SEL2_28 SEL2_29 SEL2_30 IDP IDN VBPC2 VBNC2 AVDD AVSS eeg_dac2
XR2P O2N I2P RST NRST AVDD AVSS eeg_adc_rst
XR2N O2P I2N RST NRST AVDD AVSS eeg_adc_rst
* ---- wiring estimates on the integrator outputs (before layout; for simulation only,
* gf180lay.to_cdl leaves CW* out of the LVS netlist)
CW1P O1P AVSS 2p
CW1N O1N AVSS 2p
CW2P O2P AVSS 2p
CW2N O2N AVSS 2p
* ---- quantizer
XQ O2P O2N VREFP VREFN CMP_STROBE TH0 TH1 TH2 TH3 TH4 TH5 TH6 TH7 TH8 TH9 TH10 TH11 TH12 TH13 TH14 TH15 TH16 TH17 TH18 TH19 TH20 TH21 TH22 TH23 TH24 TH25 TH26 TH27 TH28 TH29 TH30 IQ AVDD AVSS DVDD DVSS eeg_quantizer
.ends eeg_adc

* ADC_ZERO switch: TG of about 100 ohm (NMOS 10 um, PMOS 20 um; RIN is 9375 ohm per
* side), with its own inverter for the PMOS gate. Off, it adds about 20 fF per input
* node (the AFE hold capacitors are 30 pF).
.subckt eeg_adc_zero A B Z VDD VSS
XIP ZB Z VDD VDD pfet_03v3 W=2u L=0.28u nf=1
XIN ZB Z VSS VSS nfet_03v3 W=1u L=0.28u nf=1
XN A Z B VSS nfet_03v3 W=10u L=0.28u nf=2
XP A ZB B VDD pfet_03v3 W=20u L=0.28u nf=4
.ends eeg_adc_zero

* NRST for the reset TGs (10/23: the decks had an ideal inverter outside the ADC)
.subckt eeg_adc_inv Y A VDD VSS
XP Y A VDD VDD pfet_03v3 W=2u L=0.28u nf=1
XN Y A VSS VSS nfet_03v3 W=1u L=0.28u nf=1
.ends eeg_adc_inv

* integrator reset switch (as rst_tg of the imported deck)
.subckt eeg_adc_rst A B G GN VDD VSS
XN A G B VSS nfet_03v3 W=1u L=0.28u nf=1
XP A GN B VDD pfet_03v3 W=2u L=0.28u nf=1
.ends eeg_adc_rst

* C1, one side: 18 cap_mim_2f0ff of 97.23 um square in parallel (340.30 pF). TOP: OTA1
* input, BOT: OTA1 output.
.subckt eeg_c1 TOP BOT
XC0 TOP BOT cap_mim_2f0ff c_length=97.23u c_width=97.23u
XC1 TOP BOT cap_mim_2f0ff c_length=97.23u c_width=97.23u
XC2 TOP BOT cap_mim_2f0ff c_length=97.23u c_width=97.23u
XC3 TOP BOT cap_mim_2f0ff c_length=97.23u c_width=97.23u
XC4 TOP BOT cap_mim_2f0ff c_length=97.23u c_width=97.23u
XC5 TOP BOT cap_mim_2f0ff c_length=97.23u c_width=97.23u
XC6 TOP BOT cap_mim_2f0ff c_length=97.23u c_width=97.23u
XC7 TOP BOT cap_mim_2f0ff c_length=97.23u c_width=97.23u
XC8 TOP BOT cap_mim_2f0ff c_length=97.23u c_width=97.23u
XC9 TOP BOT cap_mim_2f0ff c_length=97.23u c_width=97.23u
XC10 TOP BOT cap_mim_2f0ff c_length=97.23u c_width=97.23u
XC11 TOP BOT cap_mim_2f0ff c_length=97.23u c_width=97.23u
XC12 TOP BOT cap_mim_2f0ff c_length=97.23u c_width=97.23u
XC13 TOP BOT cap_mim_2f0ff c_length=97.23u c_width=97.23u
XC14 TOP BOT cap_mim_2f0ff c_length=97.23u c_width=97.23u
XC15 TOP BOT cap_mim_2f0ff c_length=97.23u c_width=97.23u
XC16 TOP BOT cap_mim_2f0ff c_length=97.23u c_width=97.23u
XC17 TOP BOT cap_mim_2f0ff c_length=97.23u c_width=97.23u
.ends eeg_c1

* C2, one side: one cap_mim_2f0ff of 98.83 um square (19.53 pF). TOP: OTA2 input, BOT: OTA2 output.
.subckt eeg_c2 TOP BOT
XC0 TOP BOT cap_mim_2f0ff c_length=98.83u c_width=98.83u
.ends eeg_c2
