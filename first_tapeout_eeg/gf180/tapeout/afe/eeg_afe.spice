* eeg_afe: chopper-stabilised capacitively coupled instrumentation amplifier (GF180, this rev)
* Written by gf180/tapeout/afe/make_afe_netlist.py from gf180/tapeout/sim/afe/afe_noise.py
* (core 1, tg 256, ln 1.5, lp 0.28, mp 1, itail 3, scasc 1, tgo 8, boosters N [20.0, 4.0, 16, 0.001], P [20.0, 2.0, 64, 0.0006],
* booster load L 8 um). Do not edit by hand; change the generator and rerun.
* CCIA diagnostic: original MOS dimensions, physical input/output TG.
* Input TG precede Cin; fixed internal Cf/reset/CMFB/compensation.
* 18 core/CMFB MOS + 16 switch MOS; no periodic-noise claim.
.subckt eeg_afe_output_tg A B G GN VDD VSS
XN A G B VSS nfet_03v3 W=20u L=.28u nf=1 m=8 ad=10p as=10p pd=41u ps=41u nrd=.025 nrs=.025
XP A GN B VDD pfet_03v3 W=40u L=.28u nf=1 m=8 ad=20p as=20p pd=81u ps=81u nrd=.0125 nrs=.0125
.ends eeg_afe_output_tg

.subckt eeg_afe_input_tg A B G GN VDD VSS
XN A G B VSS nfet_03v3 W=20u L=.28u nf=1 m=256 ad=10p as=10p pd=41u ps=41u nrd=.025 nrs=.025
XP A GN B VDD pfet_03v3 W=40u L=.28u nf=1 m=256 ad=20p as=20p pd=81u ps=81u nrd=.0125 nrs=.0125
.ends eeg_afe_input_tg
* Newcascoded current-reuse candidate cas_L1; inputW/L unchanged, area reduced.
* Complementary current-reuse differential input stage. No ideal gm source.
* N/P input transconductances add; source tails share the branch current.
* Real8MOS gate-only CMFB controls the PMOS upper tail.
.subckt eeg_afe_core INP INN OUTP OUTN VBN VBP BLP BLN VDD VSS
XN_P DNP INP SN VSS nfet_03v3 W=10u L=1.5u nf=1 m=2048 ad=5p as=5p pd=21u ps=21u nrd=0.05 nrs=0.05
XN_N DNN INN SN VSS nfet_03v3 W=10u L=1.5u nf=1 m=2048 ad=5p as=5p pd=21u ps=21u nrd=0.05 nrs=0.05
XP_P DPP INP SP VDD pfet_03v3 W=10u L=0.28u nf=1 m=4096 ad=5p as=5p pd=21u ps=21u nrd=0.05 nrs=0.05
XP_N DPN INN SP VDD pfet_03v3 W=10u L=0.28u nf=1 m=4096 ad=5p as=5p pd=21u ps=21u nrd=0.05 nrs=0.05
XNT SN VBN VSS VSS nfet_03v3 W=10u L=1u nf=1 m=768 ad=5p as=5p pd=21u ps=21u nrd=.05 nrs=.05
XPT SP VBP VDD VDD pfet_03v3 W=10u L=2u nf=1 m=2048 ad=5p as=5p pd=21u ps=21u nrd=.05 nrs=.05
XNC_P OUTN GNCP DNP VSS nfet_03v3 W=10u L=1u nf=1 m=512 ad=5p as=5p pd=21u ps=21u nrd=.05 nrs=.05
XNC_N OUTP GNCN DNN VSS nfet_03v3 W=10u L=1u nf=1 m=512 ad=5p as=5p pd=21u ps=21u nrd=.05 nrs=.05
XPC_P OUTN GPCP DPP VDD pfet_03v3 W=10u L=1u nf=1 m=1024 ad=5p as=5p pd=21u ps=21u nrd=.05 nrs=.05
XPC_N OUTP GPCN DPN VDD pfet_03v3 W=10u L=1u nf=1 m=1024 ad=5p as=5p pd=21u ps=21u nrd=.05 nrs=.05
XGNCPB GNCP DNP VSS VSS nfet_03v3 W=20u L=4u nf=1 m=16
XGNCPL GNCP BLP VDD VDD pfet_03v3 W=20u L=8u nf=1 m=32
XGNCNB GNCN DNN VSS VSS nfet_03v3 W=20u L=4u nf=1 m=16
XGNCNL GNCN BLP VDD VDD pfet_03v3 W=20u L=8u nf=1 m=32
XGPCPB GPCP DPP VDD VDD pfet_03v3 W=20u L=2u nf=1 m=64
XGPCPL GPCP BLN VSS VSS nfet_03v3 W=20u L=8u nf=1 m=20
XGPCNB GPCN DPN VDD VDD pfet_03v3 W=20u L=2u nf=1 m=64
XGPCNL GPCN BLN VSS VSS nfet_03v3 W=20u L=8u nf=1 m=20
XBLPD BLP BLP VDD VDD pfet_03v3 W=20u L=8u nf=1 m=4
XBLND BLN BLN VSS VSS nfet_03v3 W=20u L=8u nf=1 m=4
.ends eeg_afe_core
.subckt eeg_afe_cmfb OUTP OUTN VCMREF VBCM VBP VDD VSS
XCM1 ND OUTP NTA VSS nfet_03v3 W=10u L=2u nf=1 m=4 ad=5p as=5p pd=21u ps=21u nrd=.05 nrs=.05
XCM2 VBP VCMREF NTA VSS nfet_03v3 W=10u L=2u nf=1 m=4 ad=5p as=5p pd=21u ps=21u nrd=.05 nrs=.05
XCM3 ND OUTN NTB VSS nfet_03v3 W=10u L=2u nf=1 m=4 ad=5p as=5p pd=21u ps=21u nrd=.05 nrs=.05
XCM4 VBP VCMREF NTB VSS nfet_03v3 W=10u L=2u nf=1 m=4 ad=5p as=5p pd=21u ps=21u nrd=.05 nrs=.05
XCMP1 ND ND VDD VDD pfet_03v3 W=10u L=2u nf=1 m=8 ad=5p as=5p pd=21u ps=21u nrd=.05 nrs=.05
XCMP2 VBP ND VDD VDD pfet_03v3 W=10u L=2u nf=1 m=8 ad=5p as=5p pd=21u ps=21u nrd=.05 nrs=.05
XCMT1 NTA VBCM VSS VSS nfet_03v3 W=10u L=2u nf=1 m=2 ad=5p as=5p pd=21u ps=21u nrd=.05 nrs=.05
XCMT2 NTB VBCM VSS VSS nfet_03v3 W=10u L=2u nf=1 m=2 ad=5p as=5p pd=21u ps=21u nrd=.05 nrs=.05
.ends eeg_afe_cmfb

* CCIA: explicit electrodes, switched capacitor plates, fixed core input/output ports.
.subckt eeg_afe_amp EP EN WP WN INP INN OPI ONI OUTP OUTN VCM VBN VBCM BLP BLN VBP CIA NCIA CIB NCIB CDA NCDA CDB NCDB VDD VSS
XIP_A EP WP CIA NCIA VDD VSS eeg_afe_input_tg
XIN_A EN WN CIA NCIA VDD VSS eeg_afe_input_tg
XIP_B EP WN CIB NCIB VDD VSS eeg_afe_input_tg
XIN_B EN WP CIB NCIB VDD VSS eeg_afe_input_tg
XCORE INP INN OPI ONI VBN VBP BLP BLN VDD VSS eeg_afe_core
XOP_A OPI OUTP CDA NCDA VDD VSS eeg_afe_output_tg
XON_A ONI OUTN CDA NCDA VDD VSS eeg_afe_output_tg
XOP_B OPI OUTN CDB NCDB VDD VSS eeg_afe_output_tg
XON_B ONI OUTP CDB NCDB VDD VSS eeg_afe_output_tg
XCMFB OPI ONI VCM VBCM VBP VDD VSS eeg_afe_cmfb
XCCP VBP OPI cap_mim_2f0ff c_length=70.65u c_width=70.65u
XCCN VBP ONI cap_mim_2f0ff c_length=70.65u c_width=70.65u
.ends eeg_afe_amp

* electrode-offset cancellation DAC (tracker B7), sign-magnitude
* PH: DAC phase, toggles when the input-chopper TG of the new phase closes (high in
* phase A). X = S XOR PH. Active bit k (Mk and its group enabled): P plate = VDD when
* not X, N plate = VDD when X; inactive plates stay at VSS. For S = 0 the P plates rise
* at the A->B edge: +sum(active Ck) x VDD into INP cancels the Cin step of a positive
* ELP-ELN offset, magnitude x 0.311 mV per unit (60 fF). Each plate is driven through
* R_k = 65 ns / C_k (thermal noise grows with the active capacitance, i.e.
* with the cancelled offset). Inactive plates: clamped to VSS by an NMOS sized for
* R_on x C_k = 0.2 ns. Disabled groups: plates low, top plate at VCM.
.subckt eeg_afe_offdac INP INN VCM PH S M0 M1 M2 M3 M4 M5 M6 M7 M8 M9 EN0 EN1 EN2 EN3 VDD VSS
XSB SB S VDD VSS eeg_afe_inv s=1
XNPH NPH PH VDD VSS eeg_afe_inv s=2
XMXA S XR NPH PH VDD VSS eeg_afe_tg
XMXB SB XR PH NPH VDD VSS eeg_afe_tg
XXR1 XRB XR VDD VSS eeg_afe_inv s=2
XXR2 X XRB VDD VSS eeg_afe_inv s=8
XXR3 XB X VDD VSS eeg_afe_inv s=8
XENB0 ENB0 EN0 VDD VSS eeg_afe_inv s=1
XENB1 ENB1 EN1 VDD VSS eeg_afe_inv s=1
XENB2 ENB2 EN2 VDD VSS eeg_afe_inv s=1
XENB3 ENB3 EN3 VDD VSS eeg_afe_inv s=1
XRGP0N TP0 EN0 INP VSS nfet_03v3 W=10u L=0.28u nf=1 m=1
XRGP0P TP0 ENB0 INP VDD pfet_03v3 W=20u L=0.28u nf=2 m=1
XPKP0N TP0 ENB0 VCM VSS nfet_03v3 W=1u L=0.28u nf=1 m=1
XPKP0P TP0 EN0 VCM VDD pfet_03v3 W=2u L=0.28u nf=1 m=1
XRGN0N TN0 EN0 INN VSS nfet_03v3 W=10u L=0.28u nf=1 m=1
XRGN0P TN0 ENB0 INN VDD pfet_03v3 W=20u L=0.28u nf=2 m=1
XPKN0N TN0 ENB0 VCM VSS nfet_03v3 W=1u L=0.28u nf=1 m=1
XPKN0P TN0 EN0 VCM VDD pfet_03v3 W=2u L=0.28u nf=1 m=1
XRGP1N TP1 EN1 INP VSS nfet_03v3 W=10u L=0.28u nf=1 m=1
XRGP1P TP1 ENB1 INP VDD pfet_03v3 W=20u L=0.28u nf=2 m=1
XPKP1N TP1 ENB1 VCM VSS nfet_03v3 W=1u L=0.28u nf=1 m=1
XPKP1P TP1 EN1 VCM VDD pfet_03v3 W=2u L=0.28u nf=1 m=1
XRGN1N TN1 EN1 INN VSS nfet_03v3 W=10u L=0.28u nf=1 m=1
XRGN1P TN1 ENB1 INN VDD pfet_03v3 W=20u L=0.28u nf=2 m=1
XPKN1N TN1 ENB1 VCM VSS nfet_03v3 W=1u L=0.28u nf=1 m=1
XPKN1P TN1 EN1 VCM VDD pfet_03v3 W=2u L=0.28u nf=1 m=1
XRGP2N TP2 EN2 INP VSS nfet_03v3 W=20u L=0.28u nf=2 m=1
XRGP2P TP2 ENB2 INP VDD pfet_03v3 W=40u L=0.28u nf=4 m=1
XPKP2N TP2 ENB2 VCM VSS nfet_03v3 W=1u L=0.28u nf=1 m=1
XPKP2P TP2 EN2 VCM VDD pfet_03v3 W=2u L=0.28u nf=1 m=1
XRGN2N TN2 EN2 INN VSS nfet_03v3 W=20u L=0.28u nf=2 m=1
XRGN2P TN2 ENB2 INN VDD pfet_03v3 W=40u L=0.28u nf=4 m=1
XPKN2N TN2 ENB2 VCM VSS nfet_03v3 W=1u L=0.28u nf=1 m=1
XPKN2P TN2 EN2 VCM VDD pfet_03v3 W=2u L=0.28u nf=1 m=1
XRGP3N TP3 EN3 INP VSS nfet_03v3 W=40u L=0.28u nf=4 m=1
XRGP3P TP3 ENB3 INP VDD pfet_03v3 W=80u L=0.28u nf=8 m=1
XPKP3N TP3 ENB3 VCM VSS nfet_03v3 W=1u L=0.28u nf=1 m=1
XPKP3P TP3 EN3 VCM VDD pfet_03v3 W=2u L=0.28u nf=1 m=1
XRGN3N TN3 EN3 INN VSS nfet_03v3 W=40u L=0.28u nf=4 m=1
XRGN3P TN3 ENB3 INN VDD pfet_03v3 W=80u L=0.28u nf=8 m=1
XPKN3N TN3 ENB3 VCM VSS nfet_03v3 W=1u L=0.28u nf=1 m=1
XPKN3P TN3 EN3 VCM VDD pfet_03v3 W=2u L=0.28u nf=1 m=1
* bit 0: 0.06 pF per side, group 0, R 1083 kohm, driver x1, clamp W 0.5 um
XNP0 NP0 EN0 M0 XB VDD VSS eeg_afe_nand3 s=1
XNN0 NN0 EN0 M0 X VDD VSS eeg_afe_nand3 s=1
XDP0 DP0 NP0 VDD VSS eeg_afe_inv s=1
XDN0 DN0 NN0 VDD VSS eeg_afe_inv s=1
XRDP0 DP0 BP0 VSS ppolyf_u_1k r_length=1051.1u r_width=1u
XRDN0 DN0 BN0 VSS ppolyf_u_1k r_length=1051.1u r_width=1u
XNA0 NA0 EN0 M0 VDD VSS eeg_afe_nand2 s=1
XCLP0 BP0 NA0 VSS VSS nfet_03v3 W=0.5u L=0.28u nf=1 m=1
XCLN0 BN0 NA0 VSS VSS nfet_03v3 W=0.5u L=0.28u nf=1 m=1
XCOFP0 TP0 BP0 cap_mim_2f0ff c_length=5.26u c_width=5.26u
XCOFN0 TN0 BN0 cap_mim_2f0ff c_length=5.26u c_width=5.26u
* bit 1: 0.12 pF per side, group 0, R 541.7 kohm, driver x1, clamp W 0.5 um
XNP1 NP1 EN0 M1 XB VDD VSS eeg_afe_nand3 s=1
XNN1 NN1 EN0 M1 X VDD VSS eeg_afe_nand3 s=1
XDP1 DP1 NP1 VDD VSS eeg_afe_inv s=1
XDN1 DN1 NN1 VDD VSS eeg_afe_inv s=1
XRDP1 DP1 BP1 VSS ppolyf_u_1k r_length=525.46u r_width=1u
XRDN1 DN1 BN1 VSS ppolyf_u_1k r_length=525.46u r_width=1u
XNA1 NA1 EN0 M1 VDD VSS eeg_afe_nand2 s=1
XCLP1 BP1 NA1 VSS VSS nfet_03v3 W=0.5u L=0.28u nf=1 m=1
XCLN1 BN1 NA1 VSS VSS nfet_03v3 W=0.5u L=0.28u nf=1 m=1
XCOFP1 TP0 BP1 cap_mim_2f0ff c_length=7.53u c_width=7.53u
XCOFN1 TN0 BN1 cap_mim_2f0ff c_length=7.53u c_width=7.53u
* bit 2: 0.24 pF per side, group 0, R 270.8 kohm, driver x1, clamp W 1 um
XNP2 NP2 EN0 M2 XB VDD VSS eeg_afe_nand3 s=1
XNN2 NN2 EN0 M2 X VDD VSS eeg_afe_nand3 s=1
XDP2 DP2 NP2 VDD VSS eeg_afe_inv s=1
XDN2 DN2 NN2 VDD VSS eeg_afe_inv s=1
XRDP2 DP2 BP2 VSS ppolyf_u_1k r_length=262.65u r_width=1u
XRDN2 DN2 BN2 VSS ppolyf_u_1k r_length=262.65u r_width=1u
XNA2 NA2 EN0 M2 VDD VSS eeg_afe_nand2 s=1
XCLP2 BP2 NA2 VSS VSS nfet_03v3 W=1u L=0.28u nf=1 m=1
XCLN2 BN2 NA2 VSS VSS nfet_03v3 W=1u L=0.28u nf=1 m=1
XCOFP2 TP0 BP2 cap_mim_2f0ff c_length=10.75u c_width=10.75u
XCOFN2 TN0 BN2 cap_mim_2f0ff c_length=10.75u c_width=10.75u
* bit 3: 0.48 pF per side, group 0, R 135.4 kohm, driver x1, clamp W 1.5 um
XNP3 NP3 EN0 M3 XB VDD VSS eeg_afe_nand3 s=1
XNN3 NN3 EN0 M3 X VDD VSS eeg_afe_nand3 s=1
XDP3 DP3 NP3 VDD VSS eeg_afe_inv s=1
XDN3 DN3 NN3 VDD VSS eeg_afe_inv s=1
XRDP3 DP3 BP3 VSS ppolyf_u_1k r_length=131.24u r_width=1u
XRDN3 DN3 BN3 VSS ppolyf_u_1k r_length=131.24u r_width=1u
XNA3 NA3 EN0 M3 VDD VSS eeg_afe_nand2 s=1
XCLP3 BP3 NA3 VSS VSS nfet_03v3 W=1.5u L=0.28u nf=1 m=1
XCLN3 BN3 NA3 VSS VSS nfet_03v3 W=1.5u L=0.28u nf=1 m=1
XCOFP3 TP0 BP3 cap_mim_2f0ff c_length=15.29u c_width=15.29u
XCOFN3 TN0 BN3 cap_mim_2f0ff c_length=15.29u c_width=15.29u
* bit 4: 0.96 pF per side, group 0, R 67.71 kohm, driver x1, clamp W 3 um
XNP4 NP4 EN0 M4 XB VDD VSS eeg_afe_nand3 s=1
XNN4 NN4 EN0 M4 X VDD VSS eeg_afe_nand3 s=1
XDP4 DP4 NP4 VDD VSS eeg_afe_inv s=1
XDN4 DN4 NN4 VDD VSS eeg_afe_inv s=1
XRDP4 DP4 BP4 VSS ppolyf_u_1k r_length=65.53u r_width=1u
XRDN4 DN4 BN4 VSS ppolyf_u_1k r_length=65.53u r_width=1u
XNA4 NA4 EN0 M4 VDD VSS eeg_afe_nand2 s=1
XCLP4 BP4 NA4 VSS VSS nfet_03v3 W=3u L=0.28u nf=1 m=1
XCLN4 BN4 NA4 VSS VSS nfet_03v3 W=3u L=0.28u nf=1 m=1
XCOFP4 TP0 BP4 cap_mim_2f0ff c_length=21.73u c_width=21.73u
XCOFN4 TN0 BN4 cap_mim_2f0ff c_length=21.73u c_width=21.73u
* bit 5: 1.92 pF per side, group 0, R 33.85 kohm, driver x1, clamp W 6 um
XNP5 NP5 EN0 M5 XB VDD VSS eeg_afe_nand3 s=1
XNN5 NN5 EN0 M5 X VDD VSS eeg_afe_nand3 s=1
XDP5 DP5 NP5 VDD VSS eeg_afe_inv s=1
XDN5 DN5 NN5 VDD VSS eeg_afe_inv s=1
XRDP5 DP5 BP5 VSS ppolyf_u_1k r_length=32.68u r_width=1u
XRDN5 DN5 BN5 VSS ppolyf_u_1k r_length=32.68u r_width=1u
XNA5 NA5 EN0 M5 VDD VSS eeg_afe_nand2 s=1
XCLP5 BP5 NA5 VSS VSS nfet_03v3 W=6u L=0.28u nf=1 m=1
XCLN5 BN5 NA5 VSS VSS nfet_03v3 W=6u L=0.28u nf=1 m=1
XCOFP5 TP0 BP5 cap_mim_2f0ff c_length=30.82u c_width=30.82u
XCOFN5 TN0 BN5 cap_mim_2f0ff c_length=30.82u c_width=30.82u
* bit 6: 3.84 pF per side, group 0, R 16.93 kohm, driver x2, clamp W 12 um
XNP6 NP6 EN0 M6 XB VDD VSS eeg_afe_nand3 s=1
XNN6 NN6 EN0 M6 X VDD VSS eeg_afe_nand3 s=1
XDP6 DP6 NP6 VDD VSS eeg_afe_inv s=2
XDN6 DN6 NN6 VDD VSS eeg_afe_inv s=2
XRDP6 DP6 BP6 VSS ppolyf_u_1k r_length=16.26u r_width=1u
XRDN6 DN6 BN6 VSS ppolyf_u_1k r_length=16.26u r_width=1u
XNA6 NA6 EN0 M6 VDD VSS eeg_afe_nand2 s=1
XCLP6 BP6 NA6 VSS VSS nfet_03v3 W=12u L=0.28u nf=1 m=1
XCLN6 BN6 NA6 VSS VSS nfet_03v3 W=12u L=0.28u nf=1 m=1
XCOFP6 TP0 BP6 cap_mim_2f0ff c_length=43.69u c_width=43.69u
XCOFN6 TN0 BN6 cap_mim_2f0ff c_length=43.69u c_width=43.69u
* bit 7: 7.68 pF per side, group 1, R 8.464 kohm, driver x4, clamp W 24 um
XNP7 NP7 EN1 M7 XB VDD VSS eeg_afe_nand3 s=1
XNN7 NN7 EN1 M7 X VDD VSS eeg_afe_nand3 s=1
XDP7 DP7 NP7 VDD VSS eeg_afe_inv s=4
XDN7 DN7 NN7 VDD VSS eeg_afe_inv s=4
XRDP7 DP7 BP7 VSS ppolyf_u_1k r_length=8.04u r_width=1u
XRDN7 DN7 BN7 VSS ppolyf_u_1k r_length=8.04u r_width=1u
XNA7 NA7 EN1 M7 VDD VSS eeg_afe_nand2 s=1
XCLP7 BP7 NA7 VSS VSS nfet_03v3 W=24u L=0.28u nf=2 m=1
XCLN7 BN7 NA7 VSS VSS nfet_03v3 W=24u L=0.28u nf=2 m=1
XCOFP7 TP1 BP7 cap_mim_2f0ff c_length=61.88u c_width=61.88u
XCOFN7 TN1 BN7 cap_mim_2f0ff c_length=61.88u c_width=61.88u
* bit 8: 15.36 pF per side, group 2, R 4.232 kohm, driver x8, clamp W 48 um
XNP8 NP8 EN2 M8 XB VDD VSS eeg_afe_nand3 s=2
XNN8 NN8 EN2 M8 X VDD VSS eeg_afe_nand3 s=2
XDP8 DP8 NP8 VDD VSS eeg_afe_inv s=8
XDN8 DN8 NN8 VDD VSS eeg_afe_inv s=8
XRDP8 DP8 BP8 VSS ppolyf_u_1k r_length=3.94u r_width=1u
XRDN8 DN8 BN8 VSS ppolyf_u_1k r_length=3.94u r_width=1u
XNA8 NA8 EN2 M8 VDD VSS eeg_afe_nand2 s=1
XCLP8 BP8 NA8 VSS VSS nfet_03v3 W=48u L=0.28u nf=4 m=1
XCLN8 BN8 NA8 VSS VSS nfet_03v3 W=48u L=0.28u nf=4 m=1
XCOFP8 TP2 BP8 cap_mim_2f0ff c_length=87.62u c_width=87.62u
XCOFN8 TN2 BN8 cap_mim_2f0ff c_length=87.62u c_width=87.62u
* bit 9: 30.72 pF per side, group 3, R 2.116 kohm, driver x16, clamp W 96 um
XNP9 NP9 EN3 M9 XB VDD VSS eeg_afe_nand3 s=4
XNN9 NN9 EN3 M9 X VDD VSS eeg_afe_nand3 s=4
XDP9 DP9 NP9 VDD VSS eeg_afe_inv s=16
XDN9 DN9 NN9 VDD VSS eeg_afe_inv s=16
XRDP9 DP9 BP9 VSS ppolyf_u_1k r_length=1.88u r_width=1u
XRDN9 DN9 BN9 VSS ppolyf_u_1k r_length=1.88u r_width=1u
XNA9 NA9 EN3 M9 VDD VSS eeg_afe_nand2 s=1
XCLP9 BP9 NA9 VSS VSS nfet_03v3 W=96u L=0.28u nf=9 m=1
XCLN9 BN9 NA9 VSS VSS nfet_03v3 W=96u L=0.28u nf=9 m=1
XCOFP9_0 TP3 BP9 cap_mim_2f0ff c_length=87.62u c_width=87.62u
XCOFP9_1 TP3 BP9 cap_mim_2f0ff c_length=87.62u c_width=87.62u
XCOFN9_0 TN3 BN9 cap_mim_2f0ff c_length=87.62u c_width=87.62u
XCOFN9_1 TN3 BN9 cap_mim_2f0ff c_length=87.62u c_width=87.62u
.ends eeg_afe_offdac
* s: strength (W and finger count scale with s)
.subckt eeg_afe_inv Y A VDD VSS s=1
XP Y A VDD VDD pfet_03v3 W={2.5u*s} L=0.28u nf={s} m=1
XN Y A VSS VSS nfet_03v3 W={1u*s} L=0.28u nf={s} m=1
.ends eeg_afe_inv
.subckt eeg_afe_nand2 Y A B VDD VSS s=1
XPA Y A VDD VDD pfet_03v3 W={2.5u*s} L=0.28u nf={s} m=1
XPB Y B VDD VDD pfet_03v3 W={2.5u*s} L=0.28u nf={s} m=1
XNA Y A M1 VSS nfet_03v3 W={2u*s} L=0.28u nf={s} m=1
XNB M1 B VSS VSS nfet_03v3 W={2u*s} L=0.28u nf={s} m=1
.ends eeg_afe_nand2
.subckt eeg_afe_nand3 Y A B C VDD VSS s=1
XPA Y A VDD VDD pfet_03v3 W={2.5u*s} L=0.28u nf={s} m=1
XPB Y B VDD VDD pfet_03v3 W={2.5u*s} L=0.28u nf={s} m=1
XPC Y C VDD VDD pfet_03v3 W={2.5u*s} L=0.28u nf={s} m=1
XNA Y A M1 VSS nfet_03v3 W={3u*s} L=0.28u nf={s} m=1
XNB M1 B M2 VSS nfet_03v3 W={3u*s} L=0.28u nf={s} m=1
XNC M2 C VSS VSS nfet_03v3 W={3u*s} L=0.28u nf={s} m=1
.ends eeg_afe_nand3
.subckt eeg_afe_tg A Y G GN VDD VSS
XN A G Y VSS nfet_03v3 W=1u L=0.28u nf=1 m=1
XP A GN Y VDD pfet_03v3 W=2u L=0.28u nf=1 m=1
.ends eeg_afe_tg

* Cpf trim: 27.3/54.5/109/218 fF per side (MIM; bit 0 is two smallest MIM caps in series),
* switched at the amplifier-output plate
.subckt eeg_afe_cpftrim WP WN OPI ONI VCM B0 B1 B2 B3 VDD VSS
XIB0 BN0 B0 VDD VSS eeg_afe_inv s=1
XCTP0A WP MP0 cap_mim_2f0ff c_length=5u c_width=5u
XCTP0B MP0 XP0 cap_mim_2f0ff c_length=5u c_width=5u
XTPO0 XP0 OPI B0 BN0 VDD VSS eeg_afe_tg
XTPV0 XP0 VCM BN0 B0 VDD VSS eeg_afe_tg
XCTN0A WN MN0 cap_mim_2f0ff c_length=5u c_width=5u
XCTN0B MN0 XN0 cap_mim_2f0ff c_length=5u c_width=5u
XTNO0 XN0 ONI B0 BN0 VDD VSS eeg_afe_tg
XTNV0 XN0 VCM BN0 B0 VDD VSS eeg_afe_tg
XIB1 BN1 B1 VDD VSS eeg_afe_inv s=1
XCTP1 WP XP1 cap_mim_2f0ff c_length=5u c_width=5u
XTPO1 XP1 OPI B1 BN1 VDD VSS eeg_afe_tg
XTPV1 XP1 VCM BN1 B1 VDD VSS eeg_afe_tg
XCTN1 WN XN1 cap_mim_2f0ff c_length=5u c_width=5u
XTNO1 XN1 ONI B1 BN1 VDD VSS eeg_afe_tg
XTNV1 XN1 VCM BN1 B1 VDD VSS eeg_afe_tg
XIB2 BN2 B2 VDD VSS eeg_afe_inv s=1
XCTP2 WP XP2 cap_mim_2f0ff c_length=7.17u c_width=7.17u
XTPO2 XP2 OPI B2 BN2 VDD VSS eeg_afe_tg
XTPV2 XP2 VCM BN2 B2 VDD VSS eeg_afe_tg
XCTN2 WN XN2 cap_mim_2f0ff c_length=7.17u c_width=7.17u
XTNO2 XN2 ONI B2 BN2 VDD VSS eeg_afe_tg
XTNV2 XN2 VCM BN2 B2 VDD VSS eeg_afe_tg
XIB3 BN3 B3 VDD VSS eeg_afe_inv s=1
XCTP3 WP XP3 cap_mim_2f0ff c_length=10.23u c_width=10.23u
XTPO3 XP3 OPI B3 BN3 VDD VSS eeg_afe_tg
XTPV3 XP3 VCM BN3 B3 VDD VSS eeg_afe_tg
XCTN3 WN XN3 cap_mim_2f0ff c_length=10.23u c_width=10.23u
XTNO3 XN3 ONI B3 BN3 VDD VSS eeg_afe_tg
XTNV3 XN3 VCM BN3 B3 VDD VSS eeg_afe_tg
.ends eeg_afe_cpftrim

* Cin, one side: 32 cap_mim_2f0ff of 99.7 um square in parallel (636 pF),
* the array of gf180/tapeout/layout/mim_arrays_lay.py. TOP: amplifier input, BOT: chopper side.
.subckt eeg_cin TOP BOT
XC0 TOP BOT cap_mim_2f0ff c_length=99.7u c_width=99.7u
XC1 TOP BOT cap_mim_2f0ff c_length=99.7u c_width=99.7u
XC2 TOP BOT cap_mim_2f0ff c_length=99.7u c_width=99.7u
XC3 TOP BOT cap_mim_2f0ff c_length=99.7u c_width=99.7u
XC4 TOP BOT cap_mim_2f0ff c_length=99.7u c_width=99.7u
XC5 TOP BOT cap_mim_2f0ff c_length=99.7u c_width=99.7u
XC6 TOP BOT cap_mim_2f0ff c_length=99.7u c_width=99.7u
XC7 TOP BOT cap_mim_2f0ff c_length=99.7u c_width=99.7u
XC8 TOP BOT cap_mim_2f0ff c_length=99.7u c_width=99.7u
XC9 TOP BOT cap_mim_2f0ff c_length=99.7u c_width=99.7u
XC10 TOP BOT cap_mim_2f0ff c_length=99.7u c_width=99.7u
XC11 TOP BOT cap_mim_2f0ff c_length=99.7u c_width=99.7u
XC12 TOP BOT cap_mim_2f0ff c_length=99.7u c_width=99.7u
XC13 TOP BOT cap_mim_2f0ff c_length=99.7u c_width=99.7u
XC14 TOP BOT cap_mim_2f0ff c_length=99.7u c_width=99.7u
XC15 TOP BOT cap_mim_2f0ff c_length=99.7u c_width=99.7u
XC16 TOP BOT cap_mim_2f0ff c_length=99.7u c_width=99.7u
XC17 TOP BOT cap_mim_2f0ff c_length=99.7u c_width=99.7u
XC18 TOP BOT cap_mim_2f0ff c_length=99.7u c_width=99.7u
XC19 TOP BOT cap_mim_2f0ff c_length=99.7u c_width=99.7u
XC20 TOP BOT cap_mim_2f0ff c_length=99.7u c_width=99.7u
XC21 TOP BOT cap_mim_2f0ff c_length=99.7u c_width=99.7u
XC22 TOP BOT cap_mim_2f0ff c_length=99.7u c_width=99.7u
XC23 TOP BOT cap_mim_2f0ff c_length=99.7u c_width=99.7u
XC24 TOP BOT cap_mim_2f0ff c_length=99.7u c_width=99.7u
XC25 TOP BOT cap_mim_2f0ff c_length=99.7u c_width=99.7u
XC26 TOP BOT cap_mim_2f0ff c_length=99.7u c_width=99.7u
XC27 TOP BOT cap_mim_2f0ff c_length=99.7u c_width=99.7u
XC28 TOP BOT cap_mim_2f0ff c_length=99.7u c_width=99.7u
XC29 TOP BOT cap_mim_2f0ff c_length=99.7u c_width=99.7u
XC30 TOP BOT cap_mim_2f0ff c_length=99.7u c_width=99.7u
XC31 TOP BOT cap_mim_2f0ff c_length=99.7u c_width=99.7u
.ends eeg_cin

* AFE top: input chopper TGs, Cin, Cf, Cpf, reset switches, DC path, offset DAC,
* amplifier, output chopper TGs
.subckt eeg_afe ELP ELN OUTP OUTN VCM VBN VBCM BLP BLN RST CIA NCIA CIB NCIB CDA NCDA CDB NCDB
+ OFPH OFS OFM0 OFM1 OFM2 OFM3 OFM4 OFM5 OFM6 OFM7 OFM8 OFM9 OFEN0 OFEN1 OFEN2 OFEN3 CPF0 CPF1 CPF2 CPF3 VDD VSS
XCINP INP WP eeg_cin
XCINN INN WN eeg_cin
XCFBP INP ONI cap_mim_2f0ff c_length=31.46u c_width=31.46u
XCFBN INN OPI cap_mim_2f0ff c_length=31.46u c_width=31.46u
XCPFP WP OPI cap_mim_2f0ff c_length=30.92u c_width=30.92u
XCPFN WN ONI cap_mim_2f0ff c_length=30.92u c_width=30.92u
XCPF WP WN OPI ONI VCM CPF0 CPF1 CPF2 CPF3 VDD VSS eeg_afe_cpftrim
XRSTP INP RST ONI VSS nfet_03v3 W=1u L=1u nf=1 m=1 ad=.5p as=.5p pd=3u ps=3u nrd=.5 nrs=.5
XRSTN INN RST OPI VSS nfet_03v3 W=1u L=1u nf=1 m=1 ad=.5p as=.5p pd=3u ps=3u nrd=.5 nrs=.5
* INP/INN DC path: switched-capacitor resistor to the opposite output (parallel to Cf),
* 54.52 fF per side (the smallest MIM cap), one transfer per chopper period
* (about 143 Mohm at 128 kHz)
XSCP1 INP CIA SCP VSS nfet_03v3 W=0.5u L=0.28u nf=1 m=1
XSCP2 SCP CIB ONI VSS nfet_03v3 W=0.5u L=0.28u nf=1 m=1
XCSCP SCP VSS cap_mim_2f0ff c_length=5u c_width=5u
XSCN1 INN CIA SCN VSS nfet_03v3 W=0.5u L=0.28u nf=1 m=1
XSCN2 SCN CIB OPI VSS nfet_03v3 W=0.5u L=0.28u nf=1 m=1
XCSCN SCN VSS cap_mim_2f0ff c_length=5u c_width=5u
XOFF INP INN VCM OFPH OFS OFM0 OFM1 OFM2 OFM3 OFM4 OFM5 OFM6 OFM7 OFM8 OFM9 OFEN0 OFEN1 OFEN2 OFEN3 VDD VSS eeg_afe_offdac
XAMP ELP ELN WP WN INP INN OPI ONI OUTP OUTN VCM VBN VBCM BLP BLN VBP CIA NCIA CIB NCIB CDA NCDA CDB NCDB VDD VSS eeg_afe_amp
* hold capacitors for output-chopper blanking (CDA/CDB low for 7 MCLK after each edge)
XCHOLDP_0 OUTP VSS cap_mim_2f0ff c_length=86.58u c_width=86.58u
XCHOLDP_1 OUTP VSS cap_mim_2f0ff c_length=86.58u c_width=86.58u
XCHOLDN_0 OUTN VSS cap_mim_2f0ff c_length=86.58u c_width=86.58u
XCHOLDN_1 OUTN VSS cap_mim_2f0ff c_length=86.58u c_width=86.58u
.ends eeg_afe
