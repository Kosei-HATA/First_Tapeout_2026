* Hybrid CT feedback smoke test. No ADC SNDR/ENOB claim.
.include /Volumes/mukiebi/Codex/gf180_ishi_env_20261015/native_runtime/pdk/gf180mcuD/libs.tech/ngspice/design.ngspice
.lib /Volumes/mukiebi/Codex/gf180_ishi_env_20261015/native_runtime/pdk/gf180mcuD/libs.tech/ngspice/sm141064.ngspice typical
.include quantizer.spice
.include otas.spice
.include afe_model.spice
.temp 27
.options sparse method=trap maxord=2 reltol=1e-6 vntol=1e-10 abstol=3e-13 bypass=0 keepopinfo
VDD_SRC VDD 0 3.3
VADC_SUPPLY VDD adc_vdd 0
VAFE_SUPPLY VDD af_vdd 0
VCM CM 0 1.65
VBN1 VBN1 0 .85
VNC1 VNC1 0 2
VPC1 VPC1 0 1.7
VBCM1 VBCM1 0 .82
VREF VREF 0 PWL(0 0 6.2988281250000002e-05 0 6.2993281249999999e-05 .5)
VRESET RESET_TARGET 0 PWL(0 3.3 6.2888281249999999e-05 3.3 6.2893281249999997e-05 0)
ENRESET NRESET_TARGET 0 adc_vdd RESET_TARGET 1
RRESET RESET_TARGET RESET 1000
RNRESET NRESET_TARGET NRESET 1000
VDRESET DRESET 0 PWL(0 3.3 6.2938281250000001e-05 3.3 6.2943281249999998e-05 0)
VLOAD LOAD 0 PULSE(0 3.3 6.3964843750000003e-05 2n 2n 30n 9.765625e-07)
BIA_DRV CIA_DRV 0 V=3.2999999999999998+(-3.2999999999999998)*.5*(1+tanh((time-(7.1286562499999997e-05))/(1.8204784532536748e-09)))+(3.2999999999999998)*.5*(1+tanh((time-(7.9114062499999996e-05))/(1.8204784532536748e-09)))+(-3.2999999999999998)*.5*(1+tanh((time-(8.6911562500000011e-05))/(1.8204784532536748e-09)))+(3.2999999999999998)*.5*(1+tanh((time-(9.473906250000001e-05))/(1.8204784532536748e-09)))
ENCIA NCIA_DRV 0 adc_vdd CIA_DRV 1
BIB_DRV CIB_DRV 0 V=0+(3.2999999999999998)*.5*(1+tanh((time-(7.1301562500000003e-05))/(1.8204784532536748e-09)))+(-3.2999999999999998)*.5*(1+tanh((time-(7.9099062500000004e-05))/(1.8204784532536748e-09)))+(3.2999999999999998)*.5*(1+tanh((time-(8.6926562500000003e-05))/(1.8204784532536748e-09)))+(-3.2999999999999998)*.5*(1+tanh((time-(9.4724062500000004e-05))/(1.8204784532536748e-09)))
ENCIB NCIB_DRV 0 adc_vdd CIB_DRV 1
BDA_DRV CDA_DRV 0 V=3.2999999999999998+(-3.2999999999999998)*.5*(1+tanh((time-(7.13065625e-05))/(1.8204784532536748e-09)))+(3.2999999999999998)*.5*(1+tanh((time-(7.9094062500000006e-05))/(1.8204784532536748e-09)))+(-3.2999999999999998)*.5*(1+tanh((time-(8.69315625e-05))/(1.8204784532536748e-09)))+(3.2999999999999998)*.5*(1+tanh((time-(9.4719062500000007e-05))/(1.8204784532536748e-09)))
ENCDA NCDA_DRV 0 adc_vdd CDA_DRV 1
BDB_DRV CDB_DRV 0 V=0+(3.2999999999999998)*.5*(1+tanh((time-(7.1281562499999999e-05))/(1.8204784532536748e-09)))+(-3.2999999999999998)*.5*(1+tanh((time-(7.9119062499999993e-05))/(1.8204784532536748e-09)))+(3.2999999999999998)*.5*(1+tanh((time-(8.69065625e-05))/(1.8204784532536748e-09)))+(-3.2999999999999998)*.5*(1+tanh((time-(9.4744062500000007e-05))/(1.8204784532536748e-09)))
ENCDB NCDB_DRV 0 adc_vdd CDB_DRV 1
RDRV_CIA CIA_DRV CIA 10
RDRV_NCIA NCIA_DRV NCIA 10
RDRV_CIB CIB_DRV CIB 10
RDRV_NCIB NCIB_DRV NCIB 10
RDRV_CDA CDA_DRV CDA 10
RDRV_NCDA NCDA_DRV NCDA 10
RDRV_CDB CDB_DRV CDB 10
RDRV_NCDB NCDB_DRV NCDB 10
XOTA1 I1P I1N O1P O1N CM VBN1 VNC1 VPC1 VBCM1 CIA NCIA CIB NCIB CDA NCDA CDB NCDB adc_vdd 0 gf180_inside_cascode_ota
XOTA2 I2P I2N O2P O2N CM VBN1 VNC1 VPC1 VBCM1 adc_vdd 0 gf180_ct_ota_tel16_cmfb CCOMP=10p
RINP VINP I1P 9375
RINN VINN I1N 9375
RD1P DAC1P I1P {300000/31}
RD1N DAC1N I1N {300000/31}
C1P O1N I1P 6.8051376829979684e-10
C1N O1P I1N 6.8051376829979684e-10
RF1P O1N I1P 1T
RF1N O1P I1N 1T
R21P O1P I2P 1Meg
R21N O1N I2N 1Meg
RD2P DAC2P I2P {320000000/3/31}
RD2N DAC2N I2N {320000000/3/31}
C2P O2N I2P 1.953125p
C2N O2P I2N 1.953125p
RF2P O2N I2P 1T
RF2N O2P I2N 1T
CL1P O1P 0 4p
CL1N O1N 0 4p
CL2P O2P 0 4p
CL2N O2N 0 4p
.subckt rst_tg A B G GN adc_vdd VSS
XN A G B VSS nfet_03v3 W=1u L=.28u nf=1
XP A GN B adc_vdd pfet_03v3 W=2u L=.28u nf=1
.ends rst_tg
XR1P O1N I1P RESET NRESET adc_vdd 0 rst_tg
XR1N O1P I1N RESET NRESET adc_vdd 0 rst_tg
XR2P O2N I2P RESET NRESET adc_vdd 0 rst_tg
XR2N O2P I2N RESET NRESET adc_vdd 0 rst_tg
XQ O2P O2N DLOAD DRESET_EVENT adc_vdd 0 SEL0 SEL1 SEL2 SEL3 SEL4 SEL5 SEL6 SEL7 SEL8 SEL9 SEL10 SEL11 SEL12 SEL13 SEL14 SEL15 SEL16 SEL17 SEL18 SEL19 SEL20 SEL21 SEL22 SEL23 SEL24 SEL25 SEL26 SEL27 SEL28 SEL29 SEL30 SELN0 SELN1 SELN2 SELN3 SELN4 SELN5 SELN6 SELN7 SELN8 SELN9 SELN10 SELN11 SELN12 SELN13 SELN14 SELN15 SELN16 SELN17 SELN18 SELN19 SELN20 SELN21 SELN22 SELN23 SELN24 SELN25 SELN26 SELN27 SELN28 SELN29 SELN30 S2L0 S2L1 S2L2 S2L3 S2L4 S2L5 S2L6 S2L7 S2L8 S2L9 S2L10 S2L11 S2L12 S2L13 S2L14 S2L15 S2L16 S2L17 S2L18 S2L19 S2L20 S2L21 S2L22 S2L23 S2L24 S2L25 S2L26 S2L27 S2L28 S2L29 S2L30 S2LN0 S2LN1 S2LN2 S2LN3 S2LN4 S2LN5 S2LN6 S2LN7 S2LN8 S2LN9 S2LN10 S2LN11 S2LN12 S2LN13 S2LN14 S2LN15 S2LN16 S2LN17 S2LN18 S2LN19 S2LN20 S2LN21 S2LN22 S2LN23 S2LN24 S2LN25 S2LN26 S2LN27 S2LN28 S2LN29 S2LN30 ct_quantizer5_event
AEVENT [DLOAD DRESET_EVENT] CLOCK_EVENTS
.model CLOCK_EVENTS d_source(input_file="events.txt")
ESUM1 NORM1 0 POLY(31) SEL0 0 SEL1 0 SEL2 0 SEL3 0 SEL4 0 SEL5 0 SEL6 0 SEL7 0 SEL8 0 SEL9 0 SEL10 0 SEL11 0 SEL12 0 SEL13 0 SEL14 0 SEL15 0 SEL16 0 SEL17 0 SEL18 0 SEL19 0 SEL20 0 SEL21 0 SEL22 0 SEL23 0 SEL24 0 SEL25 0 SEL26 0 SEL27 0 SEL28 0 SEL29 0 SEL30 0 -.5 0.0097751710654936461 0.0097751710654936461 0.0097751710654936461 0.0097751710654936461 0.0097751710654936461 0.0097751710654936461 0.0097751710654936461 0.0097751710654936461 0.0097751710654936461 0.0097751710654936461 0.0097751710654936461 0.0097751710654936461 0.0097751710654936461 0.0097751710654936461 0.0097751710654936461 0.0097751710654936461 0.0097751710654936461 0.0097751710654936461 0.0097751710654936461 0.0097751710654936461 0.0097751710654936461 0.0097751710654936461 0.0097751710654936461 0.0097751710654936461 0.0097751710654936461 0.0097751710654936461 0.0097751710654936461 0.0097751710654936461 0.0097751710654936461 0.0097751710654936461 0.0097751710654936461
EDAC1P DAC1P CM POLY(2) NORM1 0 VREF 0 0 0 0 0 1
EDAC1N DAC1N CM DAC1P CM -1
ESUM2 NORM2 0 POLY(31) S2L0 0 S2L1 0 S2L2 0 S2L3 0 S2L4 0 S2L5 0 S2L6 0 S2L7 0 S2L8 0 S2L9 0 S2L10 0 S2L11 0 S2L12 0 S2L13 0 S2L14 0 S2L15 0 S2L16 0 S2L17 0 S2L18 0 S2L19 0 S2L20 0 S2L21 0 S2L22 0 S2L23 0 S2L24 0 S2L25 0 S2L26 0 S2L27 0 S2L28 0 S2L29 0 S2L30 0 -.5 0.0097751710654936461 0.0097751710654936461 0.0097751710654936461 0.0097751710654936461 0.0097751710654936461 0.0097751710654936461 0.0097751710654936461 0.0097751710654936461 0.0097751710654936461 0.0097751710654936461 0.0097751710654936461 0.0097751710654936461 0.0097751710654936461 0.0097751710654936461 0.0097751710654936461 0.0097751710654936461 0.0097751710654936461 0.0097751710654936461 0.0097751710654936461 0.0097751710654936461 0.0097751710654936461 0.0097751710654936461 0.0097751710654936461 0.0097751710654936461 0.0097751710654936461 0.0097751710654936461 0.0097751710654936461 0.0097751710654936461 0.0097751710654936461 0.0097751710654936461 0.0097751710654936461
EDAC2P DAC2P CM POLY(2) NORM2 0 VREF 0 0 0 0 0 1
EDAC2N DAC2N CM DAC2P CM -1
* AFE CPF206 retained with namespace separation; only physical output-port connection added.
VAFE_BN af_vbn 0 .8485
VAFE_BCM af_vbcm 0 .82
VAFE_NC af_vnc 0 2.2
VAFE_PC af_vpc 0 1.1
VAFE_SIG af_sig 0 DC 0 PWL(0 0 3.0000000000000001e-05 0 3.0003124999999999e-05 2.2713553433033351e-06 3.0006250000000001e-05 9.0635469796082857e-06 3.0009374999999999e-05 2.0311162390467534e-05 3.0012500000000001e-05 3.5905880890902481e-05 3.0015624999999999e-05 5.5697516816813648e-05 3.0018750000000001e-05 7.949546589502583e-05 3.0021875e-05 0.00010707054086663348 3.0025000000000001e-05 0.00013815717868559076 3.0028125e-05 0.00017245599803601626 3.0031250000000002e-05 0.00020963668253792342 3.0034375e-05 0.00024934116187452933 3.0037500000000002e-05 0.00029118706020514625 3.0040625e-05 0.00033477137865355549 3.0043750000000002e-05 0.0003796743764074866 3.0046875e-05 0.00042546361305209396 3.0050000000000002e-05 0.00047169811320754707 3.0053125e-05 0.00051793261336300028 3.0056250000000002e-05 0.00056372185000760759 3.0059375000000001e-05 0.00060862484776153859 3.0062500000000002e-05 0.00065220916620994788 3.0065625000000001e-05 0.0006940550645405649 3.0068750000000002e-05 0.00073375954387717068 3.0071875000000001e-05 0.00077094022837907793 3.0074999999999999e-05 0.00080523904772950342 3.0078125000000001e-05 0.00083632568554846073 3.0081249999999999e-05 0.00086390076052006849 3.0084375000000001e-05 0.00088769870959828055 3.0087499999999999e-05 0.00090749034552419178 3.0090625000000001e-05 0.00092308506402462667 3.009375e-05 0.00093433267943548591 3.0096875000000001e-05 0.00094112487107179076 3.01e-05 0.00094339622641509424 9.0000000000000006e-05 0.00094339622641509424 9.0003125000000001e-05 0.0009388535157284876 9.0006250000000009e-05 0.00092526913245587769 9.0009375000000004e-05 0.0009027739016341592 9.0012499999999999e-05 0.00087158446463328932 9.0015625000000008e-05 0.00083200119278146697 9.0018750000000003e-05 0.00078440529462504263 9.0021875000000011e-05 0.00072925514468182733 9.0025000000000006e-05 0.00066708186904391271 9.0028125000000001e-05 0.00059848423034306172 9.003125000000001e-05 0.00052412286133924745 9.0034375000000005e-05 0.00044471390266603557 9.00375e-05 0.00036102210600480174 9.0040625000000008e-05 0.00027385346910798326 9.0043750000000003e-05 0.00018404747360012104 9.0046875000000012e-05 9.2469000310906328e-05 9.0050000000000007e-05 1.0842021724855044e-19 9.0053125000000002e-05 -9.2469000310906328e-05 9.005625000000001e-05 -0.00018404747360012093 9.0059375000000005e-05 -0.00027385346910798294 9.00625e-05 -0.00036102210600480152 9.0065625000000009e-05 -0.00044471390266603557 9.0068750000000004e-05 -0.00052412286133924713 9.0071874999999999e-05 -0.00059848423034306161 9.0075000000000007e-05 -0.0006670818690439126 9.0078125000000002e-05 -0.00072925514468182723 9.0081250000000011e-05 -0.00078440529462504274 9.0084375000000006e-05 -0.00083200119278146686 9.0087500000000001e-05 -0.00087158446463328932 9.009062500000001e-05 -0.0009027739016341591 9.0093750000000005e-05 -0.00092526913245587759 9.0096875e-05 -0.00093885351572848728 9.0100000000000008e-05 -0.00094339622641509424 0.00014999999999999999 -0.00094339622641509424 0.000150003125 -0.00094112487107179087 0.00015000624999999998 -0.00093433267943548591 0.00015000937499999999 -0.00092308506402462667 0.00015001249999999999 -0.00090749034552419178 0.00015001562499999998 -0.00088769870959828055 0.00015001874999999998 -0.00086390076052006838 0.00015002187499999999 -0.00083632568554846073 0.00015002499999999997 -0.00080523904772950342 0.00015002812499999998 -0.00077094022837907793 0.00015003124999999999 -0.00073375954387717079 0.000150034375 -0.0006940550645405649 0.00015003749999999998 -0.00065220916620994799 0.00015004062499999999 -0.0006086248477615388 0.00015004375 -0.00056372185000760759 0.00015004687499999998 -0.00051793261336300028 0.00015004999999999999 -0.00047169811320754717 0.000150053125 -0.00042546361305209396 0.00015005624999999998 -0.00037967437640748665 0.00015005937499999999 -0.00033477137865355565 0.0001500625 -0.00029118706020514636 0.00015006562499999998 -0.00024934116187452933 0.00015006874999999999 -0.00020963668253792356 0.00015007187499999999 -0.00017245599803601631 0.00015007499999999998 -0.00013815717868559082 0.00015007812499999998 -0.00010707054086663351 0.00015008124999999999 -7.9495465895025748e-05 0.00015008437499999997 -5.5697516816813689e-05 0.00015008749999999998 -3.5905880890902461e-05 0.00015009062499999999 -2.0311162390467571e-05 0.00015009375 -9.0635469796083263e-06 0.00015009687499999998 -2.2713553433034803e-06 0.00015009999999999999 0 0.00020000000000000001 0)
EAFE_P af_src_p CM af_sig 0 .5
EAFE_N af_src_n CM af_sig 0 -.5
RAFE_SP af_src_p af_vinp 50000
RAFE_SN af_src_n af_vinn 50000
CAFE_INP af_wp af_inp 636p
CAFE_INN af_wn af_inn 636p
CAFE_FBP af_oni af_inp 2p
CAFE_FBN af_opi af_inn 2p
CAFE_PFP af_wp af_opi 2.06p
CAFE_PFN af_wn af_oni 2.06p
CAFE_LOADP af_outp 0 4p
CAFE_LOADN af_outn 0 4p
XAFE_DUT af_vinp af_vinn af_wp af_wn af_inp af_inn af_opi af_oni af_outp af_outn CM af_vbn af_vbcm af_vnc af_vpc af_vbp af_cia af_ncia af_cib af_ncib af_cda af_ncda af_cdb af_ncdb af_vdd 0 gf180_ccia_local_feedback
VAFE_CIA af_cia_drv 0 DC 3.2999999999999998 PWL(0 3.2999999999999998 1.5621000000000002e-05 3.2999999999999998 1.5621250000000002e-05 3.26829571266533 1.5621500000000003e-05 3.1744012286436227 1.562175e-05 3.0219248602991997 1.5622000000000001e-05 2.8167261889578032 1.5622250000000001e-05 2.5666908844823433 1.5622500000000002e-05 2.2814276634023982 1.5622750000000002e-05 1.9718990313266118 1.5623000000000003e-05 1.6499999999999999 1.562325e-05 1.3281009686733884 1.56235e-05 1.018572336597602 1.5623750000000001e-05 0.73330911551765676 1.5624000000000002e-05 0.48327381104219669 1.5624250000000002e-05 0.27807513970080017 1.5624499999999999e-05 0.12559877135637687 1.562475e-05 0.03170428733466979 1.5625e-05 0 2.3438499999999999e-05 0 2.343875e-05 0.03170428733466979 2.3439e-05 0.12559877135637687 2.3439250000000001e-05 0.27807513970080033 2.3439499999999998e-05 0.48327381104219647 2.3439749999999999e-05 0.73330911551765621 2.3439999999999999e-05 1.0185723365976018 2.344025e-05 1.3281009686733882 2.34405e-05 1.6499999999999997 2.3440750000000001e-05 1.9718990313266114 2.3441000000000001e-05 2.2814276634023978 2.3441250000000002e-05 2.5666908844823433 2.3441500000000002e-05 2.8167261889578032 2.344175e-05 3.0219248602991997 2.3442e-05 3.1744012286436227 2.3442250000000001e-05 3.26829571266533 2.3442500000000001e-05 3.2999999999999998 3.1245999999999999e-05 3.2999999999999998 3.1246249999999996e-05 3.26829571266533 3.12465e-05 3.1744012286436227 3.1246749999999997e-05 3.0219248602991997 3.1247000000000001e-05 2.8167261889578032 3.1247249999999998e-05 2.5666908844823433 3.1247500000000002e-05 2.2814276634023982 3.1247749999999999e-05 1.9718990313266118 3.1247999999999996e-05 1.6499999999999999 3.124825e-05 1.3281009686733884 3.1248499999999997e-05 1.018572336597602 3.1248750000000001e-05 0.73330911551765676 3.1248999999999998e-05 0.48327381104219669 3.1249250000000002e-05 0.27807513970080017 3.12495e-05 0.12559877135637687 3.1249750000000003e-05 0.03170428733466979 3.1250000000000001e-05 0 3.9063500000000003e-05 0 3.906375e-05 0.03170428733466979 3.9064000000000004e-05 0.12559877135637687 3.9064250000000001e-05 0.27807513970080033 3.9064499999999998e-05 0.48327381104219647 3.9064750000000002e-05 0.73330911551765621 3.9065e-05 1.0185723365976018 3.9065250000000003e-05 1.3281009686733882 3.9065500000000001e-05 1.6499999999999997 3.9065749999999998e-05 1.9718990313266114 3.9066000000000002e-05 2.2814276634023978 3.9066249999999999e-05 2.5666908844823433 3.9066500000000003e-05 2.8167261889578032 3.906675e-05 3.0219248602991997 3.9066999999999997e-05 3.1744012286436227 3.9067250000000001e-05 3.26829571266533 3.9067499999999998e-05 3.2999999999999998 4.6870999999999999e-05 3.2999999999999998 4.6871249999999996e-05 3.26829571266533 4.68715e-05 3.1744012286436227 4.6871749999999997e-05 3.0219248602991997 4.6872000000000001e-05 2.8167261889578032 4.6872249999999998e-05 2.5666908844823433 4.6872500000000002e-05 2.2814276634023982 4.6872749999999999e-05 1.9718990313266118 4.6872999999999997e-05 1.6499999999999999 4.6873250000000001e-05 1.3281009686733884 4.6873499999999998e-05 1.018572336597602 4.6873750000000002e-05 0.73330911551765676 4.6873999999999999e-05 0.48327381104219669 4.6874250000000003e-05 0.27807513970080017 4.68745e-05 0.12559877135637687 4.6874750000000004e-05 0.03170428733466979 4.6875000000000001e-05 0 5.4688500000000003e-05 0 5.468875e-05 0.03170428733466979 5.4689000000000004e-05 0.12559877135637687 5.4689250000000002e-05 0.27807513970080033 5.4689499999999999e-05 0.48327381104219647 5.4689750000000003e-05 0.73330911551765621 5.469e-05 1.0185723365976018 5.4690250000000004e-05 1.3281009686733882 5.4690500000000001e-05 1.6499999999999997 5.4690749999999998e-05 1.9718990313266114 5.4691000000000002e-05 2.2814276634023978 5.4691249999999999e-05 2.5666908844823433 5.4691500000000003e-05 2.8167261889578032 5.469175e-05 3.0219248602991997 5.4691999999999997e-05 3.1744012286436227 5.4692250000000001e-05 3.26829571266533 5.4692499999999999e-05 3.2999999999999998 6.2496000000000006e-05 3.2999999999999998 6.249625000000001e-05 3.26829571266533 6.24965e-05 3.1744012286436227 6.2496750000000004e-05 3.0219248602991997 6.2497000000000008e-05 2.8167261889578032 6.2497249999999999e-05 2.5666908844823433 6.2497500000000003e-05 2.2814276634023982 6.2497750000000007e-05 1.9718990313266118 6.2497999999999997e-05 1.6499999999999999 6.2498250000000001e-05 1.3281009686733884 6.2498500000000005e-05 1.018572336597602 6.2498750000000009e-05 0.73330911551765676 6.2498999999999999e-05 0.48327381104219669 6.2499250000000003e-05 0.27807513970080017 6.2499500000000007e-05 0.12559877135637687 6.2499749999999997e-05 0.03170428733466979 6.2500000000000001e-05 0 7.031350000000001e-05 0 7.0313750000000014e-05 0.03170428733466979 7.0314000000000005e-05 0.12559877135637687 7.0314250000000009e-05 0.27807513970080033 7.0314500000000013e-05 0.48327381104219647 7.0314750000000003e-05 0.73330911551765621 7.0315000000000007e-05 1.0185723365976018 7.0315250000000011e-05 1.3281009686733882 7.0315500000000001e-05 1.6499999999999997 7.0315750000000005e-05 1.9718990313266114 7.0316000000000009e-05 2.2814276634023978 7.0316250000000013e-05 2.5666908844823433 7.0316500000000003e-05 2.8167261889578032 7.0316750000000007e-05 3.0219248602991997 7.0317000000000011e-05 3.1744012286436227 7.0317250000000002e-05 3.26829571266533 7.0317500000000006e-05 3.2999999999999998 7.8121000000000006e-05 3.2999999999999998 7.812125000000001e-05 3.26829571266533 7.8121500000000001e-05 3.1744012286436227 7.8121750000000005e-05 3.0219248602991997 7.8122000000000009e-05 2.8167261889578032 7.8122249999999999e-05 2.5666908844823433 7.8122500000000003e-05 2.2814276634023982 7.8122750000000007e-05 1.9718990313266118 7.8123000000000011e-05 1.6499999999999999 7.8123250000000001e-05 1.3281009686733884 7.8123500000000005e-05 1.018572336597602 7.8123750000000009e-05 0.73330911551765676 7.8123999999999999e-05 0.48327381104219669 7.8124250000000003e-05 0.27807513970080017 7.8124500000000007e-05 0.12559877135637687 7.8124749999999998e-05 0.03170428733466979 7.8125000000000002e-05 0 8.5938499999999997e-05 0 8.5938750000000001e-05 0.03170428733466979 8.5938999999999992e-05 0.12559877135637687 8.5939249999999995e-05 0.27807513970080033 8.5939499999999999e-05 0.48327381104219647 8.593974999999999e-05 0.73330911551765621 8.5939999999999994e-05 1.0185723365976018 8.5940249999999998e-05 1.3281009686733882 8.5940499999999988e-05 1.6499999999999997 8.5940749999999992e-05 1.9718990313266114 8.5940999999999996e-05 2.2814276634023978 8.594125e-05 2.5666908844823433 8.594149999999999e-05 2.8167261889578032 8.5941749999999994e-05 3.0219248602991997 8.5941999999999998e-05 3.1744012286436227 8.5942249999999988e-05 3.26829571266533 8.5942499999999992e-05 3.2999999999999998 9.3746000000000007e-05 3.2999999999999998 9.3746250000000011e-05 3.26829571266533 9.3746500000000001e-05 3.1744012286436227 9.3746750000000005e-05 3.0219248602991997 9.3747000000000009e-05 2.8167261889578032 9.3747249999999999e-05 2.5666908844823433 9.3747500000000003e-05 2.2814276634023982 9.3747750000000007e-05 1.9718990313266118 9.3747999999999998e-05 1.6499999999999999 9.3748250000000002e-05 1.3281009686733884 9.3748500000000005e-05 1.018572336597602 9.3748750000000009e-05 0.73330911551765676 9.3749e-05 0.48327381104219669 9.3749250000000004e-05 0.27807513970080017 9.3749500000000008e-05 0.12559877135637687 9.3749749999999998e-05 0.03170428733466979 9.3750000000000002e-05 0 0.00010156350000000001 0 0.00010156375000000002 0.03170428733466979 0.00010156400000000001 0.12559877135637687 0.00010156425000000001 0.27807513970080033 0.00010156450000000001 0.48327381104219647 0.00010156475 0.73330911551765621 0.00010156500000000001 1.0185723365976018 0.00010156525000000001 1.3281009686733882 0.0001015655 1.6499999999999997 0.00010156575000000001 1.9718990313266114 0.00010156600000000001 2.2814276634023978 0.00010156625000000001 2.5666908844823433 0.0001015665 2.8167261889578032 0.00010156675000000001 3.0219248602991997 0.00010156700000000001 3.1744012286436227 0.00010156725 3.26829571266533 0.00010156750000000001 3.2999999999999998 0.00010937100000000001 3.2999999999999998 0.00010937125000000001 3.26829571266533 0.0001093715 3.1744012286436227 0.00010937175000000001 3.0219248602991997 0.00010937200000000001 2.8167261889578032 0.00010937225 2.5666908844823433 0.0001093725 2.2814276634023982 0.00010937275000000001 1.9718990313266118 0.00010937300000000001 1.6499999999999999 0.00010937325 1.3281009686733884 0.00010937350000000001 1.018572336597602 0.00010937375000000001 0.73330911551765676 0.000109374 0.48327381104219669 0.00010937425 0.27807513970080017 0.00010937450000000001 0.12559877135637687 0.00010937475 0.03170428733466979 0.000109375 0 0.0001171885 0 0.00011718875 0.03170428733466979 0.00011718899999999999 0.12559877135637687 0.00011718925 0.27807513970080033 0.0001171895 0.48327381104219647 0.00011718974999999999 0.73330911551765621 0.00011718999999999999 1.0185723365976018 0.00011719025 1.3281009686733882 0.00011719049999999999 1.6499999999999997 0.00011719074999999999 1.9718990313266114 0.000117191 2.2814276634023978 0.00011719125 2.5666908844823433 0.00011719149999999999 2.8167261889578032 0.00011719174999999999 3.0219248602991997 0.000117192 3.1744012286436227 0.00011719224999999999 3.26829571266533 0.00011719249999999999 3.2999999999999998 0.00012499599999999999 3.2999999999999998 0.00012499625 3.26829571266533 0.0001249965 3.1744012286436227 0.00012499675000000001 3.0219248602991997 0.00012499700000000001 2.8167261889578032 0.00012499724999999999 2.5666908844823433 0.00012499749999999999 2.2814276634023982 0.00012499774999999999 1.9718990313266118 0.000124998 1.6499999999999999 0.00012499825 1.3281009686733884 0.00012499850000000001 1.018572336597602 0.00012499875000000001 0.73330911551765676 0.00012499899999999999 0.48327381104219669 0.00012499924999999999 0.27807513970080017 0.00012499949999999999 0.12559877135637687 0.00012499975 0.03170428733466979 0.000125 0 0.0001328135 0 0.00013281375 0.03170428733466979 0.00013281400000000001 0.12559877135637687 0.00013281425000000001 0.27807513970080033 0.00013281449999999999 0.48327381104219647 0.00013281474999999999 0.73330911551765621 0.00013281499999999999 1.0185723365976018 0.00013281525 1.3281009686733882 0.0001328155 1.6499999999999997 0.00013281575000000001 1.9718990313266114 0.00013281600000000001 2.2814276634023978 0.00013281625000000001 2.5666908844823433 0.00013281650000000002 2.8167261889578032 0.00013281675 3.0219248602991997 0.000132817 3.1744012286436227 0.00013281725 3.26829571266533 0.00013281750000000001 3.2999999999999998 0.00014062100000000001 3.2999999999999998 0.00014062125000000001 3.26829571266533 0.00014062150000000002 3.1744012286436227 0.00014062175000000002 3.0219248602991997 0.00014062200000000002 2.8167261889578032 0.00014062225 2.5666908844823433 0.0001406225 2.2814276634023982 0.00014062275000000001 1.9718990313266118 0.00014062300000000001 1.6499999999999999 0.00014062325000000002 1.3281009686733884 0.00014062350000000002 1.018572336597602 0.00014062375000000002 0.73330911551765676 0.000140624 0.48327381104219669 0.00014062425 0.27807513970080017 0.00014062450000000001 0.12559877135637687 0.00014062475000000001 0.03170428733466979 0.00014062500000000002 0 0.00014843849999999998 0 0.00014843874999999999 0.03170428733466979 0.00014843899999999999 0.12559877135637687 0.00014843925 0.27807513970080033 0.0001484395 0.48327381104219647 0.00014843974999999998 0.73330911551765621 0.00014843999999999998 1.0185723365976018 0.00014844024999999999 1.3281009686733882 0.00014844049999999999 1.6499999999999997 0.00014844074999999999 1.9718990313266114 0.000148441 2.2814276634023978 0.00014844125 2.5666908844823433 0.00014844149999999998 2.8167261889578032 0.00014844174999999998 3.0219248602991997 0.00014844199999999999 3.1744012286436227 0.00014844224999999999 3.26829571266533 0.00014844249999999999 3.2999999999999998 0.00015624599999999999 3.2999999999999998 0.00015624625 3.26829571266533 0.0001562465 3.1744012286436227 0.00015624675000000001 3.0219248602991997 0.00015624699999999998 2.8167261889578032 0.00015624724999999999 2.5666908844823433 0.00015624749999999999 2.2814276634023982 0.00015624774999999999 1.9718990313266118 0.000156248 1.6499999999999999 0.00015624825 1.3281009686733884 0.00015624850000000001 1.018572336597602 0.00015624875000000001 0.73330911551765676 0.00015624900000000001 0.48327381104219669 0.00015624924999999999 0.27807513970080017 0.0001562495 0.12559877135637687 0.00015624975 0.03170428733466979 0.00015625 0 0.0001640635 0 0.00016406375 0.03170428733466979 0.00016406400000000001 0.12559877135637687 0.00016406425000000001 0.27807513970080033 0.00016406450000000001 0.48327381104219647 0.00016406474999999999 0.73330911551765621 0.000164065 1.0185723365976018 0.00016406525 1.3281009686733882 0.0001640655 1.6499999999999997 0.00016406575000000001 1.9718990313266114 0.00016406600000000001 2.2814276634023978 0.00016406625000000002 2.5666908844823433 0.00016406649999999999 2.8167261889578032 0.00016406675 3.0219248602991997 0.000164067 3.1744012286436227 0.00016406725 3.26829571266533 0.00016406750000000001 3.2999999999999998 0.00017187099999999998 3.2999999999999998 0.00017187124999999999 3.26829571266533 0.00017187149999999999 3.1744012286436227 0.00017187174999999999 3.0219248602991997 0.000171872 2.8167261889578032 0.00017187224999999997 2.5666908844823433 0.00017187249999999998 2.2814276634023982 0.00017187274999999998 1.9718990313266118 0.00017187299999999999 1.6499999999999999 0.00017187324999999999 1.3281009686733884 0.00017187349999999999 1.018572336597602 0.00017187375 0.73330911551765676 0.00017187399999999997 0.48327381104219669 0.00017187424999999998 0.27807513970080017 0.00017187449999999998 0.12559877135637687 0.00017187474999999999 0.03170428733466979 0.00017187499999999999 0 0.00017968849999999999 0 0.00017968874999999999 0.03170428733466979 0.00017968899999999999 0.12559877135637687 0.00017968925 0.27807513970080033 0.00017968949999999997 0.48327381104219647 0.00017968974999999998 0.73330911551765621 0.00017968999999999998 1.0185723365976018 0.00017969024999999999 1.3281009686733882 0.00017969049999999999 1.6499999999999997 0.00017969074999999999 1.9718990313266114 0.000179691 2.2814276634023978 0.00017969125 2.5666908844823433 0.00017969150000000001 2.8167261889578032 0.00017969174999999998 3.0219248602991997 0.00017969199999999999 3.1744012286436227 0.00017969224999999999 3.26829571266533 0.00017969249999999999 3.2999999999999998 0.000187496 3.2999999999999998 0.00018749625 3.26829571266533 0.0001874965 3.1744012286436227 0.00018749675000000001 3.0219248602991997 0.00018749700000000001 2.8167261889578032 0.00018749724999999999 2.5666908844823433 0.00018749749999999999 2.2814276634023982 0.00018749775 1.9718990313266118 0.000187498 1.6499999999999999 0.00018749825 1.3281009686733884 0.00018749850000000001 1.018572336597602 0.00018749875000000001 0.73330911551765676 0.00018749899999999999 0.48327381104219669 0.00018749924999999999 0.27807513970080017 0.0001874995 0.12559877135637687 0.00018749975 0.03170428733466979 0.0001875 0 0.0001953135 0 0.00019531375 0.03170428733466979 0.00019531400000000001 0.12559877135637687 0.00019531425000000001 0.27807513970080033 0.00019531449999999999 0.48327381104219647 0.00019531474999999999 0.73330911551765621 0.000195315 1.0185723365976018 0.00019531525 1.3281009686733882 0.0001953155 1.6499999999999997 0.00019531575000000001 1.9718990313266114 0.00019531600000000001 2.2814276634023978 0.00019531625000000002 2.5666908844823433 0.00019531650000000002 2.8167261889578032 0.00019531675 3.0219248602991997 0.000195317 3.1744012286436227 0.00019531725 3.26829571266533 0.00019531750000000001 3.2999999999999998 0.00020000000000000001 3.2999999999999998)
EAFE_NCIA af_ncia_drv 0 af_vdd af_cia_drv 1
VAFE_CIB af_cib_drv 0 DC 0 PWL(0 0 1.5625999999999999e-05 0 1.562625e-05 0.03170428733466979 1.56265e-05 0.12559877135637687 1.5626750000000001e-05 0.27807513970080033 1.5626999999999998e-05 0.48327381104219647 1.5627249999999998e-05 0.73330911551765621 1.5627499999999999e-05 1.0185723365976018 1.562775e-05 1.3281009686733882 1.5628e-05 1.6499999999999997 1.5628250000000001e-05 1.9718990313266114 1.5628500000000001e-05 2.2814276634023978 1.5628750000000002e-05 2.5666908844823433 1.5629000000000002e-05 2.8167261889578032 1.5629249999999999e-05 3.0219248602991997 1.56295e-05 3.1744012286436227 1.5629750000000001e-05 3.26829571266533 1.5630000000000001e-05 3.2999999999999998 2.3433500000000002e-05 3.2999999999999998 2.3433750000000002e-05 3.26829571266533 2.3434000000000003e-05 3.1744012286436227 2.343425e-05 3.0219248602991997 2.3434500000000001e-05 2.8167261889578032 2.3434750000000001e-05 2.5666908844823433 2.3435000000000002e-05 2.2814276634023982 2.3435250000000002e-05 1.9718990313266118 2.3435500000000003e-05 1.6499999999999999 2.343575e-05 1.3281009686733884 2.3436000000000001e-05 1.018572336597602 2.3436250000000001e-05 0.73330911551765676 2.3436500000000002e-05 0.48327381104219669 2.3436750000000002e-05 0.27807513970080017 2.3436999999999999e-05 0.12559877135637687 2.343725e-05 0.03170428733466979 2.34375e-05 0 3.1251000000000003e-05 0 3.125125e-05 0.03170428733466979 3.1251500000000004e-05 0.12559877135637687 3.1251750000000001e-05 0.27807513970080033 3.1252000000000005e-05 0.48327381104219647 3.1252250000000002e-05 0.73330911551765621 3.1252499999999999e-05 1.0185723365976018 3.1252750000000003e-05 1.3281009686733882 3.1253e-05 1.6499999999999997 3.1253249999999998e-05 1.9718990313266114 3.1253500000000002e-05 2.2814276634023978 3.1253749999999999e-05 2.5666908844823433 3.1253999999999996e-05 2.8167261889578032 3.125425e-05 3.0219248602991997 3.1254499999999997e-05 3.1744012286436227 3.1254750000000001e-05 3.26829571266533 3.1254999999999998e-05 3.2999999999999998 3.9058499999999999e-05 3.2999999999999998 3.9058749999999996e-05 3.26829571266533 3.9059e-05 3.1744012286436227 3.9059249999999997e-05 3.0219248602991997 3.9059500000000001e-05 2.8167261889578032 3.9059749999999998e-05 2.5666908844823433 3.9060000000000002e-05 2.2814276634023982 3.9060249999999999e-05 1.9718990313266118 3.9060500000000003e-05 1.6499999999999999 3.906075e-05 1.3281009686733884 3.9060999999999998e-05 1.018572336597602 3.9061250000000001e-05 0.73330911551765676 3.9061499999999999e-05 0.48327381104219669 3.9061750000000003e-05 0.27807513970080017 3.9062e-05 0.12559877135637687 3.9062250000000004e-05 0.03170428733466979 3.9062500000000001e-05 0 4.6876000000000003e-05 0 4.687625e-05 0.03170428733466979 4.6876500000000004e-05 0.12559877135637687 4.6876750000000001e-05 0.27807513970080033 4.6877000000000005e-05 0.48327381104219647 4.6877250000000003e-05 0.73330911551765621 4.68775e-05 1.0185723365976018 4.6877750000000004e-05 1.3281009686733882 4.6878000000000001e-05 1.6499999999999997 4.6878249999999998e-05 1.9718990313266114 4.6878500000000002e-05 2.2814276634023978 4.6878749999999999e-05 2.5666908844823433 4.6878999999999996e-05 2.8167261889578032 4.687925e-05 3.0219248602991997 4.6879499999999997e-05 3.1744012286436227 4.6879750000000001e-05 3.26829571266533 4.6879999999999998e-05 3.2999999999999998 5.4683499999999999e-05 3.2999999999999998 5.4683749999999996e-05 3.26829571266533 5.4684e-05 3.1744012286436227 5.4684249999999997e-05 3.0219248602991997 5.4684500000000001e-05 2.8167261889578032 5.4684749999999998e-05 2.5666908844823433 5.4685000000000002e-05 2.2814276634023982 5.468525e-05 1.9718990313266118 5.4685500000000004e-05 1.6499999999999999 5.4685750000000001e-05 1.3281009686733884 5.4685999999999998e-05 1.018572336597602 5.4686250000000002e-05 0.73330911551765676 5.4686499999999999e-05 0.48327381104219669 5.4686750000000003e-05 0.27807513970080017 5.4687e-05 0.12559877135637687 5.4687250000000004e-05 0.03170428733466979 5.4687500000000001e-05 0 6.2501000000000003e-05 0 6.2501250000000007e-05 0.03170428733466979 6.2501499999999998e-05 0.12559877135637687 6.2501750000000002e-05 0.27807513970080033 6.2502000000000006e-05 0.48327381104219647 6.2502249999999996e-05 0.73330911551765621 6.25025e-05 1.0185723365976018 6.2502750000000004e-05 1.3281009686733882 6.2502999999999994e-05 1.6499999999999997 6.2503249999999998e-05 1.9718990313266114 6.2503500000000002e-05 2.2814276634023978 6.2503750000000006e-05 2.5666908844823433 6.2503999999999997e-05 2.8167261889578032 6.250425e-05 3.0219248602991997 6.2504500000000004e-05 3.1744012286436227 6.2504749999999995e-05 3.26829571266533 6.2504999999999999e-05 3.2999999999999998 7.0308500000000013e-05 3.2999999999999998 7.0308750000000017e-05 3.26829571266533 7.0309000000000007e-05 3.1744012286436227 7.0309250000000011e-05 3.0219248602991997 7.0309500000000015e-05 2.8167261889578032 7.0309750000000006e-05 2.5666908844823433 7.031000000000001e-05 2.2814276634023982 7.0310250000000013e-05 1.9718990313266118 7.0310500000000004e-05 1.6499999999999999 7.0310750000000008e-05 1.3281009686733884 7.0311000000000012e-05 1.018572336597602 7.0311250000000016e-05 0.73330911551765676 7.0311500000000006e-05 0.48327381104219669 7.031175000000001e-05 0.27807513970080017 7.0312000000000014e-05 0.12559877135637687 7.0312250000000004e-05 0.03170428733466979 7.0312500000000008e-05 0 7.8126000000000004e-05 0 7.8126250000000008e-05 0.03170428733466979 7.8126499999999998e-05 0.12559877135637687 7.8126750000000002e-05 0.27807513970080033 7.8127000000000006e-05 0.48327381104219647 7.8127249999999996e-05 0.73330911551765621 7.81275e-05 1.0185723365976018 7.8127750000000004e-05 1.3281009686733882 7.8128000000000008e-05 1.6499999999999997 7.8128249999999999e-05 1.9718990313266114 7.8128500000000003e-05 2.2814276634023978 7.8128750000000006e-05 2.5666908844823433 7.8128999999999997e-05 2.8167261889578032 7.8129250000000001e-05 3.0219248602991997 7.8129500000000005e-05 3.1744012286436227 7.8129749999999995e-05 3.26829571266533 7.8129999999999999e-05 3.2999999999999998 8.59335e-05 3.2999999999999998 8.5933750000000004e-05 3.26829571266533 8.5933999999999994e-05 3.1744012286436227 8.5934249999999998e-05 3.0219248602991997 8.5934500000000002e-05 2.8167261889578032 8.5934749999999992e-05 2.5666908844823433 8.5934999999999996e-05 2.2814276634023982 8.593525e-05 1.9718990313266118 8.5935499999999991e-05 1.6499999999999999 8.5935749999999995e-05 1.3281009686733884 8.5935999999999998e-05 1.018572336597602 8.5936250000000002e-05 0.73330911551765676 8.5936499999999993e-05 0.48327381104219669 8.5936749999999997e-05 0.27807513970080017 8.5937000000000001e-05 0.12559877135637687 8.5937249999999991e-05 0.03170428733466979 8.5937499999999995e-05 0 9.3751000000000004e-05 0 9.3751250000000008e-05 0.03170428733466979 9.3751499999999998e-05 0.12559877135637687 9.3751750000000002e-05 0.27807513970080033 9.3752000000000006e-05 0.48327381104219647 9.3752249999999997e-05 0.73330911551765621 9.3752500000000001e-05 1.0185723365976018 9.3752750000000005e-05 1.3281009686733882 9.3752999999999995e-05 1.6499999999999997 9.3753249999999999e-05 1.9718990313266114 9.3753500000000003e-05 2.2814276634023978 9.3753750000000007e-05 2.5666908844823433 9.3753999999999997e-05 2.8167261889578032 9.3754250000000001e-05 3.0219248602991997 9.3754500000000005e-05 3.1744012286436227 9.3754749999999995e-05 3.26829571266533 9.3754999999999999e-05 3.2999999999999998 0.00010155850000000001 3.2999999999999998 0.00010155875000000002 3.26829571266533 0.00010155900000000001 3.1744012286436227 0.00010155925000000001 3.0219248602991997 0.00010155950000000002 2.8167261889578032 0.00010155975000000001 2.5666908844823433 0.00010156000000000001 2.2814276634023982 0.00010156025000000001 1.9718990313266118 0.0001015605 1.6499999999999999 0.00010156075000000001 1.3281009686733884 0.00010156100000000001 1.018572336597602 0.00010156125000000002 0.73330911551765676 0.00010156150000000001 0.48327381104219669 0.00010156175000000001 0.27807513970080017 0.00010156200000000001 0.12559877135637687 0.00010156225 0.03170428733466979 0.00010156250000000001 0 0.000109376 0 0.00010937625000000001 0.03170428733466979 0.0001093765 0.12559877135637687 0.00010937675 0.27807513970080033 0.00010937700000000001 0.48327381104219647 0.00010937725 0.73330911551765621 0.0001093775 1.0185723365976018 0.00010937775 1.3281009686733882 0.00010937800000000001 1.6499999999999997 0.00010937825 1.9718990313266114 0.0001093785 2.2814276634023978 0.00010937875000000001 2.5666908844823433 0.000109379 2.8167261889578032 0.00010937925 3.0219248602991997 0.00010937950000000001 3.1744012286436227 0.00010937975 3.26829571266533 0.00010938 3.2999999999999998 0.0001171835 3.2999999999999998 0.00011718375 3.26829571266533 0.00011718399999999999 3.1744012286436227 0.00011718425 3.0219248602991997 0.0001171845 2.8167261889578032 0.00011718474999999999 2.5666908844823433 0.000117185 2.2814276634023982 0.00011718525 1.9718990313266118 0.00011718549999999999 1.6499999999999999 0.00011718575 1.3281009686733884 0.000117186 1.018572336597602 0.00011718625 0.73330911551765676 0.00011718649999999999 0.48327381104219669 0.00011718675 0.27807513970080017 0.000117187 0.12559877135637687 0.00011718724999999999 0.03170428733466979 0.0001171875 0 0.00012500099999999999 0 0.00012500125 0.03170428733466979 0.0001250015 0.12559877135637687 0.00012500175 0.27807513970080033 0.00012500199999999998 0.48327381104219647 0.00012500224999999998 0.73330911551765621 0.00012500249999999999 1.0185723365976018 0.00012500274999999999 1.3281009686733882 0.000125003 1.6499999999999997 0.00012500325 1.9718990313266114 0.0001250035 2.2814276634023978 0.00012500375000000001 2.5666908844823433 0.00012500400000000001 2.8167261889578032 0.00012500424999999999 3.0219248602991997 0.00012500449999999999 3.1744012286436227 0.00012500475 3.26829571266533 0.000125005 3.2999999999999998 0.0001328085 3.2999999999999998 0.00013280875 3.26829571266533 0.00013280900000000001 3.1744012286436227 0.00013280925000000001 3.0219248602991997 0.00013280950000000002 2.8167261889578032 0.00013280974999999999 2.5666908844823433 0.00013281 2.2814276634023982 0.00013281025 1.9718990313266118 0.00013281050000000001 1.6499999999999999 0.00013281075000000001 1.3281009686733884 0.00013281100000000001 1.018572336597602 0.00013281125000000002 0.73330911551765676 0.00013281149999999999 0.48327381104219669 0.00013281175 0.27807513970080017 0.000132812 0.12559877135637687 0.00013281225000000001 0.03170428733466979 0.00013281250000000001 0 0.00014062600000000001 0 0.00014062625000000001 0.03170428733466979 0.00014062650000000001 0.12559877135637687 0.00014062675000000002 0.27807513970080033 0.00014062699999999999 0.48327381104219647 0.00014062725 0.73330911551765621 0.0001406275 1.0185723365976018 0.00014062775000000001 1.3281009686733882 0.00014062800000000001 1.6499999999999997 0.00014062825000000001 1.9718990313266114 0.00014062850000000002 2.2814276634023978 0.00014062875000000002 2.5666908844823433 0.00014062900000000003 2.8167261889578032 0.00014062925 3.0219248602991997 0.00014062950000000001 3.1744012286436227 0.00014062975000000001 3.26829571266533 0.00014063000000000001 3.2999999999999998 0.00014843349999999999 3.2999999999999998 0.00014843374999999999 3.26829571266533 0.000148434 3.1744012286436227 0.00014843425 3.0219248602991997 0.00014843449999999998 2.8167261889578032 0.00014843474999999998 2.5666908844823433 0.00014843499999999998 2.2814276634023982 0.00014843524999999999 1.9718990313266118 0.00014843549999999999 1.6499999999999999 0.00014843575 1.3281009686733884 0.000148436 1.018572336597602 0.00014843625 0.73330911551765676 0.00014843650000000001 0.48327381104219669 0.00014843674999999998 0.27807513970080017 0.00014843699999999999 0.12559877135637687 0.00014843724999999999 0.03170428733466979 0.0001484375 0 0.00015625099999999999 0 0.00015625125 0.03170428733466979 0.0001562515 0.12559877135637687 0.00015625175 0.27807513970080033 0.00015625200000000001 0.48327381104219647 0.00015625224999999998 0.73330911551765621 0.00015625249999999999 1.0185723365976018 0.00015625274999999999 1.3281009686733882 0.000156253 1.6499999999999997 0.00015625325 1.9718990313266114 0.0001562535 2.2814276634023978 0.00015625375000000001 2.5666908844823433 0.00015625399999999998 2.8167261889578032 0.00015625424999999999 3.0219248602991997 0.00015625449999999999 3.1744012286436227 0.00015625475 3.26829571266533 0.000156255 3.2999999999999998 0.0001640585 3.2999999999999998 0.00016405875000000001 3.26829571266533 0.00016405900000000001 3.1744012286436227 0.00016405925000000001 3.0219248602991997 0.00016405949999999999 2.8167261889578032 0.00016405974999999999 2.5666908844823433 0.00016406 2.2814276634023982 0.00016406025 1.9718990313266118 0.00016406050000000001 1.6499999999999999 0.00016406075000000001 1.3281009686733884 0.00016406100000000001 1.018572336597602 0.00016406125000000002 0.73330911551765676 0.00016406150000000002 0.48327381104219669 0.00016406175 0.27807513970080017 0.000164062 0.12559877135637687 0.00016406225000000001 0.03170428733466979 0.00016406250000000001 0 0.00017187599999999998 0 0.00017187624999999998 0.03170428733466979 0.00017187649999999999 0.12559877135637687 0.00017187674999999999 0.27807513970080033 0.00017187699999999997 0.48327381104219647 0.00017187724999999997 0.73330911551765621 0.00017187749999999998 1.0185723365976018 0.00017187774999999998 1.3281009686733882 0.00017187799999999998 1.6499999999999997 0.00017187824999999999 1.9718990313266114 0.00017187849999999999 2.2814276634023978 0.00017187874999999999 2.5666908844823433 0.000171879 2.8167261889578032 0.00017187924999999998 3.0219248602991997 0.00017187949999999998 3.1744012286436227 0.00017187974999999998 3.26829571266533 0.00017187999999999999 3.2999999999999998 0.00017968349999999999 3.2999999999999998 0.00017968374999999999 3.26829571266533 0.000179684 3.1744012286436227 0.00017968425 3.0219248602991997 0.0001796845 2.8167261889578032 0.00017968474999999998 2.5666908844823433 0.00017968499999999998 2.2814276634023982 0.00017968524999999999 1.9718990313266118 0.00017968549999999999 1.6499999999999999 0.00017968575 1.3281009686733884 0.000179686 1.018572336597602 0.00017968625 0.73330911551765676 0.00017968649999999998 0.48327381104219669 0.00017968674999999999 0.27807513970080017 0.00017968699999999999 0.12559877135637687 0.00017968724999999999 0.03170428733466979 0.0001796875 0 0.00018750099999999999 0 0.00018750125 0.03170428733466979 0.0001875015 0.12559877135637687 0.00018750175 0.27807513970080033 0.00018750199999999998 0.48327381104219647 0.00018750224999999999 0.73330911551765621 0.00018750249999999999 1.0185723365976018 0.00018750274999999999 1.3281009686733882 0.000187503 1.6499999999999997 0.00018750325 1.9718990313266114 0.0001875035 2.2814276634023978 0.00018750375000000001 2.5666908844823433 0.00018750400000000001 2.8167261889578032 0.00018750424999999999 3.0219248602991997 0.00018750449999999999 3.1744012286436227 0.00018750475 3.26829571266533 0.000187505 3.2999999999999998 0.0001953085 3.2999999999999998 0.00019530875000000001 3.26829571266533 0.00019530900000000001 3.1744012286436227 0.00019530925000000001 3.0219248602991997 0.00019530950000000002 2.8167261889578032 0.00019530974999999999 2.5666908844823433 0.00019531 2.2814276634023982 0.00019531025 1.9718990313266118 0.00019531050000000001 1.6499999999999999 0.00019531075000000001 1.3281009686733884 0.00019531100000000001 1.018572336597602 0.00019531125000000002 0.73330911551765676 0.0001953115 0.48327381104219669 0.00019531175 0.27807513970080017 0.000195312 0.12559877135637687 0.00019531225000000001 0.03170428733466979 0.00019531250000000001 0 0.00020000000000000001 0)
EAFE_NCIB af_ncib_drv 0 af_vdd af_cib_drv 1
VAFE_CDA af_cda_drv 0 DC 3.2999999999999998 PWL(0 3.2999999999999998 1.5614999999999999e-05 3.2999999999999998 1.5615249999999999e-05 3.26829571266533 1.56155e-05 3.1744012286436227 1.561575e-05 3.0219248602991997 1.5616000000000001e-05 2.8167261889578032 1.5616249999999998e-05 2.5666908844823433 1.5616499999999999e-05 2.2814276634023982 1.5616749999999999e-05 1.9718990313266118 1.5617e-05 1.6499999999999999 1.561725e-05 1.3281009686733884 1.5617500000000001e-05 1.018572336597602 1.5617750000000001e-05 0.73330911551765676 1.5617999999999999e-05 0.48327381104219669 1.5618249999999999e-05 0.27807513970080017 1.56185e-05 0.12559877135637687 1.561875e-05 0.03170428733466979 1.5619000000000001e-05 0 2.3444499999999999e-05 0 2.3444749999999999e-05 0.03170428733466979 2.3445e-05 0.12559877135637687 2.3445250000000001e-05 0.27807513970080033 2.3445499999999998e-05 0.48327381104219647 2.3445749999999998e-05 0.73330911551765621 2.3445999999999999e-05 1.0185723365976018 2.3446249999999999e-05 1.3281009686733882 2.34465e-05 1.6499999999999997 2.344675e-05 1.9718990313266114 2.3447000000000001e-05 2.2814276634023978 2.3447250000000002e-05 2.5666908844823433 2.3447500000000002e-05 2.8167261889578032 2.3447749999999999e-05 3.0219248602991997 2.3448e-05 3.1744012286436227 2.344825e-05 3.26829571266533 2.3448500000000001e-05 3.2999999999999998 3.1239999999999999e-05 3.2999999999999998 3.1240249999999996e-05 3.26829571266533 3.12405e-05 3.1744012286436227 3.1240749999999997e-05 3.0219248602991997 3.1241000000000001e-05 2.8167261889578032 3.1241249999999998e-05 2.5666908844823433 3.1241500000000002e-05 2.2814276634023982 3.124175e-05 1.9718990313266118 3.1241999999999997e-05 1.6499999999999999 3.1242250000000001e-05 1.3281009686733884 3.1242499999999998e-05 1.018572336597602 3.1242750000000002e-05 0.73330911551765676 3.1242999999999999e-05 0.48327381104219669 3.1243250000000003e-05 0.27807513970080017 3.12435e-05 0.12559877135637687 3.1243750000000004e-05 0.03170428733466979 3.1244000000000001e-05 0 3.9069500000000003e-05 0 3.906975e-05 0.03170428733466979 3.9070000000000004e-05 0.12559877135637687 3.9070250000000001e-05 0.27807513970080033 3.9070499999999998e-05 0.48327381104219647 3.9070750000000002e-05 0.73330911551765621 3.9070999999999999e-05 1.0185723365976018 3.9071250000000003e-05 1.3281009686733882 3.90715e-05 1.6499999999999997 3.9071749999999997e-05 1.9718990313266114 3.9072000000000001e-05 2.2814276634023978 3.9072249999999998e-05 2.5666908844823433 3.9072500000000002e-05 2.8167261889578032 3.907275e-05 3.0219248602991997 3.9072999999999997e-05 3.1744012286436227 3.9073250000000001e-05 3.26829571266533 3.9073499999999998e-05 3.2999999999999998 4.6864999999999999e-05 3.2999999999999998 4.6865249999999997e-05 3.26829571266533 4.68655e-05 3.1744012286436227 4.6865749999999998e-05 3.0219248602991997 4.6866000000000002e-05 2.8167261889578032 4.6866249999999999e-05 2.5666908844823433 4.6866500000000003e-05 2.2814276634023982 4.686675e-05 1.9718990313266118 4.6866999999999997e-05 1.6499999999999999 4.6867250000000001e-05 1.3281009686733884 4.6867499999999998e-05 1.018572336597602 4.6867750000000002e-05 0.73330911551765676 4.6867999999999999e-05 0.48327381104219669 4.6868250000000003e-05 0.27807513970080017 4.68685e-05 0.12559877135637687 4.6868750000000004e-05 0.03170428733466979 4.6869000000000001e-05 0 5.4694500000000003e-05 0 5.469475e-05 0.03170428733466979 5.4695000000000004e-05 0.12559877135637687 5.4695250000000001e-05 0.27807513970080033 5.4695499999999998e-05 0.48327381104219647 5.4695750000000002e-05 0.73330911551765621 5.4695999999999999e-05 1.0185723365976018 5.4696250000000003e-05 1.3281009686733882 5.4696500000000001e-05 1.6499999999999997 5.4696749999999998e-05 1.9718990313266114 5.4697000000000002e-05 2.2814276634023978 5.4697249999999999e-05 2.5666908844823433 5.4697500000000003e-05 2.8167261889578032 5.469775e-05 3.0219248602991997 5.4697999999999997e-05 3.1744012286436227 5.4698250000000001e-05 3.26829571266533 5.4698499999999998e-05 3.2999999999999998 6.2490000000000006e-05 3.2999999999999998 6.249025000000001e-05 3.26829571266533 6.2490500000000001e-05 3.1744012286436227 6.2490750000000005e-05 3.0219248602991997 6.2491000000000009e-05 2.8167261889578032 6.2491249999999999e-05 2.5666908844823433 6.2491500000000003e-05 2.2814276634023982 6.2491750000000007e-05 1.9718990313266118 6.2492000000000011e-05 1.6499999999999999 6.2492250000000001e-05 1.3281009686733884 6.2492500000000005e-05 1.018572336597602 6.2492750000000009e-05 0.73330911551765676 6.2493e-05 0.48327381104219669 6.2493250000000003e-05 0.27807513970080017 6.2493500000000007e-05 0.12559877135637687 6.2493749999999998e-05 0.03170428733466979 6.2494000000000002e-05 0 7.031950000000001e-05 0 7.0319750000000014e-05 0.03170428733466979 7.0320000000000004e-05 0.12559877135637687 7.0320250000000008e-05 0.27807513970080033 7.0320500000000012e-05 0.48327381104219647 7.0320750000000003e-05 0.73330911551765621 7.0321000000000007e-05 1.0185723365976018 7.032125000000001e-05 1.3281009686733882 7.0321500000000014e-05 1.6499999999999997 7.0321750000000005e-05 1.9718990313266114 7.0322000000000009e-05 2.2814276634023978 7.0322250000000013e-05 2.5666908844823433 7.0322500000000003e-05 2.8167261889578032 7.0322750000000007e-05 3.0219248602991997 7.0323000000000011e-05 3.1744012286436227 7.0323250000000001e-05 3.26829571266533 7.0323500000000005e-05 3.2999999999999998 7.8115000000000007e-05 3.2999999999999998 7.8115250000000011e-05 3.26829571266533 7.8115500000000001e-05 3.1744012286436227 7.8115750000000005e-05 3.0219248602991997 7.8116000000000009e-05 2.8167261889578032 7.8116249999999999e-05 2.5666908844823433 7.8116500000000003e-05 2.2814276634023982 7.8116750000000007e-05 1.9718990313266118 7.8116999999999998e-05 1.6499999999999999 7.8117250000000002e-05 1.3281009686733884 7.8117500000000006e-05 1.018572336597602 7.8117750000000009e-05 0.73330911551765676 7.8118e-05 0.48327381104219669 7.8118250000000004e-05 0.27807513970080017 7.8118500000000008e-05 0.12559877135637687 7.8118749999999998e-05 0.03170428733466979 7.8119000000000002e-05 0 8.5944499999999997e-05 0 8.5944750000000001e-05 0.03170428733466979 8.5944999999999991e-05 0.12559877135637687 8.5945249999999995e-05 0.27807513970080033 8.5945499999999999e-05 0.48327381104219647 8.5945749999999989e-05 0.73330911551765621 8.5945999999999993e-05 1.0185723365976018 8.5946249999999997e-05 1.3281009686733882 8.5946500000000001e-05 1.6499999999999997 8.5946749999999992e-05 1.9718990313266114 8.5946999999999996e-05 2.2814276634023978 8.5947249999999999e-05 2.5666908844823433 8.594749999999999e-05 2.8167261889578032 8.5947749999999994e-05 3.0219248602991997 8.5947999999999998e-05 3.1744012286436227 8.5948249999999988e-05 3.26829571266533 8.5948499999999992e-05 3.2999999999999998 9.3740000000000007e-05 3.2999999999999998 9.3740250000000011e-05 3.26829571266533 9.3740500000000001e-05 3.1744012286436227 9.3740750000000005e-05 3.0219248602991997 9.3741000000000009e-05 2.8167261889578032 9.374125e-05 2.5666908844823433 9.3741500000000004e-05 2.2814276634023982 9.3741750000000008e-05 1.9718990313266118 9.3742000000000012e-05 1.6499999999999999 9.3742250000000002e-05 1.3281009686733884 9.3742500000000006e-05 1.018572336597602 9.374275000000001e-05 0.73330911551765676 9.3743e-05 0.48327381104219669 9.3743250000000004e-05 0.27807513970080017 9.3743500000000008e-05 0.12559877135637687 9.3743749999999998e-05 0.03170428733466979 9.3744000000000002e-05 0 0.00010156950000000001 0 0.00010156975000000001 0.03170428733466979 0.00010157000000000001 0.12559877135637687 0.00010157025000000001 0.27807513970080033 0.00010157050000000001 0.48327381104219647 0.00010157075 0.73330911551765621 0.00010157100000000001 1.0185723365976018 0.00010157125000000001 1.3281009686733882 0.00010157150000000002 1.6499999999999997 0.00010157175000000001 1.9718990313266114 0.00010157200000000001 2.2814276634023978 0.00010157225000000001 2.5666908844823433 0.0001015725 2.8167261889578032 0.00010157275000000001 3.0219248602991997 0.00010157300000000001 3.1744012286436227 0.00010157325 3.26829571266533 0.00010157350000000001 3.2999999999999998 0.00010936500000000001 3.2999999999999998 0.00010936525000000001 3.26829571266533 0.0001093655 3.1744012286436227 0.00010936575000000001 3.0219248602991997 0.00010936600000000001 2.8167261889578032 0.00010936625 2.5666908844823433 0.0001093665 2.2814276634023982 0.00010936675000000001 1.9718990313266118 0.000109367 1.6499999999999999 0.00010936725 1.3281009686733884 0.00010936750000000001 1.018572336597602 0.00010936775000000001 0.73330911551765676 0.000109368 0.48327381104219669 0.00010936825 0.27807513970080017 0.00010936850000000001 0.12559877135637687 0.00010936875 0.03170428733466979 0.000109369 0 0.0001171945 0 0.00011719475 0.03170428733466979 0.00011719499999999999 0.12559877135637687 0.00011719525 0.27807513970080033 0.0001171955 0.48327381104219647 0.00011719574999999999 0.73330911551765621 0.00011719599999999999 1.0185723365976018 0.00011719625 1.3281009686733882 0.0001171965 1.6499999999999997 0.00011719674999999999 1.9718990313266114 0.000117197 2.2814276634023978 0.00011719725 2.5666908844823433 0.00011719749999999999 2.8167261889578032 0.00011719774999999999 3.0219248602991997 0.000117198 3.1744012286436227 0.00011719824999999999 3.26829571266533 0.00011719849999999999 3.2999999999999998 0.00012499000000000001 3.2999999999999998 0.00012499025000000001 3.26829571266533 0.00012499050000000002 3.1744012286436227 0.00012499074999999999 3.0219248602991997 0.000124991 2.8167261889578032 0.00012499125 2.5666908844823433 0.0001249915 2.2814276634023982 0.00012499175000000001 1.9718990313266118 0.00012499199999999999 1.6499999999999999 0.00012499224999999999 1.3281009686733884 0.00012499249999999999 1.018572336597602 0.00012499275 0.73330911551765676 0.000124993 0.48327381104219669 0.00012499325 0.27807513970080017 0.00012499349999999998 0.12559877135637687 0.00012499374999999999 0.03170428733466979 0.00012499399999999999 0 0.00013281950000000001 0 0.00013281975000000002 0.03170428733466979 0.00013282000000000002 0.12559877135637687 0.00013282025000000002 0.27807513970080033 0.00013282050000000003 0.48327381104219647 0.00013282075 0.73330911551765621 0.00013282100000000001 1.0185723365976018 0.00013282125000000001 1.3281009686733882 0.00013282150000000002 1.6499999999999997 0.00013282175000000002 1.9718990313266114 0.00013282200000000002 2.2814276634023978 0.00013282225000000003 2.5666908844823433 0.0001328225 2.8167261889578032 0.00013282275000000001 3.0219248602991997 0.00013282300000000001 3.1744012286436227 0.00013282325000000002 3.26829571266533 0.00013282350000000002 3.2999999999999998 0.00014061500000000002 3.2999999999999998 0.00014061525000000003 3.26829571266533 0.00014061550000000003 3.1744012286436227 0.00014061575000000001 3.0219248602991997 0.00014061600000000001 2.8167261889578032 0.00014061625000000001 2.5666908844823433 0.00014061650000000002 2.2814276634023982 0.00014061675000000002 1.9718990313266118 0.000140617 1.6499999999999999 0.00014061725 1.3281009686733884 0.00014061750000000001 1.018572336597602 0.00014061775000000001 0.73330911551765676 0.00014061800000000001 0.48327381104219669 0.00014061825000000002 0.27807513970080017 0.0001406185 0.12559877135637687 0.00014061875 0.03170428733466979 0.000140619 0 0.0001484445 0 0.00014844475 0.03170428733466979 0.00014844500000000001 0.12559877135637687 0.00014844525000000001 0.27807513970080033 0.00014844549999999999 0.48327381104219647 0.00014844574999999999 0.73330911551765621 0.00014844599999999999 1.0185723365976018 0.00014844625 1.3281009686733882 0.0001484465 1.6499999999999997 0.00014844675000000001 1.9718990313266114 0.00014844700000000001 2.2814276634023978 0.00014844725000000001 2.5666908844823433 0.00014844750000000002 2.8167261889578032 0.00014844775 3.0219248602991997 0.000148448 3.1744012286436227 0.00014844825 3.26829571266533 0.00014844850000000001 3.2999999999999998 0.00015624000000000001 3.2999999999999998 0.00015624025000000001 3.26829571266533 0.00015624050000000002 3.1744012286436227 0.00015624074999999999 3.0219248602991997 0.000156241 2.8167261889578032 0.00015624125 2.5666908844823433 0.0001562415 2.2814276634023982 0.00015624175000000001 1.9718990313266118 0.00015624200000000001 1.6499999999999999 0.00015624224999999999 1.3281009686733884 0.00015624249999999999 1.018572336597602 0.00015624275 0.73330911551765676 0.000156243 0.48327381104219669 0.00015624325000000001 0.27807513970080017 0.00015624349999999998 0.12559877135637687 0.00015624374999999999 0.03170428733466979 0.00015624399999999999 0 0.00016406950000000001 0 0.00016406975000000002 0.03170428733466979 0.00016407000000000002 0.12559877135637687 0.00016407025000000002 0.27807513970080033 0.0001640705 0.48327381104219647 0.00016407075 0.73330911551765621 0.00016407100000000001 1.0185723365976018 0.00016407125000000001 1.3281009686733882 0.00016407150000000002 1.6499999999999997 0.00016407175000000002 1.9718990313266114 0.00016407200000000002 2.2814276634023978 0.00016407225000000003 2.5666908844823433 0.00016407250000000003 2.8167261889578032 0.00016407275000000001 3.0219248602991997 0.00016407300000000001 3.1744012286436227 0.00016407325000000002 3.26829571266533 0.00016407350000000002 3.2999999999999998 0.000171865 3.2999999999999998 0.00017186525 3.26829571266533 0.0001718655 3.1744012286436227 0.00017186574999999998 3.0219248602991997 0.00017186599999999998 2.8167261889578032 0.00017186624999999999 2.5666908844823433 0.00017186649999999999 2.2814276634023982 0.00017186675 1.9718990313266118 0.00017186699999999997 1.6499999999999999 0.00017186724999999998 1.3281009686733884 0.00017186749999999998 1.018572336597602 0.00017186774999999998 0.73330911551765676 0.00017186799999999999 0.48327381104219669 0.00017186824999999999 0.27807513970080017 0.00017186849999999997 0.12559877135637687 0.00017186874999999997 0.03170428733466979 0.00017186899999999998 0 0.0001796945 0 0.00017969475 0.03170428733466979 0.00017969500000000001 0.12559877135637687 0.00017969525000000001 0.27807513970080033 0.00017969550000000001 0.48327381104219647 0.00017969574999999999 0.73330911551765621 0.000179696 1.0185723365976018 0.00017969625 1.3281009686733882 0.0001796965 1.6499999999999997 0.00017969675000000001 1.9718990313266114 0.00017969700000000001 2.2814276634023978 0.00017969725000000001 2.5666908844823433 0.00017969749999999999 2.8167261889578032 0.00017969775 3.0219248602991997 0.000179698 3.1744012286436227 0.00017969825 3.26829571266533 0.00017969850000000001 3.2999999999999998 0.00018749000000000001 3.2999999999999998 0.00018749025000000001 3.26829571266533 0.00018749050000000002 3.1744012286436227 0.00018749074999999999 3.0219248602991997 0.000187491 2.8167261889578032 0.00018749125 2.5666908844823433 0.00018749150000000001 2.2814276634023982 0.00018749175000000001 1.9718990313266118 0.00018749199999999999 1.6499999999999999 0.00018749224999999999 1.3281009686733884 0.00018749249999999999 1.018572336597602 0.00018749275 0.73330911551765676 0.000187493 0.48327381104219669 0.00018749325000000001 0.27807513970080017 0.00018749349999999998 0.12559877135637687 0.00018749374999999999 0.03170428733466979 0.00018749399999999999 0 0.00019531950000000001 0 0.00019531975000000002 0.03170428733466979 0.00019532000000000002 0.12559877135637687 0.00019532025000000002 0.27807513970080033 0.00019532050000000003 0.48327381104219647 0.00019532075000000001 0.73330911551765621 0.00019532100000000001 1.0185723365976018 0.00019532125000000001 1.3281009686733882 0.00019532150000000002 1.6499999999999997 0.00019532175000000002 1.9718990313266114 0.00019532200000000002 2.2814276634023978 0.00019532225000000003 2.5666908844823433 0.00019532250000000001 2.8167261889578032 0.00019532275000000001 3.0219248602991997 0.00019532300000000001 3.1744012286436227 0.00019532325000000002 3.26829571266533 0.00019532350000000002 3.2999999999999998 0.00020000000000000001 3.2999999999999998)
EAFE_NCDA af_ncda_drv 0 af_vdd af_cda_drv 1
VAFE_CDB af_cdb_drv 0 DC 0 PWL(0 0 1.5631999999999999e-05 0 1.5632249999999999e-05 0.03170428733466979 1.56325e-05 0.12559877135637687 1.563275e-05 0.27807513970080033 1.5632999999999998e-05 0.48327381104219647 1.5633249999999998e-05 0.73330911551765621 1.5633499999999999e-05 1.0185723365976018 1.5633749999999999e-05 1.3281009686733882 1.5634e-05 1.6499999999999997 1.563425e-05 1.9718990313266114 1.5634500000000001e-05 2.2814276634023978 1.5634750000000001e-05 2.5666908844823433 1.5635000000000002e-05 2.8167261889578032 1.5635249999999999e-05 3.0219248602991997 1.56355e-05 3.1744012286436227 1.563575e-05 3.26829571266533 1.5636000000000001e-05 3.2999999999999998 2.3427499999999999e-05 3.2999999999999998 2.3427749999999999e-05 3.26829571266533 2.3428e-05 3.1744012286436227 2.3428250000000001e-05 3.0219248602991997 2.3428500000000001e-05 2.8167261889578032 2.3428749999999998e-05 2.5666908844823433 2.3428999999999999e-05 2.2814276634023982 2.3429249999999999e-05 1.9718990313266118 2.34295e-05 1.6499999999999999 2.342975e-05 1.3281009686733884 2.3430000000000001e-05 1.018572336597602 2.3430250000000002e-05 0.73330911551765676 2.3430499999999999e-05 0.48327381104219669 2.3430749999999999e-05 0.27807513970080017 2.3431e-05 0.12559877135637687 2.343125e-05 0.03170428733466979 2.3431500000000001e-05 0 3.1257000000000002e-05 0 3.125725e-05 0.03170428733466979 3.1257500000000004e-05 0.12559877135637687 3.1257750000000001e-05 0.27807513970080033 3.1258000000000005e-05 0.48327381104219647 3.1258250000000002e-05 0.73330911551765621 3.1258499999999999e-05 1.0185723365976018 3.1258750000000003e-05 1.3281009686733882 3.1259e-05 1.6499999999999997 3.1259249999999997e-05 1.9718990313266114 3.1259500000000001e-05 2.2814276634023978 3.1259749999999998e-05 2.5666908844823433 3.1259999999999995e-05 2.8167261889578032 3.1260249999999999e-05 3.0219248602991997 3.1260499999999997e-05 3.1744012286436227 3.1260750000000001e-05 3.26829571266533 3.1260999999999998e-05 3.2999999999999998 3.9052499999999999e-05 3.2999999999999998 3.9052749999999996e-05 3.26829571266533 3.9053e-05 3.1744012286436227 3.9053249999999997e-05 3.0219248602991997 3.9053500000000001e-05 2.8167261889578032 3.9053749999999999e-05 2.5666908844823433 3.9054000000000003e-05 2.2814276634023982 3.905425e-05 1.9718990313266118 3.9054500000000004e-05 1.6499999999999999 3.9054750000000001e-05 1.3281009686733884 3.9054999999999998e-05 1.018572336597602 3.9055250000000002e-05 0.73330911551765676 3.9055499999999999e-05 0.48327381104219669 3.9055750000000003e-05 0.27807513970080017 3.9056e-05 0.12559877135637687 3.9056250000000004e-05 0.03170428733466979 3.9056500000000001e-05 0 4.6882000000000003e-05 0 4.688225e-05 0.03170428733466979 4.6882500000000004e-05 0.12559877135637687 4.6882750000000001e-05 0.27807513970080033 4.6883000000000005e-05 0.48327381104219647 4.6883250000000002e-05 0.73330911551765621 4.6883499999999999e-05 1.0185723365976018 4.6883750000000003e-05 1.3281009686733882 4.6884e-05 1.6499999999999997 4.6884249999999998e-05 1.9718990313266114 4.6884500000000001e-05 2.2814276634023978 4.6884749999999999e-05 2.5666908844823433 4.6884999999999996e-05 2.8167261889578032 4.688525e-05 3.0219248602991997 4.6885499999999997e-05 3.1744012286436227 4.6885750000000001e-05 3.26829571266533 4.6885999999999998e-05 3.2999999999999998 5.46775e-05 3.2999999999999998 5.4677749999999997e-05 3.26829571266533 5.4678000000000001e-05 3.1744012286436227 5.4678249999999998e-05 3.0219248602991997 5.4678500000000002e-05 2.8167261889578032 5.4678749999999999e-05 2.5666908844823433 5.4679000000000003e-05 2.2814276634023982 5.467925e-05 1.9718990313266118 5.4679500000000004e-05 1.6499999999999999 5.4679750000000001e-05 1.3281009686733884 5.4679999999999998e-05 1.018572336597602 5.4680250000000002e-05 0.73330911551765676 5.4680499999999999e-05 0.48327381104219669 5.4680750000000003e-05 0.27807513970080017 5.4681e-05 0.12559877135637687 5.4681250000000004e-05 0.03170428733466979 5.4681500000000002e-05 0 6.2507000000000003e-05 0 6.2507250000000007e-05 0.03170428733466979 6.2507499999999997e-05 0.12559877135637687 6.2507750000000001e-05 0.27807513970080033 6.2508000000000005e-05 0.48327381104219647 6.2508249999999996e-05 0.73330911551765621 6.25085e-05 1.0185723365976018 6.2508750000000004e-05 1.3281009686733882 6.2509000000000007e-05 1.6499999999999997 6.2509249999999998e-05 1.9718990313266114 6.2509500000000002e-05 2.2814276634023978 6.2509750000000006e-05 2.5666908844823433 6.2509999999999996e-05 2.8167261889578032 6.251025e-05 3.0219248602991997 6.2510500000000004e-05 3.1744012286436227 6.2510749999999994e-05 3.26829571266533 6.2510999999999998e-05 3.2999999999999998 7.0302500000000013e-05 3.2999999999999998 7.0302750000000017e-05 3.26829571266533 7.0303000000000008e-05 3.1744012286436227 7.0303250000000012e-05 3.0219248602991997 7.0303500000000016e-05 2.8167261889578032 7.0303750000000006e-05 2.5666908844823433 7.030400000000001e-05 2.2814276634023982 7.0304250000000014e-05 1.9718990313266118 7.0304500000000018e-05 1.6499999999999999 7.0304750000000008e-05 1.3281009686733884 7.0305000000000012e-05 1.018572336597602 7.0305250000000016e-05 0.73330911551765676 7.0305500000000006e-05 0.48327381104219669 7.030575000000001e-05 0.27807513970080017 7.0306000000000014e-05 0.12559877135637687 7.0306250000000005e-05 0.03170428733466979 7.0306500000000009e-05 0 7.8132000000000003e-05 0 7.8132250000000007e-05 0.03170428733466979 7.8132499999999998e-05 0.12559877135637687 7.8132750000000002e-05 0.27807513970080033 7.8133000000000006e-05 0.48327381104219647 7.8133249999999996e-05 0.73330911551765621 7.81335e-05 1.0185723365976018 7.8133750000000004e-05 1.3281009686733882 7.8133999999999994e-05 1.6499999999999997 7.8134249999999998e-05 1.9718990313266114 7.8134500000000002e-05 2.2814276634023978 7.8134750000000006e-05 2.5666908844823433 7.8134999999999996e-05 2.8167261889578032 7.813525e-05 3.0219248602991997 7.8135500000000004e-05 3.1744012286436227 7.8135749999999995e-05 3.26829571266533 7.8135999999999999e-05 3.2999999999999998 8.59275e-05 3.2999999999999998 8.5927750000000004e-05 3.26829571266533 8.5927999999999995e-05 3.1744012286436227 8.5928249999999998e-05 3.0219248602991997 8.5928500000000002e-05 2.8167261889578032 8.5928749999999993e-05 2.5666908844823433 8.5928999999999997e-05 2.2814276634023982 8.5929250000000001e-05 1.9718990313266118 8.5929500000000005e-05 1.6499999999999999 8.5929749999999995e-05 1.3281009686733884 8.5929999999999999e-05 1.018572336597602 8.5930250000000003e-05 0.73330911551765676 8.5930499999999993e-05 0.48327381104219669 8.5930749999999997e-05 0.27807513970080017 8.5931000000000001e-05 0.12559877135637687 8.5931249999999991e-05 0.03170428733466979 8.5931499999999995e-05 0 9.3757000000000004e-05 0 9.3757250000000008e-05 0.03170428733466979 9.3757499999999998e-05 0.12559877135637687 9.3757750000000002e-05 0.27807513970080033 9.3758000000000006e-05 0.48327381104219647 9.3758249999999996e-05 0.73330911551765621 9.37585e-05 1.0185723365976018 9.3758750000000004e-05 1.3281009686733882 9.3759000000000008e-05 1.6499999999999997 9.3759249999999999e-05 1.9718990313266114 9.3759500000000002e-05 2.2814276634023978 9.3759750000000006e-05 2.5666908844823433 9.3759999999999997e-05 2.8167261889578032 9.3760250000000001e-05 3.0219248602991997 9.3760500000000005e-05 3.1744012286436227 9.3760749999999995e-05 3.26829571266533 9.3760999999999999e-05 3.2999999999999998 0.00010155250000000001 3.2999999999999998 0.00010155275000000002 3.26829571266533 0.00010155300000000001 3.1744012286436227 0.00010155325000000001 3.0219248602991997 0.00010155350000000002 2.8167261889578032 0.00010155375000000001 2.5666908844823433 0.00010155400000000001 2.2814276634023982 0.00010155425000000001 1.9718990313266118 0.00010155450000000002 1.6499999999999999 0.00010155475000000001 1.3281009686733884 0.00010155500000000001 1.018572336597602 0.00010155525000000002 0.73330911551765676 0.00010155550000000001 0.48327381104219669 0.00010155575000000001 0.27807513970080017 0.00010155600000000001 0.12559877135637687 0.00010155625000000001 0.03170428733466979 0.00010155650000000001 0 0.000109382 0 0.00010938225000000001 0.03170428733466979 0.0001093825 0.12559877135637687 0.00010938275 0.27807513970080033 0.00010938300000000001 0.48327381104219647 0.00010938325 0.73330911551765621 0.0001093835 1.0185723365976018 0.00010938375 1.3281009686733882 0.00010938399999999999 1.6499999999999997 0.00010938425 1.9718990313266114 0.0001093845 2.2814276634023978 0.00010938475000000001 2.5666908844823433 0.000109385 2.8167261889578032 0.00010938525 3.0219248602991997 0.0001093855 3.1744012286436227 0.00010938575 3.26829571266533 0.000109386 3.2999999999999998 0.0001171775 3.2999999999999998 0.00011717775 3.26829571266533 0.000117178 3.1744012286436227 0.00011717825 3.0219248602991997 0.0001171785 2.8167261889578032 0.00011717874999999999 2.5666908844823433 0.000117179 2.2814276634023982 0.00011717925 1.9718990313266118 0.00011717950000000001 1.6499999999999999 0.00011717975 1.3281009686733884 0.00011718 1.018572336597602 0.00011718025 0.73330911551765676 0.00011718049999999999 0.48327381104219669 0.00011718075 0.27807513970080017 0.000117181 0.12559877135637687 0.00011718124999999999 0.03170428733466979 0.0001171815 0 0.000125007 0 0.00012500725000000001 0.03170428733466979 0.00012500750000000001 0.12559877135637687 0.00012500775000000002 0.27807513970080033 0.00012500800000000002 0.48327381104219647 0.00012500825 0.73330911551765621 0.0001250085 1.0185723365976018 0.00012500875 1.3281009686733882 0.00012500900000000001 1.6499999999999997 0.00012500925000000001 1.9718990313266114 0.00012500950000000002 2.2814276634023978 0.00012500975000000002 2.5666908844823433 0.00012501 2.8167261889578032 0.00012501025 3.0219248602991997 0.00012501050000000001 3.1744012286436227 0.00012501075000000001 3.26829571266533 0.00012501100000000001 3.2999999999999998 0.00013280250000000001 3.2999999999999998 0.00013280275000000002 3.26829571266533 0.00013280300000000002 3.1744012286436227 0.00013280325 3.0219248602991997 0.0001328035 2.8167261889578032 0.00013280375000000001 2.5666908844823433 0.00013280400000000001 2.2814276634023982 0.00013280425000000002 1.9718990313266118 0.00013280449999999999 1.6499999999999999 0.00013280475 1.3281009686733884 0.000132805 1.018572336597602 0.00013280525 0.73330911551765676 0.00013280550000000001 0.48327381104219669 0.00013280575000000001 0.27807513970080017 0.00013280599999999999 0.12559877135637687 0.00013280624999999999 0.03170428733466979 0.0001328065 0 0.00014063200000000002 0 0.00014063225000000002 0.03170428733466979 0.00014063250000000003 0.12559877135637687 0.00014063275000000003 0.27807513970080033 0.00014063300000000003 0.48327381104219647 0.00014063325000000001 0.73330911551765621 0.00014063350000000001 1.0185723365976018 0.00014063375000000002 1.3281009686733882 0.00014063400000000002 1.6499999999999997 0.00014063425000000003 1.9718990313266114 0.00014063450000000003 2.2814276634023978 0.00014063475000000003 2.5666908844823433 0.00014063500000000001 2.8167261889578032 0.00014063525000000002 3.0219248602991997 0.00014063550000000002 3.1744012286436227 0.00014063575000000002 3.26829571266533 0.00014063600000000003 3.2999999999999998 0.0001484275 3.2999999999999998 0.00014842775000000001 3.26829571266533 0.00014842800000000001 3.1744012286436227 0.00014842824999999999 3.0219248602991997 0.00014842849999999999 2.8167261889578032 0.00014842874999999999 2.5666908844823433 0.000148429 2.2814276634023982 0.00014842925 1.9718990313266118 0.00014842950000000001 1.6499999999999999 0.00014842974999999998 1.3281009686733884 0.00014842999999999999 1.018572336597602 0.00014843024999999999 0.73330911551765676 0.00014843049999999999 0.48327381104219669 0.00014843075 0.27807513970080017 0.00014843099999999998 0.12559877135637687 0.00014843124999999998 0.03170428733466979 0.00014843149999999998 0 0.00015625700000000001 0 0.00015625725000000001 0.03170428733466979 0.00015625750000000001 0.12559877135637687 0.00015625775000000002 0.27807513970080033 0.00015625799999999999 0.48327381104219647 0.00015625825 0.73330911551765621 0.0001562585 1.0185723365976018 0.00015625875000000001 1.3281009686733882 0.00015625900000000001 1.6499999999999997 0.00015625925000000001 1.9718990313266114 0.00015625950000000002 2.2814276634023978 0.00015625975000000002 2.5666908844823433 0.00015626000000000003 2.8167261889578032 0.00015626025 3.0219248602991997 0.00015626050000000001 3.1744012286436227 0.00015626075000000001 3.26829571266533 0.00015626100000000001 3.2999999999999998 0.00016405250000000002 3.2999999999999998 0.00016405275000000002 3.26829571266533 0.00016405300000000002 3.1744012286436227 0.00016405325 3.0219248602991997 0.0001640535 2.8167261889578032 0.00016405375000000001 2.5666908844823433 0.00016405400000000001 2.2814276634023982 0.00016405425000000002 1.9718990313266118 0.00016405450000000002 1.6499999999999999 0.00016405475 1.3281009686733884 0.000164055 1.018572336597602 0.00016405525 0.73330911551765676 0.00016405550000000001 0.48327381104219669 0.00016405575000000001 0.27807513970080017 0.00016405599999999999 0.12559877135637687 0.00016405624999999999 0.03170428733466979 0.0001640565 0 0.00017188199999999999 0 0.00017188225 0.03170428733466979 0.0001718825 0.12559877135637687 0.00017188275 0.27807513970080033 0.00017188300000000001 0.48327381104219647 0.00017188324999999998 0.73330911551765621 0.00017188349999999999 1.0185723365976018 0.00017188374999999999 1.3281009686733882 0.000171884 1.6499999999999997 0.00017188425 1.9718990313266114 0.0001718845 2.2814276634023978 0.00017188475000000001 2.5666908844823433 0.00017188499999999998 2.8167261889578032 0.00017188524999999999 3.0219248602991997 0.00017188549999999999 3.1744012286436227 0.00017188575 3.26829571266533 0.000171886 3.2999999999999998 0.0001796775 3.2999999999999998 0.00017967775000000001 3.26829571266533 0.00017967800000000001 3.1744012286436227 0.00017967824999999999 3.0219248602991997 0.00017967849999999999 2.8167261889578032 0.00017967874999999999 2.5666908844823433 0.000179679 2.2814276634023982 0.00017967925 1.9718990313266118 0.00017967949999999998 1.6499999999999999 0.00017967974999999998 1.3281009686733884 0.00017967999999999999 1.018572336597602 0.00017968024999999999 0.73330911551765676 0.0001796805 0.48327381104219669 0.00017968075 0.27807513970080017 0.00017968099999999998 0.12559877135637687 0.00017968124999999998 0.03170428733466979 0.00017968149999999998 0 0.00018750700000000001 0 0.00018750725000000001 0.03170428733466979 0.00018750750000000001 0.12559877135637687 0.00018750775000000002 0.27807513970080033 0.00018750800000000002 0.48327381104219647 0.00018750825 0.73330911551765621 0.0001875085 1.0185723365976018 0.00018750875000000001 1.3281009686733882 0.00018750900000000001 1.6499999999999997 0.00018750925000000001 1.9718990313266114 0.00018750950000000002 2.2814276634023978 0.00018750975000000002 2.5666908844823433 0.00018751 2.8167261889578032 0.00018751025 3.0219248602991997 0.00018751050000000001 3.1744012286436227 0.00018751075000000001 3.26829571266533 0.00018751100000000001 3.2999999999999998 0.00019530250000000002 3.2999999999999998 0.00019530275000000002 3.26829571266533 0.00019530300000000002 3.1744012286436227 0.00019530325 3.0219248602991997 0.0001953035 2.8167261889578032 0.00019530375000000001 2.5666908844823433 0.00019530400000000001 2.2814276634023982 0.00019530425000000002 1.9718990313266118 0.00019530449999999999 1.6499999999999999 0.00019530475 1.3281009686733884 0.000195305 1.018572336597602 0.00019530525000000001 0.73330911551765676 0.00019530550000000001 0.48327381104219669 0.00019530575000000001 0.27807513970080017 0.00019530599999999999 0.12559877135637687 0.00019530624999999999 0.03170428733466979 0.0001953065 0 0.00020000000000000001 0)
EAFE_NCDB af_ncdb_drv 0 af_vdd af_cdb_drv 1
RAFE_G_CIA af_cia_drv af_cia 10
RAFE_G_NCIA af_ncia_drv af_ncia 10
RAFE_G_CIB af_cib_drv af_cib 10
RAFE_G_NCIB af_ncib_drv af_ncib 10
RAFE_G_CDA af_cda_drv af_cda 10
RAFE_G_NCDA af_ncda_drv af_ncda 10
RAFE_G_CDB af_cdb_drv af_cdb 10
RAFE_G_NCDB af_ncdb_drv af_ncdb 10
.nodeset v(af_vdd)=3.2999999999999998 v(af_cda_drv)=3.2999999999999998 v(af_cda)=3.2999999999999998 v(af_cdb)=0 v(af_cdb_drv)=0 v(af_cia)=3.2999999999999998 v(af_cia_drv)=3.2999999999999998 v(af_cib_drv)=0 v(af_cib)=0 v(CM)=1.6499999999999999 v(af_inn)=1.649998554331908 v(af_inp)=1.6499985543263991 v(af_ncda)=0 v(af_ncda_drv)=0 v(af_ncdb)=3.2999999999999998 v(af_ncdb_drv)=3.2999999999999998 v(af_ncia)=0 v(af_ncia_drv)=0 v(af_ncib_drv)=3.2999999999999998 v(af_ncib)=3.2999999999999998 v(af_outn)=1.64995246047254 v(af_outp)=1.6499524518219579 v(af_sig)=0 v(af_vbcm)=0.82000000000000006 v(af_vbn)=0.84850000000000003 v(af_vinn)=1.6499999999999999 v(af_vinp)=1.6499999999999999 v(af_vnc)=2 v(af_vpc)=1.2 v(af_vbp)=2.3311670297323519 v(XAFE_DUT.xcmfb.nd)=2.3517899448641622 v(XAFE_DUT.xcmfb.nta)=0.70267910623899421 v(XAFE_DUT.xcmfb.ntb)=0.70267910955347357 v(XAFE_DUT.xcore.dnn)=0.96256915941579357 v(XAFE_DUT.xcore.dnp)=0.96256915944047661 v(XAFE_DUT.xcore.dpn)=2.436365152142804 v(XAFE_DUT.xcore.dpp)=2.4363651521524639 v(XAFE_DUT.xcore.sn)=0.68561578216376173 v(XAFE_DUT.xcore.sp)=2.7712408445672718 v(af_opi)=1.6499524518219579 v(af_oni)=1.64995246047254 v(af_wp)=1.65 v(af_wn)=1.65 v(af_src_p)=1.65 v(af_src_n)=1.65
XAFE_RSTP af_inp af_rstp af_oni 0 nfet_03v3 W=1u L=1u nf=1 m=1 ad=.5p as=.5p pd=3u ps=3u nrd=.5 nrs=.5
XAFE_RSTN af_inn af_rstn af_opi 0 nfet_03v3 W=1u L=1u nf=1 m=1 ad=.5p as=.5p pd=3u ps=3u nrd=.5 nrs=.5
VAFE_RST af_rst_src 0 DC 3.3 PWL(0 3.2999999999999998 1.0000000000000001e-05 3.2999999999999998 1.0000312500000001e-05 3.2920547990091249 1.0000625e-05 3.26829571266533 1.00009375e-05 3.2289515539581446 1.000125e-05 3.1744012286436227 1.00015625e-05 3.1051700861747857 1.0001875000000002e-05 3.0219248602991993 1.0002187500000001e-05 2.9254672480485158 1.0002500000000001e-05 2.8167261889578032 1.0002812500000001e-05 2.6967489188700151 1.0003125000000001e-05 2.5666908844823437 1.0003437500000001e-05 2.4278046157628963 1.0003750000000001e-05 2.2814276634023978 1.00040625e-05 2.1289697174698627 1.0004375e-05 1.9718990313266116 1.00046875e-05 1.8117282815437752 1.0005000000000002e-05 1.6500000000000001 1.0005312500000001e-05 1.4882717184562249 1.0005625000000001e-05 1.3281009686733884 1.0005937500000001e-05 1.1710302825301375 1.0006250000000001e-05 1.018572336597602 1.0006562500000001e-05 0.87219538423710397 1.0006875000000001e-05 0.73330911551765654 1.00071875e-05 0.60325108112998516 1.00075e-05 0.48327381104219658 1.00078125e-05 0.37453275195148406 1.0008125e-05 0.27807513970080011 1.0008437500000002e-05 0.19482991382521453 1.0008750000000001e-05 0.12559877135637709 1.0009062500000001e-05 0.071048446041855229 1.0009375000000001e-05 0.03170428733466979 1.0009687500000001e-05 0.0079452009908753674 1.0010000000000001e-05 0 0.00020000000000000001 0)
RAFE_GRP af_rst_src af_rstp 10
RAFE_GRN af_rst_src af_rstn 10
VPORTP af_outp VINP 0
VPORTN af_outn VINN 0
* Observational digital fanout only; zero digital input_load and no signal/reset analog connection.
AOBS_EVENT [DRESET_EVENT DLOAD] [OBS_DRESET_EVENT OBS_DLOAD_EVENT] OBS_DAC
.model OBS_DAC dac_bridge(out_low=0 out_high=3.3 out_undef=1.65 t_rise=1n t_fall=1n input_load=0)
.save time v(af_sig) v(af_outp) v(af_outn) v(af_inp) v(af_inn) v(af_vinp) v(af_vinn) v(af_src_p) v(af_src_n) v(af_wp) v(af_wn) v(af_oni) v(af_opi) v(af_rst_src) v(af_rstp) v(af_rstn) v(af_vbp) v(af_cia) v(af_ncia) v(af_cib) v(af_ncib) v(af_cda) v(af_ncda) v(af_cdb) v(af_ncdb) v(af_cia_drv) v(af_cib_drv) v(af_cda_drv) v(af_cdb_drv) i(vafe_supply) i(eafe_p) i(eafe_n) @cafe_inp[i] @cafe_inn[i] @cafe_fbp[i] @cafe_fbn[i] i(vafe_rst) i(vcm) i(vafe_bn) i(vafe_bcm) i(vafe_nc) i(vafe_pc) @m.xafe_dut.xcore.xn_p.m0[vds] @m.xafe_dut.xcore.xn_p.m0[vdsat] @m.xafe_dut.xcore.xn_p.m0[vgs] @m.xafe_dut.xcore.xn_p.m0[vth] @m.xafe_dut.xcore.xn_p.m0[id] @m.xafe_dut.xcore.xn_n.m0[vds] @m.xafe_dut.xcore.xn_n.m0[vdsat] @m.xafe_dut.xcore.xn_n.m0[vgs] @m.xafe_dut.xcore.xn_n.m0[vth] @m.xafe_dut.xcore.xn_n.m0[id] @m.xafe_dut.xcore.xp_p.m0[vds] @m.xafe_dut.xcore.xp_p.m0[vdsat] @m.xafe_dut.xcore.xp_p.m0[vgs] @m.xafe_dut.xcore.xp_p.m0[vth] @m.xafe_dut.xcore.xp_p.m0[id] @m.xafe_dut.xcore.xp_n.m0[vds] @m.xafe_dut.xcore.xp_n.m0[vdsat] @m.xafe_dut.xcore.xp_n.m0[vgs] @m.xafe_dut.xcore.xp_n.m0[vth] @m.xafe_dut.xcore.xp_n.m0[id] @m.xafe_dut.xcore.xnt.m0[vds] @m.xafe_dut.xcore.xnt.m0[vdsat] @m.xafe_dut.xcore.xnt.m0[vgs] @m.xafe_dut.xcore.xnt.m0[vth] @m.xafe_dut.xcore.xnt.m0[id] @m.xafe_dut.xcore.xpt.m0[vds] @m.xafe_dut.xcore.xpt.m0[vdsat] @m.xafe_dut.xcore.xpt.m0[vgs] @m.xafe_dut.xcore.xpt.m0[vth] @m.xafe_dut.xcore.xpt.m0[id] @m.xafe_dut.xcore.xnc_p.m0[vds] @m.xafe_dut.xcore.xnc_p.m0[vdsat] @m.xafe_dut.xcore.xnc_p.m0[vgs] @m.xafe_dut.xcore.xnc_p.m0[vth] @m.xafe_dut.xcore.xnc_p.m0[id] @m.xafe_dut.xcore.xnc_n.m0[vds] @m.xafe_dut.xcore.xnc_n.m0[vdsat] @m.xafe_dut.xcore.xnc_n.m0[vgs] @m.xafe_dut.xcore.xnc_n.m0[vth] @m.xafe_dut.xcore.xnc_n.m0[id] @m.xafe_dut.xcore.xpc_p.m0[vds] @m.xafe_dut.xcore.xpc_p.m0[vdsat] @m.xafe_dut.xcore.xpc_p.m0[vgs] @m.xafe_dut.xcore.xpc_p.m0[vth] @m.xafe_dut.xcore.xpc_p.m0[id] @m.xafe_dut.xcore.xpc_n.m0[vds] @m.xafe_dut.xcore.xpc_n.m0[vdsat] @m.xafe_dut.xcore.xpc_n.m0[vgs] @m.xafe_dut.xcore.xpc_n.m0[vth] @m.xafe_dut.xcore.xpc_n.m0[id] @m.xafe_dut.xcmfb.xcm1.m0[vds] @m.xafe_dut.xcmfb.xcm1.m0[vdsat] @m.xafe_dut.xcmfb.xcm1.m0[vgs] @m.xafe_dut.xcmfb.xcm1.m0[vth] @m.xafe_dut.xcmfb.xcm1.m0[id] @m.xafe_dut.xcmfb.xcm2.m0[vds] @m.xafe_dut.xcmfb.xcm2.m0[vdsat] @m.xafe_dut.xcmfb.xcm2.m0[vgs] @m.xafe_dut.xcmfb.xcm2.m0[vth] @m.xafe_dut.xcmfb.xcm2.m0[id] @m.xafe_dut.xcmfb.xcm3.m0[vds] @m.xafe_dut.xcmfb.xcm3.m0[vdsat] @m.xafe_dut.xcmfb.xcm3.m0[vgs] @m.xafe_dut.xcmfb.xcm3.m0[vth] @m.xafe_dut.xcmfb.xcm3.m0[id] @m.xafe_dut.xcmfb.xcm4.m0[vds] @m.xafe_dut.xcmfb.xcm4.m0[vdsat] @m.xafe_dut.xcmfb.xcm4.m0[vgs] @m.xafe_dut.xcmfb.xcm4.m0[vth] @m.xafe_dut.xcmfb.xcm4.m0[id] @m.xafe_dut.xcmfb.xcmp1.m0[vds] @m.xafe_dut.xcmfb.xcmp1.m0[vdsat] @m.xafe_dut.xcmfb.xcmp1.m0[vgs] @m.xafe_dut.xcmfb.xcmp1.m0[vth] @m.xafe_dut.xcmfb.xcmp1.m0[id] @m.xafe_dut.xcmfb.xcmp2.m0[vds] @m.xafe_dut.xcmfb.xcmp2.m0[vdsat] @m.xafe_dut.xcmfb.xcmp2.m0[vgs] @m.xafe_dut.xcmfb.xcmp2.m0[vth] @m.xafe_dut.xcmfb.xcmp2.m0[id] @m.xafe_dut.xcmfb.xcmt1.m0[vds] @m.xafe_dut.xcmfb.xcmt1.m0[vdsat] @m.xafe_dut.xcmfb.xcmt1.m0[vgs] @m.xafe_dut.xcmfb.xcmt1.m0[vth] @m.xafe_dut.xcmfb.xcmt1.m0[id] @m.xafe_dut.xcmfb.xcmt2.m0[vds] @m.xafe_dut.xcmfb.xcmt2.m0[vdsat] @m.xafe_dut.xcmfb.xcmt2.m0[vgs] @m.xafe_dut.xcmfb.xcmt2.m0[vth] @m.xafe_dut.xcmfb.xcmt2.m0[id] @m.xafe_dut.xcore.xnc_p.m0[qd] @m.xafe_dut.xcore.xnc_p.m0[qs] @m.xafe_dut.xcore.xnc_n.m0[qd] @m.xafe_dut.xcore.xnc_n.m0[qs] @m.xafe_dut.xcore.xpc_p.m0[qd] @m.xafe_dut.xcore.xpc_p.m0[qs] @m.xafe_dut.xcore.xpc_n.m0[qd] @m.xafe_dut.xcore.xpc_n.m0[qs] @m.xafe_dut.xop_a.xn.m0[qd] @m.xafe_dut.xop_a.xn.m0[qs] @m.xafe_dut.xop_a.xp.m0[qd] @m.xafe_dut.xop_a.xp.m0[qs] @m.xafe_dut.xon_a.xn.m0[qd] @m.xafe_dut.xon_a.xn.m0[qs] @m.xafe_dut.xon_a.xp.m0[qd] @m.xafe_dut.xon_a.xp.m0[qs] @m.xafe_dut.xop_b.xn.m0[qd] @m.xafe_dut.xop_b.xn.m0[qs] @m.xafe_dut.xop_b.xp.m0[qd] @m.xafe_dut.xop_b.xp.m0[qs] @m.xafe_dut.xon_b.xn.m0[qd] @m.xafe_dut.xon_b.xn.m0[qs] @m.xafe_dut.xon_b.xp.m0[qd] @m.xafe_dut.xon_b.xp.m0[qs] @m.xafe_dut.xip_a.xn.m0[gds] @m.xafe_dut.xip_a.xp.m0[gds] @m.xafe_dut.xin_a.xn.m0[gds] @m.xafe_dut.xin_a.xp.m0[gds] @m.xafe_dut.xip_b.xn.m0[gds] @m.xafe_dut.xip_b.xp.m0[gds] @m.xafe_dut.xin_b.xn.m0[gds] @m.xafe_dut.xin_b.xp.m0[gds] @m.xafe_dut.xop_a.xn.m0[gds] @m.xafe_dut.xop_a.xp.m0[gds] @m.xafe_dut.xon_a.xn.m0[gds] @m.xafe_dut.xon_a.xp.m0[gds] @m.xafe_dut.xop_b.xn.m0[gds] @m.xafe_dut.xop_b.xp.m0[gds] @m.xafe_dut.xon_b.xn.m0[gds] @m.xafe_dut.xon_b.xp.m0[gds] @m.xafe_rstp.m0[id] @m.xafe_rstp.m0[vgs] @m.xafe_rstp.m0[vth] @m.xafe_rstp.m0[vds] @m.xafe_rstp.m0[vdsat] @m.xafe_rstp.m0[vbs] @m.xafe_rstp.m0[ibd] @m.xafe_rstp.m0[ibs] @m.xafe_rstp.m0[igidl] @m.xafe_rstp.m0[igisl] @m.xafe_rstp.m0[qg] @m.xafe_rstp.m0[qd] @m.xafe_rstp.m0[qs] @m.xafe_rstp.m0[qb] @m.xafe_rstn.m0[id] @m.xafe_rstn.m0[vgs] @m.xafe_rstn.m0[vth] @m.xafe_rstn.m0[vds] @m.xafe_rstn.m0[vdsat] @m.xafe_rstn.m0[vbs] @m.xafe_rstn.m0[ibd] @m.xafe_rstn.m0[ibs] @m.xafe_rstn.m0[igidl] @m.xafe_rstn.m0[igisl] @m.xafe_rstn.m0[qg] @m.xafe_rstn.m0[qd] @m.xafe_rstn.m0[qs] @m.xafe_rstn.m0[qb] @m.xafe_dut.xcore.xn_p.m0[gm] @m.xafe_dut.xcore.xn_n.m0[gm] @m.xafe_dut.xcore.xp_p.m0[gm] @m.xafe_dut.xcore.xp_n.m0[gm] @m.xafe_dut.xcore.xnt.m0[gm] @m.xafe_dut.xcore.xpt.m0[gm] @m.xafe_dut.xcore.xnc_p.m0[gm] @m.xafe_dut.xcore.xnc_n.m0[gm] @m.xafe_dut.xcore.xpc_p.m0[gm] @m.xafe_dut.xcore.xpc_n.m0[gm] @m.xafe_dut.xcmfb.xcm1.m0[gm] @m.xafe_dut.xcmfb.xcm2.m0[gm] @m.xafe_dut.xcmfb.xcm3.m0[gm] @m.xafe_dut.xcmfb.xcm4.m0[gm] @m.xafe_dut.xcmfb.xcmp1.m0[gm] @m.xafe_dut.xcmfb.xcmp2.m0[gm] @m.xafe_dut.xcmfb.xcmt1.m0[gm] @m.xafe_dut.xcmfb.xcmt2.m0[gm] v(o1p) v(o1n) v(i1p) v(i1n) v(o2p) v(o2n) v(i2p) v(i2n) v(dac1p) v(dac1n) v(dac2p) v(dac2n) v(load) v(reset) v(vref) i(vadc_supply) v(xq.xctrl.pa0) v(xq.xctrl.pa1) v(xq.xctrl.pa2) v(xq.xctrl.pa3) v(xq.xctrl.pa4) v(xq.xctrl.ca0) v(xq.xctrl.ca1) v(xq.xctrl.ca2) v(xq.xctrl.ca3) v(xq.xctrl.ca4) v(xq.xctrl.rawa0) v(xq.xctrl.rawa1) v(xq.xctrl.rawa2) v(xq.xctrl.rawa3) v(xq.xctrl.rawa4) @m.xota1.xota.xcore.xin_p.m0[vds] @m.xota1.xota.xcore.xin_p.m0[vdsat] @m.xota1.xota.xcore.xin_n.m0[vds] @m.xota1.xota.xcore.xin_n.m0[vdsat] @m.xota1.xota.xcore.xnc_p.m0[vds] @m.xota1.xota.xcore.xnc_p.m0[vdsat] @m.xota1.xota.xcore.xnc_n.m0[vds] @m.xota1.xota.xcore.xnc_n.m0[vdsat] @m.xota1.xota.xcore.xload_p.m0[vds] @m.xota1.xota.xcore.xload_p.m0[vdsat] @m.xota1.xota.xcore.xload_n.m0[vds] @m.xota1.xota.xcore.xload_n.m0[vdsat] @m.xota1.xota.xcore.xpc_p.m0[vds] @m.xota1.xota.xcore.xpc_p.m0[vdsat] @m.xota1.xota.xcore.xpc_n.m0[vds] @m.xota1.xota.xcore.xpc_n.m0[vdsat] @m.xota1.xota.xcore.xtail.m0[vds] @m.xota1.xota.xcore.xtail.m0[vdsat] @m.xota2.xcore.xin_p.m0[vds] @m.xota2.xcore.xin_p.m0[vdsat] @m.xota2.xcore.xin_n.m0[vds] @m.xota2.xcore.xin_n.m0[vdsat] @m.xota2.xcore.xnc_p.m0[vds] @m.xota2.xcore.xnc_p.m0[vdsat] @m.xota2.xcore.xnc_n.m0[vds] @m.xota2.xcore.xnc_n.m0[vdsat] @m.xota2.xcore.xload_p.m0[vds] @m.xota2.xcore.xload_p.m0[vdsat] @m.xota2.xcore.xload_n.m0[vds] @m.xota2.xcore.xload_n.m0[vdsat] @m.xota2.xcore.xpc_p.m0[vds] @m.xota2.xcore.xpc_p.m0[vdsat] @m.xota2.xcore.xpc_n.m0[vds] @m.xota2.xcore.xpc_n.m0[vdsat] @m.xota2.xcore.xtail.m0[vds] @m.xota2.xcore.xtail.m0[vdsat] @m.xota1.xota.xcore.xload_p.m0[id] @m.xota1.xota.xcore.xload_n.m0[id] @m.xota2.xcore.xload_p.m0[id] @m.xota2.xcore.xload_n.m0[id] @m.xota1.xota.xcmfb.xcmp1.m0[id] @m.xota1.xota.xcmfb.xcmp2.m0[id] @m.xota2.xcmfb.xcmp1.m0[id] @m.xota2.xcmfb.xcmp2.m0[id] v(cia) v(cib) v(cda) v(cdb) v(xota1.cip) v(xota1.cin) v(xota1.xota.vbp) v(xota1.xota.xcore.d1p) v(xota1.xota.xcore.d1n) v(xota1.xota.xcore.n1p) v(xota1.xota.xcore.n1n) v(xota1.xota.xcore.p1p) v(xota1.xota.xcore.p1n) v(xota1.xota.xcore.p2p) v(xota1.xota.xcore.p2n) v(ncia) v(ncib) v(ncda) v(ncdb) v(cia_drv) v(ncia_drv) v(cib_drv) v(ncib_drv) v(cda_drv) v(ncda_drv) v(cdb_drv) v(ncdb_drv) @m.xota1.xota.xcmfb.xcm1.m0[vds] @m.xota1.xota.xcmfb.xcm1.m0[vdsat] @m.xota1.xota.xcmfb.xcm2.m0[vds] @m.xota1.xota.xcmfb.xcm2.m0[vdsat] @m.xota1.xota.xcmfb.xcm3.m0[vds] @m.xota1.xota.xcmfb.xcm3.m0[vdsat] @m.xota1.xota.xcmfb.xcm4.m0[vds] @m.xota1.xota.xcmfb.xcm4.m0[vdsat] @m.xota1.xota.xcmfb.xcmp1.m0[vds] @m.xota1.xota.xcmfb.xcmp1.m0[vdsat] @m.xota1.xota.xcmfb.xcmp2.m0[vds] @m.xota1.xota.xcmfb.xcmp2.m0[vdsat] @m.xota1.xota.xcmfb.xcmt1.m0[vds] @m.xota1.xota.xcmfb.xcmt1.m0[vdsat] @m.xota1.xota.xcmfb.xcmt2.m0[vds] @m.xota1.xota.xcmfb.xcmt2.m0[vdsat] @m.xota2.xcmfb.xcm1.m0[vds] @m.xota2.xcmfb.xcm1.m0[vdsat] @m.xota2.xcmfb.xcm2.m0[vds] @m.xota2.xcmfb.xcm2.m0[vdsat] @m.xota2.xcmfb.xcm3.m0[vds] @m.xota2.xcmfb.xcm3.m0[vdsat] @m.xota2.xcmfb.xcm4.m0[vds] @m.xota2.xcmfb.xcm4.m0[vdsat] @m.xota2.xcmfb.xcmp1.m0[vds] @m.xota2.xcmfb.xcmp1.m0[vdsat] @m.xota2.xcmfb.xcmp2.m0[vds] @m.xota2.xcmfb.xcmp2.m0[vdsat] @m.xota2.xcmfb.xcmt1.m0[vds] @m.xota2.xcmfb.xcmt1.m0[vdsat] @m.xota2.xcmfb.xcmt2.m0[vds] @m.xota2.xcmfb.xcmt2.m0[vdsat] v(nreset) v(reset_target) v(nreset_target) @m.xr1p.xn.m0[vgs] @m.xr1p.xn.m0[vds] @m.xr1p.xn.m0[id] @m.xr1p.xn.m0[cgg] @m.xr1p.xp.m0[vgs] @m.xr1p.xp.m0[vds] @m.xr1p.xp.m0[id] @m.xr1p.xp.m0[cgg] @m.xr1n.xn.m0[vgs] @m.xr1n.xn.m0[vds] @m.xr1n.xn.m0[id] @m.xr1n.xn.m0[cgg] @m.xr1n.xp.m0[vgs] @m.xr1n.xp.m0[vds] @m.xr1n.xp.m0[id] @m.xr1n.xp.m0[cgg] @m.xr2p.xn.m0[vgs] @m.xr2p.xn.m0[vds] @m.xr2p.xn.m0[id] @m.xr2p.xn.m0[cgg] @m.xr2p.xp.m0[vgs] @m.xr2p.xp.m0[vds] @m.xr2p.xp.m0[id] @m.xr2p.xp.m0[cgg] @m.xr2n.xn.m0[vgs] @m.xr2n.xn.m0[vds] @m.xr2n.xn.m0[id] @m.xr2n.xn.m0[cgg] @m.xr2n.xp.m0[vgs] @m.xr2n.xp.m0[vds] @m.xr2n.xp.m0[id] @m.xr2n.xp.m0[cgg] v(vinp) v(vinn) v(xota2.vbp) @m.xota1.xota.xcore.xin_p.m0[id] @m.xota1.xota.xcore.xin_p.m0[gm] @m.xota1.xota.xcore.xin_n.m0[id] @m.xota1.xota.xcore.xin_n.m0[gm] @m.xota1.xota.xcore.xnc_p.m0[id] @m.xota1.xota.xcore.xnc_p.m0[gm] @m.xota1.xota.xcore.xnc_n.m0[id] @m.xota1.xota.xcore.xnc_n.m0[gm] @m.xota1.xota.xcore.xload_p.m0[gm] @m.xota1.xota.xcore.xload_n.m0[gm] @m.xota1.xota.xcore.xpc_p.m0[id] @m.xota1.xota.xcore.xpc_p.m0[gm] @m.xota1.xota.xcore.xpc_n.m0[id] @m.xota1.xota.xcore.xpc_n.m0[gm] @m.xota1.xota.xcore.xtail.m0[id] @m.xota1.xota.xcore.xtail.m0[gm] @m.xota1.xota.xcmfb.xcm1.m0[id] @m.xota1.xota.xcmfb.xcm1.m0[gm] @m.xota1.xota.xcmfb.xcm2.m0[id] @m.xota1.xota.xcmfb.xcm2.m0[gm] @m.xota1.xota.xcmfb.xcm3.m0[id] @m.xota1.xota.xcmfb.xcm3.m0[gm] @m.xota1.xota.xcmfb.xcm4.m0[id] @m.xota1.xota.xcmfb.xcm4.m0[gm] @m.xota1.xota.xcmfb.xcmp1.m0[gm] @m.xota1.xota.xcmfb.xcmp2.m0[gm] @m.xota1.xota.xcmfb.xcmt1.m0[id] @m.xota1.xota.xcmfb.xcmt1.m0[gm] @m.xota1.xota.xcmfb.xcmt2.m0[id] @m.xota1.xota.xcmfb.xcmt2.m0[gm] @m.xota2.xcore.xin_p.m0[id] @m.xota2.xcore.xin_p.m0[gm] @m.xota2.xcore.xin_n.m0[id] @m.xota2.xcore.xin_n.m0[gm] @m.xota2.xcore.xnc_p.m0[id] @m.xota2.xcore.xnc_p.m0[gm] @m.xota2.xcore.xnc_n.m0[id] @m.xota2.xcore.xnc_n.m0[gm] @m.xota2.xcore.xload_p.m0[gm] @m.xota2.xcore.xload_n.m0[gm] @m.xota2.xcore.xpc_p.m0[id] @m.xota2.xcore.xpc_p.m0[gm] @m.xota2.xcore.xpc_n.m0[id] @m.xota2.xcore.xpc_n.m0[gm] @m.xota2.xcore.xtail.m0[id] @m.xota2.xcore.xtail.m0[gm] @m.xota2.xcmfb.xcm1.m0[id] @m.xota2.xcmfb.xcm1.m0[gm] @m.xota2.xcmfb.xcm2.m0[id] @m.xota2.xcmfb.xcm2.m0[gm] @m.xota2.xcmfb.xcm3.m0[id] @m.xota2.xcmfb.xcm3.m0[gm] @m.xota2.xcmfb.xcm4.m0[id] @m.xota2.xcmfb.xcm4.m0[gm] @m.xota2.xcmfb.xcmp1.m0[gm] @m.xota2.xcmfb.xcmp2.m0[gm] @m.xota2.xcmfb.xcmt1.m0[id] @m.xota2.xcmfb.xcmt1.m0[gm] @m.xota2.xcmfb.xcmt2.m0[id] @m.xota2.xcmfb.xcmt2.m0[gm] @c1p[i] @c1n[i] @c2p[i] @c2n[i] i(vportp) i(vportn) i(vdd_src) v(af_vdd) v(adc_vdd) v(sel0) v(sel1) v(sel2) v(sel3) v(sel4) v(sel5) v(sel6) v(sel7) v(sel8) v(sel9) v(sel10) v(sel11) v(sel12) v(sel13) v(sel14) v(sel15) v(sel16) v(sel17) v(sel18) v(sel19) v(sel20) v(sel21) v(sel22) v(sel23) v(sel24) v(sel25) v(sel26) v(sel27) v(sel28) v(sel29) v(sel30) v(seln0) v(seln1) v(seln2) v(seln3) v(seln4) v(seln5) v(seln6) v(seln7) v(seln8) v(seln9) v(seln10) v(seln11) v(seln12) v(seln13) v(seln14) v(seln15) v(seln16) v(seln17) v(seln18) v(seln19) v(seln20) v(seln21) v(seln22) v(seln23) v(seln24) v(seln25) v(seln26) v(seln27) v(seln28) v(seln29) v(seln30) v(s2l0) v(s2l1) v(s2l2) v(s2l3) v(s2l4) v(s2l5) v(s2l6) v(s2l7) v(s2l8) v(s2l9) v(s2l10) v(s2l11) v(s2l12) v(s2l13) v(s2l14) v(s2l15) v(s2l16) v(s2l17) v(s2l18) v(s2l19) v(s2l20) v(s2l21) v(s2l22) v(s2l23) v(s2l24) v(s2l25) v(s2l26) v(s2l27) v(s2l28) v(s2l29) v(s2l30) v(s2ln0) v(s2ln1) v(s2ln2) v(s2ln3) v(s2ln4) v(s2ln5) v(s2ln6) v(s2ln7) v(s2ln8) v(s2ln9) v(s2ln10) v(s2ln11) v(s2ln12) v(s2ln13) v(s2ln14) v(s2ln15) v(s2ln16) v(s2ln17) v(s2ln18) v(s2ln19) v(s2ln20) v(s2ln21) v(s2ln22) v(s2ln23) v(s2ln24) v(s2ln25) v(s2ln26) v(s2ln27) v(s2ln28) v(s2ln29) v(s2ln30) v(xq.err0) v(xq.err1) v(xq.err2) v(xq.err3) v(xq.err4) v(xq.err5) v(xq.err6) v(xq.err7) v(xq.err8) v(xq.err9) v(xq.err10) v(xq.err11) v(xq.err12) v(xq.err13) v(xq.err14) v(xq.err15) v(xq.err16) v(xq.err17) v(xq.err18) v(xq.err19) v(xq.err20) v(xq.err21) v(xq.err22) v(xq.err23) v(xq.err24) v(xq.err25) v(xq.err26) v(xq.err27) v(xq.err28) v(xq.err29) v(xq.err30) v(xq.th0) v(xq.th1) v(xq.th2) v(xq.th3) v(xq.th4) v(xq.th5) v(xq.th6) v(xq.th7) v(xq.th8) v(xq.th9) v(xq.th10) v(xq.th11) v(xq.th12) v(xq.th13) v(xq.th14) v(xq.th15) v(xq.th16) v(xq.th17) v(xq.th18) v(xq.th19) v(xq.th20) v(xq.th21) v(xq.th22) v(xq.th23) v(xq.th24) v(xq.th25) v(xq.th26) v(xq.th27) v(xq.th28) v(xq.th29) v(xq.th30) v(obs_dreset_event) v(obs_dload_event)
.tran 5n 7.8857421875000002e-05 0 1n
.end
