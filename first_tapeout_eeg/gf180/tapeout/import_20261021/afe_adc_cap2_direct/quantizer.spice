* DLOAD and DRESET are DIGITAL XSPICE ports, not analog voltages.
* Drive from d_source or another digital code model. Exact same DWA/reset logic.
* Ideal CT quantizer frontend and functional event-driven 5-bit controller.
* VSS must be simulator ground; bridges use fixed 0/3.3 V levels, not VDD tracking.
* No comparator transistor offset/noise/metastability or physical digital timing/power.
.subckt ct_quantizer5_event INP INN DLOAD DRESET VDD33 VSS SEL0 SEL1 SEL2 SEL3 SEL4 SEL5 SEL6 SEL7 SEL8 SEL9 SEL10 SEL11 SEL12 SEL13 SEL14 SEL15 SEL16 SEL17 SEL18 SEL19 SEL20 SEL21 SEL22 SEL23 SEL24 SEL25 SEL26 SEL27 SEL28 SEL29 SEL30 SELN0 SELN1 SELN2 SELN3 SELN4 SELN5 SELN6 SELN7 SELN8 SELN9 SELN10 SELN11 SELN12 SELN13 SELN14 SELN15 SELN16 SELN17 SELN18 SELN19 SELN20 SELN21 SELN22 SELN23 SELN24 SELN25 SELN26 SELN27 SELN28 SELN29 SELN30 S2L0 S2L1 S2L2 S2L3 S2L4 S2L5 S2L6 S2L7 S2L8 S2L9 S2L10 S2L11 S2L12 S2L13 S2L14 S2L15 S2L16 S2L17 S2L18 S2L19 S2L20 S2L21 S2L22 S2L23 S2L24 S2L25 S2L26 S2L27 S2L28 S2L29 S2L30 S2LN0 S2LN1 S2LN2 S2LN3 S2LN4 S2LN5 S2LN6 S2LN7 S2LN8 S2LN9 S2LN10 S2LN11 S2LN12 S2LN13 S2LN14 S2LN15 S2LN16 S2LN17 S2LN18 S2LN19 S2LN20 S2LN21 S2LN22 S2LN23 S2LN24 S2LN25 S2LN26 S2LN27 S2LN28 S2LN29 S2LN30
.model QADC adc_bridge(in_low=1e-6 in_high=1e-6 rise_delay=.5n fall_delay=.5n)
.model QDAC dac_bridge(out_low=0 out_high=3.3 out_undef=1.65 t_rise=1n t_fall=1n input_load=1f)
VOFF0 OFF0 VSS 0.046875
EERR0 ERR0 OFF0 INP INN 1
VOFF1 OFF1 VSS 0.043750000000000004
EERR1 ERR1 OFF1 INP INN 1
VOFF2 OFF2 VSS 0.040625000000000001
EERR2 ERR2 OFF2 INP INN 1
VOFF3 OFF3 VSS 0.037500000000000006
EERR3 ERR3 OFF3 INP INN 1
VOFF4 OFF4 VSS 0.034375000000000003
EERR4 ERR4 OFF4 INP INN 1
VOFF5 OFF5 VSS 0.03125
EERR5 ERR5 OFF5 INP INN 1
VOFF6 OFF6 VSS 0.028125000000000001
EERR6 ERR6 OFF6 INP INN 1
VOFF7 OFF7 VSS 0.025000000000000001
EERR7 ERR7 OFF7 INP INN 1
VOFF8 OFF8 VSS 0.021875000000000002
EERR8 ERR8 OFF8 INP INN 1
VOFF9 OFF9 VSS 0.018750000000000003
EERR9 ERR9 OFF9 INP INN 1
VOFF10 OFF10 VSS 0.015625
EERR10 ERR10 OFF10 INP INN 1
VOFF11 OFF11 VSS 0.012500000000000001
EERR11 ERR11 OFF11 INP INN 1
VOFF12 OFF12 VSS 0.0093750000000000014
EERR12 ERR12 OFF12 INP INN 1
VOFF13 OFF13 VSS 0.0062500000000000003
EERR13 ERR13 OFF13 INP INN 1
VOFF14 OFF14 VSS 0.0031250000000000002
EERR14 ERR14 OFF14 INP INN 1
VOFF15 OFF15 VSS -0
EERR15 ERR15 OFF15 INP INN 1
VOFF16 OFF16 VSS -0.0031250000000000002
EERR16 ERR16 OFF16 INP INN 1
VOFF17 OFF17 VSS -0.0062500000000000003
EERR17 ERR17 OFF17 INP INN 1
VOFF18 OFF18 VSS -0.0093750000000000014
EERR18 ERR18 OFF18 INP INN 1
VOFF19 OFF19 VSS -0.012500000000000001
EERR19 ERR19 OFF19 INP INN 1
VOFF20 OFF20 VSS -0.015625
EERR20 ERR20 OFF20 INP INN 1
VOFF21 OFF21 VSS -0.018750000000000003
EERR21 ERR21 OFF21 INP INN 1
VOFF22 OFF22 VSS -0.021875000000000002
EERR22 ERR22 OFF22 INP INN 1
VOFF23 OFF23 VSS -0.025000000000000001
EERR23 ERR23 OFF23 INP INN 1
VOFF24 OFF24 VSS -0.028125000000000001
EERR24 ERR24 OFF24 INP INN 1
VOFF25 OFF25 VSS -0.03125
EERR25 ERR25 OFF25 INP INN 1
VOFF26 OFF26 VSS -0.034375000000000003
EERR26 ERR26 OFF26 INP INN 1
VOFF27 OFF27 VSS -0.037500000000000006
EERR27 ERR27 OFF27 INP INN 1
VOFF28 OFF28 VSS -0.040625000000000001
EERR28 ERR28 OFF28 INP INN 1
VOFF29 OFF29 VSS -0.043750000000000004
EERR29 ERR29 OFF29 INP INN 1
VOFF30 OFF30 VSS -0.046875
EERR30 ERR30 OFF30 INP INN 1
AQCOMPARE [ERR0 ERR1 ERR2 ERR3 ERR4 ERR5 ERR6 ERR7 ERR8 ERR9 ERR10 ERR11 ERR12 ERR13 ERR14 ERR15 ERR16 ERR17 ERR18 ERR19 ERR20 ERR21 ERR22 ERR23 ERR24 ERR25 ERR26 ERR27 ERR28 ERR29 ERR30] [QD0 QD1 QD2 QD3 QD4 QD5 QD6 QD7 QD8 QD9 QD10 QD11 QD12 QD13 QD14 QD15 QD16 QD17 QD18 QD19 QD20 QD21 QD22 QD23 QD24 QD25 QD26 QD27 QD28 QD29 QD30] QADC
AQTHERM [QD0 QD1 QD2 QD3 QD4 QD5 QD6 QD7 QD8 QD9 QD10 QD11 QD12 QD13 QD14 QD15 QD16 QD17 QD18 QD19 QD20 QD21 QD22 QD23 QD24 QD25 QD26 QD27 QD28 QD29 QD30] [TH0 TH1 TH2 TH3 TH4 TH5 TH6 TH7 TH8 TH9 TH10 TH11 TH12 TH13 TH14 TH15 TH16 TH17 TH18 TH19 TH20 TH21 TH22 TH23 TH24 TH25 TH26 TH27 TH28 TH29 TH30] QDAC
XCTRL TH0 TH1 TH2 TH3 TH4 TH5 TH6 TH7 TH8 TH9 TH10 TH11 TH12 TH13 TH14 TH15 TH16 TH17 TH18 TH19 TH20 TH21 TH22 TH23 TH24 TH25 TH26 TH27 TH28 TH29 TH30 DLOAD DRESET VDD33 VSS SEL0 SEL1 SEL2 SEL3 SEL4 SEL5 SEL6 SEL7 SEL8 SEL9 SEL10 SEL11 SEL12 SEL13 SEL14 SEL15 SEL16 SEL17 SEL18 SEL19 SEL20 SEL21 SEL22 SEL23 SEL24 SEL25 SEL26 SEL27 SEL28 SEL29 SEL30 SELN0 SELN1 SELN2 SELN3 SELN4 SELN5 SELN6 SELN7 SELN8 SELN9 SELN10 SELN11 SELN12 SELN13 SELN14 SELN15 SELN16 SELN17 SELN18 SELN19 SELN20 SELN21 SELN22 SELN23 SELN24 SELN25 SELN26 SELN27 SELN28 SELN29 SELN30 S2L0 S2L1 S2L2 S2L3 S2L4 S2L5 S2L6 S2L7 S2L8 S2L9 S2L10 S2L11 S2L12 S2L13 S2L14 S2L15 S2L16 S2L17 S2L18 S2L19 S2L20 S2L21 S2L22 S2L23 S2L24 S2L25 S2L26 S2L27 S2L28 S2L29 S2L30 S2LN0 S2LN1 S2LN2 S2LN3 S2LN4 S2LN5 S2LN6 S2LN7 S2LN8 S2LN9 S2LN10 S2LN11 S2LN12 S2LN13 S2LN14 S2LN15 S2LN16 S2LN17 S2LN18 S2LN19 S2LN20 S2LN21 S2LN22 S2LN23 S2LN24 S2LN25 S2LN26 S2LN27 S2LN28 S2LN29 S2LN30 adc_ctrl_event
.ends ct_quantizer5_event

* Exact 5-bit count, int1 DWA optional, int2 straight held code.
* Digital initial/reset code=15 (k=16), pointer=0. No nodeset state restoration.
* Bridges are model interfaces at fixed 3.3 V; not transistor logic/power.
.subckt adc_ctrl_event TH0 TH1 TH2 TH3 TH4 TH5 TH6 TH7 TH8 TH9 TH10 TH11 TH12 TH13 TH14 TH15 TH16 TH17 TH18 TH19 TH20 TH21 TH22 TH23 TH24 TH25 TH26 TH27 TH28 TH29 TH30 clk rst VDD33 VSS SEL0 SEL1 SEL2 SEL3 SEL4 SEL5 SEL6 SEL7 SEL8 SEL9 SEL10 SEL11 SEL12 SEL13 SEL14 SEL15 SEL16 SEL17 SEL18 SEL19 SEL20 SEL21 SEL22 SEL23 SEL24 SEL25 SEL26 SEL27 SEL28 SEL29 SEL30 SELN0 SELN1 SELN2 SELN3 SELN4 SELN5 SELN6 SELN7 SELN8 SELN9 SELN10 SELN11 SELN12 SELN13 SELN14 SELN15 SELN16 SELN17 SELN18 SELN19 SELN20 SELN21 SELN22 SELN23 SELN24 SELN25 SELN26 SELN27 SELN28 SELN29 SELN30 S2L0 S2L1 S2L2 S2L3 S2L4 S2L5 S2L6 S2L7 S2L8 S2L9 S2L10 S2L11 S2L12 S2L13 S2L14 S2L15 S2L16 S2L17 S2L18 S2L19 S2L20 S2L21 S2L22 S2L23 S2L24 S2L25 S2L26 S2L27 S2L28 S2L29 S2L30 S2LN0 S2LN1 S2LN2 S2LN3 S2LN4 S2LN5 S2LN6 S2LN7 S2LN8 S2LN9 S2LN10 S2LN11 S2LN12 S2LN13 S2LN14 S2LN15 S2LN16 S2LN17 S2LN18 S2LN19 S2LN20 S2LN21 S2LN22 S2LN23 S2LN24 S2LN25 S2LN26 S2LN27 S2LN28 S2LN29 S2LN30
.model ADC33 adc_bridge (in_low=0.99 in_high=2.31 rise_delay=.5n fall_delay=.5n)
.model DAC33 dac_bridge (out_low=0 out_high=3.3 out_undef=1.65 t_rise=1n t_fall=1n input_load=1f)
.model FF0 d_dff (ic=0 clk_delay=1n set_delay=1n reset_delay=1n rise_delay=1n fall_delay=1n data_load=1f clk_load=1f)
.model FF1 d_dff (ic=1 clk_delay=1n set_delay=1n reset_delay=1n rise_delay=1n fall_delay=1n data_load=1f clk_load=1f)
ATH [TH0 TH1 TH2 TH3 TH4 TH5 TH6 TH7 TH8 TH9 TH10 TH11 TH12 TH13 TH14 TH15 TH16 TH17 TH18 TH19 TH20 TH21 TH22 TH23 TH24 TH25 TH26 TH27 TH28 TH29 TH30] [dt0 dt1 dt2 dt3 dt4 dt5 dt6 dt7 dt8 dt9 dt10 dt11 dt12 dt13 dt14 dt15 dt16 dt17 dt18 dt19 dt20 dt21 dt22 dt23 dt24 dt25 dt26 dt27 dt28 dt29 dt30] ADC33
APOP0 [dt0 dt1 dt2 dt3] [g0_0 g0_1 g0_2] MPOP0
.model MPOP0 d_genlut (table_values="011010011001011000010111011111100000000000000001" rise_delay=[1n] fall_delay=[1n] input_load=[1f])
APOP1 [dt4 dt5 dt6 dt7] [g1_0 g1_1 g1_2] MPOP1
.model MPOP1 d_genlut (table_values="011010011001011000010111011111100000000000000001" rise_delay=[1n] fall_delay=[1n] input_load=[1f])
APOP2 [dt8 dt9 dt10 dt11] [g2_0 g2_1 g2_2] MPOP2
.model MPOP2 d_genlut (table_values="011010011001011000010111011111100000000000000001" rise_delay=[1n] fall_delay=[1n] input_load=[1f])
APOP3 [dt12 dt13 dt14 dt15] [g3_0 g3_1 g3_2] MPOP3
.model MPOP3 d_genlut (table_values="011010011001011000010111011111100000000000000001" rise_delay=[1n] fall_delay=[1n] input_load=[1f])
APOP4 [dt16 dt17 dt18 dt19] [g4_0 g4_1 g4_2] MPOP4
.model MPOP4 d_genlut (table_values="011010011001011000010111011111100000000000000001" rise_delay=[1n] fall_delay=[1n] input_load=[1f])
APOP5 [dt20 dt21 dt22 dt23] [g5_0 g5_1 g5_2] MPOP5
.model MPOP5 d_genlut (table_values="011010011001011000010111011111100000000000000001" rise_delay=[1n] fall_delay=[1n] input_load=[1f])
APOP6 [dt24 dt25 dt26 dt27] [g6_0 g6_1 g6_2] MPOP6
.model MPOP6 d_genlut (table_values="011010011001011000010111011111100000000000000001" rise_delay=[1n] fall_delay=[1n] input_load=[1f])
APOP7 [dt28 dt29 dt30] [g7_0 g7_1 g7_2] MPOP7
.model MPOP7 d_genlut (table_values="011010010001011100000000" rise_delay=[1n] fall_delay=[1n] input_load=[1f])
AADD0_0 [g0_0 g0_1 g0_2 g1_0 g1_1 g1_2] [a0_0_0 a0_0_1 a0_0_2 a0_0_3] MADD0_0
.model MADD0_0 d_genlut (table_values="0101010110101010010101011010101001010101101010100101010110101010001100110110011011001100100110010011001101100110110011001001100100001111000111100011110001111000111100001110000111000011100001110000000000000001000000110000011100001111000111110011111101111111" rise_delay=[1n] fall_delay=[1n] input_load=[1f])
AADD0_1 [g2_0 g2_1 g2_2 g3_0 g3_1 g3_2] [a0_1_0 a0_1_1 a0_1_2 a0_1_3] MADD0_1
.model MADD0_1 d_genlut (table_values="0101010110101010010101011010101001010101101010100101010110101010001100110110011011001100100110010011001101100110110011001001100100001111000111100011110001111000111100001110000111000011100001110000000000000001000000110000011100001111000111110011111101111111" rise_delay=[1n] fall_delay=[1n] input_load=[1f])
AADD0_2 [g4_0 g4_1 g4_2 g5_0 g5_1 g5_2] [a0_2_0 a0_2_1 a0_2_2 a0_2_3] MADD0_2
.model MADD0_2 d_genlut (table_values="0101010110101010010101011010101001010101101010100101010110101010001100110110011011001100100110010011001101100110110011001001100100001111000111100011110001111000111100001110000111000011100001110000000000000001000000110000011100001111000111110011111101111111" rise_delay=[1n] fall_delay=[1n] input_load=[1f])
AADD0_3 [g6_0 g6_1 g6_2 g7_0 g7_1 g7_2] [a0_3_0 a0_3_1 a0_3_2 a0_3_3] MADD0_3
.model MADD0_3 d_genlut (table_values="0101010110101010010101011010101001010101101010100101010110101010001100110110011011001100100110010011001101100110110011001001100100001111000111100011110001111000111100001110000111000011100001110000000000000001000000110000011100001111000111110011111101111111" rise_delay=[1n] fall_delay=[1n] input_load=[1f])
AADD1_0 [a0_0_0 a0_0_1 a0_0_2 a0_0_3 a0_1_0 a0_1_1 a0_1_2 a0_1_3] [a1_0_0 a1_0_1 a1_0_2 a1_0_3 a1_0_4] MADD1_0
.model MADD1_0 d_genlut (table_values="01010101010101011010101010101010010101010101010110101010101010100101010101010101101010101010101001010101010101011010101010101010010101010101010110101010101010100101010101010101101010101010101001010101010101011010101010101010010101010101010110101010101010100011001100110011011001100110011011001100110011001001100110011001001100110011001101100110011001101100110011001100100110011001100100110011001100110110011001100110110011001100110010011001100110010011001100110011011001100110011011001100110011001001100110011001000011110000111100011110000111100011110000111100011110000111100011110000111100001110000111100001110000111100001110000111100001110000111100001111000111100001111000111100001111000111100001111000111100001111000011100001111000011100001111000011100001111000011100000000111111110000000111111110000000111111110000000111111110000000111111110000000111111110000000111111110000000111111110000000111111110000000011111110000000011111110000000011111110000000011111110000000011111110000000011111110000000011111110000000011111110000000000000000000000000000000100000000000000110000000000000111000000000000111100000000000111110000000000111111000000000111111100000000111111110000000111111111000000111111111100000111111111110000111111111111000111111111111100111111111111110111111111111111" rise_delay=[1n] fall_delay=[1n] input_load=[1f])
AADD1_1 [a0_2_0 a0_2_1 a0_2_2 a0_2_3 a0_3_0 a0_3_1 a0_3_2 a0_3_3] [a1_1_0 a1_1_1 a1_1_2 a1_1_3 a1_1_4] MADD1_1
.model MADD1_1 d_genlut (table_values="01010101010101011010101010101010010101010101010110101010101010100101010101010101101010101010101001010101010101011010101010101010010101010101010110101010101010100101010101010101101010101010101001010101010101011010101010101010010101010101010110101010101010100011001100110011011001100110011011001100110011001001100110011001001100110011001101100110011001101100110011001100100110011001100100110011001100110110011001100110110011001100110010011001100110010011001100110011011001100110011011001100110011001001100110011001000011110000111100011110000111100011110000111100011110000111100011110000111100001110000111100001110000111100001110000111100001110000111100001111000111100001111000111100001111000111100001111000111100001111000011100001111000011100001111000011100001111000011100000000111111110000000111111110000000111111110000000111111110000000111111110000000111111110000000111111110000000111111110000000111111110000000011111110000000011111110000000011111110000000011111110000000011111110000000011111110000000011111110000000011111110000000000000000000000000000000100000000000000110000000000000111000000000000111100000000000111110000000000111111000000000111111100000000111111110000000111111111000000111111111100000111111111110000111111111111000111111111111100111111111111110111111111111111" rise_delay=[1n] fall_delay=[1n] input_load=[1f])
AADD2_0 [a1_0_0 a1_0_1 a1_0_2 a1_0_3 a1_0_4 a1_1_0 a1_1_1 a1_1_2 a1_1_3 a1_1_4] [a2_0_0 a2_0_1 a2_0_2 a2_0_3 a2_0_4] MADD2_0
.model MADD2_0 d_genlut (table_values="010101010101010101010101010101011010101010101010101010101010101x010101010101010101010101010101xx10101010101010101010101010101xxx0101010101010101010101010101xxxx101010101010101010101010101xxxxx01010101010101010101010101xxxxxx1010101010101010101010101xxxxxxx010101010101010101010101xxxxxxxx10101010101010101010101xxxxxxxxx0101010101010101010101xxxxxxxxxx101010101010101010101xxxxxxxxxxx01010101010101010101xxxxxxxxxxxx1010101010101010101xxxxxxxxxxxxx010101010101010101xxxxxxxxxxxxxx10101010101010101xxxxxxxxxxxxxxx0101010101010101xxxxxxxxxxxxxxxx101010101010101xxxxxxxxxxxxxxxxx01010101010101xxxxxxxxxxxxxxxxxx1010101010101xxxxxxxxxxxxxxxxxxx010101010101xxxxxxxxxxxxxxxxxxxx10101010101xxxxxxxxxxxxxxxxxxxxx0101010101xxxxxxxxxxxxxxxxxxxxxx101010101xxxxxxxxxxxxxxxxxxxxxxx01010101xxxxxxxxxxxxxxxxxxxxxxxx1010101xxxxxxxxxxxxxxxxxxxxxxxxx010101xxxxxxxxxxxxxxxxxxxxxxxxxx10101xxxxxxxxxxxxxxxxxxxxxxxxxxx0101xxxxxxxxxxxxxxxxxxxxxxxxxxxx101xxxxxxxxxxxxxxxxxxxxxxxxxxxxx01xxxxxxxxxxxxxxxxxxxxxxxxxxxxxx1xxxxxxxxxxxxxxxxxxxxxxxxxxxxxxx001100110011001100110011001100110110011001100110011001100110011x110011001100110011001100110011xx10011001100110011001100110011xxx0011001100110011001100110011xxxx011001100110011001100110011xxxxx11001100110011001100110011xxxxxx1001100110011001100110011xxxxxxx001100110011001100110011xxxxxxxx01100110011001100110011xxxxxxxxx1100110011001100110011xxxxxxxxxx100110011001100110011xxxxxxxxxxx00110011001100110011xxxxxxxxxxxx0110011001100110011xxxxxxxxxxxxx110011001100110011xxxxxxxxxxxxxx10011001100110011xxxxxxxxxxxxxxx0011001100110011xxxxxxxxxxxxxxxx011001100110011xxxxxxxxxxxxxxxxx11001100110011xxxxxxxxxxxxxxxxxx1001100110011xxxxxxxxxxxxxxxxxxx001100110011xxxxxxxxxxxxxxxxxxxx01100110011xxxxxxxxxxxxxxxxxxxxx1100110011xxxxxxxxxxxxxxxxxxxxxx100110011xxxxxxxxxxxxxxxxxxxxxxx00110011xxxxxxxxxxxxxxxxxxxxxxxx0110011xxxxxxxxxxxxxxxxxxxxxxxxx110011xxxxxxxxxxxxxxxxxxxxxxxxxx10011xxxxxxxxxxxxxxxxxxxxxxxxxxx0011xxxxxxxxxxxxxxxxxxxxxxxxxxxx011xxxxxxxxxxxxxxxxxxxxxxxxxxxxx11xxxxxxxxxxxxxxxxxxxxxxxxxxxxxx1xxxxxxxxxxxxxxxxxxxxxxxxxxxxxxx000011110000111100001111000011110001111000011110000111100001111x001111000011110000111100001111xx01111000011110000111100001111xxx1111000011110000111100001111xxxx111000011110000111100001111xxxxx11000011110000111100001111xxxxxx1000011110000111100001111xxxxxxx000011110000111100001111xxxxxxxx00011110000111100001111xxxxxxxxx0011110000111100001111xxxxxxxxxx011110000111100001111xxxxxxxxxxx11110000111100001111xxxxxxxxxxxx1110000111100001111xxxxxxxxxxxxx110000111100001111xxxxxxxxxxxxxx10000111100001111xxxxxxxxxxxxxxx0000111100001111xxxxxxxxxxxxxxxx000111100001111xxxxxxxxxxxxxxxxx00111100001111xxxxxxxxxxxxxxxxxx0111100001111xxxxxxxxxxxxxxxxxxx111100001111xxxxxxxxxxxxxxxxxxxx11100001111xxxxxxxxxxxxxxxxxxxxx1100001111xxxxxxxxxxxxxxxxxxxxxx100001111xxxxxxxxxxxxxxxxxxxxxxx00001111xxxxxxxxxxxxxxxxxxxxxxxx0001111xxxxxxxxxxxxxxxxxxxxxxxxx001111xxxxxxxxxxxxxxxxxxxxxxxxxx01111xxxxxxxxxxxxxxxxxxxxxxxxxxx1111xxxxxxxxxxxxxxxxxxxxxxxxxxxx111xxxxxxxxxxxxxxxxxxxxxxxxxxxxx11xxxxxxxxxxxxxxxxxxxxxxxxxxxxxx1xxxxxxxxxxxxxxxxxxxxxxxxxxxxxxx000000001111111100000000111111110000000111111110000000011111111x000000111111110000000011111111xx00000111111110000000011111111xxx0000111111110000000011111111xxxx000111111110000000011111111xxxxx00111111110000000011111111xxxxxx0111111110000000011111111xxxxxxx111111110000000011111111xxxxxxxx11111110000000011111111xxxxxxxxx1111110000000011111111xxxxxxxxxx111110000000011111111xxxxxxxxxxx11110000000011111111xxxxxxxxxxxx1110000000011111111xxxxxxxxxxxxx110000000011111111xxxxxxxxxxxxxx10000000011111111xxxxxxxxxxxxxxx0000000011111111xxxxxxxxxxxxxxxx000000011111111xxxxxxxxxxxxxxxxx00000011111111xxxxxxxxxxxxxxxxxx0000011111111xxxxxxxxxxxxxxxxxxx000011111111xxxxxxxxxxxxxxxxxxxx00011111111xxxxxxxxxxxxxxxxxxxxx0011111111xxxxxxxxxxxxxxxxxxxxxx011111111xxxxxxxxxxxxxxxxxxxxxxx11111111xxxxxxxxxxxxxxxxxxxxxxxx1111111xxxxxxxxxxxxxxxxxxxxxxxxx111111xxxxxxxxxxxxxxxxxxxxxxxxxx11111xxxxxxxxxxxxxxxxxxxxxxxxxxx1111xxxxxxxxxxxxxxxxxxxxxxxxxxxx111xxxxxxxxxxxxxxxxxxxxxxxxxxxxx11xxxxxxxxxxxxxxxxxxxxxxxxxxxxxx1xxxxxxxxxxxxxxxxxxxxxxxxxxxxxxx000000000000000011111111111111110000000000000001111111111111111x000000000000001111111111111111xx00000000000001111111111111111xxx0000000000001111111111111111xxxx000000000001111111111111111xxxxx00000000001111111111111111xxxxxx0000000001111111111111111xxxxxxx000000001111111111111111xxxxxxxx00000001111111111111111xxxxxxxxx0000001111111111111111xxxxxxxxxx000001111111111111111xxxxxxxxxxx00001111111111111111xxxxxxxxxxxx0001111111111111111xxxxxxxxxxxxx001111111111111111xxxxxxxxxxxxxx01111111111111111xxxxxxxxxxxxxxx1111111111111111xxxxxxxxxxxxxxxx111111111111111xxxxxxxxxxxxxxxxx11111111111111xxxxxxxxxxxxxxxxxx1111111111111xxxxxxxxxxxxxxxxxxx111111111111xxxxxxxxxxxxxxxxxxxx11111111111xxxxxxxxxxxxxxxxxxxxx1111111111xxxxxxxxxxxxxxxxxxxxxx111111111xxxxxxxxxxxxxxxxxxxxxxx11111111xxxxxxxxxxxxxxxxxxxxxxxx1111111xxxxxxxxxxxxxxxxxxxxxxxxx111111xxxxxxxxxxxxxxxxxxxxxxxxxx11111xxxxxxxxxxxxxxxxxxxxxxxxxxx1111xxxxxxxxxxxxxxxxxxxxxxxxxxxx111xxxxxxxxxxxxxxxxxxxxxxxxxxxxx11xxxxxxxxxxxxxxxxxxxxxxxxxxxxxx1xxxxxxxxxxxxxxxxxxxxxxxxxxxxxxx" rise_delay=[1n] fall_delay=[1n] input_load=[1f])
ADWA [a2_0_0 a2_0_1 a2_0_2 a2_0_3 a2_0_4 p0 p1 p2 p3 p4] [m0 m1 m2 m3 m4 m5 m6 m7 m8 m9 m10 m11 m12 m13 m14 m15 m16 m17 m18 m19 m20 m21 m22 m23 m24 m25 m26 m27 m28 m29 m30 np0 np1 np2 np3 np4] MDWA
.model MDWA d_genlut (table_values="11111111111111111111111111111110100000000000000000000000000000001100000000000000000000000000000011100000000000000000000000000000111100000000000000000000000000001111100000000000000000000000000011111100000000000000000000000000111111100000000000000000000000001111111100000000000000000000000011111111100000000000000000000000111111111100000000000000000000001111111111100000000000000000000011111111111100000000000000000000111111111111100000000000000000001111111111111100000000000000000011111111111111100000000000000000111111111111111100000000000000001111111111111111100000000000000011111111111111111100000000000000111111111111111111100000000000001111111111111111111100000000000011111111111111111111100000000000111111111111111111111100000000001111111111111111111111100000000011111111111111111111111100000000111111111111111111111111100000001111111111111111111111111100000011111111111111111111111111100000111111111111111111111111111100001111111111111111111111111111100011111111111111111111111111111100xxxxxxxxxxxxxxxxxxxxxxxxxxxxxxxx11111111111111111111111111111100111111111111111111111111111111101000000000000000000000000000000011000000000000000000000000000000111000000000000000000000000000001111000000000000000000000000000011111000000000000000000000000000111111000000000000000000000000001111111000000000000000000000000011111111000000000000000000000000111111111000000000000000000000001111111111000000000000000000000011111111111000000000000000000000111111111111000000000000000000001111111111111000000000000000000011111111111111000000000000000000111111111111111000000000000000001111111111111111000000000000000011111111111111111000000000000000111111111111111111000000000000001111111111111111111000000000000011111111111111111111000000000000111111111111111111111000000000001111111111111111111111000000000011111111111111111111111000000000111111111111111111111111000000001111111111111111111111111000000011111111111111111111111111000000111111111111111111111111111000001111111111111111111111111111000011111111111111111111111111111000xxxxxxxxxxxxxxxxxxxxxxxxxxxxxxxx11111111111111111111111111111000111111111111111111111111111111001111111111111111111111111111111010000000000000000000000000000000110000000000000000000000000000001110000000000000000000000000000011110000000000000000000000000000111110000000000000000000000000001111110000000000000000000000000011111110000000000000000000000000111111110000000000000000000000001111111110000000000000000000000011111111110000000000000000000000111111111110000000000000000000001111111111110000000000000000000011111111111110000000000000000000111111111111110000000000000000001111111111111110000000000000000011111111111111110000000000000000111111111111111110000000000000001111111111111111110000000000000011111111111111111110000000000000111111111111111111110000000000001111111111111111111110000000000011111111111111111111110000000000111111111111111111111110000000001111111111111111111111110000000011111111111111111111111110000000111111111111111111111111110000001111111111111111111111111110000011111111111111111111111111110000xxxxxxxxxxxxxxxxxxxxxxxxxxxxxxxx11111111111111111111111111110000111111111111111111111111111110001111111111111111111111111111110011111111111111111111111111111110100000000000000000000000000000001100000000000000000000000000000011100000000000000000000000000000111100000000000000000000000000001111100000000000000000000000000011111100000000000000000000000000111111100000000000000000000000001111111100000000000000000000000011111111100000000000000000000000111111111100000000000000000000001111111111100000000000000000000011111111111100000000000000000000111111111111100000000000000000001111111111111100000000000000000011111111111111100000000000000000111111111111111100000000000000001111111111111111100000000000000011111111111111111100000000000000111111111111111111100000000000001111111111111111111100000000000011111111111111111111100000000000111111111111111111111100000000001111111111111111111111100000000011111111111111111111111100000000111111111111111111111111100000001111111111111111111111111100000011111111111111111111111111100000xxxxxxxxxxxxxxxxxxxxxxxxxxxxxxxx11111111111111111111111111100000111111111111111111111111111100001111111111111111111111111111100011111111111111111111111111111100111111111111111111111111111111101000000000000000000000000000000011000000000000000000000000000000111000000000000000000000000000001111000000000000000000000000000011111000000000000000000000000000111111000000000000000000000000001111111000000000000000000000000011111111000000000000000000000000111111111000000000000000000000001111111111000000000000000000000011111111111000000000000000000000111111111111000000000000000000001111111111111000000000000000000011111111111111000000000000000000111111111111111000000000000000001111111111111111000000000000000011111111111111111000000000000000111111111111111111000000000000001111111111111111111000000000000011111111111111111111000000000000111111111111111111111000000000001111111111111111111111000000000011111111111111111111111000000000111111111111111111111111000000001111111111111111111111111000000011111111111111111111111111000000xxxxxxxxxxxxxxxxxxxxxxxxxxxxxxxx11111111111111111111111111000000111111111111111111111111111000001111111111111111111111111111000011111111111111111111111111111000111111111111111111111111111111001111111111111111111111111111111010000000000000000000000000000000110000000000000000000000000000001110000000000000000000000000000011110000000000000000000000000000111110000000000000000000000000001111110000000000000000000000000011111110000000000000000000000000111111110000000000000000000000001111111110000000000000000000000011111111110000000000000000000000111111111110000000000000000000001111111111110000000000000000000011111111111110000000000000000000111111111111110000000000000000001111111111111110000000000000000011111111111111110000000000000000111111111111111110000000000000001111111111111111110000000000000011111111111111111110000000000000111111111111111111110000000000001111111111111111111110000000000011111111111111111111110000000000111111111111111111111110000000001111111111111111111111110000000011111111111111111111111110000000xxxxxxxxxxxxxxxxxxxxxxxxxxxxxxxx11111111111111111111111110000000111111111111111111111111110000001111111111111111111111111110000011111111111111111111111111110000111111111111111111111111111110001111111111111111111111111111110011111111111111111111111111111110100000000000000000000000000000001100000000000000000000000000000011100000000000000000000000000000111100000000000000000000000000001111100000000000000000000000000011111100000000000000000000000000111111100000000000000000000000001111111100000000000000000000000011111111100000000000000000000000111111111100000000000000000000001111111111100000000000000000000011111111111100000000000000000000111111111111100000000000000000001111111111111100000000000000000011111111111111100000000000000000111111111111111100000000000000001111111111111111100000000000000011111111111111111100000000000000111111111111111111100000000000001111111111111111111100000000000011111111111111111111100000000000111111111111111111111100000000001111111111111111111111100000000011111111111111111111111100000000xxxxxxxxxxxxxxxxxxxxxxxxxxxxxxxx11111111111111111111111100000000111111111111111111111111100000001111111111111111111111111100000011111111111111111111111111100000111111111111111111111111111100001111111111111111111111111111100011111111111111111111111111111100111111111111111111111111111111101000000000000000000000000000000011000000000000000000000000000000111000000000000000000000000000001111000000000000000000000000000011111000000000000000000000000000111111000000000000000000000000001111111000000000000000000000000011111111000000000000000000000000111111111000000000000000000000001111111111000000000000000000000011111111111000000000000000000000111111111111000000000000000000001111111111111000000000000000000011111111111111000000000000000000111111111111111000000000000000001111111111111111000000000000000011111111111111111000000000000000111111111111111111000000000000001111111111111111111000000000000011111111111111111111000000000000111111111111111111111000000000001111111111111111111111000000000011111111111111111111111000000000xxxxxxxxxxxxxxxxxxxxxxxxxxxxxxxx11111111111111111111111000000000111111111111111111111111000000001111111111111111111111111000000011111111111111111111111111000000111111111111111111111111111000001111111111111111111111111111000011111111111111111111111111111000111111111111111111111111111111001111111111111111111111111111111010000000000000000000000000000000110000000000000000000000000000001110000000000000000000000000000011110000000000000000000000000000111110000000000000000000000000001111110000000000000000000000000011111110000000000000000000000000111111110000000000000000000000001111111110000000000000000000000011111111110000000000000000000000111111111110000000000000000000001111111111110000000000000000000011111111111110000000000000000000111111111111110000000000000000001111111111111110000000000000000011111111111111110000000000000000111111111111111110000000000000001111111111111111110000000000000011111111111111111110000000000000111111111111111111110000000000001111111111111111111110000000000011111111111111111111110000000000xxxxxxxxxxxxxxxxxxxxxxxxxxxxxxxx11111111111111111111110000000000111111111111111111111110000000001111111111111111111111110000000011111111111111111111111110000000111111111111111111111111110000001111111111111111111111111110000011111111111111111111111111110000111111111111111111111111111110001111111111111111111111111111110011111111111111111111111111111110100000000000000000000000000000001100000000000000000000000000000011100000000000000000000000000000111100000000000000000000000000001111100000000000000000000000000011111100000000000000000000000000111111100000000000000000000000001111111100000000000000000000000011111111100000000000000000000000111111111100000000000000000000001111111111100000000000000000000011111111111100000000000000000000111111111111100000000000000000001111111111111100000000000000000011111111111111100000000000000000111111111111111100000000000000001111111111111111100000000000000011111111111111111100000000000000111111111111111111100000000000001111111111111111111100000000000011111111111111111111100000000000xxxxxxxxxxxxxxxxxxxxxxxxxxxxxxxx11111111111111111111100000000000111111111111111111111100000000001111111111111111111111100000000011111111111111111111111100000000111111111111111111111111100000001111111111111111111111111100000011111111111111111111111111100000111111111111111111111111111100001111111111111111111111111111100011111111111111111111111111111100111111111111111111111111111111101000000000000000000000000000000011000000000000000000000000000000111000000000000000000000000000001111000000000000000000000000000011111000000000000000000000000000111111000000000000000000000000001111111000000000000000000000000011111111000000000000000000000000111111111000000000000000000000001111111111000000000000000000000011111111111000000000000000000000111111111111000000000000000000001111111111111000000000000000000011111111111111000000000000000000111111111111111000000000000000001111111111111111000000000000000011111111111111111000000000000000111111111111111111000000000000001111111111111111111000000000000011111111111111111111000000000000xxxxxxxxxxxxxxxxxxxxxxxxxxxxxxxx11111111111111111111000000000000111111111111111111111000000000001111111111111111111111000000000011111111111111111111111000000000111111111111111111111111000000001111111111111111111111111000000011111111111111111111111111000000111111111111111111111111111000001111111111111111111111111111000011111111111111111111111111111000111111111111111111111111111111001111111111111111111111111111111010000000000000000000000000000000110000000000000000000000000000001110000000000000000000000000000011110000000000000000000000000000111110000000000000000000000000001111110000000000000000000000000011111110000000000000000000000000111111110000000000000000000000001111111110000000000000000000000011111111110000000000000000000000111111111110000000000000000000001111111111110000000000000000000011111111111110000000000000000000111111111111110000000000000000001111111111111110000000000000000011111111111111110000000000000000111111111111111110000000000000001111111111111111110000000000000011111111111111111110000000000000xxxxxxxxxxxxxxxxxxxxxxxxxxxxxxxx11111111111111111110000000000000111111111111111111110000000000001111111111111111111110000000000011111111111111111111110000000000111111111111111111111110000000001111111111111111111111110000000011111111111111111111111110000000111111111111111111111111110000001111111111111111111111111110000011111111111111111111111111110000111111111111111111111111111110001111111111111111111111111111110011111111111111111111111111111110100000000000000000000000000000001100000000000000000000000000000011100000000000000000000000000000111100000000000000000000000000001111100000000000000000000000000011111100000000000000000000000000111111100000000000000000000000001111111100000000000000000000000011111111100000000000000000000000111111111100000000000000000000001111111111100000000000000000000011111111111100000000000000000000111111111111100000000000000000001111111111111100000000000000000011111111111111100000000000000000111111111111111100000000000000001111111111111111100000000000000011111111111111111100000000000000xxxxxxxxxxxxxxxxxxxxxxxxxxxxxxxx11111111111111111100000000000000111111111111111111100000000000001111111111111111111100000000000011111111111111111111100000000000111111111111111111111100000000001111111111111111111111100000000011111111111111111111111100000000111111111111111111111111100000001111111111111111111111111100000011111111111111111111111111100000111111111111111111111111111100001111111111111111111111111111100011111111111111111111111111111100111111111111111111111111111111101000000000000000000000000000000011000000000000000000000000000000111000000000000000000000000000001111000000000000000000000000000011111000000000000000000000000000111111000000000000000000000000001111111000000000000000000000000011111111000000000000000000000000111111111000000000000000000000001111111111000000000000000000000011111111111000000000000000000000111111111111000000000000000000001111111111111000000000000000000011111111111111000000000000000000111111111111111000000000000000001111111111111111000000000000000011111111111111111000000000000000xxxxxxxxxxxxxxxxxxxxxxxxxxxxxxxx11111111111111111000000000000000111111111111111111000000000000001111111111111111111000000000000011111111111111111111000000000000111111111111111111111000000000001111111111111111111111000000000011111111111111111111111000000000111111111111111111111111000000001111111111111111111111111000000011111111111111111111111111000000111111111111111111111111111000001111111111111111111111111111000011111111111111111111111111111000111111111111111111111111111111001111111111111111111111111111111010000000000000000000000000000000110000000000000000000000000000001110000000000000000000000000000011110000000000000000000000000000111110000000000000000000000000001111110000000000000000000000000011111110000000000000000000000000111111110000000000000000000000001111111110000000000000000000000011111111110000000000000000000000111111111110000000000000000000001111111111110000000000000000000011111111111110000000000000000000111111111111110000000000000000001111111111111110000000000000000011111111111111110000000000000000xxxxxxxxxxxxxxxxxxxxxxxxxxxxxxxx11111111111111110000000000000000111111111111111110000000000000001111111111111111110000000000000011111111111111111110000000000000111111111111111111110000000000001111111111111111111110000000000011111111111111111111110000000000111111111111111111111110000000001111111111111111111111110000000011111111111111111111111110000000111111111111111111111111110000001111111111111111111111111110000011111111111111111111111111110000111111111111111111111111111110001111111111111111111111111111110011111111111111111111111111111110100000000000000000000000000000001100000000000000000000000000000011100000000000000000000000000000111100000000000000000000000000001111100000000000000000000000000011111100000000000000000000000000111111100000000000000000000000001111111100000000000000000000000011111111100000000000000000000000111111111100000000000000000000001111111111100000000000000000000011111111111100000000000000000000111111111111100000000000000000001111111111111100000000000000000011111111111111100000000000000000xxxxxxxxxxxxxxxxxxxxxxxxxxxxxxxx11111111111111100000000000000000111111111111111100000000000000001111111111111111100000000000000011111111111111111100000000000000111111111111111111100000000000001111111111111111111100000000000011111111111111111111100000000000111111111111111111111100000000001111111111111111111111100000000011111111111111111111111100000000111111111111111111111111100000001111111111111111111111111100000011111111111111111111111111100000111111111111111111111111111100001111111111111111111111111111100011111111111111111111111111111100111111111111111111111111111111101000000000000000000000000000000011000000000000000000000000000000111000000000000000000000000000001111000000000000000000000000000011111000000000000000000000000000111111000000000000000000000000001111111000000000000000000000000011111111000000000000000000000000111111111000000000000000000000001111111111000000000000000000000011111111111000000000000000000000111111111111000000000000000000001111111111111000000000000000000011111111111111000000000000000000xxxxxxxxxxxxxxxxxxxxxxxxxxxxxxxx11111111111111000000000000000000111111111111111000000000000000001111111111111111000000000000000011111111111111111000000000000000111111111111111111000000000000001111111111111111111000000000000011111111111111111111000000000000111111111111111111111000000000001111111111111111111111000000000011111111111111111111111000000000111111111111111111111111000000001111111111111111111111111000000011111111111111111111111111000000111111111111111111111111111000001111111111111111111111111111000011111111111111111111111111111000111111111111111111111111111111001111111111111111111111111111111010000000000000000000000000000000110000000000000000000000000000001110000000000000000000000000000011110000000000000000000000000000111110000000000000000000000000001111110000000000000000000000000011111110000000000000000000000000111111110000000000000000000000001111111110000000000000000000000011111111110000000000000000000000111111111110000000000000000000001111111111110000000000000000000011111111111110000000000000000000xxxxxxxxxxxxxxxxxxxxxxxxxxxxxxxx11111111111110000000000000000000111111111111110000000000000000001111111111111110000000000000000011111111111111110000000000000000111111111111111110000000000000001111111111111111110000000000000011111111111111111110000000000000111111111111111111110000000000001111111111111111111110000000000011111111111111111111110000000000111111111111111111111110000000001111111111111111111111110000000011111111111111111111111110000000111111111111111111111111110000001111111111111111111111111110000011111111111111111111111111110000111111111111111111111111111110001111111111111111111111111111110011111111111111111111111111111110100000000000000000000000000000001100000000000000000000000000000011100000000000000000000000000000111100000000000000000000000000001111100000000000000000000000000011111100000000000000000000000000111111100000000000000000000000001111111100000000000000000000000011111111100000000000000000000000111111111100000000000000000000001111111111100000000000000000000011111111111100000000000000000000xxxxxxxxxxxxxxxxxxxxxxxxxxxxxxxx11111111111100000000000000000000111111111111100000000000000000001111111111111100000000000000000011111111111111100000000000000000111111111111111100000000000000001111111111111111100000000000000011111111111111111100000000000000111111111111111111100000000000001111111111111111111100000000000011111111111111111111100000000000111111111111111111111100000000001111111111111111111111100000000011111111111111111111111100000000111111111111111111111111100000001111111111111111111111111100000011111111111111111111111111100000111111111111111111111111111100001111111111111111111111111111100011111111111111111111111111111100111111111111111111111111111111101000000000000000000000000000000011000000000000000000000000000000111000000000000000000000000000001111000000000000000000000000000011111000000000000000000000000000111111000000000000000000000000001111111000000000000000000000000011111111000000000000000000000000111111111000000000000000000000001111111111000000000000000000000011111111111000000000000000000000xxxxxxxxxxxxxxxxxxxxxxxxxxxxxxxx11111111111000000000000000000000111111111111000000000000000000001111111111111000000000000000000011111111111111000000000000000000111111111111111000000000000000001111111111111111000000000000000011111111111111111000000000000000111111111111111111000000000000001111111111111111111000000000000011111111111111111111000000000000111111111111111111111000000000001111111111111111111111000000000011111111111111111111111000000000111111111111111111111111000000001111111111111111111111111000000011111111111111111111111111000000111111111111111111111111111000001111111111111111111111111111000011111111111111111111111111111000111111111111111111111111111111001111111111111111111111111111111010000000000000000000000000000000110000000000000000000000000000001110000000000000000000000000000011110000000000000000000000000000111110000000000000000000000000001111110000000000000000000000000011111110000000000000000000000000111111110000000000000000000000001111111110000000000000000000000011111111110000000000000000000000xxxxxxxxxxxxxxxxxxxxxxxxxxxxxxxx11111111110000000000000000000000111111111110000000000000000000001111111111110000000000000000000011111111111110000000000000000000111111111111110000000000000000001111111111111110000000000000000011111111111111110000000000000000111111111111111110000000000000001111111111111111110000000000000011111111111111111110000000000000111111111111111111110000000000001111111111111111111110000000000011111111111111111111110000000000111111111111111111111110000000001111111111111111111111110000000011111111111111111111111110000000111111111111111111111111110000001111111111111111111111111110000011111111111111111111111111110000111111111111111111111111111110001111111111111111111111111111110011111111111111111111111111111110100000000000000000000000000000001100000000000000000000000000000011100000000000000000000000000000111100000000000000000000000000001111100000000000000000000000000011111100000000000000000000000000111111100000000000000000000000001111111100000000000000000000000011111111100000000000000000000000xxxxxxxxxxxxxxxxxxxxxxxxxxxxxxxx11111111100000000000000000000000111111111100000000000000000000001111111111100000000000000000000011111111111100000000000000000000111111111111100000000000000000001111111111111100000000000000000011111111111111100000000000000000111111111111111100000000000000001111111111111111100000000000000011111111111111111100000000000000111111111111111111100000000000001111111111111111111100000000000011111111111111111111100000000000111111111111111111111100000000001111111111111111111111100000000011111111111111111111111100000000111111111111111111111111100000001111111111111111111111111100000011111111111111111111111111100000111111111111111111111111111100001111111111111111111111111111100011111111111111111111111111111100111111111111111111111111111111101000000000000000000000000000000011000000000000000000000000000000111000000000000000000000000000001111000000000000000000000000000011111000000000000000000000000000111111000000000000000000000000001111111000000000000000000000000011111111000000000000000000000000xxxxxxxxxxxxxxxxxxxxxxxxxxxxxxxx11111111000000000000000000000000111111111000000000000000000000001111111111000000000000000000000011111111111000000000000000000000111111111111000000000000000000001111111111111000000000000000000011111111111111000000000000000000111111111111111000000000000000001111111111111111000000000000000011111111111111111000000000000000111111111111111111000000000000001111111111111111111000000000000011111111111111111111000000000000111111111111111111111000000000001111111111111111111111000000000011111111111111111111111000000000111111111111111111111111000000001111111111111111111111111000000011111111111111111111111111000000111111111111111111111111111000001111111111111111111111111111000011111111111111111111111111111000111111111111111111111111111111001111111111111111111111111111111010000000000000000000000000000000110000000000000000000000000000001110000000000000000000000000000011110000000000000000000000000000111110000000000000000000000000001111110000000000000000000000000011111110000000000000000000000000xxxxxxxxxxxxxxxxxxxxxxxxxxxxxxxx11111110000000000000000000000000111111110000000000000000000000001111111110000000000000000000000011111111110000000000000000000000111111111110000000000000000000001111111111110000000000000000000011111111111110000000000000000000111111111111110000000000000000001111111111111110000000000000000011111111111111110000000000000000111111111111111110000000000000001111111111111111110000000000000011111111111111111110000000000000111111111111111111110000000000001111111111111111111110000000000011111111111111111111110000000000111111111111111111111110000000001111111111111111111111110000000011111111111111111111111110000000111111111111111111111111110000001111111111111111111111111110000011111111111111111111111111110000111111111111111111111111111110001111111111111111111111111111110011111111111111111111111111111110100000000000000000000000000000001100000000000000000000000000000011100000000000000000000000000000111100000000000000000000000000001111100000000000000000000000000011111100000000000000000000000000xxxxxxxxxxxxxxxxxxxxxxxxxxxxxxxx11111100000000000000000000000000111111100000000000000000000000001111111100000000000000000000000011111111100000000000000000000000111111111100000000000000000000001111111111100000000000000000000011111111111100000000000000000000111111111111100000000000000000001111111111111100000000000000000011111111111111100000000000000000111111111111111100000000000000001111111111111111100000000000000011111111111111111100000000000000111111111111111111100000000000001111111111111111111100000000000011111111111111111111100000000000111111111111111111111100000000001111111111111111111111100000000011111111111111111111111100000000111111111111111111111111100000001111111111111111111111111100000011111111111111111111111111100000111111111111111111111111111100001111111111111111111111111111100011111111111111111111111111111100111111111111111111111111111111101000000000000000000000000000000011000000000000000000000000000000111000000000000000000000000000001111000000000000000000000000000011111000000000000000000000000000xxxxxxxxxxxxxxxxxxxxxxxxxxxxxxxx11111000000000000000000000000000111111000000000000000000000000001111111000000000000000000000000011111111000000000000000000000000111111111000000000000000000000001111111111000000000000000000000011111111111000000000000000000000111111111111000000000000000000001111111111111000000000000000000011111111111111000000000000000000111111111111111000000000000000001111111111111111000000000000000011111111111111111000000000000000111111111111111111000000000000001111111111111111111000000000000011111111111111111111000000000000111111111111111111111000000000001111111111111111111111000000000011111111111111111111111000000000111111111111111111111111000000001111111111111111111111111000000011111111111111111111111111000000111111111111111111111111111000001111111111111111111111111111000011111111111111111111111111111000111111111111111111111111111111001111111111111111111111111111111010000000000000000000000000000000110000000000000000000000000000001110000000000000000000000000000011110000000000000000000000000000xxxxxxxxxxxxxxxxxxxxxxxxxxxxxxxx11110000000000000000000000000000111110000000000000000000000000001111110000000000000000000000000011111110000000000000000000000000111111110000000000000000000000001111111110000000000000000000000011111111110000000000000000000000111111111110000000000000000000001111111111110000000000000000000011111111111110000000000000000000111111111111110000000000000000001111111111111110000000000000000011111111111111110000000000000000111111111111111110000000000000001111111111111111110000000000000011111111111111111110000000000000111111111111111111110000000000001111111111111111111110000000000011111111111111111111110000000000111111111111111111111110000000001111111111111111111111110000000011111111111111111111111110000000111111111111111111111111110000001111111111111111111111111110000011111111111111111111111111110000111111111111111111111111111110001111111111111111111111111111110011111111111111111111111111111110100000000000000000000000000000001100000000000000000000000000000011100000000000000000000000000000xxxxxxxxxxxxxxxxxxxxxxxxxxxxxxxx11100000000000000000000000000000111100000000000000000000000000001111100000000000000000000000000011111100000000000000000000000000111111100000000000000000000000001111111100000000000000000000000011111111100000000000000000000000111111111100000000000000000000001111111111100000000000000000000011111111111100000000000000000000111111111111100000000000000000001111111111111100000000000000000011111111111111100000000000000000111111111111111100000000000000001111111111111111100000000000000011111111111111111100000000000000111111111111111111100000000000001111111111111111111100000000000011111111111111111111100000000000111111111111111111111100000000001111111111111111111111100000000011111111111111111111111100000000111111111111111111111111100000001111111111111111111111111100000011111111111111111111111111100000111111111111111111111111111100001111111111111111111111111111100011111111111111111111111111111100111111111111111111111111111111101000000000000000000000000000000011000000000000000000000000000000xxxxxxxxxxxxxxxxxxxxxxxxxxxxxxxx11000000000000000000000000000000111000000000000000000000000000001111000000000000000000000000000011111000000000000000000000000000111111000000000000000000000000001111111000000000000000000000000011111111000000000000000000000000111111111000000000000000000000001111111111000000000000000000000011111111111000000000000000000000111111111111000000000000000000001111111111111000000000000000000011111111111111000000000000000000111111111111111000000000000000001111111111111111000000000000000011111111111111111000000000000000111111111111111111000000000000001111111111111111111000000000000011111111111111111111000000000000111111111111111111111000000000001111111111111111111111000000000011111111111111111111111000000000111111111111111111111111000000001111111111111111111111111000000011111111111111111111111111000000111111111111111111111111111000001111111111111111111111111111000011111111111111111111111111111000111111111111111111111111111111001111111111111111111111111111111010000000000000000000000000000000xxxxxxxxxxxxxxxxxxxxxxxxxxxxxxxx10000000000000000000000000000000110000000000000000000000000000001110000000000000000000000000000011110000000000000000000000000000111110000000000000000000000000001111110000000000000000000000000011111110000000000000000000000000111111110000000000000000000000001111111110000000000000000000000011111111110000000000000000000000111111111110000000000000000000001111111111110000000000000000000011111111111110000000000000000000111111111111110000000000000000001111111111111110000000000000000011111111111111110000000000000000111111111111111110000000000000001111111111111111110000000000000011111111111111111110000000000000111111111111111111110000000000001111111111111111111110000000000011111111111111111111110000000000111111111111111111111110000000001111111111111111111111110000000011111111111111111111111110000000111111111111111111111111110000001111111111111111111111111110000011111111111111111111111111110000111111111111111111111111111110001111111111111111111111111111110011111111111111111111111111111110xxxxxxxxxxxxxxxxxxxxxxxxxxxxxxxx00101010101010101010101010101010100101010101010101010101010101010100101010101010101010101010101010100101010101010101010101010101010100101010101010101010101010101010100101010101010101010101010101010100101010101010101010101010101010100101010101010101010101010101010100101010101010101010101010101010100101010101010101010101010101010100101010101010101010101010101010100101010101010101010101010101010100101010101010101010101010101010100101010101010101010101010101010100101010101010101010101010101010100101010101010101010101010101010100101010101010101010101010101010100101010101010101010101010101010100101010101010101010101010101010100101010101010101010101010101010100101010101010101010101010101010100101010101010101010101010101010100101010101010101010101010101010100101010101010101010101010101010100101010101010101010101010101010100101010101010101010101010101010100101010101010101010101010101010100101010101010101010101010101010100101010101010101010101010101010100101010101010101010101010101010100xxxxxxxxxxxxxxxxxxxxxxxxxxxxxxxx01001100110011001100110011001100001001100110011001100110011001101001001100110011001100110011001111001001100110011001100110011001011001001100110011001100110011000011001001100110011001100110011010011001001100110011001100110011110011001001100110011001100110010110011001001100110011001100110000110011001001100110011001100110100110011001001100110011001100111100110011001001100110011001100101100110011001001100110011001100001100110011001001100110011001101001100110011001001100110011001111001100110011001001100110011001011001100110011001001100110011000011001100110011001001100110011010011001100110011001001100110011110011001100110011001001100110010110011001100110011001001100110000110011001100110011001001100110100110011001100110011001001100111100110011001100110011001001100101100110011001100110011001001100001100110011001100110011001001101001100110011001100110011001001111001100110011001100110011001001011001100110011001100110011001000011001100110011001100110011001010011001100110011001100110011001xxxxxxxxxxxxxxxxxxxxxxxxxxxxxxxx01110000111100001111000011110000001110000111100001111000011110000001110000111100001111000011110000001110000111100001111000011110100001110000111100001111000011111100001110000111100001111000011111100001110000111100001111000011111100001110000111100001111000010111100001110000111100001111000000111100001110000111100001111000000111100001110000111100001111000000111100001110000111100001111010000111100001110000111100001111110000111100001110000111100001111110000111100001110000111100001111110000111100001110000111100001011110000111100001110000111100000011110000111100001110000111100000011110000111100001110000111100000011110000111100001110000111101000011110000111100001110000111111000011110000111100001110000111111000011110000111100001110000111111000011110000111100001110000101111000011110000111100001110000001111000011110000111100001110000001111000011110000111100001110000001111000011110000111100001110100001111000011110000111100001111100001111000011110000111100001111100001111000011110000111100001xxxxxxxxxxxxxxxxxxxxxxxxxxxxxxxx01111111000000001111111100000000001111111000000001111111100000000001111111000000001111111100000000001111111000000001111111100000000001111111000000001111111100000000001111111000000001111111100000000001111111000000001111111100000000001111111000000001111111101000000001111111000000001111111111000000001111111000000001111111111000000001111111000000001111111111000000001111111000000001111111111000000001111111000000001111111111000000001111111000000001111111111000000001111111000000001111111111000000001111111000000001011111111000000001111111000000000011111111000000001111111000000000011111111000000001111111000000000011111111000000001111111000000000011111111000000001111111000000000011111111000000001111111000000000011111111000000001111111000000000011111111000000001111111010000000011111111000000001111111110000000011111111000000001111111110000000011111111000000001111111110000000011111111000000001111111110000000011111111000000001111111110000000011111111000000001111111110000000011111111000000001xxxxxxxxxxxxxxxxxxxxxxxxxxxxxxxx01111111111111110000000000000000001111111111111110000000000000000001111111111111110000000000000000001111111111111110000000000000000001111111111111110000000000000000001111111111111110000000000000000001111111111111110000000000000000001111111111111110000000000000000001111111111111110000000000000000001111111111111110000000000000000001111111111111110000000000000000001111111111111110000000000000000001111111111111110000000000000000001111111111111110000000000000000001111111111111110000000000000000001111111111111110100000000000000001111111111111111100000000000000001111111111111111100000000000000001111111111111111100000000000000001111111111111111100000000000000001111111111111111100000000000000001111111111111111100000000000000001111111111111111100000000000000001111111111111111100000000000000001111111111111111100000000000000001111111111111111100000000000000001111111111111111100000000000000001111111111111111100000000000000001111111111111111100000000000000001111111111111111100000000000000001xxxxxxxxxxxxxxxxxxxxxxxxxxxxxxxx" rise_delay=[1n] fall_delay=[1n] input_load=[1f])
APTR0 np0 clk NULL rst p0 NULL FF0
APTR1 np1 clk NULL rst p1 NULL FF0
APTR2 np2 clk NULL rst p2 NULL FF0
APTR3 np3 clk NULL rst p3 NULL FF0
APTR4 np4 clk NULL rst p4 NULL FF0
ASEL0 m0 clk rst NULL q0 nq0 FF1
ASEL1 m1 clk rst NULL q1 nq1 FF1
ASEL2 m2 clk rst NULL q2 nq2 FF1
ASEL3 m3 clk rst NULL q3 nq3 FF1
ASEL4 m4 clk rst NULL q4 nq4 FF1
ASEL5 m5 clk rst NULL q5 nq5 FF1
ASEL6 m6 clk rst NULL q6 nq6 FF1
ASEL7 m7 clk rst NULL q7 nq7 FF1
ASEL8 m8 clk rst NULL q8 nq8 FF1
ASEL9 m9 clk rst NULL q9 nq9 FF1
ASEL10 m10 clk rst NULL q10 nq10 FF1
ASEL11 m11 clk rst NULL q11 nq11 FF1
ASEL12 m12 clk rst NULL q12 nq12 FF1
ASEL13 m13 clk rst NULL q13 nq13 FF1
ASEL14 m14 clk rst NULL q14 nq14 FF1
ASEL15 m15 clk rst NULL q15 nq15 FF1
ASEL16 m16 clk NULL rst q16 nq16 FF0
ASEL17 m17 clk NULL rst q17 nq17 FF0
ASEL18 m18 clk NULL rst q18 nq18 FF0
ASEL19 m19 clk NULL rst q19 nq19 FF0
ASEL20 m20 clk NULL rst q20 nq20 FF0
ASEL21 m21 clk NULL rst q21 nq21 FF0
ASEL22 m22 clk NULL rst q22 nq22 FF0
ASEL23 m23 clk NULL rst q23 nq23 FF0
ASEL24 m24 clk NULL rst q24 nq24 FF0
ASEL25 m25 clk NULL rst q25 nq25 FF0
ASEL26 m26 clk NULL rst q26 nq26 FF0
ASEL27 m27 clk NULL rst q27 nq27 FF0
ASEL28 m28 clk NULL rst q28 nq28 FF0
ASEL29 m29 clk NULL rst q29 nq29 FF0
ASEL30 m30 clk NULL rst q30 nq30 FF0
ACODE0 a2_0_0 clk rst NULL c0 NULL FF1
ACODE1 a2_0_1 clk rst NULL c1 NULL FF1
ACODE2 a2_0_2 clk rst NULL c2 NULL FF1
ACODE3 a2_0_3 clk rst NULL c3 NULL FF1
ACODE4 a2_0_4 clk NULL rst c4 NULL FF0
AINT2 [c0 c1 c2 c3 c4] [s20 s21 s22 s23 s24 s25 s26 s27 s28 s29 s210 s211 s212 s213 s214 s215 s216 s217 s218 s219 s220 s221 s222 s223 s224 s225 s226 s227 s228 s229 s230 ns20 ns21 ns22 ns23 ns24 ns25 ns26 ns27 ns28 ns29 ns210 ns211 ns212 ns213 ns214 ns215 ns216 ns217 ns218 ns219 ns220 ns221 ns222 ns223 ns224 ns225 ns226 ns227 ns228 ns229 ns230] MINT2
.model MINT2 d_genlut (table_values="1111111111111111111111111111111011111111111111111111111111111100111111111111111111111111111110001111111111111111111111111111000011111111111111111111111111100000111111111111111111111111110000001111111111111111111111111000000011111111111111111111111100000000111111111111111111111110000000001111111111111111111111000000000011111111111111111111100000000000111111111111111111110000000000001111111111111111111000000000000011111111111111111100000000000000111111111111111110000000000000001111111111111111000000000000000011111111111111100000000000000000111111111111110000000000000000001111111111111000000000000000000011111111111100000000000000000000111111111110000000000000000000001111111111000000000000000000000011111111100000000000000000000000111111110000000000000000000000001111111000000000000000000000000011111100000000000000000000000000111110000000000000000000000000001111000000000000000000000000000011100000000000000000000000000000110000000000000000000000000000001000000000000000000000000000000000000000000000000000000000000001000000000000000000000000000000110000000000000000000000000000011100000000000000000000000000001111000000000000000000000000000111110000000000000000000000000011111100000000000000000000000001111111000000000000000000000000111111110000000000000000000000011111111100000000000000000000001111111111000000000000000000000111111111110000000000000000000011111111111100000000000000000001111111111111000000000000000000111111111111110000000000000000011111111111111100000000000000001111111111111111000000000000000111111111111111110000000000000011111111111111111100000000000001111111111111111111000000000000111111111111111111110000000000011111111111111111111100000000001111111111111111111111000000000111111111111111111111110000000011111111111111111111111100000001111111111111111111111111000000111111111111111111111111110000011111111111111111111111111100001111111111111111111111111111000111111111111111111111111111110011111111111111111111111111111101111111111111111111111111111111" rise_delay=[1n] fall_delay=[1n] input_load=[1f])
AOUTPUT [q0 q1 q2 q3 q4 q5 q6 q7 q8 q9 q10 q11 q12 q13 q14 q15 q16 q17 q18 q19 q20 q21 q22 q23 q24 q25 q26 q27 q28 q29 q30 nq0 nq1 nq2 nq3 nq4 nq5 nq6 nq7 nq8 nq9 nq10 nq11 nq12 nq13 nq14 nq15 nq16 nq17 nq18 nq19 nq20 nq21 nq22 nq23 nq24 nq25 nq26 nq27 nq28 nq29 nq30 s20 s21 s22 s23 s24 s25 s26 s27 s28 s29 s210 s211 s212 s213 s214 s215 s216 s217 s218 s219 s220 s221 s222 s223 s224 s225 s226 s227 s228 s229 s230 ns20 ns21 ns22 ns23 ns24 ns25 ns26 ns27 ns28 ns29 ns210 ns211 ns212 ns213 ns214 ns215 ns216 ns217 ns218 ns219 ns220 ns221 ns222 ns223 ns224 ns225 ns226 ns227 ns228 ns229 ns230] [SEL0 SEL1 SEL2 SEL3 SEL4 SEL5 SEL6 SEL7 SEL8 SEL9 SEL10 SEL11 SEL12 SEL13 SEL14 SEL15 SEL16 SEL17 SEL18 SEL19 SEL20 SEL21 SEL22 SEL23 SEL24 SEL25 SEL26 SEL27 SEL28 SEL29 SEL30 SELN0 SELN1 SELN2 SELN3 SELN4 SELN5 SELN6 SELN7 SELN8 SELN9 SELN10 SELN11 SELN12 SELN13 SELN14 SELN15 SELN16 SELN17 SELN18 SELN19 SELN20 SELN21 SELN22 SELN23 SELN24 SELN25 SELN26 SELN27 SELN28 SELN29 SELN30 S2L0 S2L1 S2L2 S2L3 S2L4 S2L5 S2L6 S2L7 S2L8 S2L9 S2L10 S2L11 S2L12 S2L13 S2L14 S2L15 S2L16 S2L17 S2L18 S2L19 S2L20 S2L21 S2L22 S2L23 S2L24 S2L25 S2L26 S2L27 S2L28 S2L29 S2L30 S2LN0 S2LN1 S2LN2 S2LN3 S2LN4 S2LN5 S2LN6 S2LN7 S2LN8 S2LN9 S2LN10 S2LN11 S2LN12 S2LN13 S2LN14 S2LN15 S2LN16 S2LN17 S2LN18 S2LN19 S2LN20 S2LN21 S2LN22 S2LN23 S2LN24 S2LN25 S2LN26 S2LN27 S2LN28 S2LN29 S2LN30] DAC33
AMON [p0 p1 p2 p3 p4 c0 c1 c2 c3 c4 a2_0_0 a2_0_1 a2_0_2 a2_0_3 a2_0_4] [pa0 pa1 pa2 pa3 pa4 ca0 ca1 ca2 ca3 ca4 rawa0 rawa1 rawa2 rawa3 rawa4] DAC33
.ends adc_ctrl_event
