* New NMOS reset/hold capacitive fixture; fixed output-chopper phaseA; deterministic function only.
.include /Volumes/mukiebi/Codex/gf180_ishi_env_20261015/native_runtime/pdk/gf180mcuD/libs.tech/ngspice/design.ngspice
.lib /Volumes/mukiebi/Codex/gf180_ishi_env_20261015/native_runtime/pdk/gf180mcuD/libs.tech/ngspice/sm141064.ngspice typical
.include candidate.spice
.temp 27
.options sparse reltol=1e-6 vntol=1e-10 abstol=3e-13 bypass=0 keepopinfo
VDD_SRC VDD 0 3.3
VCM CM 0 1.65
VBN VBN 0 .8485
VBCM VBCM 0 .82
VNC VNC 0 2.2
VPC VPC 0 1.1
BSIG SIG 0 V={4.7169811320754715e-05*(time<=31.25u?0:(time>=39.0625u?1:(0.5-0.5*cos(3.1415926535897931*(time-31.25u)/7.8125u))))*cos(628.31853071795865*time)}
EP SRC_P CM SIG 0 .5
EN SRC_N CM SIG 0 -.5
RSP SRC_P VINP 50000
RSN SRC_N VINN 50000
VCIP WP CIP_SENSE 0
CINP CIP_SENSE INP 636p
VCIN WN CIN_SENSE 0
CINN CIN_SENSE INN 636p
VCFP ONI FBP 0
CFBP FBP INP 2p
VCFN OPI FBN 0
CFBN FBN INN 2p
CPFP WP OPI 2.10p
CPFN WN ONI 2.10p
CLOADP OUTP 0 4p
CLOADN OUTN 0 4p
RLOADP OUTP CM 9375
RLOADN OUTN CM 9375
XDUT VINP VINN WP WN INP INN OPI ONI OUTP OUTN CM VBN VBCM VNC VPC VBP CIA NCIA CIB NCIB CDA NCDA CDB NCDB VDD 0 gf180_ccia_local_feedback
VCIA CIA_DRV 0 DC 3.2999999999999998 PWL(0 3.2999999999999998 1.5621000000000002e-05 3.2999999999999998 1.5621250000000002e-05 3.26829571266533 1.5621500000000003e-05 3.1744012286436227 1.562175e-05 3.0219248602991997 1.5622000000000001e-05 2.8167261889578032 1.5622250000000001e-05 2.5666908844823433 1.5622500000000002e-05 2.2814276634023982 1.5622750000000002e-05 1.9718990313266118 1.5623000000000003e-05 1.6499999999999999 1.562325e-05 1.3281009686733884 1.56235e-05 1.018572336597602 1.5623750000000001e-05 0.73330911551765676 1.5624000000000002e-05 0.48327381104219669 1.5624250000000002e-05 0.27807513970080017 1.5624499999999999e-05 0.12559877135637687 1.562475e-05 0.03170428733466979 1.5625e-05 0 2.3438499999999999e-05 0 2.343875e-05 0.03170428733466979 2.3439e-05 0.12559877135637687 2.3439250000000001e-05 0.27807513970080033 2.3439499999999998e-05 0.48327381104219647 2.3439749999999999e-05 0.73330911551765621 2.3439999999999999e-05 1.0185723365976018 2.344025e-05 1.3281009686733882 2.34405e-05 1.6499999999999997 2.3440750000000001e-05 1.9718990313266114 2.3441000000000001e-05 2.2814276634023978 2.3441250000000002e-05 2.5666908844823433 2.3441500000000002e-05 2.8167261889578032 2.344175e-05 3.0219248602991997 2.3442e-05 3.1744012286436227 2.3442250000000001e-05 3.26829571266533 2.3442500000000001e-05 3.2999999999999998 3.1245999999999999e-05 3.2999999999999998 3.1246249999999996e-05 3.26829571266533 3.12465e-05 3.1744012286436227 3.1246749999999997e-05 3.0219248602991997 3.1247000000000001e-05 2.8167261889578032 3.1247249999999998e-05 2.5666908844823433 3.1247500000000002e-05 2.2814276634023982 3.1247749999999999e-05 1.9718990313266118 3.1247999999999996e-05 1.6499999999999999 3.124825e-05 1.3281009686733884 3.1248499999999997e-05 1.018572336597602 3.1248750000000001e-05 0.73330911551765676 3.1248999999999998e-05 0.48327381104219669 3.1249250000000002e-05 0.27807513970080017 3.12495e-05 0.12559877135637687 3.1249750000000003e-05 0.03170428733466979 3.1250000000000001e-05 0 3.9063500000000003e-05 0 3.906375e-05 0.03170428733466979 3.9064000000000004e-05 0.12559877135637687 3.9064250000000001e-05 0.27807513970080033 3.9064499999999998e-05 0.48327381104219647 3.9064750000000002e-05 0.73330911551765621 3.9065e-05 1.0185723365976018 3.9065250000000003e-05 1.3281009686733882 3.9065500000000001e-05 1.6499999999999997 3.9065749999999998e-05 1.9718990313266114 3.9066000000000002e-05 2.2814276634023978 3.9066249999999999e-05 2.5666908844823433 3.9066500000000003e-05 2.8167261889578032 3.906675e-05 3.0219248602991997 3.9066999999999997e-05 3.1744012286436227 3.9067250000000001e-05 3.26829571266533 3.9067499999999998e-05 3.2999999999999998 4.6870999999999999e-05 3.2999999999999998 4.6871249999999996e-05 3.26829571266533 4.68715e-05 3.1744012286436227 4.6871749999999997e-05 3.0219248602991997 4.6872000000000001e-05 2.8167261889578032 4.6872249999999998e-05 2.5666908844823433 4.6872500000000002e-05 2.2814276634023982 4.6872749999999999e-05 1.9718990313266118 4.6872999999999997e-05 1.6499999999999999 4.6873250000000001e-05 1.3281009686733884 4.6873499999999998e-05 1.018572336597602 4.6873750000000002e-05 0.73330911551765676 4.6873999999999999e-05 0.48327381104219669 4.6874250000000003e-05 0.27807513970080017 4.68745e-05 0.12559877135637687 4.6874750000000004e-05 0.03170428733466979 4.6875000000000001e-05 0 5.4688500000000003e-05 0 5.468875e-05 0.03170428733466979 5.4689000000000004e-05 0.12559877135637687 5.4689250000000002e-05 0.27807513970080033 5.4689499999999999e-05 0.48327381104219647 5.4689750000000003e-05 0.73330911551765621 5.469e-05 1.0185723365976018 5.4690250000000004e-05 1.3281009686733882 5.4690500000000001e-05 1.6499999999999997 5.4690749999999998e-05 1.9718990313266114 5.4691000000000002e-05 2.2814276634023978 5.4691249999999999e-05 2.5666908844823433 5.4691500000000003e-05 2.8167261889578032 5.469175e-05 3.0219248602991997 5.4691999999999997e-05 3.1744012286436227 5.4692250000000001e-05 3.26829571266533 5.4692499999999999e-05 3.2999999999999998 6.2496000000000006e-05 3.2999999999999998 6.249625000000001e-05 3.26829571266533 6.24965e-05 3.1744012286436227 6.2496750000000004e-05 3.0219248602991997 6.2497000000000008e-05 2.8167261889578032 6.2497249999999999e-05 2.5666908844823433 6.2497500000000003e-05 2.2814276634023982 6.2497750000000007e-05 1.9718990313266118 6.2497999999999997e-05 1.6499999999999999 6.2498250000000001e-05 1.3281009686733884 6.2498500000000005e-05 1.018572336597602 6.2498750000000009e-05 0.73330911551765676 6.2498999999999999e-05 0.48327381104219669 6.2499250000000003e-05 0.27807513970080017 6.2499500000000007e-05 0.12559877135637687 6.2499749999999997e-05 0.03170428733466979 6.2500000000000001e-05 0 7.031350000000001e-05 0 7.0313750000000014e-05 0.03170428733466979 7.0314000000000005e-05 0.12559877135637687 7.0314250000000009e-05 0.27807513970080033 7.0314500000000013e-05 0.48327381104219647 7.0314750000000003e-05 0.73330911551765621 7.0315000000000007e-05 1.0185723365976018 7.0315250000000011e-05 1.3281009686733882 7.0315500000000001e-05 1.6499999999999997 7.0315750000000005e-05 1.9718990313266114 7.0316000000000009e-05 2.2814276634023978 7.0316250000000013e-05 2.5666908844823433 7.0316500000000003e-05 2.8167261889578032 7.0316750000000007e-05 3.0219248602991997 7.0317000000000011e-05 3.1744012286436227 7.0317250000000002e-05 3.26829571266533 7.0317500000000006e-05 3.2999999999999998 7.8121000000000006e-05 3.2999999999999998 7.812125000000001e-05 3.26829571266533 7.8121500000000001e-05 3.1744012286436227 7.8121750000000005e-05 3.0219248602991997 7.8122000000000009e-05 2.8167261889578032 7.8122249999999999e-05 2.5666908844823433 7.8122500000000003e-05 2.2814276634023982 7.8122750000000007e-05 1.9718990313266118 7.8123000000000011e-05 1.6499999999999999 7.8123250000000001e-05 1.3281009686733884 7.8123500000000005e-05 1.018572336597602 7.8123750000000009e-05 0.73330911551765676 7.8123999999999999e-05 0.48327381104219669 7.8124250000000003e-05 0.27807513970080017 7.8124500000000007e-05 0.12559877135637687 7.8124749999999998e-05 0.03170428733466979 7.8125000000000002e-05 0 8.5938499999999997e-05 0 8.5938750000000001e-05 0.03170428733466979 8.5938999999999992e-05 0.12559877135637687 8.5939249999999995e-05 0.27807513970080033 8.5939499999999999e-05 0.48327381104219647 8.593974999999999e-05 0.73330911551765621 8.5939999999999994e-05 1.0185723365976018 8.5940249999999998e-05 1.3281009686733882 8.5940499999999988e-05 1.6499999999999997 8.5940749999999992e-05 1.9718990313266114 8.5940999999999996e-05 2.2814276634023978 8.594125e-05 2.5666908844823433 8.594149999999999e-05 2.8167261889578032 8.5941749999999994e-05 3.0219248602991997 8.5941999999999998e-05 3.1744012286436227 8.5942249999999988e-05 3.26829571266533 8.5942499999999992e-05 3.2999999999999998 9.3746000000000007e-05 3.2999999999999998 9.3746250000000011e-05 3.26829571266533 9.3746500000000001e-05 3.1744012286436227 9.3746750000000005e-05 3.0219248602991997 9.3747000000000009e-05 2.8167261889578032 9.3747249999999999e-05 2.5666908844823433 9.3747500000000003e-05 2.2814276634023982 9.3747750000000007e-05 1.9718990313266118 9.3747999999999998e-05 1.6499999999999999 9.3748250000000002e-05 1.3281009686733884 9.3748500000000005e-05 1.018572336597602 9.3748750000000009e-05 0.73330911551765676 9.3749e-05 0.48327381104219669 9.3749250000000004e-05 0.27807513970080017 9.3749500000000008e-05 0.12559877135637687 9.3749749999999998e-05 0.03170428733466979 9.3750000000000002e-05 0 0.00010156350000000001 0 0.00010156375000000002 0.03170428733466979 0.00010156400000000001 0.12559877135637687 0.00010156425000000001 0.27807513970080033 0.00010156450000000001 0.48327381104219647 0.00010156475 0.73330911551765621 0.00010156500000000001 1.0185723365976018 0.00010156525000000001 1.3281009686733882 0.0001015655 1.6499999999999997 0.00010156575000000001 1.9718990313266114 0.00010156600000000001 2.2814276634023978 0.00010156625000000001 2.5666908844823433 0.0001015665 2.8167261889578032 0.00010156675000000001 3.0219248602991997 0.00010156700000000001 3.1744012286436227 0.00010156725 3.26829571266533 0.00010156750000000001 3.2999999999999998 0.00010937100000000001 3.2999999999999998 0.00010937125000000001 3.26829571266533 0.0001093715 3.1744012286436227 0.00010937175000000001 3.0219248602991997 0.00010937200000000001 2.8167261889578032 0.00010937225 2.5666908844823433 0.0001093725 2.2814276634023982 0.00010937275000000001 1.9718990313266118 0.00010937300000000001 1.6499999999999999 0.00010937325 1.3281009686733884 0.00010937350000000001 1.018572336597602 0.00010937375000000001 0.73330911551765676 0.000109374 0.48327381104219669 0.00010937425 0.27807513970080017 0.00010937450000000001 0.12559877135637687 0.00010937475 0.03170428733466979 0.000109375 0 0.0001171885 0 0.00011718875 0.03170428733466979 0.00011718899999999999 0.12559877135637687 0.00011718925 0.27807513970080033 0.0001171895 0.48327381104219647 0.00011718974999999999 0.73330911551765621 0.00011718999999999999 1.0185723365976018 0.00011719025 1.3281009686733882 0.00011719049999999999 1.6499999999999997 0.00011719074999999999 1.9718990313266114 0.000117191 2.2814276634023978 0.00011719125 2.5666908844823433 0.00011719149999999999 2.8167261889578032 0.00011719174999999999 3.0219248602991997 0.000117192 3.1744012286436227 0.00011719224999999999 3.26829571266533 0.00011719249999999999 3.2999999999999998 0.00012499599999999999 3.2999999999999998 0.00012499625 3.26829571266533 0.0001249965 3.1744012286436227 0.00012499675000000001 3.0219248602991997 0.00012499700000000001 2.8167261889578032 0.00012499724999999999 2.5666908844823433 0.00012499749999999999 2.2814276634023982 0.00012499774999999999 1.9718990313266118 0.000124998 1.6499999999999999 0.00012499825 1.3281009686733884 0.00012499850000000001 1.018572336597602 0.00012499875000000001 0.73330911551765676 0.00012499899999999999 0.48327381104219669 0.00012499924999999999 0.27807513970080017 0.00012499949999999999 0.12559877135637687 0.00012499975 0.03170428733466979 0.000125 0 0.0001328135 0 0.00013281375 0.03170428733466979 0.00013281400000000001 0.12559877135637687 0.00013281425000000001 0.27807513970080033 0.00013281449999999999 0.48327381104219647 0.00013281474999999999 0.73330911551765621 0.00013281499999999999 1.0185723365976018 0.00013281525 1.3281009686733882 0.0001328155 1.6499999999999997 0.00013281575000000001 1.9718990313266114 0.00013281600000000001 2.2814276634023978 0.00013281625000000001 2.5666908844823433 0.00013281650000000002 2.8167261889578032 0.00013281675 3.0219248602991997 0.000132817 3.1744012286436227 0.00013281725 3.26829571266533 0.00013281750000000001 3.2999999999999998 0.00014062100000000001 3.2999999999999998 0.00014062125000000001 3.26829571266533 0.00014062150000000002 3.1744012286436227 0.00014062175000000002 3.0219248602991997 0.00014062200000000002 2.8167261889578032 0.00014062225 2.5666908844823433 0.0001406225 2.2814276634023982 0.00014062275000000001 1.9718990313266118 0.00014062300000000001 1.6499999999999999 0.00014062325000000002 1.3281009686733884 0.00014062350000000002 1.018572336597602 0.00014062375000000002 0.73330911551765676 0.000140624 0.48327381104219669 0.00014062425 0.27807513970080017 0.00014062450000000001 0.12559877135637687 0.00014062475000000001 0.03170428733466979 0.00014062500000000002 0 0.00014843849999999998 0 0.00014843874999999999 0.03170428733466979 0.00014843899999999999 0.12559877135637687 0.00014843925 0.27807513970080033 0.0001484395 0.48327381104219647 0.00014843974999999998 0.73330911551765621 0.00014843999999999998 1.0185723365976018 0.00014844024999999999 1.3281009686733882 0.00014844049999999999 1.6499999999999997 0.00014844074999999999 1.9718990313266114 0.000148441 2.2814276634023978 0.00014844125 2.5666908844823433 0.00014844149999999998 2.8167261889578032 0.00014844174999999998 3.0219248602991997 0.00014844199999999999 3.1744012286436227 0.00014844224999999999 3.26829571266533 0.00014844249999999999 3.2999999999999998 0.00015624599999999999 3.2999999999999998 0.00015624625 3.26829571266533 0.0001562465 3.1744012286436227 0.00015624675000000001 3.0219248602991997 0.00015624699999999998 2.8167261889578032 0.00015624724999999999 2.5666908844823433 0.00015624749999999999 2.2814276634023982 0.00015624774999999999 1.9718990313266118 0.000156248 1.6499999999999999 0.00015624825 1.3281009686733884 0.00015624850000000001 1.018572336597602 0.00015624875000000001 0.73330911551765676 0.00015624900000000001 0.48327381104219669 0.00015624924999999999 0.27807513970080017 0.0001562495 0.12559877135637687 0.00015624975 0.03170428733466979 0.00015625 0 0.0001640635 0 0.00016406375 0.03170428733466979 0.00016406400000000001 0.12559877135637687 0.00016406425000000001 0.27807513970080033 0.00016406450000000001 0.48327381104219647 0.00016406474999999999 0.73330911551765621 0.000164065 1.0185723365976018 0.00016406525 1.3281009686733882 0.0001640655 1.6499999999999997 0.00016406575000000001 1.9718990313266114 0.00016406600000000001 2.2814276634023978 0.00016406625000000002 2.5666908844823433 0.00016406649999999999 2.8167261889578032 0.00016406675 3.0219248602991997 0.000164067 3.1744012286436227 0.00016406725 3.26829571266533 0.00016406750000000001 3.2999999999999998 0.00017187099999999998 3.2999999999999998 0.00017187124999999999 3.26829571266533 0.00017187149999999999 3.1744012286436227 0.00017187174999999999 3.0219248602991997 0.000171872 2.8167261889578032 0.00017187224999999997 2.5666908844823433 0.00017187249999999998 2.2814276634023982 0.00017187274999999998 1.9718990313266118 0.00017187299999999999 1.6499999999999999 0.00017187324999999999 1.3281009686733884 0.00017187349999999999 1.018572336597602 0.00017187375 0.73330911551765676 0.00017187399999999997 0.48327381104219669 0.00017187424999999998 0.27807513970080017 0.00017187449999999998 0.12559877135637687 0.00017187474999999999 0.03170428733466979 0.00017187499999999999 0 0.00017968849999999999 0 0.00017968874999999999 0.03170428733466979 0.00017968899999999999 0.12559877135637687 0.00017968925 0.27807513970080033 0.00017968949999999997 0.48327381104219647 0.00017968974999999998 0.73330911551765621 0.00017968999999999998 1.0185723365976018 0.00017969024999999999 1.3281009686733882 0.00017969049999999999 1.6499999999999997 0.00017969074999999999 1.9718990313266114 0.000179691 2.2814276634023978 0.00017969125 2.5666908844823433 0.00017969150000000001 2.8167261889578032 0.00017969174999999998 3.0219248602991997 0.00017969199999999999 3.1744012286436227 0.00017969224999999999 3.26829571266533 0.00017969249999999999 3.2999999999999998 0.000187496 3.2999999999999998 0.00018749625 3.26829571266533 0.0001874965 3.1744012286436227 0.00018749675000000001 3.0219248602991997 0.00018749700000000001 2.8167261889578032 0.00018749724999999999 2.5666908844823433 0.00018749749999999999 2.2814276634023982 0.00018749775 1.9718990313266118 0.000187498 1.6499999999999999 0.00018749825 1.3281009686733884 0.00018749850000000001 1.018572336597602 0.00018749875000000001 0.73330911551765676 0.00018749899999999999 0.48327381104219669 0.00018749924999999999 0.27807513970080017 0.0001874995 0.12559877135637687 0.00018749975 0.03170428733466979 0.0001875 0 0.0001953135 0 0.00019531375 0.03170428733466979 0.00019531400000000001 0.12559877135637687 0.00019531425000000001 0.27807513970080033 0.00019531449999999999 0.48327381104219647 0.00019531474999999999 0.73330911551765621 0.000195315 1.0185723365976018 0.00019531525 1.3281009686733882 0.0001953155 1.6499999999999997 0.00019531575000000001 1.9718990313266114 0.00019531600000000001 2.2814276634023978 0.00019531625000000002 2.5666908844823433 0.00019531650000000002 2.8167261889578032 0.00019531675 3.0219248602991997 0.000195317 3.1744012286436227 0.00019531725 3.26829571266533 0.00019531750000000001 3.2999999999999998 0.00020000000000000001 3.2999999999999998 0.00020312100000000001 3.2999999999999998 0.00020312125000000001 3.26829571266533 0.00020312150000000002 3.1744012286436227 0.00020312175000000002 3.0219248602991997 0.00020312200000000002 2.8167261889578032 0.00020312225 2.5666908844823433 0.00020312250000000001 2.2814276634023982 0.00020312275000000001 1.9718990313266118 0.00020312300000000001 1.6499999999999999 0.00020312325000000002 1.3281009686733884 0.00020312350000000002 1.018572336597602 0.00020312375000000003 0.73330911551765676 0.000203124 0.48327381104219669 0.00020312425000000001 0.27807513970080017 0.00020312450000000001 0.12559877135637687 0.00020312475000000001 0.03170428733466979 0.00020312500000000002 0 0.00021093849999999999 0 0.00021093874999999999 0.03170428733466979 0.00021093899999999999 0.12559877135637687 0.00021093925 0.27807513970080033 0.0002109395 0.48327381104219647 0.00021093974999999998 0.73330911551765621 0.00021093999999999998 1.0185723365976018 0.00021094024999999999 1.3281009686733882 0.00021094049999999999 1.6499999999999997 0.00021094074999999999 1.9718990313266114 0.000210941 2.2814276634023978 0.00021094125 2.5666908844823433 0.00021094149999999998 2.8167261889578032 0.00021094174999999998 3.0219248602991997 0.00021094199999999999 3.1744012286436227 0.00021094224999999999 3.26829571266533 0.0002109425 3.2999999999999998 0.000218746 3.2999999999999998 0.00021874625 3.26829571266533 0.0002187465 3.1744012286436227 0.00021874675000000001 3.0219248602991997 0.00021874699999999998 2.8167261889578032 0.00021874724999999999 2.5666908844823433 0.00021874749999999999 2.2814276634023982 0.00021874775 1.9718990313266118 0.000218748 1.6499999999999999 0.00021874825 1.3281009686733884 0.00021874850000000001 1.018572336597602 0.00021874875000000001 0.73330911551765676 0.00021874900000000002 0.48327381104219669 0.00021874924999999999 0.27807513970080017 0.0002187495 0.12559877135637687 0.00021874975 0.03170428733466979 0.00021875 0 0.0002265635 0 0.00022656375 0.03170428733466979 0.00022656400000000001 0.12559877135637687 0.00022656425000000001 0.27807513970080033 0.00022656450000000002 0.48327381104219647 0.00022656474999999999 0.73330911551765621 0.000226565 1.0185723365976018 0.00022656525 1.3281009686733882 0.0002265655 1.6499999999999997 0.00022656575000000001 1.9718990313266114 0.00022656600000000001 2.2814276634023978 0.00022656625000000002 2.5666908844823433 0.00022656649999999999 2.8167261889578032 0.00022656675 3.0219248602991997 0.000226567 3.1744012286436227 0.00022656725 3.26829571266533 0.00022656750000000001 3.2999999999999998 0.00023437099999999998 3.2999999999999998 0.00023437124999999999 3.26829571266533 0.00023437149999999999 3.1744012286436227 0.00023437174999999999 3.0219248602991997 0.000234372 2.8167261889578032 0.00023437224999999998 2.5666908844823433 0.00023437249999999998 2.2814276634023982 0.00023437274999999998 1.9718990313266118 0.00023437299999999999 1.6499999999999999 0.00023437324999999999 1.3281009686733884 0.00023437349999999999 1.018572336597602 0.00023437375 0.73330911551765676 0.00023437399999999998 0.48327381104219669 0.00023437424999999998 0.27807513970080017 0.00023437449999999998 0.12559877135637687 0.00023437474999999999 0.03170428733466979 0.00023437499999999999 0 0.00024218849999999999 0 0.00024218874999999999 0.03170428733466979 0.00024218899999999999 0.12559877135637687 0.00024218925 0.27807513970080033 0.00024218949999999998 0.48327381104219647 0.00024218974999999998 0.73330911551765621 0.00024218999999999998 1.0185723365976018 0.00024219024999999999 1.3281009686733882 0.00024219049999999999 1.6499999999999997 0.00024219075 1.9718990313266114 0.000242191 2.2814276634023978 0.00024219125 2.5666908844823433 0.00024219150000000001 2.8167261889578032 0.00024219174999999998 3.0219248602991997 0.00024219199999999999 3.1744012286436227 0.00024219224999999999 3.26829571266533 0.0002421925 3.2999999999999998 0.000249996 3.2999999999999998 0.00024999624999999997 3.26829571266533 0.0002499965 3.1744012286436227 0.00024999674999999998 3.0219248602991997 0.00024999700000000001 2.8167261889578032 0.00024999724999999999 2.5666908844823433 0.00024999750000000002 2.2814276634023982 0.00024999775 1.9718990313266118 0.00024999799999999997 1.6499999999999999 0.00024999825 1.3281009686733884 0.00024999849999999998 1.018572336597602 0.00024999875000000001 0.73330911551765676 0.00024999899999999999 0.48327381104219669 0.00024999925000000002 0.27807513970080017 0.0002499995 0.12559877135637687 0.00024999975000000003 0.03170428733466979 0.00025000000000000001 0 0.00025781350000000003 0 0.00025781375 0.03170428733466979 0.00025781400000000004 0.12559877135637687 0.00025781425000000001 0.27807513970080033 0.00025781450000000004 0.48327381104219647 0.00025781475000000002 0.73330911551765621 0.00025781500000000005 1.0185723365976018 0.00025781525000000003 1.3281009686733882 0.00025781550000000006 1.6499999999999997 0.00025781575000000004 1.9718990313266114 0.00025781600000000001 2.2814276634023978 0.00025781625000000004 2.5666908844823433 0.00025781650000000002 2.8167261889578032 0.00025781675000000005 3.0219248602991997 0.00025781700000000003 3.1744012286436227 0.00025781725000000006 3.26829571266533 0.00025781750000000004 3.2999999999999998 0.00026562100000000001 3.2999999999999998 0.00026562124999999999 3.26829571266533 0.00026562150000000002 3.1744012286436227 0.00026562175 3.0219248602991997 0.00026562200000000003 2.8167261889578032 0.00026562225 2.5666908844823433 0.00026562250000000003 2.2814276634023982 0.00026562275000000001 1.9718990313266118 0.00026562299999999999 1.6499999999999999 0.00026562325000000002 1.3281009686733884 0.0002656235 1.018572336597602 0.00026562375000000003 0.73330911551765676 0.000265624 0.48327381104219669 0.00026562425000000003 0.27807513970080017 0.00026562450000000001 0.12559877135637687 0.00026562475000000004 0.03170428733466979 0.00026562500000000002 0 0.00027343850000000004 0 0.00027343875000000002 0.03170428733466979 0.00027343900000000005 0.12559877135637687 0.00027343925000000003 0.27807513970080033 0.00027343950000000006 0.48327381104219647 0.00027343975000000003 0.73330911551765621 0.00027344000000000007 1.0185723365976018 0.00027344025000000004 1.3281009686733882 0.00027344050000000007 1.6499999999999997 0.00027344075000000005 1.9718990313266114 0.00027344100000000003 2.2814276634023978 0.00027344125000000006 2.5666908844823433 0.00027344150000000003 2.8167261889578032 0.00027344175000000007 3.0219248602991997 0.00027344200000000004 3.1744012286436227 0.00027344225000000007 3.26829571266533 0.00027344250000000005 3.2999999999999998 0.00028124600000000002 3.2999999999999998 0.00028124625 3.26829571266533 0.00028124650000000003 3.1744012286436227 0.00028124675000000001 3.0219248602991997 0.00028124700000000004 2.8167261889578032 0.00028124725000000002 2.5666908844823433 0.00028124750000000005 2.2814276634023982 0.00028124775000000002 1.9718990313266118 0.000281248 1.6499999999999999 0.00028124825000000003 1.3281009686733884 0.00028124850000000001 1.018572336597602 0.00028124875000000004 0.73330911551765676 0.00028124900000000002 0.48327381104219669 0.00028124925000000005 0.27807513970080017 0.00028124950000000003 0.12559877135637687 0.00028124975000000006 0.03170428733466979 0.00028125000000000003 0 0.0002890635 0 0.00028906374999999998 0.03170428733466979 0.00028906400000000001 0.12559877135637687 0.00028906424999999999 0.27807513970080033 0.00028906450000000002 0.48327381104219647 0.00028906474999999999 0.73330911551765621 0.00028906500000000003 1.0185723365976018 0.00028906525 1.3281009686733882 0.00028906549999999998 1.6499999999999997 0.00028906575000000001 1.9718990313266114 0.00028906599999999999 2.2814276634023978 0.00028906625000000002 2.5666908844823433 0.00028906649999999999 2.8167261889578032 0.00028906675000000003 3.0219248602991997 0.000289067 3.1744012286436227 0.00028906725000000003 3.26829571266533 0.00028906750000000001 3.2999999999999998 0.00029687099999999998 3.2999999999999998 0.00029687124999999996 3.26829571266533 0.00029687149999999999 3.1744012286436227 0.00029687174999999997 3.0219248602991997 0.000296872 2.8167261889578032 0.00029687224999999998 2.5666908844823433 0.00029687250000000001 2.2814276634023982 0.00029687274999999998 1.9718990313266118 0.00029687300000000002 1.6499999999999999 0.00029687324999999999 1.3281009686733884 0.00029687349999999997 1.018572336597602 0.00029687375 0.73330911551765676 0.00029687399999999998 0.48327381104219669 0.00029687425000000001 0.27807513970080017 0.00029687449999999998 0.12559877135637687 0.00029687475000000002 0.03170428733466979 0.00029687499999999999 0 0.00030468850000000002 0 0.00030468874999999999 0.03170428733466979 0.00030468900000000002 0.12559877135637687 0.00030468925 0.27807513970080033 0.00030468950000000003 0.48327381104219647 0.00030468975000000001 0.73330911551765621 0.00030469000000000004 1.0185723365976018 0.00030469025000000002 1.3281009686733882 0.00030469049999999999 1.6499999999999997 0.00030469075000000002 1.9718990313266114 0.000304691 2.2814276634023978 0.00030469125000000003 2.5666908844823433 0.00030469150000000001 2.8167261889578032 0.00030469175000000004 3.0219248602991997 0.00030469200000000002 3.1744012286436227 0.00030469225000000005 3.26829571266533 0.00030469250000000002 3.2999999999999998 0.000312496 3.2999999999999998 0.00031249624999999997 3.26829571266533 0.00031249650000000001 3.1744012286436227 0.00031249674999999998 3.0219248602991997 0.00031249700000000001 2.8167261889578032 0.00031249724999999999 2.5666908844823433 0.00031249750000000002 2.2814276634023982 0.00031249775 1.9718990313266118 0.00031249800000000003 1.6499999999999999 0.00031249825000000001 1.3281009686733884 0.00031249849999999998 1.018572336597602 0.00031249875000000001 0.73330911551765676 0.00031249899999999999 0.48327381104219669 0.00031249925000000002 0.27807513970080017 0.0003124995 0.12559877135637687 0.00031249975000000003 0.03170428733466979 0.00031250000000000001 0 0.00032031350000000003 0 0.00032031375000000001 0.03170428733466979 0.00032031400000000004 0.12559877135637687 0.00032031425000000001 0.27807513970080033 0.00032031450000000004 0.48327381104219647 0.00032031475000000002 0.73330911551765621 0.00032031500000000005 1.0185723365976018 0.00032031525000000003 1.3281009686733882 0.00032031550000000001 1.6499999999999997 0.00032031575000000004 1.9718990313266114 0.00032031600000000001 2.2814276634023978 0.00032031625000000005 2.5666908844823433 0.00032031650000000002 2.8167261889578032 0.00032031675000000005 3.0219248602991997 0.00032031700000000003 3.1744012286436227 0.00032031725000000006 3.26829571266533 0.00032031750000000004 3.2999999999999998 0.00032812100000000001 3.2999999999999998 0.00032812124999999999 3.26829571266533 0.00032812150000000002 3.1744012286436227 0.00032812175 3.0219248602991997 0.00032812200000000003 2.8167261889578032 0.00032812225 2.5666908844823433 0.00032812250000000004 2.2814276634023982 0.00032812275000000001 1.9718990313266118 0.00032812300000000004 1.6499999999999999 0.00032812325000000002 1.3281009686733884 0.0003281235 1.018572336597602 0.00032812375000000003 0.73330911551765676 0.000328124 0.48327381104219669 0.00032812425000000004 0.27807513970080017 0.00032812450000000001 0.12559877135637687 0.00032812475000000004 0.03170428733466979 0.00032812500000000002 0 0.00033593850000000004 0 0.00033593875000000002 0.03170428733466979 0.00033593900000000005 0.12559877135637687 0.00033593925000000003 0.27807513970080033 0.00033593950000000006 0.48327381104219647 0.00033593975000000004 0.73330911551765621 0.00033594000000000007 1.0185723365976018 0.00033594025000000004 1.3281009686733882 0.00033594050000000002 1.6499999999999997 0.00033594075000000005 1.9718990313266114 0.00033594100000000003 2.2814276634023978 0.00033594125000000006 2.5666908844823433 0.00033594150000000004 2.8167261889578032 0.00033594175000000007 3.0219248602991997 0.00033594200000000004 3.1744012286436227 0.00033594225000000008 3.26829571266533 0.00033594250000000005 3.2999999999999998 0.00034374599999999997 3.2999999999999998 0.00034374624999999995 3.26829571266533 0.00034374649999999998 3.1744012286436227 0.00034374674999999996 3.0219248602991997 0.00034374699999999999 2.8167261889578032 0.00034374724999999996 2.5666908844823433 0.00034374749999999999 2.2814276634023982 0.00034374774999999997 1.9718990313266118 0.00034374799999999995 1.6499999999999999 0.00034374824999999998 1.3281009686733884 0.00034374849999999996 1.018572336597602 0.00034374874999999999 0.73330911551765676 0.00034374899999999996 0.48327381104219669 0.00034374925 0.27807513970080017 0.00034374949999999997 0.12559877135637687 0.00034374975 0.03170428733466979 0.00034374999999999998 0 0.0003515635 0 0.00035156374999999998 0.03170428733466979 0.00035156400000000001 0.12559877135637687 0.00035156424999999999 0.27807513970080033 0.00035156450000000002 0.48327381104219647 0.00035156475 0.73330911551765621 0.00035156500000000003 1.0185723365976018 0.00035156525 1.3281009686733882 0.00035156550000000003 1.6499999999999997 0.00035156575000000001 1.9718990313266114 0.00035156599999999999 2.2814276634023978 0.00035156625000000002 2.5666908844823433 0.0003515665 2.8167261889578032 0.00035156675000000003 3.0219248602991997 0.000351567 3.1744012286436227 0.00035156725000000003 3.26829571266533 0.00035156750000000001 3.2999999999999998 0.00035937099999999999 3.2999999999999998 0.00035937124999999996 3.26829571266533 0.00035937149999999999 3.1744012286436227 0.00035937174999999997 3.0219248602991997 0.000359372 2.8167261889578032 0.00035937224999999998 2.5666908844823433 0.00035937250000000001 2.2814276634023982 0.00035937274999999999 1.9718990313266118 0.00035937299999999996 1.6499999999999999 0.00035937324999999999 1.3281009686733884 0.00035937349999999997 1.018572336597602 0.00035937375 0.73330911551765676 0.00035937399999999998 0.48327381104219669 0.00035937425000000001 0.27807513970080017 0.00035937449999999999 0.12559877135637687 0.00035937475000000002 0.03170428733466979 0.00035937499999999999 0 0.00036718850000000002 0 0.00036718874999999999 0.03170428733466979 0.00036718900000000002 0.12559877135637687 0.00036718925 0.27807513970080033 0.00036718950000000003 0.48327381104219647 0.00036718975000000001 0.73330911551765621 0.00036719000000000004 1.0185723365976018 0.00036719025000000002 1.3281009686733882 0.00036719050000000005 1.6499999999999997 0.00036719075000000002 1.9718990313266114 0.000367191 2.2814276634023978 0.00036719125000000003 2.5666908844823433 0.00036719150000000001 2.8167261889578032 0.00036719175000000004 3.0219248602991997 0.00036719200000000002 3.1744012286436227 0.00036719225000000005 3.26829571266533 0.00036719250000000003 3.2999999999999998 0.000374996 3.2999999999999998 0.00037499624999999998 3.26829571266533 0.00037499650000000001 3.1744012286436227 0.00037499674999999998 3.0219248602991997 0.00037499700000000001 2.8167261889578032 0.00037499724999999999 2.5666908844823433 0.00037499750000000002 2.2814276634023982 0.00037499775 1.9718990313266118 0.00037499799999999998 1.6499999999999999 0.00037499825000000001 1.3281009686733884 0.00037499849999999998 1.018572336597602 0.00037499875000000002 0.73330911551765676 0.00037499899999999999 0.48327381104219669 0.00037499925000000002 0.27807513970080017 0.0003749995 0.12559877135637687 0.00037499975000000003 0.03170428733466979 0.00037500000000000001 0 0.00038281350000000003 0 0.00038281375000000001 0.03170428733466979 0.00038281400000000004 0.12559877135637687 0.00038281425000000002 0.27807513970080033 0.00038281450000000005 0.48327381104219647 0.00038281475000000002 0.73330911551765621 0.00038281500000000005 1.0185723365976018 0.00038281525000000003 1.3281009686733882 0.00038281550000000006 1.6499999999999997 0.00038281575000000004 1.9718990313266114 0.00038281600000000002 2.2814276634023978 0.00038281625000000005 2.5666908844823433 0.00038281650000000002 2.8167261889578032 0.00038281675000000005 3.0219248602991997 0.00038281700000000003 3.1744012286436227 0.00038281725000000006 3.26829571266533 0.00038281750000000004 3.2999999999999998 0.00039062100000000001 3.2999999999999998 0.00039062124999999999 3.26829571266533 0.00039062150000000002 3.1744012286436227 0.00039062175 3.0219248602991997 0.00039062200000000003 2.8167261889578032 0.00039062225000000001 2.5666908844823433 0.00039062250000000004 2.2814276634023982 0.00039062275000000001 1.9718990313266118 0.00039062299999999999 1.6499999999999999 0.00039062325000000002 1.3281009686733884 0.0003906235 1.018572336597602 0.00039062375000000003 0.73330911551765676 0.00039062400000000001 0.48327381104219669 0.00039062425000000004 0.27807513970080017 0.00039062450000000001 0.12559877135637687 0.00039062475000000004 0.03170428733466979 0.00039062500000000002 0 0.00039843850000000004 0 0.00039843875000000002 0.03170428733466979 0.00039843900000000005 0.12559877135637687 0.00039843925000000003 0.27807513970080033 0.00039843950000000006 0.48327381104219647 0.00039843975000000004 0.73330911551765621 0.00039844000000000007 1.0185723365976018 0.00039844025000000004 1.3281009686733882 0.00039844050000000008 1.6499999999999997 0.00039844075000000005 1.9718990313266114 0.00039844100000000003 2.2814276634023978 0.00039844125000000006 2.5666908844823433 0.00039844150000000004 2.8167261889578032 0.00039844175000000007 3.0219248602991997 0.00039844200000000005 3.1744012286436227 0.00039844225000000008 3.26829571266533 0.00039844250000000005 3.2999999999999998 0.00040000000000000002 3.2999999999999998)
ENCIA NCIA_DRV 0 VDD CIA_DRV 1
VCIB CIB_DRV 0 DC 0 PWL(0 0 1.5625999999999999e-05 0 1.562625e-05 0.03170428733466979 1.56265e-05 0.12559877135637687 1.5626750000000001e-05 0.27807513970080033 1.5626999999999998e-05 0.48327381104219647 1.5627249999999998e-05 0.73330911551765621 1.5627499999999999e-05 1.0185723365976018 1.562775e-05 1.3281009686733882 1.5628e-05 1.6499999999999997 1.5628250000000001e-05 1.9718990313266114 1.5628500000000001e-05 2.2814276634023978 1.5628750000000002e-05 2.5666908844823433 1.5629000000000002e-05 2.8167261889578032 1.5629249999999999e-05 3.0219248602991997 1.56295e-05 3.1744012286436227 1.5629750000000001e-05 3.26829571266533 1.5630000000000001e-05 3.2999999999999998 2.3433500000000002e-05 3.2999999999999998 2.3433750000000002e-05 3.26829571266533 2.3434000000000003e-05 3.1744012286436227 2.343425e-05 3.0219248602991997 2.3434500000000001e-05 2.8167261889578032 2.3434750000000001e-05 2.5666908844823433 2.3435000000000002e-05 2.2814276634023982 2.3435250000000002e-05 1.9718990313266118 2.3435500000000003e-05 1.6499999999999999 2.343575e-05 1.3281009686733884 2.3436000000000001e-05 1.018572336597602 2.3436250000000001e-05 0.73330911551765676 2.3436500000000002e-05 0.48327381104219669 2.3436750000000002e-05 0.27807513970080017 2.3436999999999999e-05 0.12559877135637687 2.343725e-05 0.03170428733466979 2.34375e-05 0 3.1251000000000003e-05 0 3.125125e-05 0.03170428733466979 3.1251500000000004e-05 0.12559877135637687 3.1251750000000001e-05 0.27807513970080033 3.1252000000000005e-05 0.48327381104219647 3.1252250000000002e-05 0.73330911551765621 3.1252499999999999e-05 1.0185723365976018 3.1252750000000003e-05 1.3281009686733882 3.1253e-05 1.6499999999999997 3.1253249999999998e-05 1.9718990313266114 3.1253500000000002e-05 2.2814276634023978 3.1253749999999999e-05 2.5666908844823433 3.1253999999999996e-05 2.8167261889578032 3.125425e-05 3.0219248602991997 3.1254499999999997e-05 3.1744012286436227 3.1254750000000001e-05 3.26829571266533 3.1254999999999998e-05 3.2999999999999998 3.9058499999999999e-05 3.2999999999999998 3.9058749999999996e-05 3.26829571266533 3.9059e-05 3.1744012286436227 3.9059249999999997e-05 3.0219248602991997 3.9059500000000001e-05 2.8167261889578032 3.9059749999999998e-05 2.5666908844823433 3.9060000000000002e-05 2.2814276634023982 3.9060249999999999e-05 1.9718990313266118 3.9060500000000003e-05 1.6499999999999999 3.906075e-05 1.3281009686733884 3.9060999999999998e-05 1.018572336597602 3.9061250000000001e-05 0.73330911551765676 3.9061499999999999e-05 0.48327381104219669 3.9061750000000003e-05 0.27807513970080017 3.9062e-05 0.12559877135637687 3.9062250000000004e-05 0.03170428733466979 3.9062500000000001e-05 0 4.6876000000000003e-05 0 4.687625e-05 0.03170428733466979 4.6876500000000004e-05 0.12559877135637687 4.6876750000000001e-05 0.27807513970080033 4.6877000000000005e-05 0.48327381104219647 4.6877250000000003e-05 0.73330911551765621 4.68775e-05 1.0185723365976018 4.6877750000000004e-05 1.3281009686733882 4.6878000000000001e-05 1.6499999999999997 4.6878249999999998e-05 1.9718990313266114 4.6878500000000002e-05 2.2814276634023978 4.6878749999999999e-05 2.5666908844823433 4.6878999999999996e-05 2.8167261889578032 4.687925e-05 3.0219248602991997 4.6879499999999997e-05 3.1744012286436227 4.6879750000000001e-05 3.26829571266533 4.6879999999999998e-05 3.2999999999999998 5.4683499999999999e-05 3.2999999999999998 5.4683749999999996e-05 3.26829571266533 5.4684e-05 3.1744012286436227 5.4684249999999997e-05 3.0219248602991997 5.4684500000000001e-05 2.8167261889578032 5.4684749999999998e-05 2.5666908844823433 5.4685000000000002e-05 2.2814276634023982 5.468525e-05 1.9718990313266118 5.4685500000000004e-05 1.6499999999999999 5.4685750000000001e-05 1.3281009686733884 5.4685999999999998e-05 1.018572336597602 5.4686250000000002e-05 0.73330911551765676 5.4686499999999999e-05 0.48327381104219669 5.4686750000000003e-05 0.27807513970080017 5.4687e-05 0.12559877135637687 5.4687250000000004e-05 0.03170428733466979 5.4687500000000001e-05 0 6.2501000000000003e-05 0 6.2501250000000007e-05 0.03170428733466979 6.2501499999999998e-05 0.12559877135637687 6.2501750000000002e-05 0.27807513970080033 6.2502000000000006e-05 0.48327381104219647 6.2502249999999996e-05 0.73330911551765621 6.25025e-05 1.0185723365976018 6.2502750000000004e-05 1.3281009686733882 6.2502999999999994e-05 1.6499999999999997 6.2503249999999998e-05 1.9718990313266114 6.2503500000000002e-05 2.2814276634023978 6.2503750000000006e-05 2.5666908844823433 6.2503999999999997e-05 2.8167261889578032 6.250425e-05 3.0219248602991997 6.2504500000000004e-05 3.1744012286436227 6.2504749999999995e-05 3.26829571266533 6.2504999999999999e-05 3.2999999999999998 7.0308500000000013e-05 3.2999999999999998 7.0308750000000017e-05 3.26829571266533 7.0309000000000007e-05 3.1744012286436227 7.0309250000000011e-05 3.0219248602991997 7.0309500000000015e-05 2.8167261889578032 7.0309750000000006e-05 2.5666908844823433 7.031000000000001e-05 2.2814276634023982 7.0310250000000013e-05 1.9718990313266118 7.0310500000000004e-05 1.6499999999999999 7.0310750000000008e-05 1.3281009686733884 7.0311000000000012e-05 1.018572336597602 7.0311250000000016e-05 0.73330911551765676 7.0311500000000006e-05 0.48327381104219669 7.031175000000001e-05 0.27807513970080017 7.0312000000000014e-05 0.12559877135637687 7.0312250000000004e-05 0.03170428733466979 7.0312500000000008e-05 0 7.8126000000000004e-05 0 7.8126250000000008e-05 0.03170428733466979 7.8126499999999998e-05 0.12559877135637687 7.8126750000000002e-05 0.27807513970080033 7.8127000000000006e-05 0.48327381104219647 7.8127249999999996e-05 0.73330911551765621 7.81275e-05 1.0185723365976018 7.8127750000000004e-05 1.3281009686733882 7.8128000000000008e-05 1.6499999999999997 7.8128249999999999e-05 1.9718990313266114 7.8128500000000003e-05 2.2814276634023978 7.8128750000000006e-05 2.5666908844823433 7.8128999999999997e-05 2.8167261889578032 7.8129250000000001e-05 3.0219248602991997 7.8129500000000005e-05 3.1744012286436227 7.8129749999999995e-05 3.26829571266533 7.8129999999999999e-05 3.2999999999999998 8.59335e-05 3.2999999999999998 8.5933750000000004e-05 3.26829571266533 8.5933999999999994e-05 3.1744012286436227 8.5934249999999998e-05 3.0219248602991997 8.5934500000000002e-05 2.8167261889578032 8.5934749999999992e-05 2.5666908844823433 8.5934999999999996e-05 2.2814276634023982 8.593525e-05 1.9718990313266118 8.5935499999999991e-05 1.6499999999999999 8.5935749999999995e-05 1.3281009686733884 8.5935999999999998e-05 1.018572336597602 8.5936250000000002e-05 0.73330911551765676 8.5936499999999993e-05 0.48327381104219669 8.5936749999999997e-05 0.27807513970080017 8.5937000000000001e-05 0.12559877135637687 8.5937249999999991e-05 0.03170428733466979 8.5937499999999995e-05 0 9.3751000000000004e-05 0 9.3751250000000008e-05 0.03170428733466979 9.3751499999999998e-05 0.12559877135637687 9.3751750000000002e-05 0.27807513970080033 9.3752000000000006e-05 0.48327381104219647 9.3752249999999997e-05 0.73330911551765621 9.3752500000000001e-05 1.0185723365976018 9.3752750000000005e-05 1.3281009686733882 9.3752999999999995e-05 1.6499999999999997 9.3753249999999999e-05 1.9718990313266114 9.3753500000000003e-05 2.2814276634023978 9.3753750000000007e-05 2.5666908844823433 9.3753999999999997e-05 2.8167261889578032 9.3754250000000001e-05 3.0219248602991997 9.3754500000000005e-05 3.1744012286436227 9.3754749999999995e-05 3.26829571266533 9.3754999999999999e-05 3.2999999999999998 0.00010155850000000001 3.2999999999999998 0.00010155875000000002 3.26829571266533 0.00010155900000000001 3.1744012286436227 0.00010155925000000001 3.0219248602991997 0.00010155950000000002 2.8167261889578032 0.00010155975000000001 2.5666908844823433 0.00010156000000000001 2.2814276634023982 0.00010156025000000001 1.9718990313266118 0.0001015605 1.6499999999999999 0.00010156075000000001 1.3281009686733884 0.00010156100000000001 1.018572336597602 0.00010156125000000002 0.73330911551765676 0.00010156150000000001 0.48327381104219669 0.00010156175000000001 0.27807513970080017 0.00010156200000000001 0.12559877135637687 0.00010156225 0.03170428733466979 0.00010156250000000001 0 0.000109376 0 0.00010937625000000001 0.03170428733466979 0.0001093765 0.12559877135637687 0.00010937675 0.27807513970080033 0.00010937700000000001 0.48327381104219647 0.00010937725 0.73330911551765621 0.0001093775 1.0185723365976018 0.00010937775 1.3281009686733882 0.00010937800000000001 1.6499999999999997 0.00010937825 1.9718990313266114 0.0001093785 2.2814276634023978 0.00010937875000000001 2.5666908844823433 0.000109379 2.8167261889578032 0.00010937925 3.0219248602991997 0.00010937950000000001 3.1744012286436227 0.00010937975 3.26829571266533 0.00010938 3.2999999999999998 0.0001171835 3.2999999999999998 0.00011718375 3.26829571266533 0.00011718399999999999 3.1744012286436227 0.00011718425 3.0219248602991997 0.0001171845 2.8167261889578032 0.00011718474999999999 2.5666908844823433 0.000117185 2.2814276634023982 0.00011718525 1.9718990313266118 0.00011718549999999999 1.6499999999999999 0.00011718575 1.3281009686733884 0.000117186 1.018572336597602 0.00011718625 0.73330911551765676 0.00011718649999999999 0.48327381104219669 0.00011718675 0.27807513970080017 0.000117187 0.12559877135637687 0.00011718724999999999 0.03170428733466979 0.0001171875 0 0.00012500099999999999 0 0.00012500125 0.03170428733466979 0.0001250015 0.12559877135637687 0.00012500175 0.27807513970080033 0.00012500199999999998 0.48327381104219647 0.00012500224999999998 0.73330911551765621 0.00012500249999999999 1.0185723365976018 0.00012500274999999999 1.3281009686733882 0.000125003 1.6499999999999997 0.00012500325 1.9718990313266114 0.0001250035 2.2814276634023978 0.00012500375000000001 2.5666908844823433 0.00012500400000000001 2.8167261889578032 0.00012500424999999999 3.0219248602991997 0.00012500449999999999 3.1744012286436227 0.00012500475 3.26829571266533 0.000125005 3.2999999999999998 0.0001328085 3.2999999999999998 0.00013280875 3.26829571266533 0.00013280900000000001 3.1744012286436227 0.00013280925000000001 3.0219248602991997 0.00013280950000000002 2.8167261889578032 0.00013280974999999999 2.5666908844823433 0.00013281 2.2814276634023982 0.00013281025 1.9718990313266118 0.00013281050000000001 1.6499999999999999 0.00013281075000000001 1.3281009686733884 0.00013281100000000001 1.018572336597602 0.00013281125000000002 0.73330911551765676 0.00013281149999999999 0.48327381104219669 0.00013281175 0.27807513970080017 0.000132812 0.12559877135637687 0.00013281225000000001 0.03170428733466979 0.00013281250000000001 0 0.00014062600000000001 0 0.00014062625000000001 0.03170428733466979 0.00014062650000000001 0.12559877135637687 0.00014062675000000002 0.27807513970080033 0.00014062699999999999 0.48327381104219647 0.00014062725 0.73330911551765621 0.0001406275 1.0185723365976018 0.00014062775000000001 1.3281009686733882 0.00014062800000000001 1.6499999999999997 0.00014062825000000001 1.9718990313266114 0.00014062850000000002 2.2814276634023978 0.00014062875000000002 2.5666908844823433 0.00014062900000000003 2.8167261889578032 0.00014062925 3.0219248602991997 0.00014062950000000001 3.1744012286436227 0.00014062975000000001 3.26829571266533 0.00014063000000000001 3.2999999999999998 0.00014843349999999999 3.2999999999999998 0.00014843374999999999 3.26829571266533 0.000148434 3.1744012286436227 0.00014843425 3.0219248602991997 0.00014843449999999998 2.8167261889578032 0.00014843474999999998 2.5666908844823433 0.00014843499999999998 2.2814276634023982 0.00014843524999999999 1.9718990313266118 0.00014843549999999999 1.6499999999999999 0.00014843575 1.3281009686733884 0.000148436 1.018572336597602 0.00014843625 0.73330911551765676 0.00014843650000000001 0.48327381104219669 0.00014843674999999998 0.27807513970080017 0.00014843699999999999 0.12559877135637687 0.00014843724999999999 0.03170428733466979 0.0001484375 0 0.00015625099999999999 0 0.00015625125 0.03170428733466979 0.0001562515 0.12559877135637687 0.00015625175 0.27807513970080033 0.00015625200000000001 0.48327381104219647 0.00015625224999999998 0.73330911551765621 0.00015625249999999999 1.0185723365976018 0.00015625274999999999 1.3281009686733882 0.000156253 1.6499999999999997 0.00015625325 1.9718990313266114 0.0001562535 2.2814276634023978 0.00015625375000000001 2.5666908844823433 0.00015625399999999998 2.8167261889578032 0.00015625424999999999 3.0219248602991997 0.00015625449999999999 3.1744012286436227 0.00015625475 3.26829571266533 0.000156255 3.2999999999999998 0.0001640585 3.2999999999999998 0.00016405875000000001 3.26829571266533 0.00016405900000000001 3.1744012286436227 0.00016405925000000001 3.0219248602991997 0.00016405949999999999 2.8167261889578032 0.00016405974999999999 2.5666908844823433 0.00016406 2.2814276634023982 0.00016406025 1.9718990313266118 0.00016406050000000001 1.6499999999999999 0.00016406075000000001 1.3281009686733884 0.00016406100000000001 1.018572336597602 0.00016406125000000002 0.73330911551765676 0.00016406150000000002 0.48327381104219669 0.00016406175 0.27807513970080017 0.000164062 0.12559877135637687 0.00016406225000000001 0.03170428733466979 0.00016406250000000001 0 0.00017187599999999998 0 0.00017187624999999998 0.03170428733466979 0.00017187649999999999 0.12559877135637687 0.00017187674999999999 0.27807513970080033 0.00017187699999999997 0.48327381104219647 0.00017187724999999997 0.73330911551765621 0.00017187749999999998 1.0185723365976018 0.00017187774999999998 1.3281009686733882 0.00017187799999999998 1.6499999999999997 0.00017187824999999999 1.9718990313266114 0.00017187849999999999 2.2814276634023978 0.00017187874999999999 2.5666908844823433 0.000171879 2.8167261889578032 0.00017187924999999998 3.0219248602991997 0.00017187949999999998 3.1744012286436227 0.00017187974999999998 3.26829571266533 0.00017187999999999999 3.2999999999999998 0.00017968349999999999 3.2999999999999998 0.00017968374999999999 3.26829571266533 0.000179684 3.1744012286436227 0.00017968425 3.0219248602991997 0.0001796845 2.8167261889578032 0.00017968474999999998 2.5666908844823433 0.00017968499999999998 2.2814276634023982 0.00017968524999999999 1.9718990313266118 0.00017968549999999999 1.6499999999999999 0.00017968575 1.3281009686733884 0.000179686 1.018572336597602 0.00017968625 0.73330911551765676 0.00017968649999999998 0.48327381104219669 0.00017968674999999999 0.27807513970080017 0.00017968699999999999 0.12559877135637687 0.00017968724999999999 0.03170428733466979 0.0001796875 0 0.00018750099999999999 0 0.00018750125 0.03170428733466979 0.0001875015 0.12559877135637687 0.00018750175 0.27807513970080033 0.00018750199999999998 0.48327381104219647 0.00018750224999999999 0.73330911551765621 0.00018750249999999999 1.0185723365976018 0.00018750274999999999 1.3281009686733882 0.000187503 1.6499999999999997 0.00018750325 1.9718990313266114 0.0001875035 2.2814276634023978 0.00018750375000000001 2.5666908844823433 0.00018750400000000001 2.8167261889578032 0.00018750424999999999 3.0219248602991997 0.00018750449999999999 3.1744012286436227 0.00018750475 3.26829571266533 0.000187505 3.2999999999999998 0.0001953085 3.2999999999999998 0.00019530875000000001 3.26829571266533 0.00019530900000000001 3.1744012286436227 0.00019530925000000001 3.0219248602991997 0.00019530950000000002 2.8167261889578032 0.00019530974999999999 2.5666908844823433 0.00019531 2.2814276634023982 0.00019531025 1.9718990313266118 0.00019531050000000001 1.6499999999999999 0.00019531075000000001 1.3281009686733884 0.00019531100000000001 1.018572336597602 0.00019531125000000002 0.73330911551765676 0.0001953115 0.48327381104219669 0.00019531175 0.27807513970080017 0.000195312 0.12559877135637687 0.00019531225000000001 0.03170428733466979 0.00019531250000000001 0 0.00020000000000000001 0 0.00020312600000000001 0 0.00020312625000000001 0.03170428733466979 0.00020312650000000001 0.12559877135637687 0.00020312675000000002 0.27807513970080033 0.000203127 0.48327381104219647 0.00020312725 0.73330911551765621 0.0002031275 1.0185723365976018 0.00020312775000000001 1.3281009686733882 0.00020312800000000001 1.6499999999999997 0.00020312825000000001 1.9718990313266114 0.00020312850000000002 2.2814276634023978 0.00020312875000000002 2.5666908844823433 0.00020312900000000003 2.8167261889578032 0.00020312925 3.0219248602991997 0.00020312950000000001 3.1744012286436227 0.00020312975000000001 3.26829571266533 0.00020313000000000002 3.2999999999999998 0.00021093349999999999 3.2999999999999998 0.00021093374999999999 3.26829571266533 0.000210934 3.1744012286436227 0.00021093425 3.0219248602991997 0.00021093449999999998 2.8167261889578032 0.00021093474999999998 2.5666908844823433 0.00021093499999999999 2.2814276634023982 0.00021093524999999999 1.9718990313266118 0.00021093549999999999 1.6499999999999999 0.00021093575 1.3281009686733884 0.000210936 1.018572336597602 0.00021093625000000001 0.73330911551765676 0.00021093650000000001 0.48327381104219669 0.00021093674999999999 0.27807513970080017 0.00021093699999999999 0.12559877135637687 0.00021093724999999999 0.03170428733466979 0.0002109375 0 0.00021875099999999999 0 0.00021875125 0.03170428733466979 0.0002187515 0.12559877135637687 0.00021875175000000001 0.27807513970080033 0.00021875200000000001 0.48327381104219647 0.00021875224999999999 0.73330911551765621 0.00021875249999999999 1.0185723365976018 0.00021875274999999999 1.3281009686733882 0.000218753 1.6499999999999997 0.00021875325 1.9718990313266114 0.00021875350000000001 2.2814276634023978 0.00021875375000000001 2.5666908844823433 0.00021875399999999999 2.8167261889578032 0.00021875424999999999 3.0219248602991997 0.00021875449999999999 3.1744012286436227 0.00021875475 3.26829571266533 0.000218755 3.2999999999999998 0.0002265585 3.2999999999999998 0.00022655875000000001 3.26829571266533 0.00022655900000000001 3.1744012286436227 0.00022655925000000001 3.0219248602991997 0.00022655949999999999 2.8167261889578032 0.00022655975 2.5666908844823433 0.00022656 2.2814276634023982 0.00022656025 1.9718990313266118 0.00022656050000000001 1.6499999999999999 0.00022656075000000001 1.3281009686733884 0.00022656100000000001 1.018572336597602 0.00022656125000000002 0.73330911551765676 0.00022656150000000002 0.48327381104219669 0.00022656175 0.27807513970080017 0.000226562 0.12559877135637687 0.00022656225000000001 0.03170428733466979 0.00022656250000000001 0 0.00023437599999999998 0 0.00023437624999999998 0.03170428733466979 0.00023437649999999999 0.12559877135637687 0.00023437674999999999 0.27807513970080033 0.00023437699999999997 0.48327381104219647 0.00023437724999999997 0.73330911551765621 0.00023437749999999998 1.0185723365976018 0.00023437774999999998 1.3281009686733882 0.00023437799999999998 1.6499999999999997 0.00023437824999999999 1.9718990313266114 0.00023437849999999999 2.2814276634023978 0.00023437875 2.5666908844823433 0.000234379 2.8167261889578032 0.00023437924999999998 3.0219248602991997 0.00023437949999999998 3.1744012286436227 0.00023437974999999998 3.26829571266533 0.00023437999999999999 3.2999999999999998 0.00024218349999999999 3.2999999999999998 0.00024218374999999999 3.26829571266533 0.000242184 3.1744012286436227 0.00024218425 3.0219248602991997 0.00024218450000000001 2.8167261889578032 0.00024218474999999998 2.5666908844823433 0.00024218499999999999 2.2814276634023982 0.00024218524999999999 1.9718990313266118 0.00024218549999999999 1.6499999999999999 0.00024218575 1.3281009686733884 0.000242186 1.018572336597602 0.00024218625000000001 0.73330911551765676 0.00024218649999999998 0.48327381104219669 0.00024218674999999999 0.27807513970080017 0.00024218699999999999 0.12559877135637687 0.00024218724999999999 0.03170428733466979 0.0002421875 0 0.00025000100000000002 0 0.00025000125 0.03170428733466979 0.00025000150000000003 0.12559877135637687 0.00025000175000000001 0.27807513970080033 0.00025000200000000004 0.48327381104219647 0.00025000225000000001 0.73330911551765621 0.00025000250000000004 1.0185723365976018 0.00025000275000000002 1.3281009686733882 0.00025000300000000005 1.6499999999999997 0.00025000325000000003 1.9718990313266114 0.00025000350000000001 2.2814276634023978 0.00025000375000000004 2.5666908844823433 0.00025000400000000001 2.8167261889578032 0.00025000425000000005 3.0219248602991997 0.00025000450000000002 3.1744012286436227 0.00025000475000000005 3.26829571266533 0.00025000500000000003 3.2999999999999998 0.0002578085 3.2999999999999998 0.00025780874999999998 3.26829571266533 0.00025780900000000001 3.1744012286436227 0.00025780924999999999 3.0219248602991997 0.00025780950000000002 2.8167261889578032 0.00025780975 2.5666908844823433 0.00025781000000000003 2.2814276634023982 0.00025781025 1.9718990313266118 0.00025781049999999998 1.6499999999999999 0.00025781075000000001 1.3281009686733884 0.00025781099999999999 1.018572336597602 0.00025781125000000002 0.73330911551765676 0.0002578115 0.48327381104219669 0.00025781175000000003 0.27807513970080017 0.000257812 0.12559877135637687 0.00025781225000000004 0.03170428733466979 0.00025781250000000001 0 0.00026562600000000003 0 0.00026562625000000001 0.03170428733466979 0.00026562650000000004 0.12559877135637687 0.00026562675000000002 0.27807513970080033 0.00026562700000000005 0.48327381104219647 0.00026562725000000003 0.73330911551765621 0.00026562750000000006 1.0185723365976018 0.00026562775000000004 1.3281009686733882 0.00026562800000000007 1.6499999999999997 0.00026562825000000004 1.9718990313266114 0.00026562850000000002 2.2814276634023978 0.00026562875000000005 2.5666908844823433 0.00026562900000000003 2.8167261889578032 0.00026562925000000006 3.0219248602991997 0.00026562950000000004 3.1744012286436227 0.00026562975000000007 3.26829571266533 0.00026563000000000004 3.2999999999999998 0.00027343350000000002 3.2999999999999998 0.00027343374999999999 3.26829571266533 0.00027343400000000003 3.1744012286436227 0.00027343425 3.0219248602991997 0.00027343450000000003 2.8167261889578032 0.00027343475000000001 2.5666908844823433 0.00027343500000000004 2.2814276634023982 0.00027343525000000002 1.9718990313266118 0.00027343549999999999 1.6499999999999999 0.00027343575000000003 1.3281009686733884 0.000273436 1.018572336597602 0.00027343625000000003 0.73330911551765676 0.00027343650000000001 0.48327381104219669 0.00027343675000000004 0.27807513970080017 0.00027343700000000002 0.12559877135637687 0.00027343725000000005 0.03170428733466979 0.00027343750000000003 0 0.00028125100000000005 0 0.00028125125000000003 0.03170428733466979 0.00028125150000000006 0.12559877135637687 0.00028125175000000003 0.27807513970080033 0.00028125200000000006 0.48327381104219647 0.00028125225000000004 0.73330911551765621 0.00028125250000000007 1.0185723365976018 0.00028125275000000005 1.3281009686733882 0.00028125300000000008 1.6499999999999997 0.00028125325000000006 1.9718990313266114 0.00028125350000000003 2.2814276634023978 0.00028125375000000006 2.5666908844823433 0.00028125400000000004 2.8167261889578032 0.00028125425000000007 3.0219248602991997 0.00028125450000000005 3.1744012286436227 0.00028125475000000008 3.26829571266533 0.00028125500000000006 3.2999999999999998 0.00028905849999999998 3.2999999999999998 0.00028905874999999995 3.26829571266533 0.00028905899999999998 3.1744012286436227 0.00028905924999999996 3.0219248602991997 0.00028905949999999999 2.8167261889578032 0.00028905974999999997 2.5666908844823433 0.00028906 2.2814276634023982 0.00028906024999999998 1.9718990313266118 0.00028906050000000001 1.6499999999999999 0.00028906074999999999 1.3281009686733884 0.00028906099999999996 1.018572336597602 0.00028906124999999999 0.73330911551765676 0.00028906149999999997 0.48327381104219669 0.00028906175 0.27807513970080017 0.00028906199999999998 0.12559877135637687 0.00028906225000000001 0.03170428733466979 0.00028906249999999999 0 0.00029687600000000001 0 0.00029687624999999999 0.03170428733466979 0.00029687650000000002 0.12559877135637687 0.00029687674999999999 0.27807513970080033 0.00029687700000000002 0.48327381104219647 0.00029687725 0.73330911551765621 0.00029687750000000003 1.0185723365976018 0.00029687775000000001 1.3281009686733882 0.00029687799999999999 1.6499999999999997 0.00029687825000000002 1.9718990313266114 0.00029687849999999999 2.2814276634023978 0.00029687875000000002 2.5666908844823433 0.000296879 2.8167261889578032 0.00029687925000000003 3.0219248602991997 0.00029687950000000001 3.1744012286436227 0.00029687975000000004 3.26829571266533 0.00029688000000000002 3.2999999999999998 0.00030468349999999999 3.2999999999999998 0.00030468374999999997 3.26829571266533 0.000304684 3.1744012286436227 0.00030468424999999998 3.0219248602991997 0.00030468450000000001 2.8167261889578032 0.00030468474999999998 2.5666908844823433 0.00030468500000000001 2.2814276634023982 0.00030468524999999999 1.9718990313266118 0.00030468550000000002 1.6499999999999999 0.00030468575 1.3281009686733884 0.00030468599999999998 1.018572336597602 0.00030468625000000001 0.73330911551765676 0.00030468649999999998 0.48327381104219669 0.00030468675000000001 0.27807513970080017 0.00030468699999999999 0.12559877135637687 0.00030468725000000002 0.03170428733466979 0.0003046875 0 0.00031250100000000002 0 0.00031250125 0.03170428733466979 0.00031250150000000003 0.12559877135637687 0.00031250175000000001 0.27807513970080033 0.00031250200000000004 0.48327381104219647 0.00031250225000000001 0.73330911551765621 0.00031250250000000005 1.0185723365976018 0.00031250275000000002 1.3281009686733882 0.000312503 1.6499999999999997 0.00031250325000000003 1.9718990313266114 0.00031250350000000001 2.2814276634023978 0.00031250375000000004 2.5666908844823433 0.00031250400000000002 2.8167261889578032 0.00031250425000000005 3.0219248602991997 0.00031250450000000002 3.1744012286436227 0.00031250475000000005 3.26829571266533 0.00031250500000000003 3.2999999999999998 0.0003203085 3.2999999999999998 0.00032030874999999998 3.26829571266533 0.00032030900000000001 3.1744012286436227 0.00032030924999999999 3.0219248602991997 0.00032030950000000002 2.8167261889578032 0.00032030975 2.5666908844823433 0.00032031000000000003 2.2814276634023982 0.00032031025000000001 1.9718990313266118 0.00032031050000000004 1.6499999999999999 0.00032031075000000001 1.3281009686733884 0.00032031099999999999 1.018572336597602 0.00032031125000000002 0.73330911551765676 0.0003203115 0.48327381104219669 0.00032031175000000003 0.27807513970080017 0.00032031200000000001 0.12559877135637687 0.00032031225000000004 0.03170428733466979 0.00032031250000000001 0 0.00032812600000000004 0 0.00032812625000000001 0.03170428733466979 0.00032812650000000004 0.12559877135637687 0.00032812675000000002 0.27807513970080033 0.00032812700000000005 0.48327381104219647 0.00032812725000000003 0.73330911551765621 0.00032812750000000006 1.0185723365976018 0.00032812775000000004 1.3281009686733882 0.00032812800000000001 1.6499999999999997 0.00032812825000000004 1.9718990313266114 0.00032812850000000002 2.2814276634023978 0.00032812875000000005 2.5666908844823433 0.00032812900000000003 2.8167261889578032 0.00032812925000000006 3.0219248602991997 0.00032812950000000004 3.1744012286436227 0.00032812975000000007 3.26829571266533 0.00032813000000000004 3.2999999999999998 0.00033593350000000002 3.2999999999999998 0.00033593375 3.26829571266533 0.00033593400000000003 3.1744012286436227 0.00033593425 3.0219248602991997 0.00033593450000000003 2.8167261889578032 0.00033593475000000001 2.5666908844823433 0.00033593500000000004 2.2814276634023982 0.00033593525000000002 1.9718990313266118 0.00033593550000000005 1.6499999999999999 0.00033593575000000003 1.3281009686733884 0.000335936 1.018572336597602 0.00033593625000000003 0.73330911551765676 0.00033593650000000001 0.48327381104219669 0.00033593675000000004 0.27807513970080017 0.00033593700000000002 0.12559877135637687 0.00033593725000000005 0.03170428733466979 0.00033593750000000003 0 0.000343751 0 0.00034375124999999997 0.03170428733466979 0.0003437515 0.12559877135637687 0.00034375174999999998 0.27807513970080033 0.00034375200000000001 0.48327381104219647 0.00034375224999999999 0.73330911551765621 0.00034375250000000002 1.0185723365976018 0.00034375275 1.3281009686733882 0.00034375300000000003 1.6499999999999997 0.00034375325 1.9718990313266114 0.00034375349999999998 2.2814276634023978 0.00034375375000000001 2.5666908844823433 0.00034375399999999999 2.8167261889578032 0.00034375425000000002 3.0219248602991997 0.0003437545 3.1744012286436227 0.00034375475000000003 3.26829571266533 0.000343755 3.2999999999999998 0.00035155849999999998 3.2999999999999998 0.00035155874999999996 3.26829571266533 0.00035155899999999999 3.1744012286436227 0.00035155924999999996 3.0219248602991997 0.00035155949999999999 2.8167261889578032 0.00035155974999999997 2.5666908844823433 0.00035156 2.2814276634023982 0.00035156024999999998 1.9718990313266118 0.00035156049999999996 1.6499999999999999 0.00035156074999999999 1.3281009686733884 0.00035156099999999996 1.018572336597602 0.00035156124999999999 0.73330911551765676 0.00035156149999999997 0.48327381104219669 0.00035156175 0.27807513970080017 0.00035156199999999998 0.12559877135637687 0.00035156225000000001 0.03170428733466979 0.00035156249999999999 0 0.00035937600000000001 0 0.00035937624999999999 0.03170428733466979 0.00035937650000000002 0.12559877135637687 0.00035937674999999999 0.27807513970080033 0.00035937700000000003 0.48327381104219647 0.00035937725 0.73330911551765621 0.00035937750000000003 1.0185723365976018 0.00035937775000000001 1.3281009686733882 0.00035937800000000004 1.6499999999999997 0.00035937825000000002 1.9718990313266114 0.00035937849999999999 2.2814276634023978 0.00035937875000000003 2.5666908844823433 0.000359379 2.8167261889578032 0.00035937925000000003 3.0219248602991997 0.00035937950000000001 3.1744012286436227 0.00035937975000000004 3.26829571266533 0.00035938000000000002 3.2999999999999998 0.00036718349999999999 3.2999999999999998 0.00036718374999999997 3.26829571266533 0.000367184 3.1744012286436227 0.00036718424999999998 3.0219248602991997 0.00036718450000000001 2.8167261889578032 0.00036718474999999998 2.5666908844823433 0.00036718500000000002 2.2814276634023982 0.00036718524999999999 1.9718990313266118 0.00036718549999999997 1.6499999999999999 0.00036718575 1.3281009686733884 0.00036718599999999998 1.018572336597602 0.00036718625000000001 0.73330911551765676 0.00036718649999999999 0.48327381104219669 0.00036718675000000002 0.27807513970080017 0.00036718699999999999 0.12559877135637687 0.00036718725000000002 0.03170428733466979 0.0003671875 0 0.00037500100000000002 0 0.00037500125 0.03170428733466979 0.00037500150000000003 0.12559877135637687 0.00037500175000000001 0.27807513970080033 0.00037500200000000004 0.48327381104219647 0.00037500225000000002 0.73330911551765621 0.00037500250000000005 1.0185723365976018 0.00037500275000000002 1.3281009686733882 0.00037500300000000006 1.6499999999999997 0.00037500325000000003 1.9718990313266114 0.00037500350000000001 2.2814276634023978 0.00037500375000000004 2.5666908844823433 0.00037500400000000002 2.8167261889578032 0.00037500425000000005 3.0219248602991997 0.00037500450000000002 3.1744012286436227 0.00037500475000000006 3.26829571266533 0.00037500500000000003 3.2999999999999998 0.00038280850000000001 3.2999999999999998 0.00038280874999999998 3.26829571266533 0.00038280900000000001 3.1744012286436227 0.00038280924999999999 3.0219248602991997 0.00038280950000000002 2.8167261889578032 0.00038280975 2.5666908844823433 0.00038281000000000003 2.2814276634023982 0.00038281025000000001 1.9718990313266118 0.00038281049999999998 1.6499999999999999 0.00038281075000000001 1.3281009686733884 0.00038281099999999999 1.018572336597602 0.00038281125000000002 0.73330911551765676 0.0003828115 0.48327381104219669 0.00038281175000000003 0.27807513970080017 0.00038281200000000001 0.12559877135637687 0.00038281225000000004 0.03170428733466979 0.00038281250000000001 0 0.00039062600000000004 0 0.00039062625000000001 0.03170428733466979 0.00039062650000000005 0.12559877135637687 0.00039062675000000002 0.27807513970080033 0.00039062700000000005 0.48327381104219647 0.00039062725000000003 0.73330911551765621 0.00039062750000000006 1.0185723365976018 0.00039062775000000004 1.3281009686733882 0.00039062800000000007 1.6499999999999997 0.00039062825000000005 1.9718990313266114 0.00039062850000000002 2.2814276634023978 0.00039062875000000005 2.5666908844823433 0.00039062900000000003 2.8167261889578032 0.00039062925000000006 3.0219248602991997 0.00039062950000000004 3.1744012286436227 0.00039062975000000007 3.26829571266533 0.00039063000000000005 3.2999999999999998 0.00039843350000000002 3.2999999999999998 0.00039843375 3.26829571266533 0.00039843400000000003 3.1744012286436227 0.00039843425 3.0219248602991997 0.00039843450000000004 2.8167261889578032 0.00039843475000000001 2.5666908844823433 0.00039843500000000004 2.2814276634023982 0.00039843525000000002 1.9718990313266118 0.0003984355 1.6499999999999999 0.00039843575000000003 1.3281009686733884 0.00039843600000000001 1.018572336597602 0.00039843625000000004 0.73330911551765676 0.00039843650000000001 0.48327381104219669 0.00039843675000000004 0.27807513970080017 0.00039843700000000002 0.12559877135637687 0.00039843725000000005 0.03170428733466979 0.00039843750000000003 0 0.00040000000000000002 0)
ENCIB NCIB_DRV 0 VDD CIB_DRV 1
VCDA CDA_DRV 0 DC 3.2999999999999998 PWL(0 3.2999999999999998 1.5614999999999999e-05 3.2999999999999998 1.5615249999999999e-05 3.26829571266533 1.56155e-05 3.1744012286436227 1.561575e-05 3.0219248602991997 1.5616000000000001e-05 2.8167261889578032 1.5616249999999998e-05 2.5666908844823433 1.5616499999999999e-05 2.2814276634023982 1.5616749999999999e-05 1.9718990313266118 1.5617e-05 1.6499999999999999 1.561725e-05 1.3281009686733884 1.5617500000000001e-05 1.018572336597602 1.5617750000000001e-05 0.73330911551765676 1.5617999999999999e-05 0.48327381104219669 1.5618249999999999e-05 0.27807513970080017 1.56185e-05 0.12559877135637687 1.561875e-05 0.03170428733466979 1.5619000000000001e-05 0 2.3444499999999999e-05 0 2.3444749999999999e-05 0.03170428733466979 2.3445e-05 0.12559877135637687 2.3445250000000001e-05 0.27807513970080033 2.3445499999999998e-05 0.48327381104219647 2.3445749999999998e-05 0.73330911551765621 2.3445999999999999e-05 1.0185723365976018 2.3446249999999999e-05 1.3281009686733882 2.34465e-05 1.6499999999999997 2.344675e-05 1.9718990313266114 2.3447000000000001e-05 2.2814276634023978 2.3447250000000002e-05 2.5666908844823433 2.3447500000000002e-05 2.8167261889578032 2.3447749999999999e-05 3.0219248602991997 2.3448e-05 3.1744012286436227 2.344825e-05 3.26829571266533 2.3448500000000001e-05 3.2999999999999998 3.1239999999999999e-05 3.2999999999999998 3.1240249999999996e-05 3.26829571266533 3.12405e-05 3.1744012286436227 3.1240749999999997e-05 3.0219248602991997 3.1241000000000001e-05 2.8167261889578032 3.1241249999999998e-05 2.5666908844823433 3.1241500000000002e-05 2.2814276634023982 3.124175e-05 1.9718990313266118 3.1241999999999997e-05 1.6499999999999999 3.1242250000000001e-05 1.3281009686733884 3.1242499999999998e-05 1.018572336597602 3.1242750000000002e-05 0.73330911551765676 3.1242999999999999e-05 0.48327381104219669 3.1243250000000003e-05 0.27807513970080017 3.12435e-05 0.12559877135637687 3.1243750000000004e-05 0.03170428733466979 3.1244000000000001e-05 0 3.9069500000000003e-05 0 3.906975e-05 0.03170428733466979 3.9070000000000004e-05 0.12559877135637687 3.9070250000000001e-05 0.27807513970080033 3.9070499999999998e-05 0.48327381104219647 3.9070750000000002e-05 0.73330911551765621 3.9070999999999999e-05 1.0185723365976018 3.9071250000000003e-05 1.3281009686733882 3.90715e-05 1.6499999999999997 3.9071749999999997e-05 1.9718990313266114 3.9072000000000001e-05 2.2814276634023978 3.9072249999999998e-05 2.5666908844823433 3.9072500000000002e-05 2.8167261889578032 3.907275e-05 3.0219248602991997 3.9072999999999997e-05 3.1744012286436227 3.9073250000000001e-05 3.26829571266533 3.9073499999999998e-05 3.2999999999999998 4.6864999999999999e-05 3.2999999999999998 4.6865249999999997e-05 3.26829571266533 4.68655e-05 3.1744012286436227 4.6865749999999998e-05 3.0219248602991997 4.6866000000000002e-05 2.8167261889578032 4.6866249999999999e-05 2.5666908844823433 4.6866500000000003e-05 2.2814276634023982 4.686675e-05 1.9718990313266118 4.6866999999999997e-05 1.6499999999999999 4.6867250000000001e-05 1.3281009686733884 4.6867499999999998e-05 1.018572336597602 4.6867750000000002e-05 0.73330911551765676 4.6867999999999999e-05 0.48327381104219669 4.6868250000000003e-05 0.27807513970080017 4.68685e-05 0.12559877135637687 4.6868750000000004e-05 0.03170428733466979 4.6869000000000001e-05 0 5.4694500000000003e-05 0 5.469475e-05 0.03170428733466979 5.4695000000000004e-05 0.12559877135637687 5.4695250000000001e-05 0.27807513970080033 5.4695499999999998e-05 0.48327381104219647 5.4695750000000002e-05 0.73330911551765621 5.4695999999999999e-05 1.0185723365976018 5.4696250000000003e-05 1.3281009686733882 5.4696500000000001e-05 1.6499999999999997 5.4696749999999998e-05 1.9718990313266114 5.4697000000000002e-05 2.2814276634023978 5.4697249999999999e-05 2.5666908844823433 5.4697500000000003e-05 2.8167261889578032 5.469775e-05 3.0219248602991997 5.4697999999999997e-05 3.1744012286436227 5.4698250000000001e-05 3.26829571266533 5.4698499999999998e-05 3.2999999999999998 6.2490000000000006e-05 3.2999999999999998 6.249025000000001e-05 3.26829571266533 6.2490500000000001e-05 3.1744012286436227 6.2490750000000005e-05 3.0219248602991997 6.2491000000000009e-05 2.8167261889578032 6.2491249999999999e-05 2.5666908844823433 6.2491500000000003e-05 2.2814276634023982 6.2491750000000007e-05 1.9718990313266118 6.2492000000000011e-05 1.6499999999999999 6.2492250000000001e-05 1.3281009686733884 6.2492500000000005e-05 1.018572336597602 6.2492750000000009e-05 0.73330911551765676 6.2493e-05 0.48327381104219669 6.2493250000000003e-05 0.27807513970080017 6.2493500000000007e-05 0.12559877135637687 6.2493749999999998e-05 0.03170428733466979 6.2494000000000002e-05 0 7.031950000000001e-05 0 7.0319750000000014e-05 0.03170428733466979 7.0320000000000004e-05 0.12559877135637687 7.0320250000000008e-05 0.27807513970080033 7.0320500000000012e-05 0.48327381104219647 7.0320750000000003e-05 0.73330911551765621 7.0321000000000007e-05 1.0185723365976018 7.032125000000001e-05 1.3281009686733882 7.0321500000000014e-05 1.6499999999999997 7.0321750000000005e-05 1.9718990313266114 7.0322000000000009e-05 2.2814276634023978 7.0322250000000013e-05 2.5666908844823433 7.0322500000000003e-05 2.8167261889578032 7.0322750000000007e-05 3.0219248602991997 7.0323000000000011e-05 3.1744012286436227 7.0323250000000001e-05 3.26829571266533 7.0323500000000005e-05 3.2999999999999998 7.8115000000000007e-05 3.2999999999999998 7.8115250000000011e-05 3.26829571266533 7.8115500000000001e-05 3.1744012286436227 7.8115750000000005e-05 3.0219248602991997 7.8116000000000009e-05 2.8167261889578032 7.8116249999999999e-05 2.5666908844823433 7.8116500000000003e-05 2.2814276634023982 7.8116750000000007e-05 1.9718990313266118 7.8116999999999998e-05 1.6499999999999999 7.8117250000000002e-05 1.3281009686733884 7.8117500000000006e-05 1.018572336597602 7.8117750000000009e-05 0.73330911551765676 7.8118e-05 0.48327381104219669 7.8118250000000004e-05 0.27807513970080017 7.8118500000000008e-05 0.12559877135637687 7.8118749999999998e-05 0.03170428733466979 7.8119000000000002e-05 0 8.5944499999999997e-05 0 8.5944750000000001e-05 0.03170428733466979 8.5944999999999991e-05 0.12559877135637687 8.5945249999999995e-05 0.27807513970080033 8.5945499999999999e-05 0.48327381104219647 8.5945749999999989e-05 0.73330911551765621 8.5945999999999993e-05 1.0185723365976018 8.5946249999999997e-05 1.3281009686733882 8.5946500000000001e-05 1.6499999999999997 8.5946749999999992e-05 1.9718990313266114 8.5946999999999996e-05 2.2814276634023978 8.5947249999999999e-05 2.5666908844823433 8.594749999999999e-05 2.8167261889578032 8.5947749999999994e-05 3.0219248602991997 8.5947999999999998e-05 3.1744012286436227 8.5948249999999988e-05 3.26829571266533 8.5948499999999992e-05 3.2999999999999998 9.3740000000000007e-05 3.2999999999999998 9.3740250000000011e-05 3.26829571266533 9.3740500000000001e-05 3.1744012286436227 9.3740750000000005e-05 3.0219248602991997 9.3741000000000009e-05 2.8167261889578032 9.374125e-05 2.5666908844823433 9.3741500000000004e-05 2.2814276634023982 9.3741750000000008e-05 1.9718990313266118 9.3742000000000012e-05 1.6499999999999999 9.3742250000000002e-05 1.3281009686733884 9.3742500000000006e-05 1.018572336597602 9.374275000000001e-05 0.73330911551765676 9.3743e-05 0.48327381104219669 9.3743250000000004e-05 0.27807513970080017 9.3743500000000008e-05 0.12559877135637687 9.3743749999999998e-05 0.03170428733466979 9.3744000000000002e-05 0 0.00010156950000000001 0 0.00010156975000000001 0.03170428733466979 0.00010157000000000001 0.12559877135637687 0.00010157025000000001 0.27807513970080033 0.00010157050000000001 0.48327381104219647 0.00010157075 0.73330911551765621 0.00010157100000000001 1.0185723365976018 0.00010157125000000001 1.3281009686733882 0.00010157150000000002 1.6499999999999997 0.00010157175000000001 1.9718990313266114 0.00010157200000000001 2.2814276634023978 0.00010157225000000001 2.5666908844823433 0.0001015725 2.8167261889578032 0.00010157275000000001 3.0219248602991997 0.00010157300000000001 3.1744012286436227 0.00010157325 3.26829571266533 0.00010157350000000001 3.2999999999999998 0.00010936500000000001 3.2999999999999998 0.00010936525000000001 3.26829571266533 0.0001093655 3.1744012286436227 0.00010936575000000001 3.0219248602991997 0.00010936600000000001 2.8167261889578032 0.00010936625 2.5666908844823433 0.0001093665 2.2814276634023982 0.00010936675000000001 1.9718990313266118 0.000109367 1.6499999999999999 0.00010936725 1.3281009686733884 0.00010936750000000001 1.018572336597602 0.00010936775000000001 0.73330911551765676 0.000109368 0.48327381104219669 0.00010936825 0.27807513970080017 0.00010936850000000001 0.12559877135637687 0.00010936875 0.03170428733466979 0.000109369 0 0.0001171945 0 0.00011719475 0.03170428733466979 0.00011719499999999999 0.12559877135637687 0.00011719525 0.27807513970080033 0.0001171955 0.48327381104219647 0.00011719574999999999 0.73330911551765621 0.00011719599999999999 1.0185723365976018 0.00011719625 1.3281009686733882 0.0001171965 1.6499999999999997 0.00011719674999999999 1.9718990313266114 0.000117197 2.2814276634023978 0.00011719725 2.5666908844823433 0.00011719749999999999 2.8167261889578032 0.00011719774999999999 3.0219248602991997 0.000117198 3.1744012286436227 0.00011719824999999999 3.26829571266533 0.00011719849999999999 3.2999999999999998 0.00012499000000000001 3.2999999999999998 0.00012499025000000001 3.26829571266533 0.00012499050000000002 3.1744012286436227 0.00012499074999999999 3.0219248602991997 0.000124991 2.8167261889578032 0.00012499125 2.5666908844823433 0.0001249915 2.2814276634023982 0.00012499175000000001 1.9718990313266118 0.00012499199999999999 1.6499999999999999 0.00012499224999999999 1.3281009686733884 0.00012499249999999999 1.018572336597602 0.00012499275 0.73330911551765676 0.000124993 0.48327381104219669 0.00012499325 0.27807513970080017 0.00012499349999999998 0.12559877135637687 0.00012499374999999999 0.03170428733466979 0.00012499399999999999 0 0.00013281950000000001 0 0.00013281975000000002 0.03170428733466979 0.00013282000000000002 0.12559877135637687 0.00013282025000000002 0.27807513970080033 0.00013282050000000003 0.48327381104219647 0.00013282075 0.73330911551765621 0.00013282100000000001 1.0185723365976018 0.00013282125000000001 1.3281009686733882 0.00013282150000000002 1.6499999999999997 0.00013282175000000002 1.9718990313266114 0.00013282200000000002 2.2814276634023978 0.00013282225000000003 2.5666908844823433 0.0001328225 2.8167261889578032 0.00013282275000000001 3.0219248602991997 0.00013282300000000001 3.1744012286436227 0.00013282325000000002 3.26829571266533 0.00013282350000000002 3.2999999999999998 0.00014061500000000002 3.2999999999999998 0.00014061525000000003 3.26829571266533 0.00014061550000000003 3.1744012286436227 0.00014061575000000001 3.0219248602991997 0.00014061600000000001 2.8167261889578032 0.00014061625000000001 2.5666908844823433 0.00014061650000000002 2.2814276634023982 0.00014061675000000002 1.9718990313266118 0.000140617 1.6499999999999999 0.00014061725 1.3281009686733884 0.00014061750000000001 1.018572336597602 0.00014061775000000001 0.73330911551765676 0.00014061800000000001 0.48327381104219669 0.00014061825000000002 0.27807513970080017 0.0001406185 0.12559877135637687 0.00014061875 0.03170428733466979 0.000140619 0 0.0001484445 0 0.00014844475 0.03170428733466979 0.00014844500000000001 0.12559877135637687 0.00014844525000000001 0.27807513970080033 0.00014844549999999999 0.48327381104219647 0.00014844574999999999 0.73330911551765621 0.00014844599999999999 1.0185723365976018 0.00014844625 1.3281009686733882 0.0001484465 1.6499999999999997 0.00014844675000000001 1.9718990313266114 0.00014844700000000001 2.2814276634023978 0.00014844725000000001 2.5666908844823433 0.00014844750000000002 2.8167261889578032 0.00014844775 3.0219248602991997 0.000148448 3.1744012286436227 0.00014844825 3.26829571266533 0.00014844850000000001 3.2999999999999998 0.00015624000000000001 3.2999999999999998 0.00015624025000000001 3.26829571266533 0.00015624050000000002 3.1744012286436227 0.00015624074999999999 3.0219248602991997 0.000156241 2.8167261889578032 0.00015624125 2.5666908844823433 0.0001562415 2.2814276634023982 0.00015624175000000001 1.9718990313266118 0.00015624200000000001 1.6499999999999999 0.00015624224999999999 1.3281009686733884 0.00015624249999999999 1.018572336597602 0.00015624275 0.73330911551765676 0.000156243 0.48327381104219669 0.00015624325000000001 0.27807513970080017 0.00015624349999999998 0.12559877135637687 0.00015624374999999999 0.03170428733466979 0.00015624399999999999 0 0.00016406950000000001 0 0.00016406975000000002 0.03170428733466979 0.00016407000000000002 0.12559877135637687 0.00016407025000000002 0.27807513970080033 0.0001640705 0.48327381104219647 0.00016407075 0.73330911551765621 0.00016407100000000001 1.0185723365976018 0.00016407125000000001 1.3281009686733882 0.00016407150000000002 1.6499999999999997 0.00016407175000000002 1.9718990313266114 0.00016407200000000002 2.2814276634023978 0.00016407225000000003 2.5666908844823433 0.00016407250000000003 2.8167261889578032 0.00016407275000000001 3.0219248602991997 0.00016407300000000001 3.1744012286436227 0.00016407325000000002 3.26829571266533 0.00016407350000000002 3.2999999999999998 0.000171865 3.2999999999999998 0.00017186525 3.26829571266533 0.0001718655 3.1744012286436227 0.00017186574999999998 3.0219248602991997 0.00017186599999999998 2.8167261889578032 0.00017186624999999999 2.5666908844823433 0.00017186649999999999 2.2814276634023982 0.00017186675 1.9718990313266118 0.00017186699999999997 1.6499999999999999 0.00017186724999999998 1.3281009686733884 0.00017186749999999998 1.018572336597602 0.00017186774999999998 0.73330911551765676 0.00017186799999999999 0.48327381104219669 0.00017186824999999999 0.27807513970080017 0.00017186849999999997 0.12559877135637687 0.00017186874999999997 0.03170428733466979 0.00017186899999999998 0 0.0001796945 0 0.00017969475 0.03170428733466979 0.00017969500000000001 0.12559877135637687 0.00017969525000000001 0.27807513970080033 0.00017969550000000001 0.48327381104219647 0.00017969574999999999 0.73330911551765621 0.000179696 1.0185723365976018 0.00017969625 1.3281009686733882 0.0001796965 1.6499999999999997 0.00017969675000000001 1.9718990313266114 0.00017969700000000001 2.2814276634023978 0.00017969725000000001 2.5666908844823433 0.00017969749999999999 2.8167261889578032 0.00017969775 3.0219248602991997 0.000179698 3.1744012286436227 0.00017969825 3.26829571266533 0.00017969850000000001 3.2999999999999998 0.00018749000000000001 3.2999999999999998 0.00018749025000000001 3.26829571266533 0.00018749050000000002 3.1744012286436227 0.00018749074999999999 3.0219248602991997 0.000187491 2.8167261889578032 0.00018749125 2.5666908844823433 0.00018749150000000001 2.2814276634023982 0.00018749175000000001 1.9718990313266118 0.00018749199999999999 1.6499999999999999 0.00018749224999999999 1.3281009686733884 0.00018749249999999999 1.018572336597602 0.00018749275 0.73330911551765676 0.000187493 0.48327381104219669 0.00018749325000000001 0.27807513970080017 0.00018749349999999998 0.12559877135637687 0.00018749374999999999 0.03170428733466979 0.00018749399999999999 0 0.00019531950000000001 0 0.00019531975000000002 0.03170428733466979 0.00019532000000000002 0.12559877135637687 0.00019532025000000002 0.27807513970080033 0.00019532050000000003 0.48327381104219647 0.00019532075000000001 0.73330911551765621 0.00019532100000000001 1.0185723365976018 0.00019532125000000001 1.3281009686733882 0.00019532150000000002 1.6499999999999997 0.00019532175000000002 1.9718990313266114 0.00019532200000000002 2.2814276634023978 0.00019532225000000003 2.5666908844823433 0.00019532250000000001 2.8167261889578032 0.00019532275000000001 3.0219248602991997 0.00019532300000000001 3.1744012286436227 0.00019532325000000002 3.26829571266533 0.00019532350000000002 3.2999999999999998 0.00020000000000000001 3.2999999999999998 0.00020311500000000002 3.2999999999999998 0.00020311525000000003 3.26829571266533 0.00020311550000000003 3.1744012286436227 0.00020311575000000001 3.0219248602991997 0.00020311600000000001 2.8167261889578032 0.00020311625000000002 2.5666908844823433 0.00020311650000000002 2.2814276634023982 0.00020311675000000002 1.9718990313266118 0.000203117 1.6499999999999999 0.00020311725 1.3281009686733884 0.00020311750000000001 1.018572336597602 0.00020311775000000001 0.73330911551765676 0.00020311800000000002 0.48327381104219669 0.00020311825000000002 0.27807513970080017 0.0002031185 0.12559877135637687 0.00020311875 0.03170428733466979 0.000203119 0 0.0002109445 0 0.00021094475 0.03170428733466979 0.00021094500000000001 0.12559877135637687 0.00021094525000000001 0.27807513970080033 0.00021094549999999999 0.48327381104219647 0.00021094574999999999 0.73330911551765621 0.000210946 1.0185723365976018 0.00021094625 1.3281009686733882 0.0002109465 1.6499999999999997 0.00021094675000000001 1.9718990313266114 0.00021094700000000001 2.2814276634023978 0.00021094725000000002 2.5666908844823433 0.00021094750000000002 2.8167261889578032 0.00021094775 3.0219248602991997 0.000210948 3.1744012286436227 0.00021094825 3.26829571266533 0.00021094850000000001 3.2999999999999998 0.00021874000000000001 3.2999999999999998 0.00021874025000000001 3.26829571266533 0.00021874050000000002 3.1744012286436227 0.00021874074999999999 3.0219248602991997 0.000218741 2.8167261889578032 0.00021874125 2.5666908844823433 0.00021874150000000001 2.2814276634023982 0.00021874175000000001 1.9718990313266118 0.00021874200000000001 1.6499999999999999 0.00021874224999999999 1.3281009686733884 0.00021874249999999999 1.018572336597602 0.00021874275 0.73330911551765676 0.000218743 0.48327381104219669 0.00021874325000000001 0.27807513970080017 0.00021874349999999998 0.12559877135637687 0.00021874374999999999 0.03170428733466979 0.00021874399999999999 0 0.00022656950000000001 0 0.00022656975000000002 0.03170428733466979 0.00022657000000000002 0.12559877135637687 0.00022657025000000003 0.27807513970080033 0.0002265705 0.48327381104219647 0.00022657075000000001 0.73330911551765621 0.00022657100000000001 1.0185723365976018 0.00022657125000000001 1.3281009686733882 0.00022657150000000002 1.6499999999999997 0.00022657175000000002 1.9718990313266114 0.00022657200000000003 2.2814276634023978 0.00022657225000000003 2.5666908844823433 0.00022657250000000003 2.8167261889578032 0.00022657275000000001 3.0219248602991997 0.00022657300000000001 3.1744012286436227 0.00022657325000000002 3.26829571266533 0.00022657350000000002 3.2999999999999998 0.000234365 3.2999999999999998 0.00023436525 3.26829571266533 0.0002343655 3.1744012286436227 0.00023436574999999998 3.0219248602991997 0.00023436599999999999 2.8167261889578032 0.00023436624999999999 2.5666908844823433 0.00023436649999999999 2.2814276634023982 0.00023436675 1.9718990313266118 0.00023436699999999997 1.6499999999999999 0.00023436724999999998 1.3281009686733884 0.00023436749999999998 1.018572336597602 0.00023436774999999999 0.73330911551765676 0.00023436799999999999 0.48327381104219669 0.00023436824999999999 0.27807513970080017 0.00023436849999999997 0.12559877135637687 0.00023436874999999997 0.03170428733466979 0.00023436899999999998 0 0.0002421945 0 0.00024219475 0.03170428733466979 0.00024219500000000001 0.12559877135637687 0.00024219525000000001 0.27807513970080033 0.00024219550000000002 0.48327381104219647 0.00024219574999999999 0.73330911551765621 0.000242196 1.0185723365976018 0.00024219625 1.3281009686733882 0.0002421965 1.6499999999999997 0.00024219675000000001 1.9718990313266114 0.00024219700000000001 2.2814276634023978 0.00024219725000000002 2.5666908844823433 0.00024219749999999999 2.8167261889578032 0.00024219775 3.0219248602991997 0.000242198 3.1744012286436227 0.00024219825 3.26829571266533 0.00024219850000000001 3.2999999999999998 0.00024999000000000001 3.2999999999999998 0.00024999024999999999 3.26829571266533 0.00024999050000000002 3.1744012286436227 0.00024999075 3.0219248602991997 0.00024999100000000003 2.8167261889578032 0.00024999125 2.5666908844823433 0.00024999150000000003 2.2814276634023982 0.00024999175000000001 1.9718990313266118 0.00024999199999999999 1.6499999999999999 0.00024999225000000002 1.3281009686733884 0.0002499925 1.018572336597602 0.00024999275000000003 0.73330911551765676 0.000249993 0.48327381104219669 0.00024999325000000003 0.27807513970080017 0.00024999350000000001 0.12559877135637687 0.00024999375000000004 0.03170428733466979 0.00024999400000000002 0 0.00025781950000000001 0 0.00025781974999999999 0.03170428733466979 0.00025782000000000002 0.12559877135637687 0.00025782025 0.27807513970080033 0.00025782050000000003 0.48327381104219647 0.00025782075000000001 0.73330911551765621 0.00025782100000000004 1.0185723365976018 0.00025782125000000001 1.3281009686733882 0.00025782150000000005 1.6499999999999997 0.00025782175000000002 1.9718990313266114 0.000257822 2.2814276634023978 0.00025782225000000003 2.5666908844823433 0.00025782250000000001 2.8167261889578032 0.00025782275000000004 3.0219248602991997 0.00025782300000000001 3.1744012286436227 0.00025782325000000005 3.26829571266533 0.00025782350000000002 3.2999999999999998 0.00026561500000000002 3.2999999999999998 0.00026561525 3.26829571266533 0.00026561550000000003 3.1744012286436227 0.00026561575000000001 3.0219248602991997 0.00026561600000000004 2.8167261889578032 0.00026561625000000002 2.5666908844823433 0.00026561650000000005 2.2814276634023982 0.00026561675000000002 1.9718990313266118 0.000265617 1.6499999999999999 0.00026561725000000003 1.3281009686733884 0.00026561750000000001 1.018572336597602 0.00026561775000000004 0.73330911551765676 0.00026561800000000002 0.48327381104219669 0.00026561825000000005 0.27807513970080017 0.00026561850000000003 0.12559877135637687 0.00026561875000000006 0.03170428733466979 0.00026561900000000003 0 0.00027344450000000003 0 0.00027344475 0.03170428733466979 0.00027344500000000004 0.12559877135637687 0.00027344525000000001 0.27807513970080033 0.00027344550000000004 0.48327381104219647 0.00027344575000000002 0.73330911551765621 0.00027344600000000005 1.0185723365976018 0.00027344625000000003 1.3281009686733882 0.00027344650000000006 1.6499999999999997 0.00027344675000000004 1.9718990313266114 0.00027344700000000001 2.2814276634023978 0.00027344725000000004 2.5666908844823433 0.00027344750000000002 2.8167261889578032 0.00027344775000000005 3.0219248602991997 0.00027344800000000003 3.1744012286436227 0.00027344825000000006 3.26829571266533 0.00027344850000000004 3.2999999999999998 0.00028124000000000004 3.2999999999999998 0.00028124025000000001 3.26829571266533 0.00028124050000000005 3.1744012286436227 0.00028124075000000002 3.0219248602991997 0.00028124100000000005 2.8167261889578032 0.00028124125000000003 2.5666908844823433 0.00028124150000000006 2.2814276634023982 0.00028124175000000004 1.9718990313266118 0.00028124200000000002 1.6499999999999999 0.00028124225000000005 1.3281009686733884 0.00028124250000000002 1.018572336597602 0.00028124275000000005 0.73330911551765676 0.00028124300000000003 0.48327381104219669 0.00028124325000000006 0.27807513970080017 0.00028124350000000004 0.12559877135637687 0.00028124375000000007 0.03170428733466979 0.00028124400000000005 0 0.00028906949999999999 0 0.00028906974999999996 0.03170428733466979 0.00028907 0.12559877135637687 0.00028907024999999997 0.27807513970080033 0.0002890705 0.48327381104219647 0.00028907074999999998 0.73330911551765621 0.00028907100000000001 1.0185723365976018 0.00028907124999999999 1.3281009686733882 0.00028907149999999996 1.6499999999999997 0.00028907175 1.9718990313266114 0.00028907199999999997 2.2814276634023978 0.00028907225 2.5666908844823433 0.00028907249999999998 2.8167261889578032 0.00028907275000000001 3.0219248602991997 0.00028907299999999999 3.1744012286436227 0.00028907325000000002 3.26829571266533 0.0002890735 3.2999999999999998 0.000296865 3.2999999999999998 0.00029686524999999997 3.26829571266533 0.00029686550000000001 3.1744012286436227 0.00029686574999999998 3.0219248602991997 0.00029686600000000001 2.8167261889578032 0.00029686624999999999 2.5666908844823433 0.00029686650000000002 2.2814276634023982 0.00029686675 1.9718990313266118 0.00029686700000000003 1.6499999999999999 0.00029686725000000001 1.3281009686733884 0.00029686749999999998 1.018572336597602 0.00029686775000000001 0.73330911551765676 0.00029686799999999999 0.48327381104219669 0.00029686825000000002 0.27807513970080017 0.0002968685 0.12559877135637687 0.00029686875000000003 0.03170428733466979 0.00029686900000000001 0 0.0003046945 0 0.00030469474999999998 0.03170428733466979 0.00030469500000000001 0.12559877135637687 0.00030469524999999999 0.27807513970080033 0.00030469550000000002 0.48327381104219647 0.00030469574999999999 0.73330911551765621 0.00030469600000000002 1.0185723365976018 0.00030469625 1.3281009686733882 0.00030469649999999998 1.6499999999999997 0.00030469675000000001 1.9718990313266114 0.00030469699999999999 2.2814276634023978 0.00030469725000000002 2.5666908844823433 0.00030469749999999999 2.8167261889578032 0.00030469775000000003 3.0219248602991997 0.000304698 3.1744012286436227 0.00030469825000000003 3.26829571266533 0.00030469850000000001 3.2999999999999998 0.00031249000000000001 3.2999999999999998 0.00031249024999999999 3.26829571266533 0.00031249050000000002 3.1744012286436227 0.00031249075 3.0219248602991997 0.00031249100000000003 2.8167261889578032 0.00031249125 2.5666908844823433 0.00031249150000000004 2.2814276634023982 0.00031249175000000001 1.9718990313266118 0.00031249200000000004 1.6499999999999999 0.00031249225000000002 1.3281009686733884 0.0003124925 1.018572336597602 0.00031249275000000003 0.73330911551765676 0.000312493 0.48327381104219669 0.00031249325000000004 0.27807513970080017 0.00031249350000000001 0.12559877135637687 0.00031249375000000004 0.03170428733466979 0.00031249400000000002 0 0.00032031950000000002 0 0.00032031974999999999 0.03170428733466979 0.00032032000000000002 0.12559877135637687 0.00032032025 0.27807513970080033 0.00032032050000000003 0.48327381104219647 0.00032032075000000001 0.73330911551765621 0.00032032100000000004 1.0185723365976018 0.00032032125000000002 1.3281009686733882 0.00032032149999999999 1.6499999999999997 0.00032032175000000002 1.9718990313266114 0.000320322 2.2814276634023978 0.00032032225000000003 2.5666908844823433 0.00032032250000000001 2.8167261889578032 0.00032032275000000004 3.0219248602991997 0.00032032300000000002 3.1744012286436227 0.00032032325000000005 3.26829571266533 0.00032032350000000002 3.2999999999999998 0.00032811500000000003 3.2999999999999998 0.00032811525 3.26829571266533 0.00032811550000000003 3.1744012286436227 0.00032811575000000001 3.0219248602991997 0.00032811600000000004 2.8167261889578032 0.00032811625000000002 2.5666908844823433 0.00032811650000000005 2.2814276634023982 0.00032811675000000003 1.9718990313266118 0.00032811700000000006 1.6499999999999999 0.00032811725000000003 1.3281009686733884 0.00032811750000000001 1.018572336597602 0.00032811775000000004 0.73330911551765676 0.00032811800000000002 0.48327381104219669 0.00032811825000000005 0.27807513970080017 0.00032811850000000003 0.12559877135637687 0.00032811875000000006 0.03170428733466979 0.00032811900000000003 0 0.00033594450000000003 0 0.00033594475000000001 0.03170428733466979 0.00033594500000000004 0.12559877135637687 0.00033594525000000001 0.27807513970080033 0.00033594550000000004 0.48327381104219647 0.00033594575000000002 0.73330911551765621 0.00033594600000000005 1.0185723365976018 0.00033594625000000003 1.3281009686733882 0.00033594650000000001 1.6499999999999997 0.00033594675000000004 1.9718990313266114 0.00033594700000000001 2.2814276634023978 0.00033594725000000005 2.5666908844823433 0.00033594750000000002 2.8167261889578032 0.00033594775000000005 3.0219248602991997 0.00033594800000000003 3.1744012286436227 0.00033594825000000006 3.26829571266533 0.00033594850000000004 3.2999999999999998 0.00034373999999999999 3.2999999999999998 0.00034374024999999996 3.26829571266533 0.00034374049999999999 3.1744012286436227 0.00034374074999999997 3.0219248602991997 0.000343741 2.8167261889578032 0.00034374124999999998 2.5666908844823433 0.00034374150000000001 2.2814276634023982 0.00034374174999999999 1.9718990313266118 0.00034374199999999996 1.6499999999999999 0.00034374224999999999 1.3281009686733884 0.00034374249999999997 1.018572336597602 0.00034374275 0.73330911551765676 0.00034374299999999998 0.48327381104219669 0.00034374325000000001 0.27807513970080017 0.00034374349999999999 0.12559877135637687 0.00034374375000000002 0.03170428733466979 0.00034374399999999999 0 0.00035156949999999999 0 0.00035156974999999997 0.03170428733466979 0.00035157 0.12559877135637687 0.00035157024999999997 0.27807513970080033 0.0003515705 0.48327381104219647 0.00035157074999999998 0.73330911551765621 0.00035157100000000001 1.0185723365976018 0.00035157124999999999 1.3281009686733882 0.00035157150000000002 1.6499999999999997 0.00035157175 1.9718990313266114 0.00035157199999999997 2.2814276634023978 0.00035157225 2.5666908844823433 0.00035157249999999998 2.8167261889578032 0.00035157275000000001 3.0219248602991997 0.00035157299999999999 3.1744012286436227 0.00035157325000000002 3.26829571266533 0.0003515735 3.2999999999999998 0.000359365 3.2999999999999998 0.00035936524999999998 3.26829571266533 0.00035936550000000001 3.1744012286436227 0.00035936574999999998 3.0219248602991997 0.00035936600000000001 2.8167261889578032 0.00035936624999999999 2.5666908844823433 0.00035936650000000002 2.2814276634023982 0.00035936675 1.9718990313266118 0.00035936699999999998 1.6499999999999999 0.00035936725000000001 1.3281009686733884 0.00035936749999999998 1.018572336597602 0.00035936775000000002 0.73330911551765676 0.00035936799999999999 0.48327381104219669 0.00035936825000000002 0.27807513970080017 0.0003593685 0.12559877135637687 0.00035936875000000003 0.03170428733466979 0.00035936900000000001 0 0.0003671945 0 0.00036719474999999998 0.03170428733466979 0.00036719500000000001 0.12559877135637687 0.00036719524999999999 0.27807513970080033 0.00036719550000000002 0.48327381104219647 0.00036719575 0.73330911551765621 0.00036719600000000003 1.0185723365976018 0.00036719625 1.3281009686733882 0.00036719650000000003 1.6499999999999997 0.00036719675000000001 1.9718990313266114 0.00036719699999999999 2.2814276634023978 0.00036719725000000002 2.5666908844823433 0.0003671975 2.8167261889578032 0.00036719775000000003 3.0219248602991997 0.000367198 3.1744012286436227 0.00036719825000000003 3.26829571266533 0.00036719850000000001 3.2999999999999998 0.00037499000000000001 3.2999999999999998 0.00037499024999999999 3.26829571266533 0.00037499050000000002 3.1744012286436227 0.00037499075 3.0219248602991997 0.00037499100000000003 2.8167261889578032 0.00037499125000000001 2.5666908844823433 0.00037499150000000004 2.2814276634023982 0.00037499175000000001 1.9718990313266118 0.00037499199999999999 1.6499999999999999 0.00037499225000000002 1.3281009686733884 0.0003749925 1.018572336597602 0.00037499275000000003 0.73330911551765676 0.00037499300000000001 0.48327381104219669 0.00037499325000000004 0.27807513970080017 0.00037499350000000001 0.12559877135637687 0.00037499375000000004 0.03170428733466979 0.00037499400000000002 0 0.00038281950000000002 0 0.00038281974999999999 0.03170428733466979 0.00038282000000000002 0.12559877135637687 0.00038282025 0.27807513970080033 0.00038282050000000003 0.48327381104219647 0.00038282075000000001 0.73330911551765621 0.00038282100000000004 1.0185723365976018 0.00038282125000000002 1.3281009686733882 0.00038282150000000005 1.6499999999999997 0.00038282175000000002 1.9718990313266114 0.000382822 2.2814276634023978 0.00038282225000000003 2.5666908844823433 0.00038282250000000001 2.8167261889578032 0.00038282275000000004 3.0219248602991997 0.00038282300000000002 3.1744012286436227 0.00038282325000000005 3.26829571266533 0.00038282350000000003 3.2999999999999998 0.00039061500000000003 3.2999999999999998 0.00039061525 3.26829571266533 0.00039061550000000003 3.1744012286436227 0.00039061575000000001 3.0219248602991997 0.00039061600000000004 2.8167261889578032 0.00039061625000000002 2.5666908844823433 0.00039061650000000005 2.2814276634023982 0.00039061675000000003 1.9718990313266118 0.000390617 1.6499999999999999 0.00039061725000000004 1.3281009686733884 0.00039061750000000001 1.018572336597602 0.00039061775000000004 0.73330911551765676 0.00039061800000000002 0.48327381104219669 0.00039061825000000005 0.27807513970080017 0.00039061850000000003 0.12559877135637687 0.00039061875000000006 0.03170428733466979 0.00039061900000000004 0 0.00039844450000000003 0 0.00039844475000000001 0.03170428733466979 0.00039844500000000004 0.12559877135637687 0.00039844525000000002 0.27807513970080033 0.00039844550000000005 0.48327381104219647 0.00039844575000000002 0.73330911551765621 0.00039844600000000005 1.0185723365976018 0.00039844625000000003 1.3281009686733882 0.00039844650000000006 1.6499999999999997 0.00039844675000000004 1.9718990313266114 0.00039844700000000002 2.2814276634023978 0.00039844725000000005 2.5666908844823433 0.00039844750000000002 2.8167261889578032 0.00039844775000000005 3.0219248602991997 0.00039844800000000003 3.1744012286436227 0.00039844825000000006 3.26829571266533 0.00039844850000000004 3.2999999999999998 0.00040000000000000002 3.2999999999999998)
ENCDA NCDA_DRV 0 VDD CDA_DRV 1
VCDB CDB_DRV 0 DC 0 PWL(0 0 1.5631999999999999e-05 0 1.5632249999999999e-05 0.03170428733466979 1.56325e-05 0.12559877135637687 1.563275e-05 0.27807513970080033 1.5632999999999998e-05 0.48327381104219647 1.5633249999999998e-05 0.73330911551765621 1.5633499999999999e-05 1.0185723365976018 1.5633749999999999e-05 1.3281009686733882 1.5634e-05 1.6499999999999997 1.563425e-05 1.9718990313266114 1.5634500000000001e-05 2.2814276634023978 1.5634750000000001e-05 2.5666908844823433 1.5635000000000002e-05 2.8167261889578032 1.5635249999999999e-05 3.0219248602991997 1.56355e-05 3.1744012286436227 1.563575e-05 3.26829571266533 1.5636000000000001e-05 3.2999999999999998 2.3427499999999999e-05 3.2999999999999998 2.3427749999999999e-05 3.26829571266533 2.3428e-05 3.1744012286436227 2.3428250000000001e-05 3.0219248602991997 2.3428500000000001e-05 2.8167261889578032 2.3428749999999998e-05 2.5666908844823433 2.3428999999999999e-05 2.2814276634023982 2.3429249999999999e-05 1.9718990313266118 2.34295e-05 1.6499999999999999 2.342975e-05 1.3281009686733884 2.3430000000000001e-05 1.018572336597602 2.3430250000000002e-05 0.73330911551765676 2.3430499999999999e-05 0.48327381104219669 2.3430749999999999e-05 0.27807513970080017 2.3431e-05 0.12559877135637687 2.343125e-05 0.03170428733466979 2.3431500000000001e-05 0 3.1257000000000002e-05 0 3.125725e-05 0.03170428733466979 3.1257500000000004e-05 0.12559877135637687 3.1257750000000001e-05 0.27807513970080033 3.1258000000000005e-05 0.48327381104219647 3.1258250000000002e-05 0.73330911551765621 3.1258499999999999e-05 1.0185723365976018 3.1258750000000003e-05 1.3281009686733882 3.1259e-05 1.6499999999999997 3.1259249999999997e-05 1.9718990313266114 3.1259500000000001e-05 2.2814276634023978 3.1259749999999998e-05 2.5666908844823433 3.1259999999999995e-05 2.8167261889578032 3.1260249999999999e-05 3.0219248602991997 3.1260499999999997e-05 3.1744012286436227 3.1260750000000001e-05 3.26829571266533 3.1260999999999998e-05 3.2999999999999998 3.9052499999999999e-05 3.2999999999999998 3.9052749999999996e-05 3.26829571266533 3.9053e-05 3.1744012286436227 3.9053249999999997e-05 3.0219248602991997 3.9053500000000001e-05 2.8167261889578032 3.9053749999999999e-05 2.5666908844823433 3.9054000000000003e-05 2.2814276634023982 3.905425e-05 1.9718990313266118 3.9054500000000004e-05 1.6499999999999999 3.9054750000000001e-05 1.3281009686733884 3.9054999999999998e-05 1.018572336597602 3.9055250000000002e-05 0.73330911551765676 3.9055499999999999e-05 0.48327381104219669 3.9055750000000003e-05 0.27807513970080017 3.9056e-05 0.12559877135637687 3.9056250000000004e-05 0.03170428733466979 3.9056500000000001e-05 0 4.6882000000000003e-05 0 4.688225e-05 0.03170428733466979 4.6882500000000004e-05 0.12559877135637687 4.6882750000000001e-05 0.27807513970080033 4.6883000000000005e-05 0.48327381104219647 4.6883250000000002e-05 0.73330911551765621 4.6883499999999999e-05 1.0185723365976018 4.6883750000000003e-05 1.3281009686733882 4.6884e-05 1.6499999999999997 4.6884249999999998e-05 1.9718990313266114 4.6884500000000001e-05 2.2814276634023978 4.6884749999999999e-05 2.5666908844823433 4.6884999999999996e-05 2.8167261889578032 4.688525e-05 3.0219248602991997 4.6885499999999997e-05 3.1744012286436227 4.6885750000000001e-05 3.26829571266533 4.6885999999999998e-05 3.2999999999999998 5.46775e-05 3.2999999999999998 5.4677749999999997e-05 3.26829571266533 5.4678000000000001e-05 3.1744012286436227 5.4678249999999998e-05 3.0219248602991997 5.4678500000000002e-05 2.8167261889578032 5.4678749999999999e-05 2.5666908844823433 5.4679000000000003e-05 2.2814276634023982 5.467925e-05 1.9718990313266118 5.4679500000000004e-05 1.6499999999999999 5.4679750000000001e-05 1.3281009686733884 5.4679999999999998e-05 1.018572336597602 5.4680250000000002e-05 0.73330911551765676 5.4680499999999999e-05 0.48327381104219669 5.4680750000000003e-05 0.27807513970080017 5.4681e-05 0.12559877135637687 5.4681250000000004e-05 0.03170428733466979 5.4681500000000002e-05 0 6.2507000000000003e-05 0 6.2507250000000007e-05 0.03170428733466979 6.2507499999999997e-05 0.12559877135637687 6.2507750000000001e-05 0.27807513970080033 6.2508000000000005e-05 0.48327381104219647 6.2508249999999996e-05 0.73330911551765621 6.25085e-05 1.0185723365976018 6.2508750000000004e-05 1.3281009686733882 6.2509000000000007e-05 1.6499999999999997 6.2509249999999998e-05 1.9718990313266114 6.2509500000000002e-05 2.2814276634023978 6.2509750000000006e-05 2.5666908844823433 6.2509999999999996e-05 2.8167261889578032 6.251025e-05 3.0219248602991997 6.2510500000000004e-05 3.1744012286436227 6.2510749999999994e-05 3.26829571266533 6.2510999999999998e-05 3.2999999999999998 7.0302500000000013e-05 3.2999999999999998 7.0302750000000017e-05 3.26829571266533 7.0303000000000008e-05 3.1744012286436227 7.0303250000000012e-05 3.0219248602991997 7.0303500000000016e-05 2.8167261889578032 7.0303750000000006e-05 2.5666908844823433 7.030400000000001e-05 2.2814276634023982 7.0304250000000014e-05 1.9718990313266118 7.0304500000000018e-05 1.6499999999999999 7.0304750000000008e-05 1.3281009686733884 7.0305000000000012e-05 1.018572336597602 7.0305250000000016e-05 0.73330911551765676 7.0305500000000006e-05 0.48327381104219669 7.030575000000001e-05 0.27807513970080017 7.0306000000000014e-05 0.12559877135637687 7.0306250000000005e-05 0.03170428733466979 7.0306500000000009e-05 0 7.8132000000000003e-05 0 7.8132250000000007e-05 0.03170428733466979 7.8132499999999998e-05 0.12559877135637687 7.8132750000000002e-05 0.27807513970080033 7.8133000000000006e-05 0.48327381104219647 7.8133249999999996e-05 0.73330911551765621 7.81335e-05 1.0185723365976018 7.8133750000000004e-05 1.3281009686733882 7.8133999999999994e-05 1.6499999999999997 7.8134249999999998e-05 1.9718990313266114 7.8134500000000002e-05 2.2814276634023978 7.8134750000000006e-05 2.5666908844823433 7.8134999999999996e-05 2.8167261889578032 7.813525e-05 3.0219248602991997 7.8135500000000004e-05 3.1744012286436227 7.8135749999999995e-05 3.26829571266533 7.8135999999999999e-05 3.2999999999999998 8.59275e-05 3.2999999999999998 8.5927750000000004e-05 3.26829571266533 8.5927999999999995e-05 3.1744012286436227 8.5928249999999998e-05 3.0219248602991997 8.5928500000000002e-05 2.8167261889578032 8.5928749999999993e-05 2.5666908844823433 8.5928999999999997e-05 2.2814276634023982 8.5929250000000001e-05 1.9718990313266118 8.5929500000000005e-05 1.6499999999999999 8.5929749999999995e-05 1.3281009686733884 8.5929999999999999e-05 1.018572336597602 8.5930250000000003e-05 0.73330911551765676 8.5930499999999993e-05 0.48327381104219669 8.5930749999999997e-05 0.27807513970080017 8.5931000000000001e-05 0.12559877135637687 8.5931249999999991e-05 0.03170428733466979 8.5931499999999995e-05 0 9.3757000000000004e-05 0 9.3757250000000008e-05 0.03170428733466979 9.3757499999999998e-05 0.12559877135637687 9.3757750000000002e-05 0.27807513970080033 9.3758000000000006e-05 0.48327381104219647 9.3758249999999996e-05 0.73330911551765621 9.37585e-05 1.0185723365976018 9.3758750000000004e-05 1.3281009686733882 9.3759000000000008e-05 1.6499999999999997 9.3759249999999999e-05 1.9718990313266114 9.3759500000000002e-05 2.2814276634023978 9.3759750000000006e-05 2.5666908844823433 9.3759999999999997e-05 2.8167261889578032 9.3760250000000001e-05 3.0219248602991997 9.3760500000000005e-05 3.1744012286436227 9.3760749999999995e-05 3.26829571266533 9.3760999999999999e-05 3.2999999999999998 0.00010155250000000001 3.2999999999999998 0.00010155275000000002 3.26829571266533 0.00010155300000000001 3.1744012286436227 0.00010155325000000001 3.0219248602991997 0.00010155350000000002 2.8167261889578032 0.00010155375000000001 2.5666908844823433 0.00010155400000000001 2.2814276634023982 0.00010155425000000001 1.9718990313266118 0.00010155450000000002 1.6499999999999999 0.00010155475000000001 1.3281009686733884 0.00010155500000000001 1.018572336597602 0.00010155525000000002 0.73330911551765676 0.00010155550000000001 0.48327381104219669 0.00010155575000000001 0.27807513970080017 0.00010155600000000001 0.12559877135637687 0.00010155625000000001 0.03170428733466979 0.00010155650000000001 0 0.000109382 0 0.00010938225000000001 0.03170428733466979 0.0001093825 0.12559877135637687 0.00010938275 0.27807513970080033 0.00010938300000000001 0.48327381104219647 0.00010938325 0.73330911551765621 0.0001093835 1.0185723365976018 0.00010938375 1.3281009686733882 0.00010938399999999999 1.6499999999999997 0.00010938425 1.9718990313266114 0.0001093845 2.2814276634023978 0.00010938475000000001 2.5666908844823433 0.000109385 2.8167261889578032 0.00010938525 3.0219248602991997 0.0001093855 3.1744012286436227 0.00010938575 3.26829571266533 0.000109386 3.2999999999999998 0.0001171775 3.2999999999999998 0.00011717775 3.26829571266533 0.000117178 3.1744012286436227 0.00011717825 3.0219248602991997 0.0001171785 2.8167261889578032 0.00011717874999999999 2.5666908844823433 0.000117179 2.2814276634023982 0.00011717925 1.9718990313266118 0.00011717950000000001 1.6499999999999999 0.00011717975 1.3281009686733884 0.00011718 1.018572336597602 0.00011718025 0.73330911551765676 0.00011718049999999999 0.48327381104219669 0.00011718075 0.27807513970080017 0.000117181 0.12559877135637687 0.00011718124999999999 0.03170428733466979 0.0001171815 0 0.000125007 0 0.00012500725000000001 0.03170428733466979 0.00012500750000000001 0.12559877135637687 0.00012500775000000002 0.27807513970080033 0.00012500800000000002 0.48327381104219647 0.00012500825 0.73330911551765621 0.0001250085 1.0185723365976018 0.00012500875 1.3281009686733882 0.00012500900000000001 1.6499999999999997 0.00012500925000000001 1.9718990313266114 0.00012500950000000002 2.2814276634023978 0.00012500975000000002 2.5666908844823433 0.00012501 2.8167261889578032 0.00012501025 3.0219248602991997 0.00012501050000000001 3.1744012286436227 0.00012501075000000001 3.26829571266533 0.00012501100000000001 3.2999999999999998 0.00013280250000000001 3.2999999999999998 0.00013280275000000002 3.26829571266533 0.00013280300000000002 3.1744012286436227 0.00013280325 3.0219248602991997 0.0001328035 2.8167261889578032 0.00013280375000000001 2.5666908844823433 0.00013280400000000001 2.2814276634023982 0.00013280425000000002 1.9718990313266118 0.00013280449999999999 1.6499999999999999 0.00013280475 1.3281009686733884 0.000132805 1.018572336597602 0.00013280525 0.73330911551765676 0.00013280550000000001 0.48327381104219669 0.00013280575000000001 0.27807513970080017 0.00013280599999999999 0.12559877135637687 0.00013280624999999999 0.03170428733466979 0.0001328065 0 0.00014063200000000002 0 0.00014063225000000002 0.03170428733466979 0.00014063250000000003 0.12559877135637687 0.00014063275000000003 0.27807513970080033 0.00014063300000000003 0.48327381104219647 0.00014063325000000001 0.73330911551765621 0.00014063350000000001 1.0185723365976018 0.00014063375000000002 1.3281009686733882 0.00014063400000000002 1.6499999999999997 0.00014063425000000003 1.9718990313266114 0.00014063450000000003 2.2814276634023978 0.00014063475000000003 2.5666908844823433 0.00014063500000000001 2.8167261889578032 0.00014063525000000002 3.0219248602991997 0.00014063550000000002 3.1744012286436227 0.00014063575000000002 3.26829571266533 0.00014063600000000003 3.2999999999999998 0.0001484275 3.2999999999999998 0.00014842775000000001 3.26829571266533 0.00014842800000000001 3.1744012286436227 0.00014842824999999999 3.0219248602991997 0.00014842849999999999 2.8167261889578032 0.00014842874999999999 2.5666908844823433 0.000148429 2.2814276634023982 0.00014842925 1.9718990313266118 0.00014842950000000001 1.6499999999999999 0.00014842974999999998 1.3281009686733884 0.00014842999999999999 1.018572336597602 0.00014843024999999999 0.73330911551765676 0.00014843049999999999 0.48327381104219669 0.00014843075 0.27807513970080017 0.00014843099999999998 0.12559877135637687 0.00014843124999999998 0.03170428733466979 0.00014843149999999998 0 0.00015625700000000001 0 0.00015625725000000001 0.03170428733466979 0.00015625750000000001 0.12559877135637687 0.00015625775000000002 0.27807513970080033 0.00015625799999999999 0.48327381104219647 0.00015625825 0.73330911551765621 0.0001562585 1.0185723365976018 0.00015625875000000001 1.3281009686733882 0.00015625900000000001 1.6499999999999997 0.00015625925000000001 1.9718990313266114 0.00015625950000000002 2.2814276634023978 0.00015625975000000002 2.5666908844823433 0.00015626000000000003 2.8167261889578032 0.00015626025 3.0219248602991997 0.00015626050000000001 3.1744012286436227 0.00015626075000000001 3.26829571266533 0.00015626100000000001 3.2999999999999998 0.00016405250000000002 3.2999999999999998 0.00016405275000000002 3.26829571266533 0.00016405300000000002 3.1744012286436227 0.00016405325 3.0219248602991997 0.0001640535 2.8167261889578032 0.00016405375000000001 2.5666908844823433 0.00016405400000000001 2.2814276634023982 0.00016405425000000002 1.9718990313266118 0.00016405450000000002 1.6499999999999999 0.00016405475 1.3281009686733884 0.000164055 1.018572336597602 0.00016405525 0.73330911551765676 0.00016405550000000001 0.48327381104219669 0.00016405575000000001 0.27807513970080017 0.00016405599999999999 0.12559877135637687 0.00016405624999999999 0.03170428733466979 0.0001640565 0 0.00017188199999999999 0 0.00017188225 0.03170428733466979 0.0001718825 0.12559877135637687 0.00017188275 0.27807513970080033 0.00017188300000000001 0.48327381104219647 0.00017188324999999998 0.73330911551765621 0.00017188349999999999 1.0185723365976018 0.00017188374999999999 1.3281009686733882 0.000171884 1.6499999999999997 0.00017188425 1.9718990313266114 0.0001718845 2.2814276634023978 0.00017188475000000001 2.5666908844823433 0.00017188499999999998 2.8167261889578032 0.00017188524999999999 3.0219248602991997 0.00017188549999999999 3.1744012286436227 0.00017188575 3.26829571266533 0.000171886 3.2999999999999998 0.0001796775 3.2999999999999998 0.00017967775000000001 3.26829571266533 0.00017967800000000001 3.1744012286436227 0.00017967824999999999 3.0219248602991997 0.00017967849999999999 2.8167261889578032 0.00017967874999999999 2.5666908844823433 0.000179679 2.2814276634023982 0.00017967925 1.9718990313266118 0.00017967949999999998 1.6499999999999999 0.00017967974999999998 1.3281009686733884 0.00017967999999999999 1.018572336597602 0.00017968024999999999 0.73330911551765676 0.0001796805 0.48327381104219669 0.00017968075 0.27807513970080017 0.00017968099999999998 0.12559877135637687 0.00017968124999999998 0.03170428733466979 0.00017968149999999998 0 0.00018750700000000001 0 0.00018750725000000001 0.03170428733466979 0.00018750750000000001 0.12559877135637687 0.00018750775000000002 0.27807513970080033 0.00018750800000000002 0.48327381104219647 0.00018750825 0.73330911551765621 0.0001875085 1.0185723365976018 0.00018750875000000001 1.3281009686733882 0.00018750900000000001 1.6499999999999997 0.00018750925000000001 1.9718990313266114 0.00018750950000000002 2.2814276634023978 0.00018750975000000002 2.5666908844823433 0.00018751 2.8167261889578032 0.00018751025 3.0219248602991997 0.00018751050000000001 3.1744012286436227 0.00018751075000000001 3.26829571266533 0.00018751100000000001 3.2999999999999998 0.00019530250000000002 3.2999999999999998 0.00019530275000000002 3.26829571266533 0.00019530300000000002 3.1744012286436227 0.00019530325 3.0219248602991997 0.0001953035 2.8167261889578032 0.00019530375000000001 2.5666908844823433 0.00019530400000000001 2.2814276634023982 0.00019530425000000002 1.9718990313266118 0.00019530449999999999 1.6499999999999999 0.00019530475 1.3281009686733884 0.000195305 1.018572336597602 0.00019530525000000001 0.73330911551765676 0.00019530550000000001 0.48327381104219669 0.00019530575000000001 0.27807513970080017 0.00019530599999999999 0.12559877135637687 0.00019530624999999999 0.03170428733466979 0.0001953065 0 0.00020000000000000001 0 0.00020313200000000002 0 0.00020313225000000002 0.03170428733466979 0.00020313250000000003 0.12559877135637687 0.00020313275000000003 0.27807513970080033 0.00020313300000000004 0.48327381104219647 0.00020313325000000001 0.73330911551765621 0.00020313350000000002 1.0185723365976018 0.00020313375000000002 1.3281009686733882 0.00020313400000000002 1.6499999999999997 0.00020313425000000003 1.9718990313266114 0.00020313450000000003 2.2814276634023978 0.00020313475000000004 2.5666908844823433 0.00020313500000000001 2.8167261889578032 0.00020313525000000002 3.0219248602991997 0.00020313550000000002 3.1744012286436227 0.00020313575000000002 3.26829571266533 0.00020313600000000003 3.2999999999999998 0.0002109275 3.2999999999999998 0.00021092775000000001 3.26829571266533 0.00021092800000000001 3.1744012286436227 0.00021092824999999999 3.0219248602991997 0.00021092849999999999 2.8167261889578032 0.00021092875 2.5666908844823433 0.000210929 2.2814276634023982 0.00021092925 1.9718990313266118 0.00021092950000000001 1.6499999999999999 0.00021092974999999998 1.3281009686733884 0.00021092999999999999 1.018572336597602 0.00021093024999999999 0.73330911551765676 0.0002109305 0.48327381104219669 0.00021093075 0.27807513970080017 0.00021093099999999998 0.12559877135637687 0.00021093124999999998 0.03170428733466979 0.00021093149999999998 0 0.00021875700000000001 0 0.00021875725000000001 0.03170428733466979 0.00021875750000000001 0.12559877135637687 0.00021875775000000002 0.27807513970080033 0.00021875799999999999 0.48327381104219647 0.00021875825 0.73330911551765621 0.0002187585 1.0185723365976018 0.00021875875000000001 1.3281009686733882 0.00021875900000000001 1.6499999999999997 0.00021875925000000001 1.9718990313266114 0.00021875950000000002 2.2814276634023978 0.00021875975000000002 2.5666908844823433 0.00021876000000000003 2.8167261889578032 0.00021876025 3.0219248602991997 0.00021876050000000001 3.1744012286436227 0.00021876075000000001 3.26829571266533 0.00021876100000000002 3.2999999999999998 0.00022655250000000002 3.2999999999999998 0.00022655275000000002 3.26829571266533 0.00022655300000000002 3.1744012286436227 0.00022655325 3.0219248602991997 0.00022655350000000001 2.8167261889578032 0.00022655375000000001 2.5666908844823433 0.00022655400000000001 2.2814276634023982 0.00022655425000000002 1.9718990313266118 0.00022655450000000002 1.6499999999999999 0.00022655475 1.3281009686733884 0.000226555 1.018572336597602 0.00022655525000000001 0.73330911551765676 0.00022655550000000001 0.48327381104219669 0.00022655575000000001 0.27807513970080017 0.00022655599999999999 0.12559877135637687 0.00022655624999999999 0.03170428733466979 0.0002265565 0 0.00023438199999999999 0 0.00023438225 0.03170428733466979 0.0002343825 0.12559877135637687 0.00023438275 0.27807513970080033 0.00023438300000000001 0.48327381104219647 0.00023438324999999999 0.73330911551765621 0.00023438349999999999 1.0185723365976018 0.00023438374999999999 1.3281009686733882 0.000234384 1.6499999999999997 0.00023438425 1.9718990313266114 0.00023438450000000001 2.2814276634023978 0.00023438475000000001 2.5666908844823433 0.00023438499999999999 2.8167261889578032 0.00023438524999999999 3.0219248602991997 0.00023438549999999999 3.1744012286436227 0.00023438575 3.26829571266533 0.000234386 3.2999999999999998 0.0002421775 3.2999999999999998 0.00024217775000000001 3.26829571266533 0.00024217800000000001 3.1744012286436227 0.00024217824999999999 3.0219248602991997 0.00024217849999999999 2.8167261889578032 0.00024217875 2.5666908844823433 0.000242179 2.2814276634023982 0.00024217925 1.9718990313266118 0.00024217949999999998 1.6499999999999999 0.00024217974999999998 1.3281009686733884 0.00024217999999999999 1.018572336597602 0.00024218024999999999 0.73330911551765676 0.0002421805 0.48327381104219669 0.00024218075 0.27807513970080017 0.00024218099999999998 0.12559877135637687 0.00024218124999999998 0.03170428733466979 0.00024218149999999999 0 0.00025000700000000001 0 0.00025000724999999998 0.03170428733466979 0.00025000750000000001 0.12559877135637687 0.00025000774999999999 0.27807513970080033 0.00025000800000000002 0.48327381104219647 0.00025000825 0.73330911551765621 0.00025000850000000003 1.0185723365976018 0.00025000875000000001 1.3281009686733882 0.00025000900000000004 1.6499999999999997 0.00025000925000000002 1.9718990313266114 0.00025000949999999999 2.2814276634023978 0.00025000975000000002 2.5666908844823433 0.00025001 2.8167261889578032 0.00025001025000000003 3.0219248602991997 0.00025001050000000001 3.1744012286436227 0.00025001075000000004 3.26829571266533 0.00025001100000000002 3.2999999999999998 0.00025780250000000002 3.2999999999999998 0.00025780274999999999 3.26829571266533 0.00025780300000000003 3.1744012286436227 0.00025780325 3.0219248602991997 0.00025780350000000003 2.8167261889578032 0.00025780375000000001 2.5666908844823433 0.00025780400000000004 2.2814276634023982 0.00025780425000000002 1.9718990313266118 0.00025780449999999999 1.6499999999999999 0.00025780475000000003 1.3281009686733884 0.000257805 1.018572336597602 0.00025780525000000003 0.73330911551765676 0.00025780550000000001 0.48327381104219669 0.00025780575000000004 0.27807513970080017 0.00025780600000000002 0.12559877135637687 0.00025780625000000005 0.03170428733466979 0.00025780650000000003 0 0.00026563200000000002 0 0.00026563225 0.03170428733466979 0.00026563250000000003 0.12559877135637687 0.00026563275000000001 0.27807513970080033 0.00026563300000000004 0.48327381104219647 0.00026563325000000001 0.73330911551765621 0.00026563350000000004 1.0185723365976018 0.00026563375000000002 1.3281009686733882 0.00026563400000000005 1.6499999999999997 0.00026563425000000003 1.9718990313266114 0.00026563450000000001 2.2814276634023978 0.00026563475000000004 2.5666908844823433 0.00026563500000000001 2.8167261889578032 0.00026563525000000004 3.0219248602991997 0.00026563550000000002 3.1744012286436227 0.00026563575000000005 3.26829571266533 0.00026563600000000003 3.2999999999999998 0.00027342750000000003 3.2999999999999998 0.00027342775000000001 3.26829571266533 0.00027342800000000004 3.1744012286436227 0.00027342825000000002 3.0219248602991997 0.00027342850000000005 2.8167261889578032 0.00027342875000000002 2.5666908844823433 0.00027342900000000005 2.2814276634023982 0.00027342925000000003 1.9718990313266118 0.00027342950000000001 1.6499999999999999 0.00027342975000000004 1.3281009686733884 0.00027343000000000002 1.018572336597602 0.00027343025000000005 0.73330911551765676 0.00027343050000000002 0.48327381104219669 0.00027343075000000006 0.27807513970080017 0.00027343100000000003 0.12559877135637687 0.00027343125000000006 0.03170428733466979 0.00027343150000000004 0 0.00028125700000000003 0 0.00028125725000000001 0.03170428733466979 0.00028125750000000004 0.12559877135637687 0.00028125775000000002 0.27807513970080033 0.00028125800000000005 0.48327381104219647 0.00028125825000000003 0.73330911551765621 0.00028125850000000006 1.0185723365976018 0.00028125875000000004 1.3281009686733882 0.00028125900000000007 1.6499999999999997 0.00028125925000000004 1.9718990313266114 0.00028125950000000002 2.2814276634023978 0.00028125975000000005 2.5666908844823433 0.00028126000000000003 2.8167261889578032 0.00028126025000000006 3.0219248602991997 0.00028126050000000004 3.1744012286436227 0.00028126075000000007 3.26829571266533 0.00028126100000000004 3.2999999999999998 0.00028905249999999999 3.2999999999999998 0.00028905274999999997 3.26829571266533 0.000289053 3.1744012286436227 0.00028905324999999998 3.0219248602991997 0.00028905350000000001 2.8167261889578032 0.00028905374999999998 2.5666908844823433 0.00028905400000000001 2.2814276634023982 0.00028905424999999999 1.9718990313266118 0.00028905450000000002 1.6499999999999999 0.00028905475 1.3281009686733884 0.00028905499999999998 1.018572336597602 0.00028905525000000001 0.73330911551765676 0.00028905549999999998 0.48327381104219669 0.00028905575000000001 0.27807513970080017 0.00028905599999999999 0.12559877135637687 0.00028905625000000002 0.03170428733466979 0.0002890565 0 0.00029688199999999999 0 0.00029688224999999997 0.03170428733466979 0.0002968825 0.12559877135637687 0.00029688274999999998 0.27807513970080033 0.00029688300000000001 0.48327381104219647 0.00029688324999999999 0.73330911551765621 0.00029688350000000002 1.0185723365976018 0.00029688374999999999 1.3281009686733882 0.00029688399999999997 1.6499999999999997 0.00029688425 1.9718990313266114 0.00029688449999999998 2.2814276634023978 0.00029688475000000001 2.5666908844823433 0.00029688499999999999 2.8167261889578032 0.00029688525000000002 3.0219248602991997 0.0002968855 3.1744012286436227 0.00029688575000000003 3.26829571266533 0.000296886 3.2999999999999998 0.0003046775 3.2999999999999998 0.00030467774999999998 3.26829571266533 0.00030467800000000001 3.1744012286436227 0.00030467824999999999 3.0219248602991997 0.00030467850000000002 2.8167261889578032 0.00030467875 2.5666908844823433 0.00030467900000000003 2.2814276634023982 0.00030467925000000001 1.9718990313266118 0.00030467950000000004 1.6499999999999999 0.00030467975000000001 1.3281009686733884 0.00030467999999999999 1.018572336597602 0.00030468025000000002 0.73330911551765676 0.0003046805 0.48327381104219669 0.00030468075000000003 0.27807513970080017 0.00030468100000000001 0.12559877135637687 0.00030468125000000004 0.03170428733466979 0.00030468150000000001 0 0.00031250700000000001 0 0.00031250724999999999 0.03170428733466979 0.00031250750000000002 0.12559877135637687 0.00031250774999999999 0.27807513970080033 0.00031250800000000002 0.48327381104219647 0.00031250825 0.73330911551765621 0.00031250850000000003 1.0185723365976018 0.00031250875000000001 1.3281009686733882 0.00031250899999999999 1.6499999999999997 0.00031250925000000002 1.9718990313266114 0.00031250949999999999 2.2814276634023978 0.00031250975000000002 2.5666908844823433 0.00031251 2.8167261889578032 0.00031251025000000003 3.0219248602991997 0.00031251050000000001 3.1744012286436227 0.00031251075000000004 3.26829571266533 0.00031251100000000002 3.2999999999999998 0.00032030250000000002 3.2999999999999998 0.00032030275 3.26829571266533 0.00032030300000000003 3.1744012286436227 0.00032030325 3.0219248602991997 0.00032030350000000003 2.8167261889578032 0.00032030375000000001 2.5666908844823433 0.00032030400000000004 2.2814276634023982 0.00032030425000000002 1.9718990313266118 0.00032030450000000005 1.6499999999999999 0.00032030475000000003 1.3281009686733884 0.000320305 1.018572336597602 0.00032030525000000003 0.73330911551765676 0.00032030550000000001 0.48327381104219669 0.00032030575000000004 0.27807513970080017 0.00032030600000000002 0.12559877135637687 0.00032030625000000005 0.03170428733466979 0.00032030650000000003 0 0.00032813200000000002 0 0.00032813225 0.03170428733466979 0.00032813250000000003 0.12559877135637687 0.00032813275000000001 0.27807513970080033 0.00032813300000000004 0.48327381104219647 0.00032813325000000001 0.73330911551765621 0.00032813350000000005 1.0185723365976018 0.00032813375000000002 1.3281009686733882 0.000328134 1.6499999999999997 0.00032813425000000003 1.9718990313266114 0.00032813450000000001 2.2814276634023978 0.00032813475000000004 2.5666908844823433 0.00032813500000000002 2.8167261889578032 0.00032813525000000005 3.0219248602991997 0.00032813550000000002 3.1744012286436227 0.00032813575000000005 3.26829571266533 0.00032813600000000003 3.2999999999999998 0.00033592750000000003 3.2999999999999998 0.00033592775000000001 3.26829571266533 0.00033592800000000004 3.1744012286436227 0.00033592825000000002 3.0219248602991997 0.00033592850000000005 2.8167261889578032 0.00033592875000000003 2.5666908844823433 0.00033592900000000006 2.2814276634023982 0.00033592925000000003 1.9718990313266118 0.00033592950000000006 1.6499999999999999 0.00033592975000000004 1.3281009686733884 0.00033593000000000002 1.018572336597602 0.00033593025000000005 0.73330911551765676 0.00033593050000000003 0.48327381104219669 0.00033593075000000006 0.27807513970080017 0.00033593100000000003 0.12559877135637687 0.00033593125000000006 0.03170428733466979 0.00033593150000000004 0 0.00034375699999999998 0 0.00034375724999999996 0.03170428733466979 0.00034375749999999999 0.12559877135637687 0.00034375774999999997 0.27807513970080033 0.000343758 0.48327381104219647 0.00034375824999999997 0.73330911551765621 0.00034375850000000001 1.0185723365976018 0.00034375874999999998 1.3281009686733882 0.00034375900000000001 1.6499999999999997 0.00034375924999999999 1.9718990313266114 0.00034375949999999997 2.2814276634023978 0.00034375975 2.5666908844823433 0.00034375999999999997 2.8167261889578032 0.00034376025000000001 3.0219248602991997 0.00034376049999999998 3.1744012286436227 0.00034376075000000001 3.26829571266533 0.00034376099999999999 3.2999999999999998 0.00035155249999999999 3.2999999999999998 0.00035155274999999997 3.26829571266533 0.000351553 3.1744012286436227 0.00035155324999999998 3.0219248602991997 0.00035155350000000001 2.8167261889578032 0.00035155374999999998 2.5666908844823433 0.00035155400000000002 2.2814276634023982 0.00035155424999999999 1.9718990313266118 0.00035155449999999997 1.6499999999999999 0.00035155475 1.3281009686733884 0.00035155499999999998 1.018572336597602 0.00035155525000000001 0.73330911551765676 0.00035155549999999999 0.48327381104219669 0.00035155575000000002 0.27807513970080017 0.00035155599999999999 0.12559877135637687 0.00035155625000000002 0.03170428733466979 0.0003515565 0 0.000359382 0 0.00035938224999999997 0.03170428733466979 0.0003593825 0.12559877135637687 0.00035938274999999998 0.27807513970080033 0.00035938300000000001 0.48327381104219647 0.00035938324999999999 0.73330911551765621 0.00035938350000000002 1.0185723365976018 0.00035938375 1.3281009686733882 0.00035938400000000003 1.6499999999999997 0.00035938425 1.9718990313266114 0.00035938449999999998 2.2814276634023978 0.00035938475000000001 2.5666908844823433 0.00035938499999999999 2.8167261889578032 0.00035938525000000002 3.0219248602991997 0.0003593855 3.1744012286436227 0.00035938575000000003 3.26829571266533 0.000359386 3.2999999999999998 0.00036717750000000001 3.2999999999999998 0.00036717774999999998 3.26829571266533 0.00036717800000000001 3.1744012286436227 0.00036717824999999999 3.0219248602991997 0.00036717850000000002 2.8167261889578032 0.00036717875 2.5666908844823433 0.00036717900000000003 2.2814276634023982 0.00036717925000000001 1.9718990313266118 0.00036717949999999998 1.6499999999999999 0.00036717975000000001 1.3281009686733884 0.00036717999999999999 1.018572336597602 0.00036718025000000002 0.73330911551765676 0.0003671805 0.48327381104219669 0.00036718075000000003 0.27807513970080017 0.00036718100000000001 0.12559877135637687 0.00036718125000000004 0.03170428733466979 0.00036718150000000001 0 0.00037500700000000001 0 0.00037500724999999999 0.03170428733466979 0.00037500750000000002 0.12559877135637687 0.00037500774999999999 0.27807513970080033 0.00037500800000000003 0.48327381104219647 0.00037500825 0.73330911551765621 0.00037500850000000003 1.0185723365976018 0.00037500875000000001 1.3281009686733882 0.00037500900000000004 1.6499999999999997 0.00037500925000000002 1.9718990313266114 0.00037500949999999999 2.2814276634023978 0.00037500975000000003 2.5666908844823433 0.00037501 2.8167261889578032 0.00037501025000000003 3.0219248602991997 0.00037501050000000001 3.1744012286436227 0.00037501075000000004 3.26829571266533 0.00037501100000000002 3.2999999999999998 0.00038280250000000002 3.2999999999999998 0.00038280275 3.26829571266533 0.00038280300000000003 3.1744012286436227 0.00038280325 3.0219248602991997 0.00038280350000000004 2.8167261889578032 0.00038280375000000001 2.5666908844823433 0.00038280400000000004 2.2814276634023982 0.00038280425000000002 1.9718990313266118 0.0003828045 1.6499999999999999 0.00038280475000000003 1.3281009686733884 0.00038280500000000001 1.018572336597602 0.00038280525000000004 0.73330911551765676 0.00038280550000000001 0.48327381104219669 0.00038280575000000004 0.27807513970080017 0.00038280600000000002 0.12559877135637687 0.00038280625000000005 0.03170428733466979 0.00038280650000000003 0 0.00039063200000000002 0 0.00039063225 0.03170428733466979 0.00039063250000000003 0.12559877135637687 0.00039063275000000001 0.27807513970080033 0.00039063300000000004 0.48327381104219647 0.00039063325000000002 0.73330911551765621 0.00039063350000000005 1.0185723365976018 0.00039063375000000002 1.3281009686733882 0.00039063400000000005 1.6499999999999997 0.00039063425000000003 1.9718990313266114 0.00039063450000000001 2.2814276634023978 0.00039063475000000004 2.5666908844823433 0.00039063500000000002 2.8167261889578032 0.00039063525000000005 3.0219248602991997 0.00039063550000000002 3.1744012286436227 0.00039063575000000006 3.26829571266533 0.00039063600000000003 3.2999999999999998 0.00039842750000000003 3.2999999999999998 0.00039842775000000001 3.26829571266533 0.00039842800000000004 3.1744012286436227 0.00039842825000000002 3.0219248602991997 0.00039842850000000005 2.8167261889578032 0.00039842875000000003 2.5666908844823433 0.00039842900000000006 2.2814276634023982 0.00039842925000000003 1.9718990313266118 0.00039842950000000001 1.6499999999999999 0.00039842975000000004 1.3281009686733884 0.00039843000000000002 1.018572336597602 0.00039843025000000005 0.73330911551765676 0.00039843050000000003 0.48327381104219669 0.00039843075000000006 0.27807513970080017 0.00039843100000000003 0.12559877135637687 0.00039843125000000007 0.03170428733466979 0.00039843150000000004 0 0.00040000000000000002 0)
ENCDB NCDB_DRV 0 VDD CDB_DRV 1
RG_CIA CIA_DRV CIA 10
RG_NCIA NCIA_DRV NCIA 10
RG_CIB CIB_DRV CIB 10
RG_NCIB NCIB_DRV NCIB 10
RG_CDA CDA_DRV CDA 10
RG_NCDA NCDA_DRV NCDA 10
RG_CDB CDB_DRV CDB 10
RG_NCDB NCDB_DRV NCDB 10
.nodeset v(vdd)=3.2999999999999998 v(cda_drv)=3.2999999999999998 v(cda)=3.2999999999999998 v(cdb)=0 v(cdb_drv)=0 v(cia)=3.2999999999999998 v(cia_drv)=3.2999999999999998 v(cib_drv)=0 v(cib)=0 v(cm)=1.6499999999999999 v(inn)=1.649998554331908 v(inp)=1.6499985543263991 v(ncda)=0 v(ncda_drv)=0 v(ncdb)=3.2999999999999998 v(ncdb_drv)=3.2999999999999998 v(ncia)=0 v(ncia_drv)=0 v(ncib_drv)=3.2999999999999998 v(ncib)=3.2999999999999998 v(outn)=1.64995246047254 v(outp)=1.6499524518219579 v(sig)=0 v(vbcm)=0.82000000000000006 v(vbn)=0.84850000000000003 v(vinn)=1.6499999999999999 v(vinp)=1.6499999999999999 v(vnc)=2 v(vpc)=1.2 v(vbp)=2.3311670297323519 v(xdut.xcmfb.nd)=2.3517899448641622 v(xdut.xcmfb.nta)=0.70267910623899421 v(xdut.xcmfb.ntb)=0.70267910955347357 v(xdut.xcore.dnn)=0.96256915941579357 v(xdut.xcore.dnp)=0.96256915944047661 v(xdut.xcore.dpn)=2.436365152142804 v(xdut.xcore.dpp)=2.4363651521524639 v(xdut.xcore.sn)=0.68561578216376173 v(xdut.xcore.sp)=2.7712408445672718 v(opi)=1.6499524518219579 v(oni)=1.64995246047254 v(wp)=1.65 v(wn)=1.65 v(cip_sense)=1.65 v(cin_sense)=1.65 v(src_p)=1.65 v(src_n)=1.65
XRSTP INP RSTP ONI 0 nfet_03v3 W=1u L=1u nf=1 m=1 ad=.5p as=.5p pd=3u ps=3u nrd=.5 nrs=.5
XRSTN INN RSTN OPI 0 nfet_03v3 W=1u L=1u nf=1 m=1 ad=.5p as=.5p pd=3u ps=3u nrd=.5 nrs=.5
VRST RST_SRC 0 DC 3.3 PWL(0 3.2999999999999998 1.0000000000000001e-05 3.2999999999999998 1.0000312500000001e-05 3.2920547990091249 1.0000625e-05 3.26829571266533 1.00009375e-05 3.2289515539581446 1.000125e-05 3.1744012286436227 1.00015625e-05 3.1051700861747857 1.0001875000000002e-05 3.0219248602991993 1.0002187500000001e-05 2.9254672480485158 1.0002500000000001e-05 2.8167261889578032 1.0002812500000001e-05 2.6967489188700151 1.0003125000000001e-05 2.5666908844823437 1.0003437500000001e-05 2.4278046157628963 1.0003750000000001e-05 2.2814276634023978 1.00040625e-05 2.1289697174698627 1.0004375e-05 1.9718990313266116 1.00046875e-05 1.8117282815437752 1.0005000000000002e-05 1.6500000000000001 1.0005312500000001e-05 1.4882717184562249 1.0005625000000001e-05 1.3281009686733884 1.0005937500000001e-05 1.1710302825301375 1.0006250000000001e-05 1.018572336597602 1.0006562500000001e-05 0.87219538423710397 1.0006875000000001e-05 0.73330911551765654 1.00071875e-05 0.60325108112998516 1.00075e-05 0.48327381104219658 1.00078125e-05 0.37453275195148406 1.0008125e-05 0.27807513970080011 1.0008437500000002e-05 0.19482991382521453 1.0008750000000001e-05 0.12559877135637709 1.0009062500000001e-05 0.071048446041855229 1.0009375000000001e-05 0.03170428733466979 1.0009687500000001e-05 0.0079452009908753674 1.0010000000000001e-05 0 0.00020000000000000001 0)
RGRP RST_SRC RSTP 10
RGRN RST_SRC RSTN 10
.save v(sig) v(outp) v(outn) v(inp) v(inn) v(vinp) v(vinn) v(src_p) v(src_n) v(wp) v(wn) v(cip_sense) v(cin_sense) v(fbp) v(fbn) v(rst_src) v(rstp) v(rstn) v(opi) v(oni) v(vbp) v(cia) v(ncia) v(cib) v(ncib) v(cda) v(ncda) v(cdb) v(ncdb) v(cia_drv) v(cib_drv) v(cda_drv) v(cdb_drv) i(vdd_src) i(ep) i(en) i(vcip) i(vcin) i(vcfp) i(vcfn) i(vrst) i(vcm) i(vbn) i(vbcm) i(vnc) i(vpc) @m.xdut.xcore.xn_p.m0[vds] @m.xdut.xcore.xn_p.m0[vdsat] @m.xdut.xcore.xn_p.m0[vgs] @m.xdut.xcore.xn_p.m0[vth] @m.xdut.xcore.xn_p.m0[id] @m.xdut.xcore.xn_n.m0[vds] @m.xdut.xcore.xn_n.m0[vdsat] @m.xdut.xcore.xn_n.m0[vgs] @m.xdut.xcore.xn_n.m0[vth] @m.xdut.xcore.xn_n.m0[id] @m.xdut.xcore.xp_p.m0[vds] @m.xdut.xcore.xp_p.m0[vdsat] @m.xdut.xcore.xp_p.m0[vgs] @m.xdut.xcore.xp_p.m0[vth] @m.xdut.xcore.xp_p.m0[id] @m.xdut.xcore.xp_n.m0[vds] @m.xdut.xcore.xp_n.m0[vdsat] @m.xdut.xcore.xp_n.m0[vgs] @m.xdut.xcore.xp_n.m0[vth] @m.xdut.xcore.xp_n.m0[id] @m.xdut.xcore.xnt.m0[vds] @m.xdut.xcore.xnt.m0[vdsat] @m.xdut.xcore.xnt.m0[vgs] @m.xdut.xcore.xnt.m0[vth] @m.xdut.xcore.xnt.m0[id] @m.xdut.xcore.xpt.m0[vds] @m.xdut.xcore.xpt.m0[vdsat] @m.xdut.xcore.xpt.m0[vgs] @m.xdut.xcore.xpt.m0[vth] @m.xdut.xcore.xpt.m0[id] @m.xdut.xcore.xnc_p.m0[vds] @m.xdut.xcore.xnc_p.m0[vdsat] @m.xdut.xcore.xnc_p.m0[vgs] @m.xdut.xcore.xnc_p.m0[vth] @m.xdut.xcore.xnc_p.m0[id] @m.xdut.xcore.xnc_n.m0[vds] @m.xdut.xcore.xnc_n.m0[vdsat] @m.xdut.xcore.xnc_n.m0[vgs] @m.xdut.xcore.xnc_n.m0[vth] @m.xdut.xcore.xnc_n.m0[id] @m.xdut.xcore.xpc_p.m0[vds] @m.xdut.xcore.xpc_p.m0[vdsat] @m.xdut.xcore.xpc_p.m0[vgs] @m.xdut.xcore.xpc_p.m0[vth] @m.xdut.xcore.xpc_p.m0[id] @m.xdut.xcore.xpc_n.m0[vds] @m.xdut.xcore.xpc_n.m0[vdsat] @m.xdut.xcore.xpc_n.m0[vgs] @m.xdut.xcore.xpc_n.m0[vth] @m.xdut.xcore.xpc_n.m0[id] @m.xdut.xcmfb.xcm1.m0[vds] @m.xdut.xcmfb.xcm1.m0[vdsat] @m.xdut.xcmfb.xcm1.m0[vgs] @m.xdut.xcmfb.xcm1.m0[vth] @m.xdut.xcmfb.xcm1.m0[id] @m.xdut.xcmfb.xcm2.m0[vds] @m.xdut.xcmfb.xcm2.m0[vdsat] @m.xdut.xcmfb.xcm2.m0[vgs] @m.xdut.xcmfb.xcm2.m0[vth] @m.xdut.xcmfb.xcm2.m0[id] @m.xdut.xcmfb.xcm3.m0[vds] @m.xdut.xcmfb.xcm3.m0[vdsat] @m.xdut.xcmfb.xcm3.m0[vgs] @m.xdut.xcmfb.xcm3.m0[vth] @m.xdut.xcmfb.xcm3.m0[id] @m.xdut.xcmfb.xcm4.m0[vds] @m.xdut.xcmfb.xcm4.m0[vdsat] @m.xdut.xcmfb.xcm4.m0[vgs] @m.xdut.xcmfb.xcm4.m0[vth] @m.xdut.xcmfb.xcm4.m0[id] @m.xdut.xcmfb.xcmp1.m0[vds] @m.xdut.xcmfb.xcmp1.m0[vdsat] @m.xdut.xcmfb.xcmp1.m0[vgs] @m.xdut.xcmfb.xcmp1.m0[vth] @m.xdut.xcmfb.xcmp1.m0[id] @m.xdut.xcmfb.xcmp2.m0[vds] @m.xdut.xcmfb.xcmp2.m0[vdsat] @m.xdut.xcmfb.xcmp2.m0[vgs] @m.xdut.xcmfb.xcmp2.m0[vth] @m.xdut.xcmfb.xcmp2.m0[id] @m.xdut.xcmfb.xcmt1.m0[vds] @m.xdut.xcmfb.xcmt1.m0[vdsat] @m.xdut.xcmfb.xcmt1.m0[vgs] @m.xdut.xcmfb.xcmt1.m0[vth] @m.xdut.xcmfb.xcmt1.m0[id] @m.xdut.xcmfb.xcmt2.m0[vds] @m.xdut.xcmfb.xcmt2.m0[vdsat] @m.xdut.xcmfb.xcmt2.m0[vgs] @m.xdut.xcmfb.xcmt2.m0[vth] @m.xdut.xcmfb.xcmt2.m0[id] @m.xdut.xcore.xnc_p.m0[qd] @m.xdut.xcore.xnc_p.m0[qs] @m.xdut.xcore.xnc_n.m0[qd] @m.xdut.xcore.xnc_n.m0[qs] @m.xdut.xcore.xpc_p.m0[qd] @m.xdut.xcore.xpc_p.m0[qs] @m.xdut.xcore.xpc_n.m0[qd] @m.xdut.xcore.xpc_n.m0[qs] @m.xdut.xop_a.xn.m0[qd] @m.xdut.xop_a.xn.m0[qs] @m.xdut.xop_a.xp.m0[qd] @m.xdut.xop_a.xp.m0[qs] @m.xdut.xon_a.xn.m0[qd] @m.xdut.xon_a.xn.m0[qs] @m.xdut.xon_a.xp.m0[qd] @m.xdut.xon_a.xp.m0[qs] @m.xdut.xop_b.xn.m0[qd] @m.xdut.xop_b.xn.m0[qs] @m.xdut.xop_b.xp.m0[qd] @m.xdut.xop_b.xp.m0[qs] @m.xdut.xon_b.xn.m0[qd] @m.xdut.xon_b.xn.m0[qs] @m.xdut.xon_b.xp.m0[qd] @m.xdut.xon_b.xp.m0[qs] @m.xdut.xip_a.xn.m0[gds] @m.xdut.xip_a.xp.m0[gds] @m.xdut.xin_a.xn.m0[gds] @m.xdut.xin_a.xp.m0[gds] @m.xdut.xip_b.xn.m0[gds] @m.xdut.xip_b.xp.m0[gds] @m.xdut.xin_b.xn.m0[gds] @m.xdut.xin_b.xp.m0[gds] @m.xdut.xop_a.xn.m0[gds] @m.xdut.xop_a.xp.m0[gds] @m.xdut.xon_a.xn.m0[gds] @m.xdut.xon_a.xp.m0[gds] @m.xdut.xop_b.xn.m0[gds] @m.xdut.xop_b.xp.m0[gds] @m.xdut.xon_b.xn.m0[gds] @m.xdut.xon_b.xp.m0[gds] @m.xrstp.m0[id] @m.xrstp.m0[vgs] @m.xrstp.m0[vth] @m.xrstp.m0[vds] @m.xrstp.m0[vdsat] @m.xrstp.m0[vbs] @m.xrstp.m0[ibd] @m.xrstp.m0[ibs] @m.xrstp.m0[igidl] @m.xrstp.m0[igisl] @m.xrstp.m0[qg] @m.xrstp.m0[qd] @m.xrstp.m0[qs] @m.xrstp.m0[qb] @m.xrstn.m0[id] @m.xrstn.m0[vgs] @m.xrstn.m0[vth] @m.xrstn.m0[vds] @m.xrstn.m0[vdsat] @m.xrstn.m0[vbs] @m.xrstn.m0[ibd] @m.xrstn.m0[ibs] @m.xrstn.m0[igidl] @m.xrstn.m0[igisl] @m.xrstn.m0[qg] @m.xrstn.m0[qd] @m.xrstn.m0[qs] @m.xrstn.m0[qb] @m.xdut.xcore.xn_p.m0[gm] @m.xdut.xcore.xn_n.m0[gm] @m.xdut.xcore.xp_p.m0[gm] @m.xdut.xcore.xp_n.m0[gm] @m.xdut.xcore.xnt.m0[gm] @m.xdut.xcore.xpt.m0[gm] @m.xdut.xcore.xnc_p.m0[gm] @m.xdut.xcore.xnc_n.m0[gm] @m.xdut.xcore.xpc_p.m0[gm] @m.xdut.xcore.xpc_n.m0[gm] @m.xdut.xcmfb.xcm1.m0[gm] @m.xdut.xcmfb.xcm2.m0[gm] @m.xdut.xcmfb.xcm3.m0[gm] @m.xdut.xcmfb.xcm4.m0[gm] @m.xdut.xcmfb.xcmp1.m0[gm] @m.xdut.xcmfb.xcmp2.m0[gm] @m.xdut.xcmfb.xcmt1.m0[gm] @m.xdut.xcmfb.xcmt2.m0[gm]
.tran 4n 400u 0 4n
.end
