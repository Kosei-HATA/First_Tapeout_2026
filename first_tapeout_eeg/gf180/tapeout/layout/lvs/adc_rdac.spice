* LVS wrapper for the layout block adc_rdac (gf180/tapeout/layout/rdac1_lay.py): the
* ADC's stage-1 input resistors RIN and the DAC1, which share one resistor array
* (RIN = 16 unit resistors per side, a DAC1 element two in series), as in gf180/tapeout/adc/eeg_adc.spice.
* Since r11 a unit is two ppolyf_u strips in series; the RIN units' middle nodes are joined.
.subckt adc_rdac INP INN I1P I1N VREFP VREFN SEL1_0 SEL1_1 SEL1_2 SEL1_3 SEL1_4 SEL1_5 SEL1_6 SEL1_7 SEL1_8 SEL1_9 SEL1_10 SEL1_11 SEL1_12 SEL1_13 SEL1_14 SEL1_15 SEL1_16 SEL1_17 SEL1_18 SEL1_19 SEL1_20 SEL1_21 SEL1_22 SEL1_23 SEL1_24 SEL1_25 SEL1_26 SEL1_27 SEL1_28 SEL1_29 SEL1_30 DAC_CLK AVDD AVSS
XRINPA INP RINPM AVSS ppolyf_u r_length=320.48u r_width=0.8u m=16
XRINPB RINPM I1P AVSS ppolyf_u r_length=320.48u r_width=0.8u m=16
XRINNA INN RINNM AVSS ppolyf_u r_length=320.48u r_width=0.8u m=16
XRINNB RINNM I1N AVSS ppolyf_u r_length=320.48u r_width=0.8u m=16
XDAC1 I1P I1N VREFP VREFN SEL1_0 SEL1_1 SEL1_2 SEL1_3 SEL1_4 SEL1_5 SEL1_6 SEL1_7 SEL1_8 SEL1_9 SEL1_10 SEL1_11 SEL1_12 SEL1_13 SEL1_14 SEL1_15 SEL1_16 SEL1_17 SEL1_18 SEL1_19 SEL1_20 SEL1_21 SEL1_22 SEL1_23 SEL1_24 SEL1_25 SEL1_26 SEL1_27 SEL1_28 SEL1_29 SEL1_30 DAC_CLK AVDD AVSS eeg_dac1
.ends adc_rdac
