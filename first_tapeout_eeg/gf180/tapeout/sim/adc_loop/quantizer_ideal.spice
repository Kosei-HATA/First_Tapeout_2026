* eeg_quantizer_ideal: same ports as eeg_quantizer (gf180/tapeout/adc/eeg_quantizer.spice),
* ideal comparators sampled at the CMP_STROBE rising edge and held until the next
* one. Threshold k = (k - 15) (VREFP - VREFN) / 160, i.e. (k - 15) x 3.125 mV at
* VREFP - VREFN = 0.5 V, like the transistor ladder. Reference for the transistor
* quantizer in the loop deck (make_deck.py --quant ideal); IQ and the supplies are
* unused.
.subckt eeg_quantizer_ideal INP INN VREFP VREFN CMP_STROBE TH0 TH1 TH2 TH3 TH4 TH5 TH6 TH7 TH8 TH9 TH10 TH11 TH12 TH13
+ TH14 TH15 TH16 TH17 TH18 TH19 TH20 TH21 TH22 TH23 TH24 TH25 TH26 TH27 TH28 TH29 TH30 IQ AVDD AVSS DVDD DVSS
.model QI_ADC adc_bridge(in_low=0 in_high=0 rise_delay=0.1n fall_delay=0.1n)
.model QI_CLK adc_bridge(in_low=1.65 in_high=1.65 rise_delay=0.1n fall_delay=0.1n)
.model QI_FF d_dff(ic=0 clk_delay=0.5n set_delay=0.5n reset_delay=0.5n rise_delay=0.5n fall_delay=0.5n data_load=1f clk_load=1f)
.model QI_DAC dac_bridge(out_low=0 out_high=3.3 out_undef=1.65 t_rise=0.5n t_fall=0.5n input_load=1f)
ACLK [CMP_STROBE] [DCLK] QI_CLK
BE0 E0 AVSS V=V(INP)-V(INN)-(-15)*(V(VREFP)-V(VREFN))/160
BE1 E1 AVSS V=V(INP)-V(INN)-(-14)*(V(VREFP)-V(VREFN))/160
BE2 E2 AVSS V=V(INP)-V(INN)-(-13)*(V(VREFP)-V(VREFN))/160
BE3 E3 AVSS V=V(INP)-V(INN)-(-12)*(V(VREFP)-V(VREFN))/160
BE4 E4 AVSS V=V(INP)-V(INN)-(-11)*(V(VREFP)-V(VREFN))/160
BE5 E5 AVSS V=V(INP)-V(INN)-(-10)*(V(VREFP)-V(VREFN))/160
BE6 E6 AVSS V=V(INP)-V(INN)-(-9)*(V(VREFP)-V(VREFN))/160
BE7 E7 AVSS V=V(INP)-V(INN)-(-8)*(V(VREFP)-V(VREFN))/160
BE8 E8 AVSS V=V(INP)-V(INN)-(-7)*(V(VREFP)-V(VREFN))/160
BE9 E9 AVSS V=V(INP)-V(INN)-(-6)*(V(VREFP)-V(VREFN))/160
BE10 E10 AVSS V=V(INP)-V(INN)-(-5)*(V(VREFP)-V(VREFN))/160
BE11 E11 AVSS V=V(INP)-V(INN)-(-4)*(V(VREFP)-V(VREFN))/160
BE12 E12 AVSS V=V(INP)-V(INN)-(-3)*(V(VREFP)-V(VREFN))/160
BE13 E13 AVSS V=V(INP)-V(INN)-(-2)*(V(VREFP)-V(VREFN))/160
BE14 E14 AVSS V=V(INP)-V(INN)-(-1)*(V(VREFP)-V(VREFN))/160
BE15 E15 AVSS V=V(INP)-V(INN)-(0)*(V(VREFP)-V(VREFN))/160
BE16 E16 AVSS V=V(INP)-V(INN)-(1)*(V(VREFP)-V(VREFN))/160
BE17 E17 AVSS V=V(INP)-V(INN)-(2)*(V(VREFP)-V(VREFN))/160
BE18 E18 AVSS V=V(INP)-V(INN)-(3)*(V(VREFP)-V(VREFN))/160
BE19 E19 AVSS V=V(INP)-V(INN)-(4)*(V(VREFP)-V(VREFN))/160
BE20 E20 AVSS V=V(INP)-V(INN)-(5)*(V(VREFP)-V(VREFN))/160
BE21 E21 AVSS V=V(INP)-V(INN)-(6)*(V(VREFP)-V(VREFN))/160
BE22 E22 AVSS V=V(INP)-V(INN)-(7)*(V(VREFP)-V(VREFN))/160
BE23 E23 AVSS V=V(INP)-V(INN)-(8)*(V(VREFP)-V(VREFN))/160
BE24 E24 AVSS V=V(INP)-V(INN)-(9)*(V(VREFP)-V(VREFN))/160
BE25 E25 AVSS V=V(INP)-V(INN)-(10)*(V(VREFP)-V(VREFN))/160
BE26 E26 AVSS V=V(INP)-V(INN)-(11)*(V(VREFP)-V(VREFN))/160
BE27 E27 AVSS V=V(INP)-V(INN)-(12)*(V(VREFP)-V(VREFN))/160
BE28 E28 AVSS V=V(INP)-V(INN)-(13)*(V(VREFP)-V(VREFN))/160
BE29 E29 AVSS V=V(INP)-V(INN)-(14)*(V(VREFP)-V(VREFN))/160
BE30 E30 AVSS V=V(INP)-V(INN)-(15)*(V(VREFP)-V(VREFN))/160
AQ [E0 E1 E2 E3 E4 E5 E6 E7 E8 E9 E10 E11 E12 E13 E14 E15 E16 E17 E18 E19 E20 E21 E22 E23 E24 E25 E26 E27 E28 E29 E30] [D0 D1 D2 D3 D4 D5 D6 D7 D8 D9 D10 D11 D12 D13 D14 D15 D16 D17 D18 D19 D20 D21 D22 D23 D24 D25 D26 D27 D28 D29 D30] QI_ADC
AF0 D0 DCLK NULL NULL Q0 NULL QI_FF
AF1 D1 DCLK NULL NULL Q1 NULL QI_FF
AF2 D2 DCLK NULL NULL Q2 NULL QI_FF
AF3 D3 DCLK NULL NULL Q3 NULL QI_FF
AF4 D4 DCLK NULL NULL Q4 NULL QI_FF
AF5 D5 DCLK NULL NULL Q5 NULL QI_FF
AF6 D6 DCLK NULL NULL Q6 NULL QI_FF
AF7 D7 DCLK NULL NULL Q7 NULL QI_FF
AF8 D8 DCLK NULL NULL Q8 NULL QI_FF
AF9 D9 DCLK NULL NULL Q9 NULL QI_FF
AF10 D10 DCLK NULL NULL Q10 NULL QI_FF
AF11 D11 DCLK NULL NULL Q11 NULL QI_FF
AF12 D12 DCLK NULL NULL Q12 NULL QI_FF
AF13 D13 DCLK NULL NULL Q13 NULL QI_FF
AF14 D14 DCLK NULL NULL Q14 NULL QI_FF
AF15 D15 DCLK NULL NULL Q15 NULL QI_FF
AF16 D16 DCLK NULL NULL Q16 NULL QI_FF
AF17 D17 DCLK NULL NULL Q17 NULL QI_FF
AF18 D18 DCLK NULL NULL Q18 NULL QI_FF
AF19 D19 DCLK NULL NULL Q19 NULL QI_FF
AF20 D20 DCLK NULL NULL Q20 NULL QI_FF
AF21 D21 DCLK NULL NULL Q21 NULL QI_FF
AF22 D22 DCLK NULL NULL Q22 NULL QI_FF
AF23 D23 DCLK NULL NULL Q23 NULL QI_FF
AF24 D24 DCLK NULL NULL Q24 NULL QI_FF
AF25 D25 DCLK NULL NULL Q25 NULL QI_FF
AF26 D26 DCLK NULL NULL Q26 NULL QI_FF
AF27 D27 DCLK NULL NULL Q27 NULL QI_FF
AF28 D28 DCLK NULL NULL Q28 NULL QI_FF
AF29 D29 DCLK NULL NULL Q29 NULL QI_FF
AF30 D30 DCLK NULL NULL Q30 NULL QI_FF
AO [Q0 Q1 Q2 Q3 Q4 Q5 Q6 Q7 Q8 Q9 Q10 Q11 Q12 Q13 Q14 Q15 Q16 Q17 Q18 Q19 Q20 Q21 Q22 Q23 Q24 Q25 Q26 Q27 Q28 Q29 Q30] [TH0 TH1 TH2 TH3 TH4 TH5 TH6 TH7 TH8 TH9 TH10 TH11 TH12 TH13 TH14 TH15 TH16 TH17 TH18 TH19 TH20 TH21 TH22 TH23 TH24 TH25 TH26 TH27 TH28 TH29 TH30] QI_DAC
.ends eeg_quantizer_ideal
