* LVS reference netlist for eeg_bias_gen (KLayout sky130.lvs deck).
* Mirrors source/trials/20260902/xschem/eeg_bias_gen.spice with the deck
* conventions (see core_ref.spice header): M in SI units, 3-terminal R
* with positional value and L = N_seg * 34.5u, MIM cap with A/P in SI.
* RSET=25k (1 seg), RFILT=1Meg (10 seg), RSTART=20Meg (200 seg),
* CFILT=1nF (25x50 of 20x20 um capm: A=500000 um2, P=200000 um).
.subckt eeg_bias_gen VBN VBNF VBP VDD18 VSS
MMP1 VBN VBP VDD18 VDD18 sky130_fd_pr__pfet_01v8 L=4u W=10u
MMN1 VBN VBN VSS VSS sky130_fd_pr__nfet_01v8 L=4u W=10u
MMP2 VBP VBP VDD18 VDD18 sky130_fd_pr__pfet_01v8 L=4u W=10u
MMN2 VBP VBN SNS2 VSS sky130_fd_pr__nfet_01v8 L=4u W=40u
RRSET SNS2 VSS VSS 25k sky130_fd_pr__res_xhigh_po_0p69 W=0.69u L=8.62u
RRSTART VDD18 VBN VSS 20Meg sky130_fd_pr__res_xhigh_po_0p69 W=0.69u L=6900u
RRF VBN VBNF VSS 1Meg sky130_fd_pr__res_xhigh_po_0p69 W=0.69u L=345u
CCF VBNF VSS sky130_fd_pr__model__cap_mim C=1e-9 A=5e-7 P=0.1
.ends eeg_bias_gen
