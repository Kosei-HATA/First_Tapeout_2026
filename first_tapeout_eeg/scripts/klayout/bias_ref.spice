* LVS reference netlist for eeg_bias_gen (KLayout sky130.lvs deck).
* Mirrors source/trials/20260902/xschem/eeg_bias_gen.spice with the deck
* conventions (see core_ref.spice header): M in SI units, 3-terminal R
* with positional value and L = N_seg * 34.5u, MIM cap with A/P in SI.
* RSET=25k (1 seg), RFILT=10Meg (100 seg), RSTART = eeg_pseudo_res,
* CFILT=100pF (5x25 of 20x20 um capm: A=50000 um2, P=10000 um).
* (2026-09-11: RSTART 20Meg resistor -> pseudo-resistor, RFILT 1->10Meg,
*  CFILT 1n->100p — schematic-verified, see the canonical netlist header.)
.subckt eeg_pseudo_res A B
MMP1 M M A A sky130_fd_pr__pfet_01v8 L=4u W=1u
MMP2 M M B B sky130_fd_pr__pfet_01v8 L=4u W=1u
.ends eeg_pseudo_res

.subckt eeg_bias_gen VBN VBNF VBP VDD18 VSS
MMP1 VBN VBP VDD18 VDD18 sky130_fd_pr__pfet_01v8 L=4u W=10u
MMN1 VBN VBN VSS VSS sky130_fd_pr__nfet_01v8 L=4u W=10u
MMP2 VBP VBP VDD18 VDD18 sky130_fd_pr__pfet_01v8 L=4u W=10u
MMN2 VBP VBN SNS2 VSS sky130_fd_pr__nfet_01v8 L=4u W=40u
RRSET SNS2 VSS VSS 25k sky130_fd_pr__res_xhigh_po_0p69 W=0.69u L=8.62u
XRSTART VDD18 VBN eeg_pseudo_res
RRF VBN VBNF VSS 10Meg sky130_fd_pr__res_xhigh_po_0p69 W=0.69u L=3450u
CCF VBNF VSS sky130_fd_pr__model__cap_mim C=1e-10 A=5e-8 P=1e-2
.ends eeg_bias_gen
