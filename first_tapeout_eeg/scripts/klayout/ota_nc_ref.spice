* LVS reference netlist for eeg_fd_ota_full2_nc (KLayout sky130.lvs deck).
*
* Hierarchical mirror of source/trials/20260902/xschem/eeg_fd_ota_full2_nc.spice
* (full2 minus the choppers; core.OUTP/OUTN wire straight to stage2's N2x).
* Same deck conventions as full2_ref.spice.  The schematic inlines the
* stage-2 devices; the layout keeps them in the verified "stage2" cell, so
* this ref instantiates that subckt with N2P=N1P, N2N=N1N (same device
* count/connectivity — hierarchical compare).

.subckt eeg_cmfb_amp_dl2 VCM_SENSE VCM_REF VBN VBP VDD18 VSS
MM6 NLEFT VCM_SENSE NTAIL VSS sky130_fd_pr__nfet_01v8 L=2u W=2u
MM7 VBP VCM_REF NTAIL VSS sky130_fd_pr__nfet_01v8 L=2u W=2u
MM8 NLEFT NLEFT VDD18 VDD18 sky130_fd_pr__pfet_01v8 L=2u W=2u
MM9 VBP VBP VDD18 VDD18 sky130_fd_pr__pfet_01v8 L=4u W=4u
MM10 NTAIL VBN VSS VSS sky130_fd_pr__nfet_01v8 L=4u W=12u
.ends eeg_cmfb_amp_dl2

.subckt eeg_cmfb_amp_dl2_s2 VCM_SENSE VCM_REF VBN VBP VDD18 VSS
MM6 NLEFT VCM_SENSE NTAIL VSS sky130_fd_pr__nfet_01v8 L=2u W=2u
MM7 VBP VCM_REF NTAIL VSS sky130_fd_pr__nfet_01v8 L=2u W=2u
MM8 NLEFT NLEFT VDD18 VDD18 sky130_fd_pr__pfet_01v8 L=2u W=2u
MM9 VBP VBP VDD18 VDD18 sky130_fd_pr__pfet_01v8 L=4u W=0.5u
MM10 NTAIL VBN VSS VSS sky130_fd_pr__nfet_01v8 L=4u W=12u
.ends eeg_cmfb_amp_dl2_s2

.subckt eeg_pseudo_res A B
MMP1 M M A A sky130_fd_pr__pfet_01v8 L=4u W=1u
MMP2 M M B B sky130_fd_pr__pfet_01v8 L=4u W=1u
.ends eeg_pseudo_res

.subckt eeg_bias_gen VBN VBNF VBP VDD18 VSS
MMP1 VBN VBP VDD18 VDD18 sky130_fd_pr__pfet_01v8 L=4u W=10u
MMN1 VBN VBN VSS VSS sky130_fd_pr__nfet_01v8 L=4u W=10u
MMP2 VBP VBP VDD18 VDD18 sky130_fd_pr__pfet_01v8 L=4u W=10u
MMN2 VBP VBN SNS2 VSS sky130_fd_pr__nfet_01v8 L=4u W=40u
RRSET SNS2 VSS VSS 25k sky130_fd_pr__res_xhigh_po_0p69 W=0.69u L=8.62u
XRSTART VDD18 VBN eeg_pseudo_res
RRF VBN VBNF VSS 10Meg sky130_fd_pr__res_xhigh_po_0p69 W=0.69u L=3450u
CCF VBNF VSS sky130_fd_pr__model__cap_mim C=1e-10 A=5e-8 P=1e-2
.ends eeg_bias_gen

.subckt eeg_fd_ota_core_soft INP INN VBP VBN OUTP OUTN VCM_SENSE VCM_REF VDD18 VSS
MM1 OUTP INP TAIL VSS sky130_fd_pr__nfet_01v8 L=4u W=240u
MM2 OUTN INN TAIL VSS sky130_fd_pr__nfet_01v8 L=4u W=240u
MMDP OUTP VSS TAIL VSS sky130_fd_pr__nfet_01v8 L=4u W=20u
MM3 OUTP VBP VDD18 VDD18 sky130_fd_pr__pfet_01v8 L=4u W=48u
MM4 OUTN VBP VDD18 VDD18 sky130_fd_pr__pfet_01v8 L=4u W=48u
MM5 TAIL VBN VSS VSS sky130_fd_pr__nfet_01v8 L=4u W=96u
RRCM1 OUTP VCM_SENSE VSS 5Meg sky130_fd_pr__res_xhigh_po_0p69 W=0.69u L=1725u
RRCM2 OUTN VCM_SENSE VSS 5Meg sky130_fd_pr__res_xhigh_po_0p69 W=0.69u L=1725u
RRLOADP OUTP VCM_REF VSS 2Meg sky130_fd_pr__res_xhigh_po_0p69 W=0.69u L=690u
RRLOADN OUTN VCM_REF VSS 2Meg sky130_fd_pr__res_xhigh_po_0p69 W=0.69u L=690u
.ends eeg_fd_ota_core_soft

.subckt stage2 N2P N2N OUTP OUTN VBP2 VCM2 VCM_REF VDD18 VSS
MM21 OUTP N2P VSS VSS sky130_fd_pr__nfet_01v8 L=12u W=12u
MM22 OUTN N2N VSS VSS sky130_fd_pr__nfet_01v8 L=12u W=12u
MM23 OUTP VBP2 VDD18 VDD18 sky130_fd_pr__pfet_01v8 L=12u W=48u
MM24 OUTN VBP2 VDD18 VDD18 sky130_fd_pr__pfet_01v8 L=12u W=48u
RRCMO1 OUTP VCM2 VSS 5Meg sky130_fd_pr__res_xhigh_po_0p69 W=0.69u L=1725u
RRCMO2 OUTN VCM2 VSS 5Meg sky130_fd_pr__res_xhigh_po_0p69 W=0.69u L=1725u
RRLOADO1 OUTP VCM_REF VSS 2Meg sky130_fd_pr__res_xhigh_po_0p69 W=0.69u L=690u
RRLOADO2 OUTN VCM_REF VSS 2Meg sky130_fd_pr__res_xhigh_po_0p69 W=0.69u L=690u
RRZP N2P NZP VSS 20k sky130_fd_pr__res_xhigh_po_0p69 W=0.69u L=6.9u
RRZN N2N NZN VSS 20k sky130_fd_pr__res_xhigh_po_0p69 W=0.69u L=6.9u
CCP NZP OUTP sky130_fd_pr__model__cap_mim C=1e-11 A=5e-9 P=1.3e-3
CCN NZN OUTN sky130_fd_pr__model__cap_mim C=1e-11 A=5e-9 P=1.3e-3
.ends stage2

.subckt eeg_fd_ota_full2_nc INP INN VCM_REF OUTP OUTN VDD18 VSS
XBG VBNRAW VBN VBP_BIAS VDD18 VSS eeg_bias_gen
XSTG1 INP INN VBP1 VBN N1P N1N VCM1 VCM_REF VDD18 VSS eeg_fd_ota_core_soft
XCM1 VCM1 VCM_REF VBN VBP1 VDD18 VSS eeg_cmfb_amp_dl2
XCM2 VCM2 VCM_REF VBN VBP2 VDD18 VSS eeg_cmfb_amp_dl2_s2
XS2 N1P N1N OUTP OUTN VBP2 VCM2 VCM_REF VDD18 VSS stage2
.ends eeg_fd_ota_full2_nc
