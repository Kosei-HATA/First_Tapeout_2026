* Non-chopped two-stage OTA on the full2 platform (bias gen + dl CMFB),
* for the SDM integrators. Choppers omitted; DC bias path via core.
.subckt eeg_fd_ota_full2_nc INP INN VCM_REF OUTP OUTN VDD18 VSS params: W91=4 L91=4 W92=0.5 L92=4 W10=12 RLOAD=2Meg CC=10p RZ=20k RSET=25k RFILT=10Meg CFILT=100p
XBG VBNRAW VBN VBP_BIAS VDD18 VSS eeg_bias_gen RSET={RSET} RFILT={RFILT} CFILT={CFILT}
XSTG1 INP INN VBP1 VBN N1P N1N VCM1 VCM_REF VDD18 VSS eeg_fd_ota_core_soft RLOAD={RLOAD}
XCM1 VCM1 VCM_REF VBN VBP1 VDD18 VSS eeg_cmfb_amp_dl2 W9={W91} L9={L91} W10={W10}
XM21 OUTP N1P VSS VSS sky130_fd_pr__nfet_01v8 L=12 W=12 nf=2
XM22 OUTN N1N VSS VSS sky130_fd_pr__nfet_01v8 L=12 W=12 nf=2
XM23 OUTP VBP2 VDD18 VDD18 sky130_fd_pr__pfet_01v8 L=12 W=48 nf=8
XM24 OUTN VBP2 VDD18 VDD18 sky130_fd_pr__pfet_01v8 L=12 W=48 nf=8
RCMO1 OUTP VCM2 5Meg
RCMO2 OUTN VCM2 5Meg
RLOADO1 OUTP VCM_REF {RLOAD}
RLOADO2 OUTN VCM_REF {RLOAD}
XCM2 VCM2 VCM_REF VBN VBP2 VDD18 VSS eeg_cmfb_amp_dl2 W9={W92} L9={L92} W10={W10}
RZP N1P NZP {RZ}
CCP NZP OUTP {CC}
RZN N1N NZN {RZ}
CCN NZN OUTN {CC}
.ends
