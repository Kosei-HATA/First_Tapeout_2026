* rev2 low-noise AFE OTA: canonical eeg_fd_ota_chopped_full2 (nodsl layout-
* verified version) with ONLY the CM-softening load resistors raised:
*   stage-1 RLOAD 2Meg -> 20Meg (S1RLOAD), stage-2 RLOADO 2Meg -> 20Meg.
* Measured (documentation/afe_lownoise_study.md): in-band input-referred
* noise 0.644 -> 0.130 µVrms (0.5-100 Hz, fchop=1 kHz metric), gain/PM/GBW/
* CM settling/idd unchanged, real chopped transient PASS.
* Everything else (devices, CMFB, bias, compensation) is IDENTICAL to the
* canonical file: it shares eeg_cmfb_amp_dl2 (canonical, defined in
* eeg_fd_ota_chopped_full2.spice / ...nodsl.spice) and eeg_cmos_chopper_lowq.
* rev2_afe_core_soft below is a verbatim copy of eeg_fd_ota_core_soft with
* the RLOAD default changed to 20Meg (parameter remains overridable).
.subckt rev2_afe_core_soft INP INN VBP VBN OUTP OUTN VCM_SENSE VCM_REF VDD18 VSS params: RLOAD=20Meg RCM=5Meg S1W=240 S1NF=24
XM1 OUTP INP TAIL VSS sky130_fd_pr__nfet_01v8 L=4 W={S1W} nf={S1NF}
XM2 OUTN INN TAIL VSS sky130_fd_pr__nfet_01v8 L=4 W={S1W} nf={S1NF}
XM3 OUTP VBP VDD18 VDD18 sky130_fd_pr__pfet_01v8 L=4 W=48 nf=8
XM4 OUTN VBP VDD18 VDD18 sky130_fd_pr__pfet_01v8 L=4 W=48 nf=8
XM5 TAIL VBN VSS VSS sky130_fd_pr__nfet_01v8 L=4 W=96 nf=16
RCM1 OUTP VCM_SENSE {RCM}
RCM2 OUTN VCM_SENSE {RCM}
RLOADP OUTP VCM_REF {RLOAD}
RLOADN OUTN VCM_REF {RLOAD}
.ends

.subckt rev2_afe_chopped_full2 INP INN VCM_REF OUTP OUTN PHII NPHII PHIBI NPHIBI PHIM NPHIM PHIBM NPHIBM VDD18 VSS params: W91=4 L91=4 W92=0.5 L92=4 W10=12 RLOAD=20Meg CC=10p RZ=20k RSET=25k RFILT=10Meg CFILT=100p DVOS=0 CDSLV=2n
XBG VBNRAW VBN VBP_BIAS VDD18 VSS eeg_bias_gen RSET={RSET} RFILT={RFILT} CFILT={CFILT}
XCHIN INP INN INP_M INN_M PHII NPHII PHIBI NPHIBI VDD18 VSS eeg_cmos_chopper_lowq
VOS1 INP_M INP_MX {DVOS}
XSTG1 INP_MX INN_M VBP1 VBN N1P N1N VCM1 VCM_REF VDD18 VSS rev2_afe_core_soft RLOAD={RLOAD}
XCM1 VCM1 VCM_REF VBN VBP1 VDD18 VSS eeg_cmfb_amp_dl2 W9={W91} L9={L91} W10={W10}
XCHMID N1P N1N N2P N2N PHIM NPHIM PHIBM NPHIBM VDD18 VSS eeg_cmos_chopper_lowq
XM21 OUTP N2P VSS VSS sky130_fd_pr__nfet_01v8 L=12 W=12 nf=2
XM22 OUTN N2N VSS VSS sky130_fd_pr__nfet_01v8 L=12 W=12 nf=2
XM23 OUTP VBP2 VDD18 VDD18 sky130_fd_pr__pfet_01v8 L=12 W=48 nf=8
XM24 OUTN VBP2 VDD18 VDD18 sky130_fd_pr__pfet_01v8 L=12 W=48 nf=8
RCMO1 OUTP VCM2 5Meg
RCMO2 OUTN VCM2 5Meg
RLOADO1 OUTP VCM_REF {RLOAD}
RLOADO2 OUTN VCM_REF {RLOAD}
XCM2 VCM2 VCM_REF VBN VBP2 VDD18 VSS eeg_cmfb_amp_dl2 W9={W92} L9={L92} W10={W10}
RZP N2P NZP {RZ}
CCP NZP OUTP {CC}
RZN N2N NZN {RZ}
CCN NZN OUTN {CC}
.ends
