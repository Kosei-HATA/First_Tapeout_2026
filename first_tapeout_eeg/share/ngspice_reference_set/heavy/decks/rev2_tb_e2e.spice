* rev2 END-TO-END: electrodes(+offset, CM interference) -> LN chopped PGA x32
* -> sdm3 SC 2nd-order ADC (fs=256 kHz) -> bitstream.
* Stimulus identical to eeg_e2e_tb.spice: 300 mV diff electrode offset +
* 200 uV 50 Hz CM interference + 100 uV 8 Hz EEG.
* sdm3 clocks generated behaviorally here from the 256 kHz master timing
* (clkgen RTL update for PH1/PH2/CMPCK is a separate task).
.lib /Users/noah/.volare/volare/sky130/versions/0fe599b2afb6708d281543108caf8310912f54af/sky130A/libs.tech/ngspice/sky130.lib.spice tt
.include eeg_tg_lowq.spice
.include eeg_bias_gen.spice
.include eeg_fd_ota_chopped_full2.spice
.include eeg_pseudo_res.spice
.include rev2_afe_chopped_full2.spice
.include rev2_afe_pga.spice
.include eeg_fd_ota_core_soft.spice
.include eeg_fd_ota_full2_nc.spice
.include eeg_sd_int.spice
.include sdm3_int1.spice
.include eeg_strongarm.spice
.include sdm3_mod.spice
.include rev2_top.spice
.param VDD=1.80 VCM=0.9 VCMA=0.927 TCHOP=1m TCLK=3.90625u
VDD_SRC VDD18 0 {VDD}
VREF VCM_REF 0 {VCM}
* references centered on the actual analog CM (~0.927 at TT)
VVP VP 0 {VCMA+25m}
VVN VN 0 {VCMA-25m}
* 1 kHz chopper clocks
VPHI PHI 0 PULSE(0 {VDD} 50n 20n 20n 499.85u {TCHOP})
VPHIB PHIB 0 PULSE(0 {VDD} 500.05u 20n 20n 499.85u {TCHOP})
BNPHI NPHI 0 V={VDD}-v(PHI)
BNPHIB NPHIB 0 V={VDD}-v(PHIB)
* sdm3 256 kHz 2-phase non-overlap clocks + comparator clock (see tb_sdm3_256k)
VPH1 PH1 0 PULSE(0 {VDD} 0.1u 30n 30n 1.62u {TCLK})
VPH2 PH2 0 PULSE(0 {VDD} 2.053u 30n 30n 1.62u {TCLK})
VCMPCK CMPCK 0 PULSE(0 {VDD} 1.30u 20n 20n 0.36u {TCLK})
BNPH1 NPH1 0 V={VDD}-v(PH1)
BNPH2 NPH2 0 V={VDD}-v(PH2)
* electrodes: 300 mV diff offset + 200 uV 50 Hz CM interference + 100 uV 8 Hz EEG
VELP ELPD 0 {VCM+150m}
VELN ELND 0 {VCM-150m}
VCMP ELPD ELPC SIN(0 200u 50)
VCMN ELND ELNC SIN(0 200u 50)
VSGP ELPC ELP2 SIN(0 100u 8)
VSGN ELNC ELN2 SIN(0 100u 8 0 0 180)
.nodeset v(XTOP.XAFE.INP)=0.9 v(XTOP.XAFE.INN)=0.9 v(XTOP.PGA_OUTP)=0.93 v(XTOP.PGA_OUTN)=0.93 v(XTOP.XAFE.OUTP)=0.93 v(XTOP.XAFE.OUTN)=0.93 v(BIT)=1.8
.nodeset v(XTOP.ADC_O1P)=0.93 v(XTOP.ADC_O1N)=0.93 v(XTOP.ADC_O2P)=0.93 v(XTOP.ADC_O2N)=0.93
.nodeset v(XTOP.XADC.XINT1.INP)=0.9 v(XTOP.XADC.XINT1.INN)=0.9 v(XTOP.XADC.XINT2.INP)=0.9 v(XTOP.XADC.XINT2.INN)=0.9
VS8 S8N 0 0
VS16 S16N 0 0
VS32 S32N 0 {VDD}
VS64 S64N 0 0
XTOP ELP2 ELN2 VCM_REF VP VN PHI NPHI PHIB NPHIB PHI NPHI PHIB NPHIB PH1 NPH1 PH2 NPH2 CMPCK BIT NBIT S8N S16N S32N S64N VDD18 0 rev2_top
.control
set noaskquit
save time v(BIT) v(XTOP.PGA_OUTP) v(XTOP.PGA_OUTN)
tran 100n 0.55s
wrdata ../results/rev2_e2e.csv time v(BIT) v(XTOP.PGA_OUTP) v(XTOP.PGA_OUTN)
quit
.endc
.end
