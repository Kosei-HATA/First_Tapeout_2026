* Sky130 1.8V inverting amplifier with 1-bit ADC - POST-LAYOUT (PEX)
* Hand-written top-level netlist for batch ngspice simulation
* Same stimulus/feedback as 1samp_opamp_adc_manual.spice (ideal), but the
* opamp+comparator is the EXTRACTED layout block (gds/opamp_adc.gds) with
* layout parasitic capacitors annotated (opamp_adc_pex.spice, generated by
* ../lvs_work/ext2pex.py from the magic .ext database).

* Power and bias sources
V1 VDD 0 1.8
Vinp VINP 0 0.7
Vref VREF 0 0.9
Vbias VBIAS 0 0.7

* Input signal (10mVpp sine at 100Hz, AC 1 for closed-loop AC response)
Vi input 0 DC 0 AC 1 SIN(0 5m 100)
C_in input N1 1m
XR2 N1 VINN sky130_fd_pr__res_generic_po W=1 L=21
XR1 VOUT VINN sky130_fd_pr__res_generic_po W=1 L=2054

* Post-layout OPAMP_ADC block: 2-stage opamp + comparator + inverter
X1 VDD 0 VINP VINN VBIAS VREF VOUT DOUT OPAMP_ADC_0

* PDK models
.lib /Users/noah/.volare/volare/sky130/versions/0fe599b2afb6708d281543108caf8310912f54af/sky130A/libs.tech/combined/sky130.lib.spice tt
.include /Users/noah/OSBCIChip/xschem/opamp_adc_pex.spice

.control
op
ac dec 20 1 1GHz
tran 10u 30m
write 1samp_opamp_adc_pex.raw
wrdata 1samp_opamp_adc_pex.txt V(input) V(VOUT) V(DOUT)
.endc

.end
