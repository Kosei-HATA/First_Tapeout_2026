* NGSPICE flat PEX netlist for OPAMP_ADC_0 (sky130A)
* Devices: magic `ext2spice lvs` netlist, hierarchy inlined by lvs_work/ext2pex.py
* Parasitic capacitors: magic .ext database (node->substrate, cap->coupling)
* sky130A extraction excludes FET gate/diffusion caps (kept in BSIM
* ad/as/pd/ps terms), so no double counting. Caps in farads.
* totals: 251 devices, 823 caps (121.154 fF substrate + 92.409 fF coupling)

.subckt OPAMP_ADC_0 VDD VSS VINP VINN VBIAS VREF VOUT DOUT
X0 VOUT VBIAS PMOS_S_41129712_X4_Y2_1786338312_0/a_316_1638# VDD sky130_fd_pr__pfet_01v8 ad=0.147 pd=1.33 as=0.147 ps=1.33 w=1.05 l=0.15
X1 VDD VBIAS PMOS_S_41129712_X4_Y2_1786338312_0/a_574_1638# VDD sky130_fd_pr__pfet_01v8 ad=0.147 pd=1.33 as=0.147 ps=1.33 w=1.05 l=0.15
X2 PMOS_S_41129712_X4_Y2_1786338312_0/a_1262_1638# VBIAS VDD VDD sky130_fd_pr__pfet_01v8 ad=0.147 pd=1.33 as=0.147 ps=1.33 w=1.05 l=0.15
X3 PMOS_S_41129712_X4_Y2_1786338312_0/a_1004_1638# VBIAS VOUT VDD sky130_fd_pr__pfet_01v8 ad=0.147 pd=1.33 as=0.147 ps=1.33 w=1.05 l=0.15
X4 PMOS_S_41129712_X4_Y2_1786338312_0/a_1864_1638# VBIAS PMOS_S_41129712_X4_Y2_1786338312_0/a_1778_1638# VDD sky130_fd_pr__pfet_01v8 ad=0.147 pd=1.33 as=0.147 ps=1.33 w=1.05 l=0.15
X5 PMOS_S_41129712_X4_Y2_1786338312_0/a_746_462# VBIAS VDD VDD sky130_fd_pr__pfet_01v8 ad=0.147 pd=1.33 as=0.147 ps=1.33 w=1.05 l=0.15
X6 PMOS_S_41129712_X4_Y2_1786338312_0/a_1606_1638# VBIAS PMOS_S_41129712_X4_Y2_1786338312_0/a_1520_1638# VDD sky130_fd_pr__pfet_01v8 ad=0.147 pd=1.33 as=0.147 ps=1.33 w=1.05 l=0.15
X7 PMOS_S_41129712_X4_Y2_1786338312_0/a_1090_1638# VBIAS PMOS_S_41129712_X4_Y2_1786338312_0/a_1004_1638# VDD sky130_fd_pr__pfet_01v8 ad=0.147 pd=1.33 as=0.147 ps=1.33 w=1.05 l=0.15
X8 VOUT VBIAS PMOS_S_41129712_X4_Y2_1786338312_0/a_1864_1638# VDD sky130_fd_pr__pfet_01v8 ad=0.147 pd=1.33 as=0.147 ps=1.33 w=1.05 l=0.15
X9 VDD VBIAS PMOS_S_41129712_X4_Y2_1786338312_0/a_1606_1638# VDD sky130_fd_pr__pfet_01v8 ad=0.147 pd=1.33 as=0.147 ps=1.33 w=1.05 l=0.15
X10 VDD VBIAS PMOS_S_41129712_X4_Y2_1786338312_0/a_1090_462# VDD sky130_fd_pr__pfet_01v8 ad=0.147 pd=1.33 as=0.147 ps=1.33 w=1.05 l=0.15
X11 PMOS_S_41129712_X4_Y2_1786338312_0/a_1606_462# VBIAS PMOS_S_41129712_X4_Y2_1786338312_0/a_1520_462# VDD sky130_fd_pr__pfet_01v8 ad=0.147 pd=1.33 as=0.147 ps=1.33 w=1.05 l=0.15
X12 VOUT VBIAS PMOS_S_41129712_X4_Y2_1786338312_0/a_1864_462# VDD sky130_fd_pr__pfet_01v8 ad=0.147 pd=1.33 as=0.147 ps=1.33 w=1.05 l=0.15
X13 PMOS_S_41129712_X4_Y2_1786338312_0/a_1520_1638# VBIAS VOUT VDD sky130_fd_pr__pfet_01v8 ad=0.147 pd=1.33 as=0.147 ps=1.33 w=1.05 l=0.15
X14 PMOS_S_41129712_X4_Y2_1786338312_0/a_2036_462# VBIAS VOUT VDD sky130_fd_pr__pfet_01v8 ad=0.147 pd=1.33 as=0.147 ps=1.33 w=1.05 l=0.15
X15 PMOS_S_41129712_X4_Y2_1786338312_0/a_2122_462# VBIAS PMOS_S_41129712_X4_Y2_1786338312_0/a_2036_462# VDD sky130_fd_pr__pfet_01v8 ad=0.147 pd=1.33 as=0.147 ps=1.33 w=1.05 l=0.15
X16 PMOS_S_41129712_X4_Y2_1786338312_0/a_488_462# VBIAS VOUT VDD sky130_fd_pr__pfet_01v8 ad=0.147 pd=1.33 as=0.147 ps=1.33 w=1.05 l=0.15
X17 PMOS_S_41129712_X4_Y2_1786338312_0/a_832_462# VBIAS PMOS_S_41129712_X4_Y2_1786338312_0/a_746_462# VDD sky130_fd_pr__pfet_01v8 ad=0.147 pd=1.33 as=0.147 ps=1.33 w=1.05 l=0.15
X18 PMOS_S_41129712_X4_Y2_1786338312_0/a_2036_1638# VBIAS VOUT VDD sky130_fd_pr__pfet_01v8 ad=0.147 pd=1.33 as=0.147 ps=1.33 w=1.05 l=0.15
X19 VOUT VBIAS PMOS_S_41129712_X4_Y2_1786338312_0/a_832_462# VDD sky130_fd_pr__pfet_01v8 ad=0.147 pd=1.33 as=0.147 ps=1.33 w=1.05 l=0.15
X20 PMOS_S_41129712_X4_Y2_1786338312_0/a_1262_462# VBIAS VDD VDD sky130_fd_pr__pfet_01v8 ad=0.147 pd=1.33 as=0.147 ps=1.33 w=1.05 l=0.15
X21 VDD VBIAS PMOS_S_41129712_X4_Y2_1786338312_0/a_2122_1638# VDD sky130_fd_pr__pfet_01v8 ad=0.27825 pd=2.63 as=0.147 ps=1.33 w=1.05 l=0.15
X22 VDD VBIAS PMOS_S_41129712_X4_Y2_1786338312_0/a_1606_462# VDD sky130_fd_pr__pfet_01v8 ad=0.147 pd=1.33 as=0.147 ps=1.33 w=1.05 l=0.15
X23 PMOS_S_41129712_X4_Y2_1786338312_0/a_574_462# VBIAS PMOS_S_41129712_X4_Y2_1786338312_0/a_488_462# VDD sky130_fd_pr__pfet_01v8 ad=0.147 pd=1.33 as=0.147 ps=1.33 w=1.05 l=0.15
X24 VDD VBIAS PMOS_S_41129712_X4_Y2_1786338312_0/a_2122_462# VDD sky130_fd_pr__pfet_01v8 ad=0.27825 pd=2.63 as=0.147 ps=1.33 w=1.05 l=0.15
X25 PMOS_S_41129712_X4_Y2_1786338312_0/a_1004_462# VBIAS VOUT VDD sky130_fd_pr__pfet_01v8 ad=0.147 pd=1.33 as=0.147 ps=1.33 w=1.05 l=0.15
X26 PMOS_S_41129712_X4_Y2_1786338312_0/a_2122_1638# VBIAS PMOS_S_41129712_X4_Y2_1786338312_0/a_2036_1638# VDD sky130_fd_pr__pfet_01v8 ad=0.147 pd=1.33 as=0.147 ps=1.33 w=1.05 l=0.15
X27 PMOS_S_41129712_X4_Y2_1786338312_0/a_1348_462# VBIAS PMOS_S_41129712_X4_Y2_1786338312_0/a_1262_462# VDD sky130_fd_pr__pfet_01v8 ad=0.147 pd=1.33 as=0.147 ps=1.33 w=1.05 l=0.15
X28 PMOS_S_41129712_X4_Y2_1786338312_0/a_230_462# VBIAS VDD VDD sky130_fd_pr__pfet_01v8 ad=0.147 pd=1.33 as=0.27825 ps=2.63 w=1.05 l=0.15
X29 PMOS_S_41129712_X4_Y2_1786338312_0/a_1778_462# VBIAS VDD VDD sky130_fd_pr__pfet_01v8 ad=0.147 pd=1.33 as=0.147 ps=1.33 w=1.05 l=0.15
X30 PMOS_S_41129712_X4_Y2_1786338312_0/a_316_462# VBIAS PMOS_S_41129712_X4_Y2_1786338312_0/a_230_462# VDD sky130_fd_pr__pfet_01v8 ad=0.147 pd=1.33 as=0.147 ps=1.33 w=1.05 l=0.15
X31 VDD VBIAS PMOS_S_41129712_X4_Y2_1786338312_0/a_574_462# VDD sky130_fd_pr__pfet_01v8 ad=0.147 pd=1.33 as=0.147 ps=1.33 w=1.05 l=0.15
X32 PMOS_S_41129712_X4_Y2_1786338312_0/a_746_1638# VBIAS VDD VDD sky130_fd_pr__pfet_01v8 ad=0.147 pd=1.33 as=0.147 ps=1.33 w=1.05 l=0.15
X33 PMOS_S_41129712_X4_Y2_1786338312_0/a_1348_1638# VBIAS PMOS_S_41129712_X4_Y2_1786338312_0/a_1262_1638# VDD sky130_fd_pr__pfet_01v8 ad=0.147 pd=1.33 as=0.147 ps=1.33 w=1.05 l=0.15
X34 PMOS_S_41129712_X4_Y2_1786338312_0/a_488_1638# VBIAS VOUT VDD sky130_fd_pr__pfet_01v8 ad=0.147 pd=1.33 as=0.147 ps=1.33 w=1.05 l=0.15
X35 PMOS_S_41129712_X4_Y2_1786338312_0/a_1090_462# VBIAS PMOS_S_41129712_X4_Y2_1786338312_0/a_1004_462# VDD sky130_fd_pr__pfet_01v8 ad=0.147 pd=1.33 as=0.147 ps=1.33 w=1.05 l=0.15
X36 PMOS_S_41129712_X4_Y2_1786338312_0/a_230_1638# VBIAS VDD VDD sky130_fd_pr__pfet_01v8 ad=0.147 pd=1.33 as=0.27825 ps=2.63 w=1.05 l=0.15
X37 PMOS_S_41129712_X4_Y2_1786338312_0/a_574_1638# VBIAS PMOS_S_41129712_X4_Y2_1786338312_0/a_488_1638# VDD sky130_fd_pr__pfet_01v8 ad=0.147 pd=1.33 as=0.147 ps=1.33 w=1.05 l=0.15
X38 PMOS_S_41129712_X4_Y2_1786338312_0/a_832_1638# VBIAS PMOS_S_41129712_X4_Y2_1786338312_0/a_746_1638# VDD sky130_fd_pr__pfet_01v8 ad=0.147 pd=1.33 as=0.147 ps=1.33 w=1.05 l=0.15
X39 VDD VBIAS PMOS_S_41129712_X4_Y2_1786338312_0/a_1090_1638# VDD sky130_fd_pr__pfet_01v8 ad=0.147 pd=1.33 as=0.147 ps=1.33 w=1.05 l=0.15
X40 VOUT VBIAS PMOS_S_41129712_X4_Y2_1786338312_0/a_1348_1638# VDD sky130_fd_pr__pfet_01v8 ad=0.147 pd=1.33 as=0.147 ps=1.33 w=1.05 l=0.15
X41 VOUT VBIAS PMOS_S_41129712_X4_Y2_1786338312_0/a_1348_462# VDD sky130_fd_pr__pfet_01v8 ad=0.147 pd=1.33 as=0.147 ps=1.33 w=1.05 l=0.15
X42 PMOS_S_41129712_X4_Y2_1786338312_0/a_1520_462# VBIAS VOUT VDD sky130_fd_pr__pfet_01v8 ad=0.147 pd=1.33 as=0.147 ps=1.33 w=1.05 l=0.15
X43 PMOS_S_41129712_X4_Y2_1786338312_0/a_316_1638# VBIAS PMOS_S_41129712_X4_Y2_1786338312_0/a_230_1638# VDD sky130_fd_pr__pfet_01v8 ad=0.147 pd=1.33 as=0.147 ps=1.33 w=1.05 l=0.15
X44 PMOS_S_41129712_X4_Y2_1786338312_0/a_1778_1638# VBIAS VDD VDD sky130_fd_pr__pfet_01v8 ad=0.147 pd=1.33 as=0.147 ps=1.33 w=1.05 l=0.15
X45 PMOS_S_41129712_X4_Y2_1786338312_0/a_1864_462# VBIAS PMOS_S_41129712_X4_Y2_1786338312_0/a_1778_462# VDD sky130_fd_pr__pfet_01v8 ad=0.147 pd=1.33 as=0.147 ps=1.33 w=1.05 l=0.15
X46 VOUT VBIAS PMOS_S_41129712_X4_Y2_1786338312_0/a_832_1638# VDD sky130_fd_pr__pfet_01v8 ad=0.147 pd=1.33 as=0.147 ps=1.33 w=1.05 l=0.15
X47 VOUT VBIAS PMOS_S_41129712_X4_Y2_1786338312_0/a_316_462# VDD sky130_fd_pr__pfet_01v8 ad=0.147 pd=1.33 as=0.147 ps=1.33 w=1.05 l=0.15
X48 DOUT m1_7138_2744# VSS VSS sky130_fd_pr__nfet_01v8 ad=0.147 pd=1.33 as=0.27825 ps=2.63 w=1.05 l=0.15
X49 VSS m1_7138_2744# DOUT VSS sky130_fd_pr__nfet_01v8 ad=0.27825 pd=2.63 as=0.147 ps=1.33 w=1.05 l=0.15
X50 VDD m1_7138_2744# DOUT VDD sky130_fd_pr__pfet_01v8 ad=0.27825 pd=2.63 as=0.147 ps=1.33 w=1.05 l=0.15
X51 DOUT m1_7138_2744# VDD VDD sky130_fd_pr__pfet_01v8 ad=0.147 pd=1.33 as=0.27825 ps=2.63 w=1.05 l=0.15
X52 VDD m1_7138_2744# DOUT VDD sky130_fd_pr__pfet_01v8 ad=0.147 pd=1.33 as=0.147 ps=1.33 w=1.05 l=0.15
X53 DOUT m1_7138_2744# VDD VDD sky130_fd_pr__pfet_01v8 ad=0.147 pd=1.33 as=0.147 ps=1.33 w=1.05 l=0.15
X54 m1_6536_2828# VBIAS VSS VSS sky130_fd_pr__nfet_01v8 ad=0.147 pd=1.33 as=0.147 ps=1.33 w=1.05 l=0.15
X55 VSS VBIAS m1_6536_2828# VSS sky130_fd_pr__nfet_01v8 ad=0.27825 pd=2.63 as=0.147 ps=1.33 w=1.05 l=0.15
X56 m1_6536_2828# VBIAS VSS VSS sky130_fd_pr__nfet_01v8 ad=0.147 pd=1.33 as=0.27825 ps=2.63 w=1.05 l=0.15
X57 VSS VBIAS m1_6536_2828# VSS sky130_fd_pr__nfet_01v8 ad=0.147 pd=1.33 as=0.147 ps=1.33 w=1.05 l=0.15
X58 m1_7138_2744# VREF m1_6536_2828# VSS sky130_fd_pr__nfet_01v8 ad=0.147 pd=1.33 as=0.27825 ps=2.63 w=1.05 l=0.15
X59 m1_6536_2828# VREF m1_7138_2744# VSS sky130_fd_pr__nfet_01v8 ad=0.27825 pd=2.63 as=0.147 ps=1.33 w=1.05 l=0.15
X60 m1_6450_2744# VOUT m1_6536_2828# VSS sky130_fd_pr__nfet_01v8 ad=0.147 pd=1.33 as=0.27825 ps=2.63 w=1.05 l=0.15
X61 m1_6536_2828# VOUT m1_6450_2744# VSS sky130_fd_pr__nfet_01v8 ad=0.27825 pd=2.63 as=0.147 ps=1.33 w=1.05 l=0.15
X62 m2_2208_2735# VINP NMOS_4T_97698174_X1_Y1_1786338308_0/a_316_462# VSS sky130_fd_pr__nfet_01v8 ad=0.147 pd=1.33 as=0.147 ps=1.33 w=1.05 l=0.15
X63 NMOS_4T_97698174_X1_Y1_1786338308_0/a_488_462# VINP m2_2208_2735# VSS sky130_fd_pr__nfet_01v8 ad=0.147 pd=1.33 as=0.147 ps=1.33 w=1.05 l=0.15
X64 NMOS_4T_97698174_X1_Y1_1786338308_0/a_574_462# VINP NMOS_4T_97698174_X1_Y1_1786338308_0/a_488_462# VSS sky130_fd_pr__nfet_01v8 ad=0.147 pd=1.33 as=0.147 ps=1.33 w=1.05 l=0.15
X65 NMOS_4T_97698174_X1_Y1_1786338308_0/a_230_462# VINP m1_5160_2828# VSS sky130_fd_pr__nfet_01v8 ad=0.147 pd=1.33 as=0.27825 ps=2.63 w=1.05 l=0.15
X66 NMOS_4T_97698174_X1_Y1_1786338308_0/a_316_462# VINP NMOS_4T_97698174_X1_Y1_1786338308_0/a_230_462# VSS sky130_fd_pr__nfet_01v8 ad=0.147 pd=1.33 as=0.147 ps=1.33 w=1.05 l=0.15
X67 m1_5160_2828# VINP NMOS_4T_97698174_X1_Y1_1786338308_0/a_574_462# VSS sky130_fd_pr__nfet_01v8 ad=0.27825 pd=2.63 as=0.147 ps=1.33 w=1.05 l=0.15
X68 m1_2290_2744# VINN NMOS_4T_97698174_X1_Y1_1786338308_1/a_316_462# VSS sky130_fd_pr__nfet_01v8 ad=0.147 pd=1.33 as=0.147 ps=1.33 w=1.05 l=0.15
X69 NMOS_4T_97698174_X1_Y1_1786338308_1/a_488_462# VINN m1_2290_2744# VSS sky130_fd_pr__nfet_01v8 ad=0.147 pd=1.33 as=0.147 ps=1.33 w=1.05 l=0.15
X70 NMOS_4T_97698174_X1_Y1_1786338308_1/a_574_462# VINN NMOS_4T_97698174_X1_Y1_1786338308_1/a_488_462# VSS sky130_fd_pr__nfet_01v8 ad=0.147 pd=1.33 as=0.147 ps=1.33 w=1.05 l=0.15
X71 NMOS_4T_97698174_X1_Y1_1786338308_1/a_230_462# VINN m1_5160_2828# VSS sky130_fd_pr__nfet_01v8 ad=0.147 pd=1.33 as=0.27825 ps=2.63 w=1.05 l=0.15
X72 NMOS_4T_97698174_X1_Y1_1786338308_1/a_316_462# VINN NMOS_4T_97698174_X1_Y1_1786338308_1/a_230_462# VSS sky130_fd_pr__nfet_01v8 ad=0.147 pd=1.33 as=0.147 ps=1.33 w=1.05 l=0.15
X73 m1_5160_2828# VINN NMOS_4T_97698174_X1_Y1_1786338308_1/a_574_462# VSS sky130_fd_pr__nfet_01v8 ad=0.27825 pd=2.63 as=0.147 ps=1.33 w=1.05 l=0.15
X74 m2_2208_2735# VOUT sky130_fd_pr__cap_mim_m3_1 l=1.05 w=1.05
X75 NMOS_S_26850855_X4_Y2_1786338309_0/a_746_1638# VBIAS VSS VSS sky130_fd_pr__nfet_01v8 ad=0.147 pd=1.33 as=0.147 ps=1.33 w=1.05 l=0.15
X76 NMOS_S_26850855_X4_Y2_1786338309_0/a_1348_1638# VBIAS NMOS_S_26850855_X4_Y2_1786338309_0/a_1262_1638# VSS sky130_fd_pr__nfet_01v8 ad=0.147 pd=1.33 as=0.147 ps=1.33 w=1.05 l=0.15
X77 NMOS_S_26850855_X4_Y2_1786338309_0/a_488_1638# VBIAS m1_5160_2828# VSS sky130_fd_pr__nfet_01v8 ad=0.147 pd=1.33 as=0.147 ps=1.33 w=1.05 l=0.15
X78 NMOS_S_26850855_X4_Y2_1786338309_0/a_230_1638# VBIAS VSS VSS sky130_fd_pr__nfet_01v8 ad=0.147 pd=1.33 as=0.27825 ps=2.63 w=1.05 l=0.15
X79 NMOS_S_26850855_X4_Y2_1786338309_0/a_1090_462# VBIAS NMOS_S_26850855_X4_Y2_1786338309_0/a_1004_462# VSS sky130_fd_pr__nfet_01v8 ad=0.147 pd=1.33 as=0.147 ps=1.33 w=1.05 l=0.15
X80 NMOS_S_26850855_X4_Y2_1786338309_0/a_574_1638# VBIAS NMOS_S_26850855_X4_Y2_1786338309_0/a_488_1638# VSS sky130_fd_pr__nfet_01v8 ad=0.147 pd=1.33 as=0.147 ps=1.33 w=1.05 l=0.15
X81 NMOS_S_26850855_X4_Y2_1786338309_0/a_832_1638# VBIAS NMOS_S_26850855_X4_Y2_1786338309_0/a_746_1638# VSS sky130_fd_pr__nfet_01v8 ad=0.147 pd=1.33 as=0.147 ps=1.33 w=1.05 l=0.15
X82 m1_5160_2828# VBIAS NMOS_S_26850855_X4_Y2_1786338309_0/a_1348_1638# VSS sky130_fd_pr__nfet_01v8 ad=0.147 pd=1.33 as=0.147 ps=1.33 w=1.05 l=0.15
X83 m1_5160_2828# VBIAS NMOS_S_26850855_X4_Y2_1786338309_0/a_1348_462# VSS sky130_fd_pr__nfet_01v8 ad=0.147 pd=1.33 as=0.147 ps=1.33 w=1.05 l=0.15
X84 NMOS_S_26850855_X4_Y2_1786338309_0/a_1520_462# VBIAS m1_5160_2828# VSS sky130_fd_pr__nfet_01v8 ad=0.147 pd=1.33 as=0.147 ps=1.33 w=1.05 l=0.15
X85 NMOS_S_26850855_X4_Y2_1786338309_0/a_316_1638# VBIAS NMOS_S_26850855_X4_Y2_1786338309_0/a_230_1638# VSS sky130_fd_pr__nfet_01v8 ad=0.147 pd=1.33 as=0.147 ps=1.33 w=1.05 l=0.15
X86 VSS VBIAS NMOS_S_26850855_X4_Y2_1786338309_0/a_1090_1638# VSS sky130_fd_pr__nfet_01v8 ad=0.147 pd=1.33 as=0.147 ps=1.33 w=1.05 l=0.15
X87 NMOS_S_26850855_X4_Y2_1786338309_0/a_1864_462# VBIAS NMOS_S_26850855_X4_Y2_1786338309_0/a_1778_462# VSS sky130_fd_pr__nfet_01v8 ad=0.147 pd=1.33 as=0.147 ps=1.33 w=1.05 l=0.15
X88 m1_5160_2828# VBIAS NMOS_S_26850855_X4_Y2_1786338309_0/a_832_1638# VSS sky130_fd_pr__nfet_01v8 ad=0.147 pd=1.33 as=0.147 ps=1.33 w=1.05 l=0.15
X89 NMOS_S_26850855_X4_Y2_1786338309_0/a_1778_1638# VBIAS VSS VSS sky130_fd_pr__nfet_01v8 ad=0.147 pd=1.33 as=0.147 ps=1.33 w=1.05 l=0.15
X90 m1_5160_2828# VBIAS NMOS_S_26850855_X4_Y2_1786338309_0/a_316_462# VSS sky130_fd_pr__nfet_01v8 ad=0.147 pd=1.33 as=0.147 ps=1.33 w=1.05 l=0.15
X91 VSS VBIAS NMOS_S_26850855_X4_Y2_1786338309_0/a_574_1638# VSS sky130_fd_pr__nfet_01v8 ad=0.147 pd=1.33 as=0.147 ps=1.33 w=1.05 l=0.15
X92 NMOS_S_26850855_X4_Y2_1786338309_0/a_1262_1638# VBIAS VSS VSS sky130_fd_pr__nfet_01v8 ad=0.147 pd=1.33 as=0.147 ps=1.33 w=1.05 l=0.15
X93 m1_5160_2828# VBIAS NMOS_S_26850855_X4_Y2_1786338309_0/a_316_1638# VSS sky130_fd_pr__nfet_01v8 ad=0.147 pd=1.33 as=0.147 ps=1.33 w=1.05 l=0.15
X94 NMOS_S_26850855_X4_Y2_1786338309_0/a_1864_1638# VBIAS NMOS_S_26850855_X4_Y2_1786338309_0/a_1778_1638# VSS sky130_fd_pr__nfet_01v8 ad=0.147 pd=1.33 as=0.147 ps=1.33 w=1.05 l=0.15
X95 NMOS_S_26850855_X4_Y2_1786338309_0/a_746_462# VBIAS VSS VSS sky130_fd_pr__nfet_01v8 ad=0.147 pd=1.33 as=0.147 ps=1.33 w=1.05 l=0.15
X96 NMOS_S_26850855_X4_Y2_1786338309_0/a_1004_1638# VBIAS m1_5160_2828# VSS sky130_fd_pr__nfet_01v8 ad=0.147 pd=1.33 as=0.147 ps=1.33 w=1.05 l=0.15
X97 NMOS_S_26850855_X4_Y2_1786338309_0/a_1606_1638# VBIAS NMOS_S_26850855_X4_Y2_1786338309_0/a_1520_1638# VSS sky130_fd_pr__nfet_01v8 ad=0.147 pd=1.33 as=0.147 ps=1.33 w=1.05 l=0.15
X98 NMOS_S_26850855_X4_Y2_1786338309_0/a_1090_1638# VBIAS NMOS_S_26850855_X4_Y2_1786338309_0/a_1004_1638# VSS sky130_fd_pr__nfet_01v8 ad=0.147 pd=1.33 as=0.147 ps=1.33 w=1.05 l=0.15
X99 VSS VBIAS NMOS_S_26850855_X4_Y2_1786338309_0/a_1606_1638# VSS sky130_fd_pr__nfet_01v8 ad=0.147 pd=1.33 as=0.147 ps=1.33 w=1.05 l=0.15
X100 m1_5160_2828# VBIAS NMOS_S_26850855_X4_Y2_1786338309_0/a_1864_1638# VSS sky130_fd_pr__nfet_01v8 ad=0.147 pd=1.33 as=0.147 ps=1.33 w=1.05 l=0.15
X101 VSS VBIAS NMOS_S_26850855_X4_Y2_1786338309_0/a_1090_462# VSS sky130_fd_pr__nfet_01v8 ad=0.147 pd=1.33 as=0.147 ps=1.33 w=1.05 l=0.15
X102 NMOS_S_26850855_X4_Y2_1786338309_0/a_1606_462# VBIAS NMOS_S_26850855_X4_Y2_1786338309_0/a_1520_462# VSS sky130_fd_pr__nfet_01v8 ad=0.147 pd=1.33 as=0.147 ps=1.33 w=1.05 l=0.15
X103 m1_5160_2828# VBIAS NMOS_S_26850855_X4_Y2_1786338309_0/a_1864_462# VSS sky130_fd_pr__nfet_01v8 ad=0.147 pd=1.33 as=0.147 ps=1.33 w=1.05 l=0.15
X104 NMOS_S_26850855_X4_Y2_1786338309_0/a_1520_1638# VBIAS m1_5160_2828# VSS sky130_fd_pr__nfet_01v8 ad=0.147 pd=1.33 as=0.147 ps=1.33 w=1.05 l=0.15
X105 NMOS_S_26850855_X4_Y2_1786338309_0/a_2036_462# VBIAS m1_5160_2828# VSS sky130_fd_pr__nfet_01v8 ad=0.147 pd=1.33 as=0.147 ps=1.33 w=1.05 l=0.15
X106 NMOS_S_26850855_X4_Y2_1786338309_0/a_2122_462# VBIAS NMOS_S_26850855_X4_Y2_1786338309_0/a_2036_462# VSS sky130_fd_pr__nfet_01v8 ad=0.147 pd=1.33 as=0.147 ps=1.33 w=1.05 l=0.15
X107 NMOS_S_26850855_X4_Y2_1786338309_0/a_488_462# VBIAS m1_5160_2828# VSS sky130_fd_pr__nfet_01v8 ad=0.147 pd=1.33 as=0.147 ps=1.33 w=1.05 l=0.15
X108 NMOS_S_26850855_X4_Y2_1786338309_0/a_2036_1638# VBIAS m1_5160_2828# VSS sky130_fd_pr__nfet_01v8 ad=0.147 pd=1.33 as=0.147 ps=1.33 w=1.05 l=0.15
X109 NMOS_S_26850855_X4_Y2_1786338309_0/a_832_462# VBIAS NMOS_S_26850855_X4_Y2_1786338309_0/a_746_462# VSS sky130_fd_pr__nfet_01v8 ad=0.147 pd=1.33 as=0.147 ps=1.33 w=1.05 l=0.15
X110 m1_5160_2828# VBIAS NMOS_S_26850855_X4_Y2_1786338309_0/a_832_462# VSS sky130_fd_pr__nfet_01v8 ad=0.147 pd=1.33 as=0.147 ps=1.33 w=1.05 l=0.15
X111 NMOS_S_26850855_X4_Y2_1786338309_0/a_1262_462# VBIAS VSS VSS sky130_fd_pr__nfet_01v8 ad=0.147 pd=1.33 as=0.147 ps=1.33 w=1.05 l=0.15
X112 VSS VBIAS NMOS_S_26850855_X4_Y2_1786338309_0/a_2122_1638# VSS sky130_fd_pr__nfet_01v8 ad=0.27825 pd=2.63 as=0.147 ps=1.33 w=1.05 l=0.15
X113 VSS VBIAS NMOS_S_26850855_X4_Y2_1786338309_0/a_1606_462# VSS sky130_fd_pr__nfet_01v8 ad=0.147 pd=1.33 as=0.147 ps=1.33 w=1.05 l=0.15
X114 NMOS_S_26850855_X4_Y2_1786338309_0/a_574_462# VBIAS NMOS_S_26850855_X4_Y2_1786338309_0/a_488_462# VSS sky130_fd_pr__nfet_01v8 ad=0.147 pd=1.33 as=0.147 ps=1.33 w=1.05 l=0.15
X115 VSS VBIAS NMOS_S_26850855_X4_Y2_1786338309_0/a_2122_462# VSS sky130_fd_pr__nfet_01v8 ad=0.27825 pd=2.63 as=0.147 ps=1.33 w=1.05 l=0.15
X116 NMOS_S_26850855_X4_Y2_1786338309_0/a_1004_462# VBIAS m1_5160_2828# VSS sky130_fd_pr__nfet_01v8 ad=0.147 pd=1.33 as=0.147 ps=1.33 w=1.05 l=0.15
X117 NMOS_S_26850855_X4_Y2_1786338309_0/a_2122_1638# VBIAS NMOS_S_26850855_X4_Y2_1786338309_0/a_2036_1638# VSS sky130_fd_pr__nfet_01v8 ad=0.147 pd=1.33 as=0.147 ps=1.33 w=1.05 l=0.15
X118 NMOS_S_26850855_X4_Y2_1786338309_0/a_1348_462# VBIAS NMOS_S_26850855_X4_Y2_1786338309_0/a_1262_462# VSS sky130_fd_pr__nfet_01v8 ad=0.147 pd=1.33 as=0.147 ps=1.33 w=1.05 l=0.15
X119 NMOS_S_26850855_X4_Y2_1786338309_0/a_230_462# VBIAS VSS VSS sky130_fd_pr__nfet_01v8 ad=0.147 pd=1.33 as=0.27825 ps=2.63 w=1.05 l=0.15
X120 NMOS_S_26850855_X4_Y2_1786338309_0/a_316_462# VBIAS NMOS_S_26850855_X4_Y2_1786338309_0/a_230_462# VSS sky130_fd_pr__nfet_01v8 ad=0.147 pd=1.33 as=0.147 ps=1.33 w=1.05 l=0.15
X121 NMOS_S_26850855_X4_Y2_1786338309_0/a_1778_462# VBIAS VSS VSS sky130_fd_pr__nfet_01v8 ad=0.147 pd=1.33 as=0.147 ps=1.33 w=1.05 l=0.15
X122 VSS VBIAS NMOS_S_26850855_X4_Y2_1786338309_0/a_574_462# VSS sky130_fd_pr__nfet_01v8 ad=0.147 pd=1.33 as=0.147 ps=1.33 w=1.05 l=0.15
X123 m1_6450_2744# m1_6450_2744# VDD VDD sky130_fd_pr__pfet_01v8 ad=0.147 pd=1.33 as=0.147 ps=1.33 w=1.05 l=0.15
X124 VDD m1_6450_2744# m1_7138_2744# VDD sky130_fd_pr__pfet_01v8 ad=0.147 pd=1.33 as=0.147 ps=1.33 w=1.05 l=0.15
X125 VDD m1_6450_2744# m1_6450_2744# VDD sky130_fd_pr__pfet_01v8 ad=0.27825 pd=2.63 as=0.147 ps=1.33 w=1.05 l=0.15
X126 m1_7138_2744# m1_6450_2744# VDD VDD sky130_fd_pr__pfet_01v8 ad=0.147 pd=1.33 as=0.147 ps=1.33 w=1.05 l=0.15
X127 m1_6450_2744# m1_6450_2744# VDD VDD sky130_fd_pr__pfet_01v8 ad=0.147 pd=1.33 as=0.27825 ps=2.63 w=1.05 l=0.15
X128 VDD m1_6450_2744# m1_6450_2744# VDD sky130_fd_pr__pfet_01v8 ad=0.147 pd=1.33 as=0.147 ps=1.33 w=1.05 l=0.15
X129 VDD m1_6450_2744# m1_7138_2744# VDD sky130_fd_pr__pfet_01v8 ad=0.147 pd=1.33 as=0.147 ps=1.33 w=1.05 l=0.15
X130 m1_7138_2744# m1_6450_2744# VDD VDD sky130_fd_pr__pfet_01v8 ad=0.147 pd=1.33 as=0.147 ps=1.33 w=1.05 l=0.15
X131 NMOS_S_64076268_X4_Y1_1786338310_0/a_1090_462# m2_2208_2735# NMOS_S_64076268_X4_Y1_1786338310_0/a_1004_462# VSS sky130_fd_pr__nfet_01v8 ad=0.147 pd=1.33 as=0.147 ps=1.33 w=1.05 l=0.15
X132 VOUT m2_2208_2735# NMOS_S_64076268_X4_Y1_1786338310_0/a_1348_462# VSS sky130_fd_pr__nfet_01v8 ad=0.147 pd=1.33 as=0.147 ps=1.33 w=1.05 l=0.15
X133 NMOS_S_64076268_X4_Y1_1786338310_0/a_1520_462# m2_2208_2735# VOUT VSS sky130_fd_pr__nfet_01v8 ad=0.147 pd=1.33 as=0.147 ps=1.33 w=1.05 l=0.15
X134 NMOS_S_64076268_X4_Y1_1786338310_0/a_1864_462# m2_2208_2735# NMOS_S_64076268_X4_Y1_1786338310_0/a_1778_462# VSS sky130_fd_pr__nfet_01v8 ad=0.147 pd=1.33 as=0.147 ps=1.33 w=1.05 l=0.15
X135 VOUT m2_2208_2735# NMOS_S_64076268_X4_Y1_1786338310_0/a_316_462# VSS sky130_fd_pr__nfet_01v8 ad=0.147 pd=1.33 as=0.147 ps=1.33 w=1.05 l=0.15
X136 NMOS_S_64076268_X4_Y1_1786338310_0/a_746_462# m2_2208_2735# VSS VSS sky130_fd_pr__nfet_01v8 ad=0.147 pd=1.33 as=0.147 ps=1.33 w=1.05 l=0.15
X137 VSS m2_2208_2735# NMOS_S_64076268_X4_Y1_1786338310_0/a_1090_462# VSS sky130_fd_pr__nfet_01v8 ad=0.147 pd=1.33 as=0.147 ps=1.33 w=1.05 l=0.15
X138 NMOS_S_64076268_X4_Y1_1786338310_0/a_1606_462# m2_2208_2735# NMOS_S_64076268_X4_Y1_1786338310_0/a_1520_462# VSS sky130_fd_pr__nfet_01v8 ad=0.147 pd=1.33 as=0.147 ps=1.33 w=1.05 l=0.15
X139 VOUT m2_2208_2735# NMOS_S_64076268_X4_Y1_1786338310_0/a_1864_462# VSS sky130_fd_pr__nfet_01v8 ad=0.147 pd=1.33 as=0.147 ps=1.33 w=1.05 l=0.15
X140 NMOS_S_64076268_X4_Y1_1786338310_0/a_2036_462# m2_2208_2735# VOUT VSS sky130_fd_pr__nfet_01v8 ad=0.147 pd=1.33 as=0.147 ps=1.33 w=1.05 l=0.15
X141 NMOS_S_64076268_X4_Y1_1786338310_0/a_2122_462# m2_2208_2735# NMOS_S_64076268_X4_Y1_1786338310_0/a_2036_462# VSS sky130_fd_pr__nfet_01v8 ad=0.147 pd=1.33 as=0.147 ps=1.33 w=1.05 l=0.15
X142 NMOS_S_64076268_X4_Y1_1786338310_0/a_488_462# m2_2208_2735# VOUT VSS sky130_fd_pr__nfet_01v8 ad=0.147 pd=1.33 as=0.147 ps=1.33 w=1.05 l=0.15
X143 NMOS_S_64076268_X4_Y1_1786338310_0/a_832_462# m2_2208_2735# NMOS_S_64076268_X4_Y1_1786338310_0/a_746_462# VSS sky130_fd_pr__nfet_01v8 ad=0.147 pd=1.33 as=0.147 ps=1.33 w=1.05 l=0.15
X144 VOUT m2_2208_2735# NMOS_S_64076268_X4_Y1_1786338310_0/a_832_462# VSS sky130_fd_pr__nfet_01v8 ad=0.147 pd=1.33 as=0.147 ps=1.33 w=1.05 l=0.15
X145 NMOS_S_64076268_X4_Y1_1786338310_0/a_1262_462# m2_2208_2735# VSS VSS sky130_fd_pr__nfet_01v8 ad=0.147 pd=1.33 as=0.147 ps=1.33 w=1.05 l=0.15
X146 VSS m2_2208_2735# NMOS_S_64076268_X4_Y1_1786338310_0/a_1606_462# VSS sky130_fd_pr__nfet_01v8 ad=0.147 pd=1.33 as=0.147 ps=1.33 w=1.05 l=0.15
X147 NMOS_S_64076268_X4_Y1_1786338310_0/a_574_462# m2_2208_2735# NMOS_S_64076268_X4_Y1_1786338310_0/a_488_462# VSS sky130_fd_pr__nfet_01v8 ad=0.147 pd=1.33 as=0.147 ps=1.33 w=1.05 l=0.15
X148 VSS m2_2208_2735# NMOS_S_64076268_X4_Y1_1786338310_0/a_2122_462# VSS sky130_fd_pr__nfet_01v8 ad=0.27825 pd=2.63 as=0.147 ps=1.33 w=1.05 l=0.15
X149 NMOS_S_64076268_X4_Y1_1786338310_0/a_1004_462# m2_2208_2735# VOUT VSS sky130_fd_pr__nfet_01v8 ad=0.147 pd=1.33 as=0.147 ps=1.33 w=1.05 l=0.15
X150 NMOS_S_64076268_X4_Y1_1786338310_0/a_1348_462# m2_2208_2735# NMOS_S_64076268_X4_Y1_1786338310_0/a_1262_462# VSS sky130_fd_pr__nfet_01v8 ad=0.147 pd=1.33 as=0.147 ps=1.33 w=1.05 l=0.15
X151 NMOS_S_64076268_X4_Y1_1786338310_0/a_230_462# m2_2208_2735# VSS VSS sky130_fd_pr__nfet_01v8 ad=0.147 pd=1.33 as=0.27825 ps=2.63 w=1.05 l=0.15
X152 NMOS_S_64076268_X4_Y1_1786338310_0/a_316_462# m2_2208_2735# NMOS_S_64076268_X4_Y1_1786338310_0/a_230_462# VSS sky130_fd_pr__nfet_01v8 ad=0.147 pd=1.33 as=0.147 ps=1.33 w=1.05 l=0.15
X153 NMOS_S_64076268_X4_Y1_1786338310_0/a_1778_462# m2_2208_2735# VSS VSS sky130_fd_pr__nfet_01v8 ad=0.147 pd=1.33 as=0.147 ps=1.33 w=1.05 l=0.15
X154 VSS m2_2208_2735# NMOS_S_64076268_X4_Y1_1786338310_0/a_574_462# VSS sky130_fd_pr__nfet_01v8 ad=0.147 pd=1.33 as=0.147 ps=1.33 w=1.05 l=0.15
X155 m2_2208_2735# m1_2290_2744# SCM_PMOS_74423661_X4_Y2_1786338313_0/a_316_1638# VDD sky130_fd_pr__pfet_01v8 ad=0.147 pd=1.33 as=0.147 ps=1.33 w=1.05 l=0.15
X156 VDD m1_2290_2744# SCM_PMOS_74423661_X4_Y2_1786338313_0/a_574_1638# VDD sky130_fd_pr__pfet_01v8 ad=0.147 pd=1.33 as=0.147 ps=1.33 w=1.05 l=0.15
X157 SCM_PMOS_74423661_X4_Y2_1786338313_0/a_1262_1638# m1_2290_2744# VDD VDD sky130_fd_pr__pfet_01v8 ad=0.147 pd=1.33 as=0.147 ps=1.33 w=1.05 l=0.15
X158 SCM_PMOS_74423661_X4_Y2_1786338313_0/a_3326_1638# m1_2290_2744# VDD VDD sky130_fd_pr__pfet_01v8 ad=0.147 pd=1.33 as=0.147 ps=1.33 w=1.05 l=0.15
X159 SCM_PMOS_74423661_X4_Y2_1786338313_0/a_2810_462# m1_2290_2744# VDD VDD sky130_fd_pr__pfet_01v8 ad=0.147 pd=1.33 as=0.147 ps=1.33 w=1.05 l=0.15
X160 SCM_PMOS_74423661_X4_Y2_1786338313_0/a_1004_1638# m1_2290_2744# m1_2290_2744# VDD sky130_fd_pr__pfet_01v8 ad=0.147 pd=1.33 as=0.147 ps=1.33 w=1.05 l=0.15
X161 SCM_PMOS_74423661_X4_Y2_1786338313_0/a_1864_1638# m1_2290_2744# SCM_PMOS_74423661_X4_Y2_1786338313_0/a_1778_1638# VDD sky130_fd_pr__pfet_01v8 ad=0.147 pd=1.33 as=0.147 ps=1.33 w=1.05 l=0.15
X162 SCM_PMOS_74423661_X4_Y2_1786338313_0/a_3928_1638# m1_2290_2744# SCM_PMOS_74423661_X4_Y2_1786338313_0/a_3842_1638# VDD sky130_fd_pr__pfet_01v8 ad=0.147 pd=1.33 as=0.147 ps=1.33 w=1.05 l=0.15
X163 SCM_PMOS_74423661_X4_Y2_1786338313_0/a_746_462# m1_2290_2744# VDD VDD sky130_fd_pr__pfet_01v8 ad=0.147 pd=1.33 as=0.147 ps=1.33 w=1.05 l=0.15
X164 SCM_PMOS_74423661_X4_Y2_1786338313_0/a_1606_1638# m1_2290_2744# SCM_PMOS_74423661_X4_Y2_1786338313_0/a_1520_1638# VDD sky130_fd_pr__pfet_01v8 ad=0.147 pd=1.33 as=0.147 ps=1.33 w=1.05 l=0.15
X165 SCM_PMOS_74423661_X4_Y2_1786338313_0/a_3412_1638# m1_2290_2744# SCM_PMOS_74423661_X4_Y2_1786338313_0/a_3326_1638# VDD sky130_fd_pr__pfet_01v8 ad=0.147 pd=1.33 as=0.147 ps=1.33 w=1.05 l=0.15
X166 SCM_PMOS_74423661_X4_Y2_1786338313_0/a_3670_1638# m1_2290_2744# SCM_PMOS_74423661_X4_Y2_1786338313_0/a_3584_1638# VDD sky130_fd_pr__pfet_01v8 ad=0.147 pd=1.33 as=0.147 ps=1.33 w=1.05 l=0.15
X167 VDD m1_2290_2744# SCM_PMOS_74423661_X4_Y2_1786338313_0/a_3154_462# VDD sky130_fd_pr__pfet_01v8 ad=0.147 pd=1.33 as=0.147 ps=1.33 w=1.05 l=0.15
X168 SCM_PMOS_74423661_X4_Y2_1786338313_0/a_3326_462# m1_2290_2744# VDD VDD sky130_fd_pr__pfet_01v8 ad=0.147 pd=1.33 as=0.147 ps=1.33 w=1.05 l=0.15
X169 SCM_PMOS_74423661_X4_Y2_1786338313_0/a_1090_1638# m1_2290_2744# SCM_PMOS_74423661_X4_Y2_1786338313_0/a_1004_1638# VDD sky130_fd_pr__pfet_01v8 ad=0.147 pd=1.33 as=0.147 ps=1.33 w=1.05 l=0.15
X170 m2_2208_2735# m1_2290_2744# SCM_PMOS_74423661_X4_Y2_1786338313_0/a_1864_1638# VDD sky130_fd_pr__pfet_01v8 ad=0.147 pd=1.33 as=0.147 ps=1.33 w=1.05 l=0.15
X171 m2_2208_2735# m1_2290_2744# SCM_PMOS_74423661_X4_Y2_1786338313_0/a_3928_1638# VDD sky130_fd_pr__pfet_01v8 ad=0.147 pd=1.33 as=0.147 ps=1.33 w=1.05 l=0.15
X172 SCM_PMOS_74423661_X4_Y2_1786338313_0/a_3670_462# m1_2290_2744# SCM_PMOS_74423661_X4_Y2_1786338313_0/a_3584_462# VDD sky130_fd_pr__pfet_01v8 ad=0.147 pd=1.33 as=0.147 ps=1.33 w=1.05 l=0.15
X173 VDD m1_2290_2744# SCM_PMOS_74423661_X4_Y2_1786338313_0/a_1606_1638# VDD sky130_fd_pr__pfet_01v8 ad=0.147 pd=1.33 as=0.147 ps=1.33 w=1.05 l=0.15
X174 VDD m1_2290_2744# SCM_PMOS_74423661_X4_Y2_1786338313_0/a_1090_462# VDD sky130_fd_pr__pfet_01v8 ad=0.147 pd=1.33 as=0.147 ps=1.33 w=1.05 l=0.15
X175 SCM_PMOS_74423661_X4_Y2_1786338313_0/a_4186_462# m1_2290_2744# SCM_PMOS_74423661_X4_Y2_1786338313_0/a_4100_462# VDD sky130_fd_pr__pfet_01v8 ad=0.147 pd=1.33 as=0.147 ps=1.33 w=1.05 l=0.15
X176 SCM_PMOS_74423661_X4_Y2_1786338313_0/a_1606_462# m1_2290_2744# SCM_PMOS_74423661_X4_Y2_1786338313_0/a_1520_462# VDD sky130_fd_pr__pfet_01v8 ad=0.147 pd=1.33 as=0.147 ps=1.33 w=1.05 l=0.15
X177 m1_2290_2744# m1_2290_2744# SCM_PMOS_74423661_X4_Y2_1786338313_0/a_1864_462# VDD sky130_fd_pr__pfet_01v8 ad=0.147 pd=1.33 as=0.147 ps=1.33 w=1.05 l=0.15
X178 SCM_PMOS_74423661_X4_Y2_1786338313_0/a_1520_1638# m1_2290_2744# m1_2290_2744# VDD sky130_fd_pr__pfet_01v8 ad=0.147 pd=1.33 as=0.147 ps=1.33 w=1.05 l=0.15
X179 SCM_PMOS_74423661_X4_Y2_1786338313_0/a_2036_462# m1_2290_2744# m1_2290_2744# VDD sky130_fd_pr__pfet_01v8 ad=0.147 pd=1.33 as=0.147 ps=1.33 w=1.05 l=0.15
X180 SCM_PMOS_74423661_X4_Y2_1786338313_0/a_2122_462# m1_2290_2744# SCM_PMOS_74423661_X4_Y2_1786338313_0/a_2036_462# VDD sky130_fd_pr__pfet_01v8 ad=0.147 pd=1.33 as=0.147 ps=1.33 w=1.05 l=0.15
X181 SCM_PMOS_74423661_X4_Y2_1786338313_0/a_488_462# m1_2290_2744# m1_2290_2744# VDD sky130_fd_pr__pfet_01v8 ad=0.147 pd=1.33 as=0.147 ps=1.33 w=1.05 l=0.15
X182 SCM_PMOS_74423661_X4_Y2_1786338313_0/a_832_462# m1_2290_2744# SCM_PMOS_74423661_X4_Y2_1786338313_0/a_746_462# VDD sky130_fd_pr__pfet_01v8 ad=0.147 pd=1.33 as=0.147 ps=1.33 w=1.05 l=0.15
X183 m1_2290_2744# m1_2290_2744# SCM_PMOS_74423661_X4_Y2_1786338313_0/a_2380_462# VDD sky130_fd_pr__pfet_01v8 ad=0.147 pd=1.33 as=0.147 ps=1.33 w=1.05 l=0.15
X184 SCM_PMOS_74423661_X4_Y2_1786338313_0/a_2036_1638# m1_2290_2744# m2_2208_2735# VDD sky130_fd_pr__pfet_01v8 ad=0.147 pd=1.33 as=0.147 ps=1.33 w=1.05 l=0.15
X185 SCM_PMOS_74423661_X4_Y2_1786338313_0/a_2638_1638# m1_2290_2744# SCM_PMOS_74423661_X4_Y2_1786338313_0/a_2552_1638# VDD sky130_fd_pr__pfet_01v8 ad=0.147 pd=1.33 as=0.147 ps=1.33 w=1.05 l=0.15
X186 m2_2208_2735# m1_2290_2744# SCM_PMOS_74423661_X4_Y2_1786338313_0/a_832_462# VDD sky130_fd_pr__pfet_01v8 ad=0.147 pd=1.33 as=0.147 ps=1.33 w=1.05 l=0.15
X187 SCM_PMOS_74423661_X4_Y2_1786338313_0/a_2896_462# m1_2290_2744# SCM_PMOS_74423661_X4_Y2_1786338313_0/a_2810_462# VDD sky130_fd_pr__pfet_01v8 ad=0.147 pd=1.33 as=0.147 ps=1.33 w=1.05 l=0.15
X188 SCM_PMOS_74423661_X4_Y2_1786338313_0/a_3412_462# m1_2290_2744# SCM_PMOS_74423661_X4_Y2_1786338313_0/a_3326_462# VDD sky130_fd_pr__pfet_01v8 ad=0.147 pd=1.33 as=0.147 ps=1.33 w=1.05 l=0.15
X189 SCM_PMOS_74423661_X4_Y2_1786338313_0/a_4186_1638# m1_2290_2744# SCM_PMOS_74423661_X4_Y2_1786338313_0/a_4100_1638# VDD sky130_fd_pr__pfet_01v8 ad=0.147 pd=1.33 as=0.147 ps=1.33 w=1.05 l=0.15
X190 SCM_PMOS_74423661_X4_Y2_1786338313_0/a_1262_462# m1_2290_2744# VDD VDD sky130_fd_pr__pfet_01v8 ad=0.147 pd=1.33 as=0.147 ps=1.33 w=1.05 l=0.15
X191 VDD m1_2290_2744# SCM_PMOS_74423661_X4_Y2_1786338313_0/a_3670_462# VDD sky130_fd_pr__pfet_01v8 ad=0.147 pd=1.33 as=0.147 ps=1.33 w=1.05 l=0.15
X192 VDD m1_2290_2744# SCM_PMOS_74423661_X4_Y2_1786338313_0/a_2122_1638# VDD sky130_fd_pr__pfet_01v8 ad=0.147 pd=1.33 as=0.147 ps=1.33 w=1.05 l=0.15
X193 m2_2208_2735# m1_2290_2744# SCM_PMOS_74423661_X4_Y2_1786338313_0/a_2380_1638# VDD sky130_fd_pr__pfet_01v8 ad=0.147 pd=1.33 as=0.147 ps=1.33 w=1.05 l=0.15
X194 VDD m1_2290_2744# SCM_PMOS_74423661_X4_Y2_1786338313_0/a_1606_462# VDD sky130_fd_pr__pfet_01v8 ad=0.147 pd=1.33 as=0.147 ps=1.33 w=1.05 l=0.15
X195 VDD m1_2290_2744# SCM_PMOS_74423661_X4_Y2_1786338313_0/a_4186_462# VDD sky130_fd_pr__pfet_01v8 ad=0.27825 pd=2.63 as=0.147 ps=1.33 w=1.05 l=0.15
X196 VDD m1_2290_2744# SCM_PMOS_74423661_X4_Y2_1786338313_0/a_4186_1638# VDD sky130_fd_pr__pfet_01v8 ad=0.27825 pd=2.63 as=0.147 ps=1.33 w=1.05 l=0.15
X197 SCM_PMOS_74423661_X4_Y2_1786338313_0/a_2552_1638# m1_2290_2744# m2_2208_2735# VDD sky130_fd_pr__pfet_01v8 ad=0.147 pd=1.33 as=0.147 ps=1.33 w=1.05 l=0.15
X198 SCM_PMOS_74423661_X4_Y2_1786338313_0/a_2294_1638# m1_2290_2744# VDD VDD sky130_fd_pr__pfet_01v8 ad=0.147 pd=1.33 as=0.147 ps=1.33 w=1.05 l=0.15
X199 SCM_PMOS_74423661_X4_Y2_1786338313_0/a_574_462# m1_2290_2744# SCM_PMOS_74423661_X4_Y2_1786338313_0/a_488_462# VDD sky130_fd_pr__pfet_01v8 ad=0.147 pd=1.33 as=0.147 ps=1.33 w=1.05 l=0.15
X200 VDD m1_2290_2744# SCM_PMOS_74423661_X4_Y2_1786338313_0/a_2122_462# VDD sky130_fd_pr__pfet_01v8 ad=0.147 pd=1.33 as=0.147 ps=1.33 w=1.05 l=0.15
X201 SCM_PMOS_74423661_X4_Y2_1786338313_0/a_2552_462# m1_2290_2744# m1_2290_2744# VDD sky130_fd_pr__pfet_01v8 ad=0.147 pd=1.33 as=0.147 ps=1.33 w=1.05 l=0.15
X202 SCM_PMOS_74423661_X4_Y2_1786338313_0/a_2896_1638# m1_2290_2744# SCM_PMOS_74423661_X4_Y2_1786338313_0/a_2810_1638# VDD sky130_fd_pr__pfet_01v8 ad=0.147 pd=1.33 as=0.147 ps=1.33 w=1.05 l=0.15
X203 SCM_PMOS_74423661_X4_Y2_1786338313_0/a_4100_1638# m1_2290_2744# m2_2208_2735# VDD sky130_fd_pr__pfet_01v8 ad=0.147 pd=1.33 as=0.147 ps=1.33 w=1.05 l=0.15
X204 SCM_PMOS_74423661_X4_Y2_1786338313_0/a_1004_462# m1_2290_2744# m2_2208_2735# VDD sky130_fd_pr__pfet_01v8 ad=0.147 pd=1.33 as=0.147 ps=1.33 w=1.05 l=0.15
X205 m2_2208_2735# m1_2290_2744# SCM_PMOS_74423661_X4_Y2_1786338313_0/a_2896_462# VDD sky130_fd_pr__pfet_01v8 ad=0.147 pd=1.33 as=0.147 ps=1.33 w=1.05 l=0.15
X206 SCM_PMOS_74423661_X4_Y2_1786338313_0/a_2380_1638# m1_2290_2744# SCM_PMOS_74423661_X4_Y2_1786338313_0/a_2294_1638# VDD sky130_fd_pr__pfet_01v8 ad=0.147 pd=1.33 as=0.147 ps=1.33 w=1.05 l=0.15
X207 SCM_PMOS_74423661_X4_Y2_1786338313_0/a_3068_462# m1_2290_2744# m2_2208_2735# VDD sky130_fd_pr__pfet_01v8 ad=0.147 pd=1.33 as=0.147 ps=1.33 w=1.05 l=0.15
X208 SCM_PMOS_74423661_X4_Y2_1786338313_0/a_2122_1638# m1_2290_2744# SCM_PMOS_74423661_X4_Y2_1786338313_0/a_2036_1638# VDD sky130_fd_pr__pfet_01v8 ad=0.147 pd=1.33 as=0.147 ps=1.33 w=1.05 l=0.15
X209 m1_2290_2744# m1_2290_2744# SCM_PMOS_74423661_X4_Y2_1786338313_0/a_2896_1638# VDD sky130_fd_pr__pfet_01v8 ad=0.147 pd=1.33 as=0.147 ps=1.33 w=1.05 l=0.15
X210 m2_2208_2735# m1_2290_2744# SCM_PMOS_74423661_X4_Y2_1786338313_0/a_3412_462# VDD sky130_fd_pr__pfet_01v8 ad=0.147 pd=1.33 as=0.147 ps=1.33 w=1.05 l=0.15
X211 VDD m1_2290_2744# SCM_PMOS_74423661_X4_Y2_1786338313_0/a_2638_1638# VDD sky130_fd_pr__pfet_01v8 ad=0.147 pd=1.33 as=0.147 ps=1.33 w=1.05 l=0.15
X212 SCM_PMOS_74423661_X4_Y2_1786338313_0/a_3842_462# m1_2290_2744# VDD VDD sky130_fd_pr__pfet_01v8 ad=0.147 pd=1.33 as=0.147 ps=1.33 w=1.05 l=0.15
X213 SCM_PMOS_74423661_X4_Y2_1786338313_0/a_3928_462# m1_2290_2744# SCM_PMOS_74423661_X4_Y2_1786338313_0/a_3842_462# VDD sky130_fd_pr__pfet_01v8 ad=0.147 pd=1.33 as=0.147 ps=1.33 w=1.05 l=0.15
X214 SCM_PMOS_74423661_X4_Y2_1786338313_0/a_1348_462# m1_2290_2744# SCM_PMOS_74423661_X4_Y2_1786338313_0/a_1262_462# VDD sky130_fd_pr__pfet_01v8 ad=0.147 pd=1.33 as=0.147 ps=1.33 w=1.05 l=0.15
X215 SCM_PMOS_74423661_X4_Y2_1786338313_0/a_230_462# m1_2290_2744# VDD VDD sky130_fd_pr__pfet_01v8 ad=0.147 pd=1.33 as=0.27825 ps=2.63 w=1.05 l=0.15
X216 SCM_PMOS_74423661_X4_Y2_1786338313_0/a_1778_462# m1_2290_2744# VDD VDD sky130_fd_pr__pfet_01v8 ad=0.147 pd=1.33 as=0.147 ps=1.33 w=1.05 l=0.15
X217 SCM_PMOS_74423661_X4_Y2_1786338313_0/a_2810_1638# m1_2290_2744# VDD VDD sky130_fd_pr__pfet_01v8 ad=0.147 pd=1.33 as=0.147 ps=1.33 w=1.05 l=0.15
X218 SCM_PMOS_74423661_X4_Y2_1786338313_0/a_316_462# m1_2290_2744# SCM_PMOS_74423661_X4_Y2_1786338313_0/a_230_462# VDD sky130_fd_pr__pfet_01v8 ad=0.147 pd=1.33 as=0.147 ps=1.33 w=1.05 l=0.15
X219 SCM_PMOS_74423661_X4_Y2_1786338313_0/a_2294_462# m1_2290_2744# VDD VDD sky130_fd_pr__pfet_01v8 ad=0.147 pd=1.33 as=0.147 ps=1.33 w=1.05 l=0.15
X220 VDD m1_2290_2744# SCM_PMOS_74423661_X4_Y2_1786338313_0/a_574_462# VDD sky130_fd_pr__pfet_01v8 ad=0.147 pd=1.33 as=0.147 ps=1.33 w=1.05 l=0.15
X221 SCM_PMOS_74423661_X4_Y2_1786338313_0/a_3068_1638# m1_2290_2744# m1_2290_2744# VDD sky130_fd_pr__pfet_01v8 ad=0.147 pd=1.33 as=0.147 ps=1.33 w=1.05 l=0.15
X222 SCM_PMOS_74423661_X4_Y2_1786338313_0/a_2638_462# m1_2290_2744# SCM_PMOS_74423661_X4_Y2_1786338313_0/a_2552_462# VDD sky130_fd_pr__pfet_01v8 ad=0.147 pd=1.33 as=0.147 ps=1.33 w=1.05 l=0.15
X223 VDD m1_2290_2744# SCM_PMOS_74423661_X4_Y2_1786338313_0/a_2638_462# VDD sky130_fd_pr__pfet_01v8 ad=0.147 pd=1.33 as=0.147 ps=1.33 w=1.05 l=0.15
X224 SCM_PMOS_74423661_X4_Y2_1786338313_0/a_746_1638# m1_2290_2744# VDD VDD sky130_fd_pr__pfet_01v8 ad=0.147 pd=1.33 as=0.147 ps=1.33 w=1.05 l=0.15
X225 SCM_PMOS_74423661_X4_Y2_1786338313_0/a_1348_1638# m1_2290_2744# SCM_PMOS_74423661_X4_Y2_1786338313_0/a_1262_1638# VDD sky130_fd_pr__pfet_01v8 ad=0.147 pd=1.33 as=0.147 ps=1.33 w=1.05 l=0.15
X226 SCM_PMOS_74423661_X4_Y2_1786338313_0/a_3154_462# m1_2290_2744# SCM_PMOS_74423661_X4_Y2_1786338313_0/a_3068_462# VDD sky130_fd_pr__pfet_01v8 ad=0.147 pd=1.33 as=0.147 ps=1.33 w=1.05 l=0.15
X227 SCM_PMOS_74423661_X4_Y2_1786338313_0/a_488_1638# m1_2290_2744# m2_2208_2735# VDD sky130_fd_pr__pfet_01v8 ad=0.147 pd=1.33 as=0.147 ps=1.33 w=1.05 l=0.15
X228 SCM_PMOS_74423661_X4_Y2_1786338313_0/a_3154_1638# m1_2290_2744# SCM_PMOS_74423661_X4_Y2_1786338313_0/a_3068_1638# VDD sky130_fd_pr__pfet_01v8 ad=0.147 pd=1.33 as=0.147 ps=1.33 w=1.05 l=0.15
X229 SCM_PMOS_74423661_X4_Y2_1786338313_0/a_1090_462# m1_2290_2744# SCM_PMOS_74423661_X4_Y2_1786338313_0/a_1004_462# VDD sky130_fd_pr__pfet_01v8 ad=0.147 pd=1.33 as=0.147 ps=1.33 w=1.05 l=0.15
X230 SCM_PMOS_74423661_X4_Y2_1786338313_0/a_3584_462# m1_2290_2744# m2_2208_2735# VDD sky130_fd_pr__pfet_01v8 ad=0.147 pd=1.33 as=0.147 ps=1.33 w=1.05 l=0.15
X231 SCM_PMOS_74423661_X4_Y2_1786338313_0/a_230_1638# m1_2290_2744# VDD VDD sky130_fd_pr__pfet_01v8 ad=0.147 pd=1.33 as=0.27825 ps=2.63 w=1.05 l=0.15
X232 VDD m1_2290_2744# SCM_PMOS_74423661_X4_Y2_1786338313_0/a_3670_1638# VDD sky130_fd_pr__pfet_01v8 ad=0.147 pd=1.33 as=0.147 ps=1.33 w=1.05 l=0.15
X233 m1_2290_2744# m1_2290_2744# SCM_PMOS_74423661_X4_Y2_1786338313_0/a_3928_462# VDD sky130_fd_pr__pfet_01v8 ad=0.147 pd=1.33 as=0.147 ps=1.33 w=1.05 l=0.15
X234 SCM_PMOS_74423661_X4_Y2_1786338313_0/a_4100_462# m1_2290_2744# m1_2290_2744# VDD sky130_fd_pr__pfet_01v8 ad=0.147 pd=1.33 as=0.147 ps=1.33 w=1.05 l=0.15
X235 SCM_PMOS_74423661_X4_Y2_1786338313_0/a_574_1638# m1_2290_2744# SCM_PMOS_74423661_X4_Y2_1786338313_0/a_488_1638# VDD sky130_fd_pr__pfet_01v8 ad=0.147 pd=1.33 as=0.147 ps=1.33 w=1.05 l=0.15
X236 SCM_PMOS_74423661_X4_Y2_1786338313_0/a_832_1638# m1_2290_2744# SCM_PMOS_74423661_X4_Y2_1786338313_0/a_746_1638# VDD sky130_fd_pr__pfet_01v8 ad=0.147 pd=1.33 as=0.147 ps=1.33 w=1.05 l=0.15
X237 VDD m1_2290_2744# SCM_PMOS_74423661_X4_Y2_1786338313_0/a_1090_1638# VDD sky130_fd_pr__pfet_01v8 ad=0.147 pd=1.33 as=0.147 ps=1.33 w=1.05 l=0.15
X238 m1_2290_2744# m1_2290_2744# SCM_PMOS_74423661_X4_Y2_1786338313_0/a_1348_1638# VDD sky130_fd_pr__pfet_01v8 ad=0.147 pd=1.33 as=0.147 ps=1.33 w=1.05 l=0.15
X239 m1_2290_2744# m1_2290_2744# SCM_PMOS_74423661_X4_Y2_1786338313_0/a_3412_1638# VDD sky130_fd_pr__pfet_01v8 ad=0.147 pd=1.33 as=0.147 ps=1.33 w=1.05 l=0.15
X240 m2_2208_2735# m1_2290_2744# SCM_PMOS_74423661_X4_Y2_1786338313_0/a_1348_462# VDD sky130_fd_pr__pfet_01v8 ad=0.147 pd=1.33 as=0.147 ps=1.33 w=1.05 l=0.15
X241 SCM_PMOS_74423661_X4_Y2_1786338313_0/a_1520_462# m1_2290_2744# m2_2208_2735# VDD sky130_fd_pr__pfet_01v8 ad=0.147 pd=1.33 as=0.147 ps=1.33 w=1.05 l=0.15
X242 SCM_PMOS_74423661_X4_Y2_1786338313_0/a_316_1638# m1_2290_2744# SCM_PMOS_74423661_X4_Y2_1786338313_0/a_230_1638# VDD sky130_fd_pr__pfet_01v8 ad=0.147 pd=1.33 as=0.147 ps=1.33 w=1.05 l=0.15
X243 SCM_PMOS_74423661_X4_Y2_1786338313_0/a_1778_1638# m1_2290_2744# VDD VDD sky130_fd_pr__pfet_01v8 ad=0.147 pd=1.33 as=0.147 ps=1.33 w=1.05 l=0.15
X244 VDD m1_2290_2744# SCM_PMOS_74423661_X4_Y2_1786338313_0/a_3154_1638# VDD sky130_fd_pr__pfet_01v8 ad=0.147 pd=1.33 as=0.147 ps=1.33 w=1.05 l=0.15
X245 SCM_PMOS_74423661_X4_Y2_1786338313_0/a_1864_462# m1_2290_2744# SCM_PMOS_74423661_X4_Y2_1786338313_0/a_1778_462# VDD sky130_fd_pr__pfet_01v8 ad=0.147 pd=1.33 as=0.147 ps=1.33 w=1.05 l=0.15
X246 m1_2290_2744# m1_2290_2744# SCM_PMOS_74423661_X4_Y2_1786338313_0/a_832_1638# VDD sky130_fd_pr__pfet_01v8 ad=0.147 pd=1.33 as=0.147 ps=1.33 w=1.05 l=0.15
X247 SCM_PMOS_74423661_X4_Y2_1786338313_0/a_3584_1638# m1_2290_2744# m1_2290_2744# VDD sky130_fd_pr__pfet_01v8 ad=0.147 pd=1.33 as=0.147 ps=1.33 w=1.05 l=0.15
X248 SCM_PMOS_74423661_X4_Y2_1786338313_0/a_3842_1638# m1_2290_2744# VDD VDD sky130_fd_pr__pfet_01v8 ad=0.147 pd=1.33 as=0.147 ps=1.33 w=1.05 l=0.15
X249 m1_2290_2744# m1_2290_2744# SCM_PMOS_74423661_X4_Y2_1786338313_0/a_316_462# VDD sky130_fd_pr__pfet_01v8 ad=0.147 pd=1.33 as=0.147 ps=1.33 w=1.05 l=0.15
X250 SCM_PMOS_74423661_X4_Y2_1786338313_0/a_2380_462# m1_2290_2744# SCM_PMOS_74423661_X4_Y2_1786338313_0/a_2294_462# VDD sky130_fd_pr__pfet_01v8 ad=0.147 pd=1.33 as=0.147 ps=1.33 w=1.05 l=0.15
C0 DOUT VDD 5.702098e-17
C1 DOUT VOUT 2.550318e-18
C2 DOUT VREF 4.932960e-19
C3 DOUT VSS -1.078467e-17
C4 DOUT m1_6450_2744# 9.541250e-20
C5 DOUT m1_7138_2744# -6.690740e-18
C6 NMOS_4T_97698174_X1_Y1_1786338308_0/a_230_462# VBIAS 3.046510e-19
C7 NMOS_4T_97698174_X1_Y1_1786338308_0/a_230_462# VDD 2.458760e-20
C8 NMOS_4T_97698174_X1_Y1_1786338308_0/a_230_462# VOUT 8.183010e-20
C9 NMOS_4T_97698174_X1_Y1_1786338308_0/a_230_462# VSS 3.358290e-18
C10 NMOS_4T_97698174_X1_Y1_1786338308_0/a_230_462# m1_7138_2744# 7.665260e-20
C11 NMOS_4T_97698174_X1_Y1_1786338308_0/a_230_462# m2_2208_2735# 7.710640e-19
C12 NMOS_4T_97698174_X1_Y1_1786338308_0/a_316_462# VDD 5.379830e-20
C13 NMOS_4T_97698174_X1_Y1_1786338308_0/a_316_462# VSS 3.020720e-18
C14 NMOS_4T_97698174_X1_Y1_1786338308_0/a_316_462# m1_7138_2744# 6.759740e-20
C15 NMOS_4T_97698174_X1_Y1_1786338308_0/a_316_462# m2_2208_2735# 9.039500e-19
C16 NMOS_4T_97698174_X1_Y1_1786338308_0/a_488_462# VDD 6.778960e-20
C17 NMOS_4T_97698174_X1_Y1_1786338308_0/a_488_462# VSS 3.483489e-18
C18 NMOS_4T_97698174_X1_Y1_1786338308_0/a_488_462# m1_7138_2744# 5.366170e-20
C19 NMOS_4T_97698174_X1_Y1_1786338308_0/a_488_462# m2_2208_2735# 1.270060e-18
C20 NMOS_4T_97698174_X1_Y1_1786338308_0/a_574_462# VDD 7.688400e-20
C21 NMOS_4T_97698174_X1_Y1_1786338308_0/a_574_462# VSS 3.025614e-18
C22 NMOS_4T_97698174_X1_Y1_1786338308_0/a_574_462# m1_7138_2744# 2.280330e-20
C23 NMOS_4T_97698174_X1_Y1_1786338308_0/a_574_462# m2_2208_2735# 1.517160e-18
C24 NMOS_4T_97698174_X1_Y1_1786338308_1/a_230_462# VDD 5.226460e-19
C25 NMOS_4T_97698174_X1_Y1_1786338308_1/a_230_462# VOUT 1.812570e-18
C26 NMOS_4T_97698174_X1_Y1_1786338308_1/a_230_462# m1_5160_2828# 2.015640e-19
C27 NMOS_4T_97698174_X1_Y1_1786338308_1/a_230_462# m2_2208_2735# 3.929545e-18
C28 NMOS_4T_97698174_X1_Y1_1786338308_1/a_316_462# VDD 3.996220e-19
C29 NMOS_4T_97698174_X1_Y1_1786338308_1/a_316_462# VOUT 1.517160e-18
C30 NMOS_4T_97698174_X1_Y1_1786338308_1/a_316_462# m2_2208_2735# 4.272984e-18
C31 NMOS_4T_97698174_X1_Y1_1786338308_1/a_488_462# VBIAS 3.046510e-19
C32 NMOS_4T_97698174_X1_Y1_1786338308_1/a_488_462# VDD 2.482920e-19
C33 NMOS_4T_97698174_X1_Y1_1786338308_1/a_488_462# VOUT 1.067910e-18
C34 NMOS_4T_97698174_X1_Y1_1786338308_1/a_488_462# VSS 1.379444e-18
C35 NMOS_4T_97698174_X1_Y1_1786338308_1/a_488_462# m2_2208_2735# 4.782898e-18
C36 NMOS_4T_97698174_X1_Y1_1786338308_1/a_574_462# VDD 2.014690e-19
C37 NMOS_4T_97698174_X1_Y1_1786338308_1/a_574_462# VSS 7.495560e-19
C38 NMOS_4T_97698174_X1_Y1_1786338308_1/a_574_462# m2_2208_2735# 6.168998e-18
C39 NMOS_S_26850855_X4_Y2_1786338309_0/a_1004_462# VDD 3.721700e-18
C40 NMOS_S_26850855_X4_Y2_1786338309_0/a_1004_462# VOUT 2.256548e-18
C41 NMOS_S_26850855_X4_Y2_1786338309_0/a_1004_462# VSS -2.171530e-18
C42 NMOS_S_26850855_X4_Y2_1786338309_0/a_1004_462# m2_2208_2735# 1.358450e-18
C43 NMOS_S_26850855_X4_Y2_1786338309_0/a_1090_462# VDD 3.721700e-18
C44 NMOS_S_26850855_X4_Y2_1786338309_0/a_1090_462# VSS -2.171530e-18
C45 NMOS_S_26850855_X4_Y2_1786338309_0/a_1090_462# m1_2290_2744# 2.015640e-19
C46 NMOS_S_26850855_X4_Y2_1786338309_0/a_1262_462# VDD 3.721700e-18
C47 NMOS_S_26850855_X4_Y2_1786338309_0/a_1262_462# VSS -2.171530e-18
C48 NMOS_S_26850855_X4_Y2_1786338309_0/a_1348_1638# VBIAS 1.072900e-18
C49 NMOS_S_26850855_X4_Y2_1786338309_0/a_1348_462# VBIAS 1.939000e-18
C50 NMOS_S_26850855_X4_Y2_1786338309_0/a_1348_462# VDD 3.721700e-18
C51 NMOS_S_26850855_X4_Y2_1786338309_0/a_1348_462# VOUT 6.012290e-19
C52 NMOS_S_26850855_X4_Y2_1786338309_0/a_1348_462# VSS -7.110000e-22
C53 NMOS_S_26850855_X4_Y2_1786338309_0/a_1348_462# m1_5160_2828# 6.298880e-19
C54 NMOS_S_26850855_X4_Y2_1786338309_0/a_1520_1638# VBIAS 1.072900e-18
C55 NMOS_S_26850855_X4_Y2_1786338309_0/a_1520_462# VBIAS 1.939000e-18
C56 NMOS_S_26850855_X4_Y2_1786338309_0/a_1520_462# VDD 3.721700e-18
C57 NMOS_S_26850855_X4_Y2_1786338309_0/a_1520_462# VOUT 2.840850e-19
C58 NMOS_S_26850855_X4_Y2_1786338309_0/a_1520_462# VSS 7.842800e-20
C59 NMOS_S_26850855_X4_Y2_1786338309_0/a_1606_1638# VBIAS 1.072900e-18
C60 NMOS_S_26850855_X4_Y2_1786338309_0/a_1606_462# VBIAS 1.939000e-18
C61 NMOS_S_26850855_X4_Y2_1786338309_0/a_1606_462# VDD 3.721700e-18
C62 NMOS_S_26850855_X4_Y2_1786338309_0/a_1606_462# VOUT 2.536520e-19
C63 NMOS_S_26850855_X4_Y2_1786338309_0/a_1606_462# VSS 1.291420e-19
C64 NMOS_S_26850855_X4_Y2_1786338309_0/a_1778_1638# VBIAS 1.072900e-18
C65 NMOS_S_26850855_X4_Y2_1786338309_0/a_1778_462# VBIAS 1.939001e-18
C66 NMOS_S_26850855_X4_Y2_1786338309_0/a_1778_462# VDD 3.721700e-18
C67 NMOS_S_26850855_X4_Y2_1786338309_0/a_1778_462# VOUT 2.044280e-19
C68 NMOS_S_26850855_X4_Y2_1786338309_0/a_1778_462# VSS 2.626380e-19
C69 NMOS_S_26850855_X4_Y2_1786338309_0/a_1864_1638# VBIAS 1.072900e-18
C70 NMOS_S_26850855_X4_Y2_1786338309_0/a_1864_462# VBIAS 1.939000e-18
C71 NMOS_S_26850855_X4_Y2_1786338309_0/a_1864_462# VDD 3.721700e-18
C72 NMOS_S_26850855_X4_Y2_1786338309_0/a_1864_462# VOUT 1.845480e-19
C73 NMOS_S_26850855_X4_Y2_1786338309_0/a_1864_462# VSS 3.510970e-19
C74 NMOS_S_26850855_X4_Y2_1786338309_0/a_2036_1638# VBIAS 1.072900e-18
C75 NMOS_S_26850855_X4_Y2_1786338309_0/a_2036_462# VBIAS 1.939000e-18
C76 NMOS_S_26850855_X4_Y2_1786338309_0/a_2036_462# VDD 3.721700e-18
C77 NMOS_S_26850855_X4_Y2_1786338309_0/a_2036_462# VOUT 1.520410e-19
C78 NMOS_S_26850855_X4_Y2_1786338309_0/a_2036_462# VSS 5.920760e-19
C79 NMOS_S_26850855_X4_Y2_1786338309_0/a_2122_1638# VBIAS 1.924360e-18
C80 NMOS_S_26850855_X4_Y2_1786338309_0/a_2122_462# VBIAS 6.570210e-18
C81 NMOS_S_26850855_X4_Y2_1786338309_0/a_2122_462# VDD 3.721700e-18
C82 NMOS_S_26850855_X4_Y2_1786338309_0/a_2122_462# VOUT 6.789880e-20
C83 NMOS_S_26850855_X4_Y2_1786338309_0/a_2122_462# VSS 6.484000e-21
C84 NMOS_S_26850855_X4_Y2_1786338309_0/a_230_1638# VBIAS 7.688400e-20
C85 NMOS_S_26850855_X4_Y2_1786338309_0/a_230_1638# VOUT 7.566420e-19
C86 NMOS_S_26850855_X4_Y2_1786338309_0/a_230_462# VBIAS 1.224944e-18
C87 NMOS_S_26850855_X4_Y2_1786338309_0/a_230_462# VDD 3.721700e-18
C88 NMOS_S_26850855_X4_Y2_1786338309_0/a_230_462# VOUT 6.163840e-18
C89 NMOS_S_26850855_X4_Y2_1786338309_0/a_230_462# VSS -2.921086e-18
C90 NMOS_S_26850855_X4_Y2_1786338309_0/a_230_462# m1_2290_2744# 8.889970e-20
C91 NMOS_S_26850855_X4_Y2_1786338309_0/a_230_462# m1_5160_2828# -7.710640e-19
C92 NMOS_S_26850855_X4_Y2_1786338309_0/a_230_462# m2_2208_2735# 8.870260e-19
C93 NMOS_S_26850855_X4_Y2_1786338309_0/a_316_1638# VBIAS 6.778960e-20
C94 NMOS_S_26850855_X4_Y2_1786338309_0/a_316_1638# VOUT 7.566420e-19
C95 NMOS_S_26850855_X4_Y2_1786338309_0/a_316_462# VBIAS 1.215850e-18
C96 NMOS_S_26850855_X4_Y2_1786338309_0/a_316_462# VDD 3.721700e-18
C97 NMOS_S_26850855_X4_Y2_1786338309_0/a_316_462# VOUT 6.331300e-18
C98 NMOS_S_26850855_X4_Y2_1786338309_0/a_316_462# VSS -2.921086e-18
C99 NMOS_S_26850855_X4_Y2_1786338309_0/a_316_462# m1_5160_2828# -9.039500e-19
C100 NMOS_S_26850855_X4_Y2_1786338309_0/a_316_462# m2_2208_2735# 8.870260e-19
C101 NMOS_S_26850855_X4_Y2_1786338309_0/a_488_1638# VBIAS 5.379830e-20
C102 NMOS_S_26850855_X4_Y2_1786338309_0/a_488_1638# VOUT 1.307430e-18
C103 NMOS_S_26850855_X4_Y2_1786338309_0/a_488_462# VBIAS 5.379830e-20
C104 NMOS_S_26850855_X4_Y2_1786338309_0/a_488_462# VDD 3.999512e-18
C105 NMOS_S_26850855_X4_Y2_1786338309_0/a_488_462# VOUT 6.115200e-18
C106 NMOS_S_26850855_X4_Y2_1786338309_0/a_488_462# VSS -2.171530e-18
C107 NMOS_S_26850855_X4_Y2_1786338309_0/a_488_462# m1_5160_2828# -1.270060e-18
C108 NMOS_S_26850855_X4_Y2_1786338309_0/a_574_1638# VBIAS 2.458760e-20
C109 NMOS_S_26850855_X4_Y2_1786338309_0/a_574_462# VBIAS 2.458760e-20
C110 NMOS_S_26850855_X4_Y2_1786338309_0/a_574_462# VDD 3.721700e-18
C111 NMOS_S_26850855_X4_Y2_1786338309_0/a_574_462# VOUT 4.117894e-18
C112 NMOS_S_26850855_X4_Y2_1786338309_0/a_574_462# VSS -2.171530e-18
C113 NMOS_S_26850855_X4_Y2_1786338309_0/a_574_462# m1_5160_2828# 8.881780e-34
C114 NMOS_S_26850855_X4_Y2_1786338309_0/a_574_462# m2_2208_2735# 1.358450e-18
C115 NMOS_S_26850855_X4_Y2_1786338309_0/a_746_462# VDD 3.721700e-18
C116 NMOS_S_26850855_X4_Y2_1786338309_0/a_746_462# VOUT 3.450721e-18
C117 NMOS_S_26850855_X4_Y2_1786338309_0/a_746_462# VSS -2.171530e-18
C118 NMOS_S_26850855_X4_Y2_1786338309_0/a_746_462# m1_5160_2828# -8.881780e-34
C119 NMOS_S_26850855_X4_Y2_1786338309_0/a_746_462# m2_2208_2735# 1.358450e-18
C120 NMOS_S_26850855_X4_Y2_1786338309_0/a_832_462# VDD 3.721700e-18
C121 NMOS_S_26850855_X4_Y2_1786338309_0/a_832_462# VOUT 3.028137e-18
C122 NMOS_S_26850855_X4_Y2_1786338309_0/a_832_462# VSS -2.171530e-18
C123 NMOS_S_26850855_X4_Y2_1786338309_0/a_832_462# m1_5160_2828# 6.298880e-19
C124 NMOS_S_26850855_X4_Y2_1786338309_0/a_832_462# m2_2208_2735# 1.358450e-18
C125 NMOS_S_64076268_X4_Y1_1786338310_0/a_1004_462# m1_5160_2828# 1.548710e-19
C126 NMOS_S_64076268_X4_Y1_1786338310_0/a_1004_462# m2_2208_2735# 1.812570e-18
C127 NMOS_S_64076268_X4_Y1_1786338310_0/a_1090_462# m2_2208_2735# 1.517160e-18
C128 NMOS_S_64076268_X4_Y1_1786338310_0/a_1262_462# VSS 6.298880e-19
C129 NMOS_S_64076268_X4_Y1_1786338310_0/a_1348_462# VDD 1.014330e-19
C130 NMOS_S_64076268_X4_Y1_1786338310_0/a_1520_462# VDD 3.111620e-19
C131 NMOS_S_64076268_X4_Y1_1786338310_0/a_1520_462# m1_5160_2828# 1.548710e-19
C132 NMOS_S_64076268_X4_Y1_1786338310_0/a_1606_462# VDD 3.475180e-19
C133 NMOS_S_64076268_X4_Y1_1786338310_0/a_1778_462# VDD 4.410150e-19
C134 NMOS_S_64076268_X4_Y1_1786338310_0/a_1778_462# VOUT 3.555080e-19
C135 NMOS_S_64076268_X4_Y1_1786338310_0/a_1778_462# VSS 9.895900e-19
C136 NMOS_S_64076268_X4_Y1_1786338310_0/a_1864_462# VDD 5.015910e-19
C137 NMOS_S_64076268_X4_Y1_1786338310_0/a_1864_462# m1_6536_2828# 1.548710e-19
C138 NMOS_S_64076268_X4_Y1_1786338310_0/a_2036_462# VDD 6.629710e-19
C139 NMOS_S_64076268_X4_Y1_1786338310_0/a_2036_462# m1_6536_2828# 1.548710e-19
C140 NMOS_S_64076268_X4_Y1_1786338310_0/a_2122_462# VDD 7.710640e-19
C141 NMOS_S_64076268_X4_Y1_1786338310_0/a_230_462# VSS -5.745110e-19
C142 NMOS_S_64076268_X4_Y1_1786338310_0/a_230_462# m2_2208_2735# 2.150140e-18
C143 NMOS_S_64076268_X4_Y1_1786338310_0/a_316_462# VSS -6.629710e-19
C144 NMOS_S_64076268_X4_Y1_1786338310_0/a_316_462# m2_2208_2735# 2.504590e-18
C145 NMOS_S_64076268_X4_Y1_1786338310_0/a_488_462# VSS -9.039500e-19
C146 NMOS_S_64076268_X4_Y1_1786338310_0/a_488_462# m2_2208_2735# 3.031190e-18
C147 NMOS_S_64076268_X4_Y1_1786338310_0/a_574_462# VSS -1.067910e-18
C148 NMOS_S_64076268_X4_Y1_1786338310_0/a_574_462# m2_2208_2735# 6.115200e-18
C149 NMOS_S_64076268_X4_Y1_1786338310_0/a_746_462# m2_2208_2735# 2.823120e-18
C150 NMOS_S_64076268_X4_Y1_1786338310_0/a_832_462# m2_2208_2735# 2.504590e-18
C151 PMOS_S_41129712_X4_Y2_1786338312_0/a_1004_462# VDD 4.588200e-19
C152 PMOS_S_41129712_X4_Y2_1786338312_0/a_1004_462# VOUT 3.631490e-19
C153 PMOS_S_41129712_X4_Y2_1786338312_0/a_1004_462# m2_2208_2735# 2.546240e-19
C154 PMOS_S_41129712_X4_Y2_1786338312_0/a_1090_1638# VOUT 1.208150e-18
C155 PMOS_S_41129712_X4_Y2_1786338312_0/a_1090_462# VDD 5.914170e-19
C156 PMOS_S_41129712_X4_Y2_1786338312_0/a_1262_1638# VBIAS 3.721700e-18
C157 PMOS_S_41129712_X4_Y2_1786338312_0/a_1262_1638# VDD -2.171530e-18
C158 PMOS_S_41129712_X4_Y2_1786338312_0/a_1262_462# VBIAS -2.493000e-18
C159 PMOS_S_41129712_X4_Y2_1786338312_0/a_1262_462# VDD 4.506210e-18
C160 PMOS_S_41129712_X4_Y2_1786338312_0/a_1262_462# m2_2208_2735# 1.759690e-35
C161 PMOS_S_41129712_X4_Y2_1786338312_0/a_1348_1638# VBIAS 3.721700e-18
C162 PMOS_S_41129712_X4_Y2_1786338312_0/a_1348_1638# VDD -2.171530e-18
C163 PMOS_S_41129712_X4_Y2_1786338312_0/a_1348_1638# VOUT 1.208150e-18
C164 PMOS_S_41129712_X4_Y2_1786338312_0/a_1348_462# VBIAS -2.493000e-18
C165 PMOS_S_41129712_X4_Y2_1786338312_0/a_1348_462# VDD 6.620890e-18
C166 PMOS_S_41129712_X4_Y2_1786338312_0/a_1348_462# VOUT 2.001067e-18
C167 PMOS_S_41129712_X4_Y2_1786338312_0/a_1348_462# m2_2208_2735# 4.816810e-19
C168 PMOS_S_41129712_X4_Y2_1786338312_0/a_1520_1638# VBIAS 3.721700e-18
C169 PMOS_S_41129712_X4_Y2_1786338312_0/a_1520_1638# VDD -2.171530e-18
C170 PMOS_S_41129712_X4_Y2_1786338312_0/a_1520_1638# VOUT 1.208150e-18
C171 PMOS_S_41129712_X4_Y2_1786338312_0/a_1520_1638# VSS 2.458760e-20
C172 PMOS_S_41129712_X4_Y2_1786338312_0/a_1520_1638# m1_2290_2744# 3.027640e-19
C173 PMOS_S_41129712_X4_Y2_1786338312_0/a_1520_462# VBIAS -2.493000e-18
C174 PMOS_S_41129712_X4_Y2_1786338312_0/a_1520_462# VDD 3.028150e-18
C175 PMOS_S_41129712_X4_Y2_1786338312_0/a_1520_462# VOUT 2.120288e-18
C176 PMOS_S_41129712_X4_Y2_1786338312_0/a_1520_462# VSS 2.458760e-20
C177 PMOS_S_41129712_X4_Y2_1786338312_0/a_1520_462# m1_2290_2744# 4.616320e-18
C178 PMOS_S_41129712_X4_Y2_1786338312_0/a_1520_462# m2_2208_2735# 2.331913e-18
C179 PMOS_S_41129712_X4_Y2_1786338312_0/a_1606_1638# VBIAS 3.721700e-18
C180 PMOS_S_41129712_X4_Y2_1786338312_0/a_1606_1638# VDD -2.171530e-18
C181 PMOS_S_41129712_X4_Y2_1786338312_0/a_1606_1638# VOUT 1.208150e-18
C182 PMOS_S_41129712_X4_Y2_1786338312_0/a_1606_1638# VSS 5.379830e-20
C183 PMOS_S_41129712_X4_Y2_1786338312_0/a_1606_462# VBIAS -2.493000e-18
C184 PMOS_S_41129712_X4_Y2_1786338312_0/a_1606_462# VDD 3.075410e-18
C185 PMOS_S_41129712_X4_Y2_1786338312_0/a_1606_462# VOUT 2.194033e-18
C186 PMOS_S_41129712_X4_Y2_1786338312_0/a_1606_462# VSS 5.379830e-20
C187 PMOS_S_41129712_X4_Y2_1786338312_0/a_1606_462# m1_2290_2744# 2.585520e-18
C188 PMOS_S_41129712_X4_Y2_1786338312_0/a_1606_462# m2_2208_2735# 2.379569e-18
C189 PMOS_S_41129712_X4_Y2_1786338312_0/a_1778_1638# VBIAS 3.721700e-18
C190 PMOS_S_41129712_X4_Y2_1786338312_0/a_1778_1638# VDD -2.171530e-18
C191 PMOS_S_41129712_X4_Y2_1786338312_0/a_1778_1638# VOUT 1.208150e-18
C192 PMOS_S_41129712_X4_Y2_1786338312_0/a_1778_1638# VSS 6.778960e-20
C193 PMOS_S_41129712_X4_Y2_1786338312_0/a_1778_462# VBIAS -2.493000e-18
C194 PMOS_S_41129712_X4_Y2_1786338312_0/a_1778_462# VDD 3.159810e-18
C195 PMOS_S_41129712_X4_Y2_1786338312_0/a_1778_462# VOUT 2.376862e-18
C196 PMOS_S_41129712_X4_Y2_1786338312_0/a_1778_462# VSS 6.778960e-20
C197 PMOS_S_41129712_X4_Y2_1786338312_0/a_1778_462# m1_2290_2744# 2.585520e-18
C198 PMOS_S_41129712_X4_Y2_1786338312_0/a_1778_462# m2_2208_2735# 2.485648e-18
C199 PMOS_S_41129712_X4_Y2_1786338312_0/a_1864_1638# VBIAS 3.721700e-18
C200 PMOS_S_41129712_X4_Y2_1786338312_0/a_1864_1638# VDD -2.171530e-18
C201 PMOS_S_41129712_X4_Y2_1786338312_0/a_1864_1638# VOUT 1.208150e-18
C202 PMOS_S_41129712_X4_Y2_1786338312_0/a_1864_1638# VSS 7.688400e-20
C203 PMOS_S_41129712_X4_Y2_1786338312_0/a_1864_462# VBIAS -2.493000e-18
C204 PMOS_S_41129712_X4_Y2_1786338312_0/a_1864_462# VDD 3.192750e-18
C205 PMOS_S_41129712_X4_Y2_1786338312_0/a_1864_462# VOUT 2.576314e-18
C206 PMOS_S_41129712_X4_Y2_1786338312_0/a_1864_462# VSS 7.688400e-20
C207 PMOS_S_41129712_X4_Y2_1786338312_0/a_1864_462# m1_2290_2744# 2.585520e-18
C208 PMOS_S_41129712_X4_Y2_1786338312_0/a_1864_462# m2_2208_2735# 2.543257e-18
C209 PMOS_S_41129712_X4_Y2_1786338312_0/a_2036_1638# VBIAS 3.721700e-18
C210 PMOS_S_41129712_X4_Y2_1786338312_0/a_2036_1638# VDD -2.171530e-18
C211 PMOS_S_41129712_X4_Y2_1786338312_0/a_2036_1638# VOUT 1.208150e-18
C212 PMOS_S_41129712_X4_Y2_1786338312_0/a_2036_1638# VSS 1.013850e-19
C213 PMOS_S_41129712_X4_Y2_1786338312_0/a_2036_462# VDD 2.492013e-18
C214 PMOS_S_41129712_X4_Y2_1786338312_0/a_2036_462# VOUT 3.022383e-18
C215 PMOS_S_41129712_X4_Y2_1786338312_0/a_2036_462# VSS 1.013850e-19
C216 PMOS_S_41129712_X4_Y2_1786338312_0/a_2036_462# m1_2290_2744# 2.585520e-18
C217 PMOS_S_41129712_X4_Y2_1786338312_0/a_2036_462# m2_2208_2735# 2.662980e-18
C218 PMOS_S_41129712_X4_Y2_1786338312_0/a_2122_1638# VBIAS 3.721700e-18
C219 PMOS_S_41129712_X4_Y2_1786338312_0/a_2122_1638# VDD -2.171530e-18
C220 PMOS_S_41129712_X4_Y2_1786338312_0/a_2122_1638# VOUT 1.208150e-18
C221 PMOS_S_41129712_X4_Y2_1786338312_0/a_2122_1638# VSS 1.181320e-19
C222 PMOS_S_41129712_X4_Y2_1786338312_0/a_2122_462# VDD 2.509731e-18
C223 PMOS_S_41129712_X4_Y2_1786338312_0/a_2122_462# VOUT 3.202122e-18
C224 PMOS_S_41129712_X4_Y2_1786338312_0/a_2122_462# VSS 1.181320e-19
C225 PMOS_S_41129712_X4_Y2_1786338312_0/a_2122_462# m1_2290_2744# 2.585520e-18
C226 PMOS_S_41129712_X4_Y2_1786338312_0/a_2122_462# m2_2208_2735# 2.721920e-18
C227 PMOS_S_41129712_X4_Y2_1786338312_0/a_230_462# VDD 5.884920e-20
C228 PMOS_S_41129712_X4_Y2_1786338312_0/a_316_462# VDD 6.933980e-20
C229 PMOS_S_41129712_X4_Y2_1786338312_0/a_488_462# VDD 1.002670e-19
C230 PMOS_S_41129712_X4_Y2_1786338312_0/a_574_462# VDD 1.235190e-19
C231 PMOS_S_41129712_X4_Y2_1786338312_0/a_746_462# VDD 1.986150e-19
C232 PMOS_S_41129712_X4_Y2_1786338312_0/a_832_462# VDD 2.596420e-19
C233 SCM_PMOS_74423661_X4_Y2_1786338313_0/a_1004_1638# m2_2208_2735# 1.014330e-19
C234 SCM_PMOS_74423661_X4_Y2_1786338313_0/a_1004_462# VINN 7.688400e-20
C235 SCM_PMOS_74423661_X4_Y2_1786338313_0/a_1004_462# VOUT 7.710640e-19
C236 SCM_PMOS_74423661_X4_Y2_1786338313_0/a_1004_462# m2_2208_2735# 1.970190e-18
C237 SCM_PMOS_74423661_X4_Y2_1786338313_0/a_1090_462# VINN 6.778960e-20
C238 SCM_PMOS_74423661_X4_Y2_1786338313_0/a_1090_462# VOUT 6.629710e-19
C239 SCM_PMOS_74423661_X4_Y2_1786338313_0/a_1090_462# m2_2208_2735# 1.072900e-18
C240 SCM_PMOS_74423661_X4_Y2_1786338313_0/a_1262_462# VINN 5.379830e-20
C241 SCM_PMOS_74423661_X4_Y2_1786338313_0/a_1262_462# VOUT 5.015910e-19
C242 SCM_PMOS_74423661_X4_Y2_1786338313_0/a_1262_462# m2_2208_2735# 1.072900e-18
C243 SCM_PMOS_74423661_X4_Y2_1786338313_0/a_1348_462# VINN 2.458760e-20
C244 SCM_PMOS_74423661_X4_Y2_1786338313_0/a_1348_462# VOUT 4.410150e-19
C245 SCM_PMOS_74423661_X4_Y2_1786338313_0/a_1348_462# m2_2208_2735# 1.072900e-18
C246 SCM_PMOS_74423661_X4_Y2_1786338313_0/a_1520_462# VOUT 3.475180e-19
C247 SCM_PMOS_74423661_X4_Y2_1786338313_0/a_1520_462# m2_2208_2735# 1.072900e-18
C248 SCM_PMOS_74423661_X4_Y2_1786338313_0/a_1606_462# VOUT 3.111620e-19
C249 SCM_PMOS_74423661_X4_Y2_1786338313_0/a_1606_462# m2_2208_2735# 1.072900e-18
C250 SCM_PMOS_74423661_X4_Y2_1786338313_0/a_1778_462# VOUT 1.014330e-19
C251 SCM_PMOS_74423661_X4_Y2_1786338313_0/a_1778_462# m2_2208_2735# 1.072900e-18
C252 SCM_PMOS_74423661_X4_Y2_1786338313_0/a_1864_462# m2_2208_2735# 1.072900e-18
C253 SCM_PMOS_74423661_X4_Y2_1786338313_0/a_2036_462# m2_2208_2735# 1.072900e-18
C254 SCM_PMOS_74423661_X4_Y2_1786338313_0/a_230_1638# m2_2208_2735# 7.710640e-19
C255 SCM_PMOS_74423661_X4_Y2_1786338313_0/a_230_462# VINN 3.996220e-19
C256 SCM_PMOS_74423661_X4_Y2_1786338313_0/a_230_462# VOUT 3.031190e-18
C257 SCM_PMOS_74423661_X4_Y2_1786338313_0/a_230_462# m1_5160_2828# 8.889980e-20
C258 SCM_PMOS_74423661_X4_Y2_1786338313_0/a_230_462# m2_2208_2735# 1.072900e-18
C259 SCM_PMOS_74423661_X4_Y2_1786338313_0/a_2380_1638# VDD 7.539610e-19
C260 SCM_PMOS_74423661_X4_Y2_1786338313_0/a_2380_462# VDD 4.319250e-18
C261 SCM_PMOS_74423661_X4_Y2_1786338313_0/a_2552_462# VOUT 1.577749e-18
C262 SCM_PMOS_74423661_X4_Y2_1786338313_0/a_316_1638# m2_2208_2735# 6.629710e-19
C263 SCM_PMOS_74423661_X4_Y2_1786338313_0/a_316_462# VINN 3.118080e-19
C264 SCM_PMOS_74423661_X4_Y2_1786338313_0/a_316_462# VOUT 2.823120e-18
C265 SCM_PMOS_74423661_X4_Y2_1786338313_0/a_316_462# m2_2208_2735# 1.072900e-18
C266 SCM_PMOS_74423661_X4_Y2_1786338313_0/a_488_1638# m2_2208_2735# 5.015910e-19
C267 SCM_PMOS_74423661_X4_Y2_1786338313_0/a_488_462# VINN 2.014690e-19
C268 SCM_PMOS_74423661_X4_Y2_1786338313_0/a_488_462# VOUT 2.150140e-18
C269 SCM_PMOS_74423661_X4_Y2_1786338313_0/a_488_462# VSS 2.778120e-19
C270 SCM_PMOS_74423661_X4_Y2_1786338313_0/a_488_462# m2_2208_2735# 1.072900e-18
C271 SCM_PMOS_74423661_X4_Y2_1786338313_0/a_574_1638# m2_2208_2735# 4.410150e-19
C272 SCM_PMOS_74423661_X4_Y2_1786338313_0/a_574_462# VINN 1.662470e-19
C273 SCM_PMOS_74423661_X4_Y2_1786338313_0/a_574_462# VOUT 1.812570e-18
C274 SCM_PMOS_74423661_X4_Y2_1786338313_0/a_574_462# m2_2208_2735# 1.072900e-18
C275 SCM_PMOS_74423661_X4_Y2_1786338313_0/a_746_1638# m2_2208_2735# 3.475180e-19
C276 SCM_PMOS_74423661_X4_Y2_1786338313_0/a_746_462# VINN 1.181320e-19
C277 SCM_PMOS_74423661_X4_Y2_1786338313_0/a_746_462# VOUT 1.270060e-18
C278 SCM_PMOS_74423661_X4_Y2_1786338313_0/a_746_462# m2_2208_2735# 1.072900e-18
C279 SCM_PMOS_74423661_X4_Y2_1786338313_0/a_832_1638# m2_2208_2735# 3.111620e-19
C280 SCM_PMOS_74423661_X4_Y2_1786338313_0/a_832_462# VINN 1.013850e-19
C281 SCM_PMOS_74423661_X4_Y2_1786338313_0/a_832_462# VOUT 1.067910e-18
C282 SCM_PMOS_74423661_X4_Y2_1786338313_0/a_832_462# m2_2208_2735# 1.072900e-18
C283 VBIAS VDD 1.275225e-15
C284 VBIAS VINN 5.714280e-18
C285 VBIAS VINP 5.714280e-18
C286 VBIAS VOUT 4.927667e-16
C287 VBIAS VSS 2.182457e-15
C288 VBIAS m1_2290_2744# 8.770369e-17
C289 VBIAS m1_5160_2828# 4.514611e-16
C290 VBIAS m1_6450_2744# 3.997530e-17
C291 VBIAS m1_6536_2828# 2.300682e-19
C292 VBIAS m2_2208_2735# 1.142216e-16
C293 VDD VINN 4.272305e-17
C294 VDD VINP 3.109289e-19
C295 VDD VOUT 1.155160e-15
C296 VDD VREF 1.305784e-17
C297 VDD VSS 5.464900e-15
C298 VDD m1_2290_2744# 1.204620e-15
C299 VDD m1_5160_2828# 3.000827e-16
C300 VDD m1_6450_2744# 3.499437e-16
C301 VDD m1_6536_2828# 9.630677e-17
C302 VDD m1_7138_2744# 5.243284e-16
C303 VDD m2_2208_2735# 7.654967e-16
C304 VINN VINP 3.124696e-17
C305 VINN VOUT 1.686842e-17
C306 VINN VSS 1.066731e-17
C307 VINN m1_2290_2744# 7.727507e-18
C308 VINN m1_5160_2828# 2.846478e-18
C309 VINN m2_2208_2735# 8.639028e-17
C310 VINP VOUT 4.091188e-17
C311 VINP VSS 5.192601e-17
C312 VINP m1_2290_2744# 5.096449e-20
C313 VINP m1_5160_2828# 1.537183e-18
C314 VINP m1_6536_2828# 8.863100e-19
C315 VINP m1_7138_2744# 1.443990e-19
C316 VINP m2_2208_2735# 2.071617e-17
C317 VOUT VREF 3.600510e-17
C318 VOUT VSS 3.214488e-15
C319 VOUT m1_2290_2744# 6.985782e-16
C320 VOUT m1_5160_2828# 1.874464e-16
C321 VOUT m1_6450_2744# 2.171750e-19
C322 VOUT m1_6536_2828# 2.069960e-18
C323 VOUT m1_7138_2744# 1.959147e-18
C324 VOUT m2_2208_2735# 5.926692e-16
C325 VREF VSS 1.979979e-17
C326 VREF m1_6450_2744# 4.215704e-19
C327 VREF m1_6536_2828# 8.863100e-19
C328 VREF m1_7138_2744# 1.366130e-17
C329 VSS m1_2290_2744# 5.560780e-17
C330 VSS m1_5160_2828# 1.836566e-16
C331 VSS m1_6450_2744# 2.339509e-16
C332 VSS m1_6536_2828# 2.634254e-16
C333 VSS m1_7138_2744# 1.384231e-16
C334 VSS m2_2208_2735# 4.645400e-16
C335 m1_2290_2744# VSS 9.129070e-16
C336 m1_2290_2744# m1_5160_2828# 3.218977e-16
C337 m1_2290_2744# m2_2208_2735# 7.276865e-16
C338 m1_5160_2828# VSS 1.882180e-16
C339 m1_5160_2828# m1_6450_2744# 1.272410e-18
C340 m1_5160_2828# m1_6536_2828# 6.725246e-17
C341 m1_5160_2828# m1_7138_2744# 5.927460e-20
C342 m1_5160_2828# m2_2208_2735# 9.656172e-16
C343 m1_6450_2744# VSS 2.666700e-16
C344 m1_6450_2744# m1_6536_2828# 4.218484e-16
C345 m1_6450_2744# m1_7138_2744# 4.827242e-16
C346 m1_6450_2744# m2_2208_2735# 8.052457e-18
C347 m1_6536_2828# VSS 1.939437e-16
C348 m1_6536_2828# m1_7138_2744# 6.096625e-17
C349 m1_6536_2828# m2_2208_2735# 4.241380e-19
C350 m1_7138_2744# VSS 3.517480e-16
C351 m1_7138_2744# m2_2208_2735# 1.905589e-17
C352 m2_2208_2735# VSS 1.929804e-15
C353 PMOS_S_41129712_X4_Y2_1786338312_0/a_1004_1638# VBIAS 5.316120e-18
C354 PMOS_S_41129712_X4_Y2_1786338312_0/a_1004_1638# VDD 7.704620e-18
C355 PMOS_S_41129712_X4_Y2_1786338312_0/a_1004_1638# VOUT 8.192680e-18
C356 PMOS_S_41129712_X4_Y2_1786338312_0/a_1004_462# VBIAS 2.493000e-18
C357 PMOS_S_41129712_X4_Y2_1786338312_0/a_1004_462# VDD 7.704620e-18
C358 PMOS_S_41129712_X4_Y2_1786338312_0/a_1004_462# VOUT 1.122390e-17
C359 PMOS_S_41129712_X4_Y2_1786338312_0/a_1090_1638# VBIAS 5.524190e-18
C360 PMOS_S_41129712_X4_Y2_1786338312_0/a_1090_1638# VDD 1.036420e-17
C361 PMOS_S_41129712_X4_Y2_1786338312_0/a_1090_1638# VOUT 7.182450e-18
C362 PMOS_S_41129712_X4_Y2_1786338312_0/a_1090_462# VBIAS 2.493000e-18
C363 PMOS_S_41129712_X4_Y2_1786338312_0/a_1090_462# VDD 1.036420e-17
C364 PMOS_S_41129712_X4_Y2_1786338312_0/a_1090_462# VOUT 1.164830e-17
C365 PMOS_S_41129712_X4_Y2_1786338312_0/a_1262_1638# VBIAS 2.493000e-18
C366 PMOS_S_41129712_X4_Y2_1786338312_0/a_1262_1638# VDD 1.647940e-17
C367 PMOS_S_41129712_X4_Y2_1786338312_0/a_1262_1638# VOUT 5.533090e-18
C368 PMOS_S_41129712_X4_Y2_1786338312_0/a_1262_462# VBIAS 2.493000e-18
C369 PMOS_S_41129712_X4_Y2_1786338312_0/a_1262_462# VDD 1.647940e-17
C370 PMOS_S_41129712_X4_Y2_1786338312_0/a_1262_462# VOUT 5.533090e-18
C371 PMOS_S_41129712_X4_Y2_1786338312_0/a_1348_1638# VBIAS 2.493000e-18
C372 PMOS_S_41129712_X4_Y2_1786338312_0/a_1348_1638# VDD 1.073580e-17
C373 PMOS_S_41129712_X4_Y2_1786338312_0/a_1348_1638# VOUT 8.192680e-18
C374 PMOS_S_41129712_X4_Y2_1786338312_0/a_1348_462# VBIAS 2.493000e-18
C375 PMOS_S_41129712_X4_Y2_1786338312_0/a_1348_462# VDD 1.073580e-17
C376 PMOS_S_41129712_X4_Y2_1786338312_0/a_1348_462# VOUT 8.192680e-18
C377 PMOS_S_41129712_X4_Y2_1786338312_0/a_1520_1638# VBIAS 2.493000e-18
C378 PMOS_S_41129712_X4_Y2_1786338312_0/a_1520_1638# VDD 1.020920e-17
C379 PMOS_S_41129712_X4_Y2_1786338312_0/a_1520_1638# VOUT 8.192680e-18
C380 PMOS_S_41129712_X4_Y2_1786338312_0/a_1520_462# VBIAS 2.493000e-18
C381 PMOS_S_41129712_X4_Y2_1786338312_0/a_1520_462# VDD 1.020920e-17
C382 PMOS_S_41129712_X4_Y2_1786338312_0/a_1520_462# VOUT 8.192680e-18
C383 PMOS_S_41129712_X4_Y2_1786338312_0/a_1606_1638# VBIAS 2.493000e-18
C384 PMOS_S_41129712_X4_Y2_1786338312_0/a_1606_1638# VDD 1.251440e-17
C385 PMOS_S_41129712_X4_Y2_1786338312_0/a_1606_1638# VOUT 5.533090e-18
C386 PMOS_S_41129712_X4_Y2_1786338312_0/a_1606_462# VBIAS 2.493000e-18
C387 PMOS_S_41129712_X4_Y2_1786338312_0/a_1606_462# VDD 1.251440e-17
C388 PMOS_S_41129712_X4_Y2_1786338312_0/a_1606_462# VOUT 5.533090e-18
C389 PMOS_S_41129712_X4_Y2_1786338312_0/a_1778_1638# VBIAS 2.493000e-18
C390 PMOS_S_41129712_X4_Y2_1786338312_0/a_1778_1638# VDD 1.188140e-17
C391 PMOS_S_41129712_X4_Y2_1786338312_0/a_1778_1638# VOUT 5.533090e-18
C392 PMOS_S_41129712_X4_Y2_1786338312_0/a_1778_462# VBIAS 2.493000e-18
C393 PMOS_S_41129712_X4_Y2_1786338312_0/a_1778_462# VDD 1.188140e-17
C394 PMOS_S_41129712_X4_Y2_1786338312_0/a_1778_462# VOUT 5.533090e-18
C395 PMOS_S_41129712_X4_Y2_1786338312_0/a_1864_1638# VBIAS 2.493000e-18
C396 PMOS_S_41129712_X4_Y2_1786338312_0/a_1864_1638# VDD 8.974680e-18
C397 PMOS_S_41129712_X4_Y2_1786338312_0/a_1864_1638# VOUT 8.192680e-18
C398 PMOS_S_41129712_X4_Y2_1786338312_0/a_1864_462# VBIAS 2.493000e-18
C399 PMOS_S_41129712_X4_Y2_1786338312_0/a_1864_462# VDD 8.974680e-18
C400 PMOS_S_41129712_X4_Y2_1786338312_0/a_1864_462# VOUT 8.192680e-18
C401 PMOS_S_41129712_X4_Y2_1786338312_0/a_2036_1638# VDD 8.608570e-18
C402 PMOS_S_41129712_X4_Y2_1786338312_0/a_2036_1638# VOUT 8.192680e-18
C403 PMOS_S_41129712_X4_Y2_1786338312_0/a_2036_462# VDD 9.358130e-18
C404 PMOS_S_41129712_X4_Y2_1786338312_0/a_2036_462# VOUT 8.192680e-18
C405 PMOS_S_41129712_X4_Y2_1786338312_0/a_2122_1638# VDD 1.113530e-17
C406 PMOS_S_41129712_X4_Y2_1786338312_0/a_2122_1638# VOUT 5.533090e-18
C407 PMOS_S_41129712_X4_Y2_1786338312_0/a_2122_462# VDD 1.188480e-17
C408 PMOS_S_41129712_X4_Y2_1786338312_0/a_2122_462# VOUT 5.533090e-18
C409 PMOS_S_41129712_X4_Y2_1786338312_0/a_230_1638# VBIAS 6.629710e-19
C410 PMOS_S_41129712_X4_Y2_1786338312_0/a_230_1638# VDD 1.036420e-17
C411 PMOS_S_41129712_X4_Y2_1786338312_0/a_230_1638# VOUT 5.533090e-18
C412 PMOS_S_41129712_X4_Y2_1786338312_0/a_230_462# VDD 1.111380e-17
C413 PMOS_S_41129712_X4_Y2_1786338312_0/a_230_462# VOUT 6.304150e-18
C414 PMOS_S_41129712_X4_Y2_1786338312_0/a_316_1638# VBIAS 7.710640e-19
C415 PMOS_S_41129712_X4_Y2_1786338312_0/a_316_1638# VDD 7.704620e-18
C416 PMOS_S_41129712_X4_Y2_1786338312_0/a_316_1638# VOUT 8.192680e-18
C417 PMOS_S_41129712_X4_Y2_1786338312_0/a_316_462# VDD 8.454180e-18
C418 PMOS_S_41129712_X4_Y2_1786338312_0/a_316_462# VOUT 9.096630e-18
C419 PMOS_S_41129712_X4_Y2_1786338312_0/a_488_1638# VBIAS 3.560910e-18
C420 PMOS_S_41129712_X4_Y2_1786338312_0/a_488_1638# VDD 7.704620e-18
C421 PMOS_S_41129712_X4_Y2_1786338312_0/a_488_1638# VOUT 8.192680e-18
C422 PMOS_S_41129712_X4_Y2_1786338312_0/a_488_462# VBIAS 2.493000e-18
C423 PMOS_S_41129712_X4_Y2_1786338312_0/a_488_462# VDD 7.704620e-18
C424 PMOS_S_41129712_X4_Y2_1786338312_0/a_488_462# VOUT 9.462750e-18
C425 PMOS_S_41129712_X4_Y2_1786338312_0/a_574_1638# VBIAS 3.763060e-18
C426 PMOS_S_41129712_X4_Y2_1786338312_0/a_574_1638# VDD 1.036420e-17
C427 PMOS_S_41129712_X4_Y2_1786338312_0/a_574_1638# VOUT 5.533090e-18
C428 PMOS_S_41129712_X4_Y2_1786338312_0/a_574_462# VBIAS 2.493000e-18
C429 PMOS_S_41129712_X4_Y2_1786338312_0/a_574_462# VDD 1.036420e-17
C430 PMOS_S_41129712_X4_Y2_1786338312_0/a_574_462# VOUT 7.050240e-18
C431 PMOS_S_41129712_X4_Y2_1786338312_0/a_746_1638# VBIAS 4.305570e-18
C432 PMOS_S_41129712_X4_Y2_1786338312_0/a_746_1638# VDD 1.036420e-17
C433 PMOS_S_41129712_X4_Y2_1786338312_0/a_746_1638# VOUT 5.533090e-18
C434 PMOS_S_41129712_X4_Y2_1786338312_0/a_746_462# VBIAS 2.493000e-18
C435 PMOS_S_41129712_X4_Y2_1786338312_0/a_746_462# VDD 1.036420e-17
C436 PMOS_S_41129712_X4_Y2_1786338312_0/a_746_462# VOUT 7.683220e-18
C437 PMOS_S_41129712_X4_Y2_1786338312_0/a_832_1638# VBIAS 4.643140e-18
C438 PMOS_S_41129712_X4_Y2_1786338312_0/a_832_1638# VDD 7.704620e-18
C439 PMOS_S_41129712_X4_Y2_1786338312_0/a_832_1638# VOUT 8.192680e-18
C440 PMOS_S_41129712_X4_Y2_1786338312_0/a_832_462# VBIAS 2.493000e-18
C441 PMOS_S_41129712_X4_Y2_1786338312_0/a_832_462# VDD 7.704620e-18
C442 PMOS_S_41129712_X4_Y2_1786338312_0/a_832_462# VOUT 1.069730e-17
C443 VBIAS VDD 1.169330e-14
C444 VBIAS VOUT 1.678080e-15
C445 VBIAS VSS 1.198640e-15
C446 VDD VOUT 5.007640e-15
C447 VDD VSS 1.941730e-14
C448 VOUT VSS 4.512760e-16
C449 DOUT VDD 3.525100e-17
C450 DOUT VSS 1.843831e-16
C451 DOUT m1_7138_2744# 2.436128e-16
C452 VDD VSS 1.429702e-17
C453 VDD m1_7138_2744# 5.717783e-16
C454 VSS m1_7138_2744# 4.992345e-16
C455 m1_7138_2744# VSS 8.465830e-16
C456 DOUT VSS 8.486980e-16
C457 DOUT m1_7138_2744# 9.706250e-17
C458 m1_7138_2744# VSS 8.560650e-16
C459 DOUT VDD 1.475790e-15
C460 DOUT VSS 7.872840e-17
C461 DOUT m1_7138_2744# 1.850510e-16
C462 VDD VSS 3.692110e-15
C463 VDD m1_7138_2744# 1.147720e-15
C464 m1_7138_2744# VSS 2.186250e-16
C465 VBIAS VSS 1.366340e-15
C466 VBIAS m1_6536_2828# 1.850510e-16
C467 m1_6536_2828# VSS 1.554520e-15
C468 VREF VSS 7.252440e-16
C469 VREF m1_6536_2828# 9.332410e-17
C470 VREF m1_7138_2744# 9.706250e-17
C471 m1_6536_2828# VSS 4.328010e-16
C472 m1_6536_2828# m1_7138_2744# 7.009300e-16
C473 m1_7138_2744# VSS 1.316880e-16
C474 VOUT VSS 7.252440e-16
C475 VOUT m1_6450_2744# 9.706250e-17
C476 VOUT m1_6536_2828# 9.332410e-17
C477 m1_6450_2744# VSS 1.316880e-16
C478 m1_6450_2744# m1_6536_2828# 7.009300e-16
C479 m1_6536_2828# VSS 4.328010e-16
C480 NMOS_4T_97698174_X1_Y1_1786338308_0/a_230_462# VINP 2.493000e-18
C481 NMOS_4T_97698174_X1_Y1_1786338308_0/a_230_462# m1_5160_2828# 1.036420e-17
C482 NMOS_4T_97698174_X1_Y1_1786338308_0/a_230_462# m2_2208_2735# 5.533090e-18
C483 NMOS_4T_97698174_X1_Y1_1786338308_0/a_316_462# VINP 2.493000e-18
C484 NMOS_4T_97698174_X1_Y1_1786338308_0/a_316_462# m1_5160_2828# 7.704620e-18
C485 NMOS_4T_97698174_X1_Y1_1786338308_0/a_316_462# m2_2208_2735# 8.192680e-18
C486 NMOS_4T_97698174_X1_Y1_1786338308_0/a_488_462# m1_5160_2828# 7.704620e-18
C487 NMOS_4T_97698174_X1_Y1_1786338308_0/a_488_462# m2_2208_2735# 8.192680e-18
C488 NMOS_4T_97698174_X1_Y1_1786338308_0/a_574_462# m1_5160_2828# 1.036420e-17
C489 NMOS_4T_97698174_X1_Y1_1786338308_0/a_574_462# m2_2208_2735# 5.533090e-18
C490 VINP VSS 1.474260e-15
C491 VINP m1_5160_2828# 1.495340e-16
C492 VINP m2_2208_2735# 1.294170e-16
C493 m1_5160_2828# VSS 5.918520e-16
C494 m1_5160_2828# m2_2208_2735# 3.365820e-16
C495 m2_2208_2735# VSS 1.749920e-16
C496 NMOS_4T_97698174_X1_Y1_1786338308_1/a_230_462# VINN 2.493000e-18
C497 NMOS_4T_97698174_X1_Y1_1786338308_1/a_230_462# m1_2290_2744# 5.533090e-18
C498 NMOS_4T_97698174_X1_Y1_1786338308_1/a_230_462# m1_5160_2828# 1.036420e-17
C499 NMOS_4T_97698174_X1_Y1_1786338308_1/a_316_462# VINN 2.493000e-18
C500 NMOS_4T_97698174_X1_Y1_1786338308_1/a_316_462# m1_2290_2744# 8.192680e-18
C501 NMOS_4T_97698174_X1_Y1_1786338308_1/a_316_462# m1_5160_2828# 7.704620e-18
C502 NMOS_4T_97698174_X1_Y1_1786338308_1/a_488_462# m1_2290_2744# 8.192680e-18
C503 NMOS_4T_97698174_X1_Y1_1786338308_1/a_488_462# m1_5160_2828# 7.704620e-18
C504 NMOS_4T_97698174_X1_Y1_1786338308_1/a_574_462# m1_2290_2744# 5.533090e-18
C505 NMOS_4T_97698174_X1_Y1_1786338308_1/a_574_462# m1_5160_2828# 1.036420e-17
C506 VINN VSS 1.474260e-15
C507 VINN m1_2290_2744# 1.294170e-16
C508 VINN m1_5160_2828# 1.495340e-16
C509 m1_2290_2744# VSS 1.749920e-16
C510 m1_2290_2744# m1_5160_2828# 3.365820e-16
C511 m1_5160_2828# VSS 5.918520e-16
C512 VOUT VSS 4.161380e-16
C513 VOUT m2_2208_2735# 2.238100e-16
C514 m2_2208_2735# VSS 3.976620e-16
C515 NMOS_S_26850855_X4_Y2_1786338309_0/a_1004_1638# VBIAS 5.316120e-18
C516 NMOS_S_26850855_X4_Y2_1786338309_0/a_1004_1638# VSS 7.704620e-18
C517 NMOS_S_26850855_X4_Y2_1786338309_0/a_1004_1638# m1_5160_2828# 8.192680e-18
C518 NMOS_S_26850855_X4_Y2_1786338309_0/a_1004_462# VBIAS 2.493000e-18
C519 NMOS_S_26850855_X4_Y2_1786338309_0/a_1004_462# VSS 7.704620e-18
C520 NMOS_S_26850855_X4_Y2_1786338309_0/a_1004_462# m1_5160_2828# 1.122390e-17
C521 NMOS_S_26850855_X4_Y2_1786338309_0/a_1090_1638# VBIAS 5.524190e-18
C522 NMOS_S_26850855_X4_Y2_1786338309_0/a_1090_1638# VSS 1.036420e-17
C523 NMOS_S_26850855_X4_Y2_1786338309_0/a_1090_1638# m1_5160_2828# 7.182450e-18
C524 NMOS_S_26850855_X4_Y2_1786338309_0/a_1090_462# VBIAS 2.493000e-18
C525 NMOS_S_26850855_X4_Y2_1786338309_0/a_1090_462# VSS 1.036420e-17
C526 NMOS_S_26850855_X4_Y2_1786338309_0/a_1090_462# m1_5160_2828# 1.164830e-17
C527 NMOS_S_26850855_X4_Y2_1786338309_0/a_1262_1638# VBIAS 2.493000e-18
C528 NMOS_S_26850855_X4_Y2_1786338309_0/a_1262_1638# VSS 1.647940e-17
C529 NMOS_S_26850855_X4_Y2_1786338309_0/a_1262_1638# m1_5160_2828# 5.533090e-18
C530 NMOS_S_26850855_X4_Y2_1786338309_0/a_1262_462# VBIAS 2.493000e-18
C531 NMOS_S_26850855_X4_Y2_1786338309_0/a_1262_462# VSS 1.647940e-17
C532 NMOS_S_26850855_X4_Y2_1786338309_0/a_1262_462# m1_5160_2828# 5.533090e-18
C533 NMOS_S_26850855_X4_Y2_1786338309_0/a_1348_1638# VBIAS 2.493000e-18
C534 NMOS_S_26850855_X4_Y2_1786338309_0/a_1348_1638# VSS 1.073580e-17
C535 NMOS_S_26850855_X4_Y2_1786338309_0/a_1348_1638# m1_5160_2828# 8.192680e-18
C536 NMOS_S_26850855_X4_Y2_1786338309_0/a_1348_462# VBIAS 2.493000e-18
C537 NMOS_S_26850855_X4_Y2_1786338309_0/a_1348_462# VSS 1.073580e-17
C538 NMOS_S_26850855_X4_Y2_1786338309_0/a_1348_462# m1_5160_2828# 8.192680e-18
C539 NMOS_S_26850855_X4_Y2_1786338309_0/a_1520_1638# VBIAS 2.493000e-18
C540 NMOS_S_26850855_X4_Y2_1786338309_0/a_1520_1638# VSS 1.020920e-17
C541 NMOS_S_26850855_X4_Y2_1786338309_0/a_1520_1638# m1_5160_2828# 8.192680e-18
C542 NMOS_S_26850855_X4_Y2_1786338309_0/a_1520_462# VBIAS 2.493000e-18
C543 NMOS_S_26850855_X4_Y2_1786338309_0/a_1520_462# VSS 1.020920e-17
C544 NMOS_S_26850855_X4_Y2_1786338309_0/a_1520_462# m1_5160_2828# 8.192680e-18
C545 NMOS_S_26850855_X4_Y2_1786338309_0/a_1606_1638# VBIAS 2.493000e-18
C546 NMOS_S_26850855_X4_Y2_1786338309_0/a_1606_1638# VSS 1.251440e-17
C547 NMOS_S_26850855_X4_Y2_1786338309_0/a_1606_1638# m1_5160_2828# 5.533090e-18
C548 NMOS_S_26850855_X4_Y2_1786338309_0/a_1606_462# VBIAS 2.493000e-18
C549 NMOS_S_26850855_X4_Y2_1786338309_0/a_1606_462# VSS 1.251440e-17
C550 NMOS_S_26850855_X4_Y2_1786338309_0/a_1606_462# m1_5160_2828# 5.533090e-18
C551 NMOS_S_26850855_X4_Y2_1786338309_0/a_1778_1638# VBIAS 2.493000e-18
C552 NMOS_S_26850855_X4_Y2_1786338309_0/a_1778_1638# VSS 1.188140e-17
C553 NMOS_S_26850855_X4_Y2_1786338309_0/a_1778_1638# m1_5160_2828# 5.533090e-18
C554 NMOS_S_26850855_X4_Y2_1786338309_0/a_1778_462# VBIAS 2.493000e-18
C555 NMOS_S_26850855_X4_Y2_1786338309_0/a_1778_462# VSS 1.188140e-17
C556 NMOS_S_26850855_X4_Y2_1786338309_0/a_1778_462# m1_5160_2828# 5.533090e-18
C557 NMOS_S_26850855_X4_Y2_1786338309_0/a_1864_1638# VBIAS 2.493000e-18
C558 NMOS_S_26850855_X4_Y2_1786338309_0/a_1864_1638# VSS 8.974680e-18
C559 NMOS_S_26850855_X4_Y2_1786338309_0/a_1864_1638# m1_5160_2828# 8.192680e-18
C560 NMOS_S_26850855_X4_Y2_1786338309_0/a_1864_462# VBIAS 2.493000e-18
C561 NMOS_S_26850855_X4_Y2_1786338309_0/a_1864_462# VSS 8.974680e-18
C562 NMOS_S_26850855_X4_Y2_1786338309_0/a_1864_462# m1_5160_2828# 8.192680e-18
C563 NMOS_S_26850855_X4_Y2_1786338309_0/a_2036_1638# VSS 8.608570e-18
C564 NMOS_S_26850855_X4_Y2_1786338309_0/a_2036_1638# m1_5160_2828# 8.192680e-18
C565 NMOS_S_26850855_X4_Y2_1786338309_0/a_2036_462# VSS 9.358130e-18
C566 NMOS_S_26850855_X4_Y2_1786338309_0/a_2036_462# m1_5160_2828# 8.192680e-18
C567 NMOS_S_26850855_X4_Y2_1786338309_0/a_2122_1638# VSS 1.113530e-17
C568 NMOS_S_26850855_X4_Y2_1786338309_0/a_2122_1638# m1_5160_2828# 5.533090e-18
C569 NMOS_S_26850855_X4_Y2_1786338309_0/a_2122_462# VSS 1.188480e-17
C570 NMOS_S_26850855_X4_Y2_1786338309_0/a_2122_462# m1_5160_2828# 5.533090e-18
C571 NMOS_S_26850855_X4_Y2_1786338309_0/a_230_1638# VBIAS 6.629710e-19
C572 NMOS_S_26850855_X4_Y2_1786338309_0/a_230_1638# VSS 1.036420e-17
C573 NMOS_S_26850855_X4_Y2_1786338309_0/a_230_1638# m1_5160_2828# 5.533090e-18
C574 NMOS_S_26850855_X4_Y2_1786338309_0/a_230_462# VSS 1.111380e-17
C575 NMOS_S_26850855_X4_Y2_1786338309_0/a_230_462# m1_5160_2828# 6.304150e-18
C576 NMOS_S_26850855_X4_Y2_1786338309_0/a_316_1638# VBIAS 7.710640e-19
C577 NMOS_S_26850855_X4_Y2_1786338309_0/a_316_1638# VSS 7.704620e-18
C578 NMOS_S_26850855_X4_Y2_1786338309_0/a_316_1638# m1_5160_2828# 8.192680e-18
C579 NMOS_S_26850855_X4_Y2_1786338309_0/a_316_462# VSS 8.454180e-18
C580 NMOS_S_26850855_X4_Y2_1786338309_0/a_316_462# m1_5160_2828# 9.096630e-18
C581 NMOS_S_26850855_X4_Y2_1786338309_0/a_488_1638# VBIAS 3.560910e-18
C582 NMOS_S_26850855_X4_Y2_1786338309_0/a_488_1638# VSS 7.704620e-18
C583 NMOS_S_26850855_X4_Y2_1786338309_0/a_488_1638# m1_5160_2828# 8.192680e-18
C584 NMOS_S_26850855_X4_Y2_1786338309_0/a_488_462# VBIAS 2.493000e-18
C585 NMOS_S_26850855_X4_Y2_1786338309_0/a_488_462# VSS 7.704620e-18
C586 NMOS_S_26850855_X4_Y2_1786338309_0/a_488_462# m1_5160_2828# 9.462750e-18
C587 NMOS_S_26850855_X4_Y2_1786338309_0/a_574_1638# VBIAS 3.763060e-18
C588 NMOS_S_26850855_X4_Y2_1786338309_0/a_574_1638# VSS 1.036420e-17
C589 NMOS_S_26850855_X4_Y2_1786338309_0/a_574_1638# m1_5160_2828# 5.533090e-18
C590 NMOS_S_26850855_X4_Y2_1786338309_0/a_574_462# VBIAS 2.493000e-18
C591 NMOS_S_26850855_X4_Y2_1786338309_0/a_574_462# VSS 1.036420e-17
C592 NMOS_S_26850855_X4_Y2_1786338309_0/a_574_462# m1_5160_2828# 7.050240e-18
C593 NMOS_S_26850855_X4_Y2_1786338309_0/a_746_1638# VBIAS 4.305570e-18
C594 NMOS_S_26850855_X4_Y2_1786338309_0/a_746_1638# VSS 1.036420e-17
C595 NMOS_S_26850855_X4_Y2_1786338309_0/a_746_1638# m1_5160_2828# 5.533090e-18
C596 NMOS_S_26850855_X4_Y2_1786338309_0/a_746_462# VBIAS 2.493000e-18
C597 NMOS_S_26850855_X4_Y2_1786338309_0/a_746_462# VSS 1.036420e-17
C598 NMOS_S_26850855_X4_Y2_1786338309_0/a_746_462# m1_5160_2828# 7.683220e-18
C599 NMOS_S_26850855_X4_Y2_1786338309_0/a_832_1638# VBIAS 4.643140e-18
C600 NMOS_S_26850855_X4_Y2_1786338309_0/a_832_1638# VSS 7.704620e-18
C601 NMOS_S_26850855_X4_Y2_1786338309_0/a_832_1638# m1_5160_2828# 8.192680e-18
C602 NMOS_S_26850855_X4_Y2_1786338309_0/a_832_462# VBIAS 2.493000e-18
C603 NMOS_S_26850855_X4_Y2_1786338309_0/a_832_462# VSS 7.704620e-18
C604 NMOS_S_26850855_X4_Y2_1786338309_0/a_832_462# m1_5160_2828# 1.069730e-17
C605 VBIAS VSS 1.289190e-14
C606 VBIAS m1_5160_2828# 1.678080e-15
C607 m1_5160_2828# VSS 5.458920e-15
C608 VDD VSS 5.084450e-15
C609 VDD m1_6450_2744# 3.969370e-15
C610 VDD m1_7138_2744# 1.465700e-15
C611 m1_6450_2744# VSS 5.677430e-16
C612 m1_6450_2744# m1_7138_2744# 4.124300e-16
C613 m1_7138_2744# VSS 2.841330e-17
C614 NMOS_S_64076268_X4_Y1_1786338310_0/a_1004_462# VOUT 8.192680e-18
C615 NMOS_S_64076268_X4_Y1_1786338310_0/a_1004_462# VSS 1.020920e-17
C616 NMOS_S_64076268_X4_Y1_1786338310_0/a_1004_462# m2_2208_2735# 2.493000e-18
C617 NMOS_S_64076268_X4_Y1_1786338310_0/a_1090_462# VOUT 5.533090e-18
C618 NMOS_S_64076268_X4_Y1_1786338310_0/a_1090_462# VSS 1.318730e-17
C619 NMOS_S_64076268_X4_Y1_1786338310_0/a_1090_462# m2_2208_2735# 2.493000e-18
C620 NMOS_S_64076268_X4_Y1_1786338310_0/a_1262_462# VOUT 5.533090e-18
C621 NMOS_S_64076268_X4_Y1_1786338310_0/a_1262_462# VSS 1.647940e-17
C622 NMOS_S_64076268_X4_Y1_1786338310_0/a_1262_462# m2_2208_2735# 2.493000e-18
C623 NMOS_S_64076268_X4_Y1_1786338310_0/a_1348_462# VOUT 8.192680e-18
C624 NMOS_S_64076268_X4_Y1_1786338310_0/a_1348_462# VSS 1.073580e-17
C625 NMOS_S_64076268_X4_Y1_1786338310_0/a_1348_462# m2_2208_2735# 2.493000e-18
C626 NMOS_S_64076268_X4_Y1_1786338310_0/a_1520_462# VOUT 8.192680e-18
C627 NMOS_S_64076268_X4_Y1_1786338310_0/a_1520_462# VSS 1.020920e-17
C628 NMOS_S_64076268_X4_Y1_1786338310_0/a_1520_462# m2_2208_2735# 2.493000e-18
C629 NMOS_S_64076268_X4_Y1_1786338310_0/a_1606_462# VOUT 5.533090e-18
C630 NMOS_S_64076268_X4_Y1_1786338310_0/a_1606_462# VSS 1.251440e-17
C631 NMOS_S_64076268_X4_Y1_1786338310_0/a_1606_462# m2_2208_2735# 2.493000e-18
C632 NMOS_S_64076268_X4_Y1_1786338310_0/a_1778_462# VOUT 5.533090e-18
C633 NMOS_S_64076268_X4_Y1_1786338310_0/a_1778_462# VSS 1.188140e-17
C634 NMOS_S_64076268_X4_Y1_1786338310_0/a_1778_462# m2_2208_2735# 2.493000e-18
C635 NMOS_S_64076268_X4_Y1_1786338310_0/a_1864_462# VOUT 8.192680e-18
C636 NMOS_S_64076268_X4_Y1_1786338310_0/a_1864_462# VSS 8.974680e-18
C637 NMOS_S_64076268_X4_Y1_1786338310_0/a_1864_462# m2_2208_2735# 2.493000e-18
C638 NMOS_S_64076268_X4_Y1_1786338310_0/a_2036_462# VOUT 8.192680e-18
C639 NMOS_S_64076268_X4_Y1_1786338310_0/a_2036_462# VSS 8.608570e-18
C640 NMOS_S_64076268_X4_Y1_1786338310_0/a_2122_462# VOUT 5.533090e-18
C641 NMOS_S_64076268_X4_Y1_1786338310_0/a_2122_462# VSS 1.113530e-17
C642 NMOS_S_64076268_X4_Y1_1786338310_0/a_230_462# VOUT 5.533090e-18
C643 NMOS_S_64076268_X4_Y1_1786338310_0/a_230_462# VSS 1.093870e-17
C644 NMOS_S_64076268_X4_Y1_1786338310_0/a_316_462# VOUT 8.192680e-18
C645 NMOS_S_64076268_X4_Y1_1786338310_0/a_316_462# VSS 8.367590e-18
C646 NMOS_S_64076268_X4_Y1_1786338310_0/a_488_462# VOUT 8.192680e-18
C647 NMOS_S_64076268_X4_Y1_1786338310_0/a_488_462# VSS 8.608570e-18
C648 NMOS_S_64076268_X4_Y1_1786338310_0/a_488_462# m2_2208_2735# 2.493000e-18
C649 NMOS_S_64076268_X4_Y1_1786338310_0/a_574_462# VOUT 5.533090e-18
C650 NMOS_S_64076268_X4_Y1_1786338310_0/a_574_462# VSS 1.143210e-17
C651 NMOS_S_64076268_X4_Y1_1786338310_0/a_574_462# m2_2208_2735# 2.493000e-18
C652 NMOS_S_64076268_X4_Y1_1786338310_0/a_746_462# VOUT 5.533090e-18
C653 NMOS_S_64076268_X4_Y1_1786338310_0/a_746_462# VSS 1.188140e-17
C654 NMOS_S_64076268_X4_Y1_1786338310_0/a_746_462# m2_2208_2735# 2.493000e-18
C655 NMOS_S_64076268_X4_Y1_1786338310_0/a_832_462# VOUT 8.192680e-18
C656 NMOS_S_64076268_X4_Y1_1786338310_0/a_832_462# VSS 9.517190e-18
C657 NMOS_S_64076268_X4_Y1_1786338310_0/a_832_462# m2_2208_2735# 2.493000e-18
C658 VOUT VSS 2.577800e-15
C659 VOUT m2_2208_2735# 5.201260e-16
C660 m2_2208_2735# VSS 6.187820e-15
C661 SCM_PMOS_74423661_X4_Y2_1786338313_0/a_1004_1638# VDD 8.395320e-18
C662 SCM_PMOS_74423661_X4_Y2_1786338313_0/a_1004_1638# m1_2290_2744# 1.118730e-17
C663 SCM_PMOS_74423661_X4_Y2_1786338313_0/a_1004_462# VDD 8.395320e-18
C664 SCM_PMOS_74423661_X4_Y2_1786338313_0/a_1004_462# m1_2290_2744# 2.994590e-18
C665 SCM_PMOS_74423661_X4_Y2_1786338313_0/a_1004_462# m2_2208_2735# 8.192680e-18
C666 SCM_PMOS_74423661_X4_Y2_1786338313_0/a_1090_1638# VDD 1.105490e-17
C667 SCM_PMOS_74423661_X4_Y2_1786338313_0/a_1090_1638# m1_2290_2744# 8.600600e-18
C668 SCM_PMOS_74423661_X4_Y2_1786338313_0/a_1090_462# VDD 1.105490e-17
C669 SCM_PMOS_74423661_X4_Y2_1786338313_0/a_1090_462# m1_2290_2744# 3.067510e-18
C670 SCM_PMOS_74423661_X4_Y2_1786338313_0/a_1090_462# m2_2208_2735# 5.533090e-18
C671 SCM_PMOS_74423661_X4_Y2_1786338313_0/a_1262_1638# VDD 1.105490e-17
C672 SCM_PMOS_74423661_X4_Y2_1786338313_0/a_1262_1638# m1_2290_2744# 8.797150e-18
C673 SCM_PMOS_74423661_X4_Y2_1786338313_0/a_1262_462# VDD 1.105490e-17
C674 SCM_PMOS_74423661_X4_Y2_1786338313_0/a_1262_462# m1_2290_2744# 3.264060e-18
C675 SCM_PMOS_74423661_X4_Y2_1786338313_0/a_1262_462# m2_2208_2735# 5.533090e-18
C676 SCM_PMOS_74423661_X4_Y2_1786338313_0/a_1348_1638# VDD 8.395320e-18
C677 SCM_PMOS_74423661_X4_Y2_1786338313_0/a_1348_1638# m1_2290_2744# 1.158960e-17
C678 SCM_PMOS_74423661_X4_Y2_1786338313_0/a_1348_462# VDD 8.395320e-18
C679 SCM_PMOS_74423661_X4_Y2_1786338313_0/a_1348_462# m1_2290_2744# 3.396950e-18
C680 SCM_PMOS_74423661_X4_Y2_1786338313_0/a_1348_462# m2_2208_2735# 8.192680e-18
C681 SCM_PMOS_74423661_X4_Y2_1786338313_0/a_1520_1638# VDD 8.395320e-18
C682 SCM_PMOS_74423661_X4_Y2_1786338313_0/a_1520_1638# m1_2290_2744# 1.195570e-17
C683 SCM_PMOS_74423661_X4_Y2_1786338313_0/a_1520_462# VDD 8.395320e-18
C684 SCM_PMOS_74423661_X4_Y2_1786338313_0/a_1520_462# m1_2290_2744# 3.763060e-18
C685 SCM_PMOS_74423661_X4_Y2_1786338313_0/a_1520_462# m2_2208_2735# 8.192680e-18
C686 SCM_PMOS_74423661_X4_Y2_1786338313_0/a_1606_1638# VDD 1.105490e-17
C687 SCM_PMOS_74423661_X4_Y2_1786338313_0/a_1606_1638# m1_2290_2744# 9.543240e-18
C688 SCM_PMOS_74423661_X4_Y2_1786338313_0/a_1606_462# VDD 1.105490e-17
C689 SCM_PMOS_74423661_X4_Y2_1786338313_0/a_1606_462# m1_2290_2744# 4.010160e-18
C690 SCM_PMOS_74423661_X4_Y2_1786338313_0/a_1606_462# m2_2208_2735# 5.533090e-18
C691 SCM_PMOS_74423661_X4_Y2_1786338313_0/a_1778_1638# VDD 1.105490e-17
C692 SCM_PMOS_74423661_X4_Y2_1786338313_0/a_1778_1638# m1_2290_2744# 4.643140e-18
C693 SCM_PMOS_74423661_X4_Y2_1786338313_0/a_1778_1638# m2_2208_2735# 5.533090e-18
C694 SCM_PMOS_74423661_X4_Y2_1786338313_0/a_1778_462# VDD 1.105490e-17
C695 SCM_PMOS_74423661_X4_Y2_1786338313_0/a_1778_462# m1_2290_2744# 1.017620e-17
C696 SCM_PMOS_74423661_X4_Y2_1786338313_0/a_1864_1638# VDD 8.395320e-18
C697 SCM_PMOS_74423661_X4_Y2_1786338313_0/a_1864_1638# m1_2290_2744# 4.997590e-18
C698 SCM_PMOS_74423661_X4_Y2_1786338313_0/a_1864_1638# m2_2208_2735# 8.192680e-18
C699 SCM_PMOS_74423661_X4_Y2_1786338313_0/a_1864_462# VDD 8.395320e-18
C700 SCM_PMOS_74423661_X4_Y2_1786338313_0/a_1864_462# m1_2290_2744# 1.319030e-17
C701 SCM_PMOS_74423661_X4_Y2_1786338313_0/a_2036_1638# VDD 8.395320e-18
C702 SCM_PMOS_74423661_X4_Y2_1786338313_0/a_2036_1638# m1_2290_2744# 5.524190e-18
C703 SCM_PMOS_74423661_X4_Y2_1786338313_0/a_2036_1638# m2_2208_2735# 8.192680e-18
C704 SCM_PMOS_74423661_X4_Y2_1786338313_0/a_2036_462# VDD 8.395320e-18
C705 SCM_PMOS_74423661_X4_Y2_1786338313_0/a_2036_462# m1_2290_2744# 1.371690e-17
C706 SCM_PMOS_74423661_X4_Y2_1786338313_0/a_2122_1638# VDD 1.105490e-17
C707 SCM_PMOS_74423661_X4_Y2_1786338313_0/a_2122_1638# m1_2290_2744# 8.608200e-18
C708 SCM_PMOS_74423661_X4_Y2_1786338313_0/a_2122_1638# m2_2208_2735# 5.533090e-18
C709 SCM_PMOS_74423661_X4_Y2_1786338313_0/a_2122_462# VDD 1.105490e-17
C710 SCM_PMOS_74423661_X4_Y2_1786338313_0/a_2122_462# m1_2290_2744# 1.414130e-17
C711 SCM_PMOS_74423661_X4_Y2_1786338313_0/a_2294_1638# VDD 1.717010e-17
C712 SCM_PMOS_74423661_X4_Y2_1786338313_0/a_2294_1638# m1_2290_2744# 2.493000e-18
C713 SCM_PMOS_74423661_X4_Y2_1786338313_0/a_2294_1638# m2_2208_2735# 5.533090e-18
C714 SCM_PMOS_74423661_X4_Y2_1786338313_0/a_2294_462# VDD 1.717010e-17
C715 SCM_PMOS_74423661_X4_Y2_1786338313_0/a_2294_462# m1_2290_2744# 8.026090e-18
C716 SCM_PMOS_74423661_X4_Y2_1786338313_0/a_230_1638# VDD 1.105490e-17
C717 SCM_PMOS_74423661_X4_Y2_1786338313_0/a_230_1638# m2_2208_2735# 5.533090e-18
C718 SCM_PMOS_74423661_X4_Y2_1786338313_0/a_230_462# VDD 1.167600e-17
C719 SCM_PMOS_74423661_X4_Y2_1786338313_0/a_230_462# m1_2290_2744# 5.533090e-18
C720 SCM_PMOS_74423661_X4_Y2_1786338313_0/a_2380_1638# VDD 1.142650e-17
C721 SCM_PMOS_74423661_X4_Y2_1786338313_0/a_2380_1638# m1_2290_2744# 2.493000e-18
C722 SCM_PMOS_74423661_X4_Y2_1786338313_0/a_2380_1638# m2_2208_2735# 8.192680e-18
C723 SCM_PMOS_74423661_X4_Y2_1786338313_0/a_2380_462# VDD 1.142650e-17
C724 SCM_PMOS_74423661_X4_Y2_1786338313_0/a_2380_462# m1_2290_2744# 1.068570e-17
C725 SCM_PMOS_74423661_X4_Y2_1786338313_0/a_2552_1638# VDD 1.089990e-17
C726 SCM_PMOS_74423661_X4_Y2_1786338313_0/a_2552_1638# m1_2290_2744# 2.493000e-18
C727 SCM_PMOS_74423661_X4_Y2_1786338313_0/a_2552_1638# m2_2208_2735# 8.192680e-18
C728 SCM_PMOS_74423661_X4_Y2_1786338313_0/a_2552_462# VDD 1.089990e-17
C729 SCM_PMOS_74423661_X4_Y2_1786338313_0/a_2552_462# m1_2290_2744# 1.068570e-17
C730 SCM_PMOS_74423661_X4_Y2_1786338313_0/a_2638_1638# VDD 1.320500e-17
C731 SCM_PMOS_74423661_X4_Y2_1786338313_0/a_2638_1638# m1_2290_2744# 2.493000e-18
C732 SCM_PMOS_74423661_X4_Y2_1786338313_0/a_2638_1638# m2_2208_2735# 5.533090e-18
C733 SCM_PMOS_74423661_X4_Y2_1786338313_0/a_2638_462# VDD 1.320500e-17
C734 SCM_PMOS_74423661_X4_Y2_1786338313_0/a_2638_462# m1_2290_2744# 8.026090e-18
C735 SCM_PMOS_74423661_X4_Y2_1786338313_0/a_2810_1638# VDD 1.257210e-17
C736 SCM_PMOS_74423661_X4_Y2_1786338313_0/a_2810_1638# m1_2290_2744# 8.026090e-18
C737 SCM_PMOS_74423661_X4_Y2_1786338313_0/a_2810_462# VDD 1.257210e-17
C738 SCM_PMOS_74423661_X4_Y2_1786338313_0/a_2810_462# m1_2290_2744# 2.493000e-18
C739 SCM_PMOS_74423661_X4_Y2_1786338313_0/a_2810_462# m2_2208_2735# 5.533090e-18
C740 SCM_PMOS_74423661_X4_Y2_1786338313_0/a_2896_1638# VDD 9.665380e-18
C741 SCM_PMOS_74423661_X4_Y2_1786338313_0/a_2896_1638# m1_2290_2744# 1.068570e-17
C742 SCM_PMOS_74423661_X4_Y2_1786338313_0/a_2896_462# VDD 9.665380e-18
C743 SCM_PMOS_74423661_X4_Y2_1786338313_0/a_2896_462# m1_2290_2744# 2.493000e-18
C744 SCM_PMOS_74423661_X4_Y2_1786338313_0/a_2896_462# m2_2208_2735# 8.192680e-18
C745 SCM_PMOS_74423661_X4_Y2_1786338313_0/a_3068_1638# VDD 9.299270e-18
C746 SCM_PMOS_74423661_X4_Y2_1786338313_0/a_3068_1638# m1_2290_2744# 1.068570e-17
C747 SCM_PMOS_74423661_X4_Y2_1786338313_0/a_3068_462# VDD 9.299270e-18
C748 SCM_PMOS_74423661_X4_Y2_1786338313_0/a_3068_462# m1_2290_2744# 2.493000e-18
C749 SCM_PMOS_74423661_X4_Y2_1786338313_0/a_3068_462# m2_2208_2735# 8.192680e-18
C750 SCM_PMOS_74423661_X4_Y2_1786338313_0/a_3154_1638# VDD 1.182600e-17
C751 SCM_PMOS_74423661_X4_Y2_1786338313_0/a_3154_1638# m1_2290_2744# 8.026090e-18
C752 SCM_PMOS_74423661_X4_Y2_1786338313_0/a_3154_462# VDD 1.182600e-17
C753 SCM_PMOS_74423661_X4_Y2_1786338313_0/a_3154_462# m1_2290_2744# 2.493000e-18
C754 SCM_PMOS_74423661_X4_Y2_1786338313_0/a_3154_462# m2_2208_2735# 5.533090e-18
C755 SCM_PMOS_74423661_X4_Y2_1786338313_0/a_316_1638# VDD 8.395320e-18
C756 SCM_PMOS_74423661_X4_Y2_1786338313_0/a_316_1638# m2_2208_2735# 8.192680e-18
C757 SCM_PMOS_74423661_X4_Y2_1786338313_0/a_316_462# VDD 9.016370e-18
C758 SCM_PMOS_74423661_X4_Y2_1786338313_0/a_316_462# m1_2290_2744# 8.192680e-18
C759 SCM_PMOS_74423661_X4_Y2_1786338313_0/a_3326_1638# VDD 1.162940e-17
C760 SCM_PMOS_74423661_X4_Y2_1786338313_0/a_3326_1638# m1_2290_2744# 8.026090e-18
C761 SCM_PMOS_74423661_X4_Y2_1786338313_0/a_3326_462# VDD 1.162940e-17
C762 SCM_PMOS_74423661_X4_Y2_1786338313_0/a_3326_462# m1_2290_2744# 2.493000e-18
C763 SCM_PMOS_74423661_X4_Y2_1786338313_0/a_3326_462# m2_2208_2735# 5.533090e-18
C764 SCM_PMOS_74423661_X4_Y2_1786338313_0/a_3412_1638# VDD 8.896910e-18
C765 SCM_PMOS_74423661_X4_Y2_1786338313_0/a_3412_1638# m1_2290_2744# 1.068570e-17
C766 SCM_PMOS_74423661_X4_Y2_1786338313_0/a_3412_462# VDD 8.896910e-18
C767 SCM_PMOS_74423661_X4_Y2_1786338313_0/a_3412_462# m1_2290_2744# 2.493000e-18
C768 SCM_PMOS_74423661_X4_Y2_1786338313_0/a_3412_462# m2_2208_2735# 8.192680e-18
C769 SCM_PMOS_74423661_X4_Y2_1786338313_0/a_3584_1638# VDD 8.785620e-18
C770 SCM_PMOS_74423661_X4_Y2_1786338313_0/a_3584_1638# m1_2290_2744# 1.068570e-17
C771 SCM_PMOS_74423661_X4_Y2_1786338313_0/a_3584_462# VDD 8.785620e-18
C772 SCM_PMOS_74423661_X4_Y2_1786338313_0/a_3584_462# m1_2290_2744# 2.493000e-18
C773 SCM_PMOS_74423661_X4_Y2_1786338313_0/a_3584_462# m2_2208_2735# 8.192680e-18
C774 SCM_PMOS_74423661_X4_Y2_1786338313_0/a_3670_1638# VDD 1.140240e-17
C775 SCM_PMOS_74423661_X4_Y2_1786338313_0/a_3670_1638# m1_2290_2744# 8.026090e-18
C776 SCM_PMOS_74423661_X4_Y2_1786338313_0/a_3670_462# VDD 1.140240e-17
C777 SCM_PMOS_74423661_X4_Y2_1786338313_0/a_3670_462# m1_2290_2744# 2.493000e-18
C778 SCM_PMOS_74423661_X4_Y2_1786338313_0/a_3670_462# m2_2208_2735# 5.533090e-18
C779 SCM_PMOS_74423661_X4_Y2_1786338313_0/a_3842_1638# VDD 1.133500e-17
C780 SCM_PMOS_74423661_X4_Y2_1786338313_0/a_3842_1638# m1_2290_2744# 2.493000e-18
C781 SCM_PMOS_74423661_X4_Y2_1786338313_0/a_3842_1638# m2_2208_2735# 5.533090e-18
C782 SCM_PMOS_74423661_X4_Y2_1786338313_0/a_3842_462# VDD 1.133500e-17
C783 SCM_PMOS_74423661_X4_Y2_1786338313_0/a_3842_462# m1_2290_2744# 8.026090e-18
C784 SCM_PMOS_74423661_X4_Y2_1786338313_0/a_3928_1638# VDD 8.496750e-18
C785 SCM_PMOS_74423661_X4_Y2_1786338313_0/a_3928_1638# m1_2290_2744# 2.493000e-18
C786 SCM_PMOS_74423661_X4_Y2_1786338313_0/a_3928_1638# m2_2208_2735# 8.192680e-18
C787 SCM_PMOS_74423661_X4_Y2_1786338313_0/a_3928_462# VDD 8.496750e-18
C788 SCM_PMOS_74423661_X4_Y2_1786338313_0/a_3928_462# m1_2290_2744# 1.068570e-17
C789 SCM_PMOS_74423661_X4_Y2_1786338313_0/a_4100_1638# VDD 8.395320e-18
C790 SCM_PMOS_74423661_X4_Y2_1786338313_0/a_4100_1638# m2_2208_2735# 8.192680e-18
C791 SCM_PMOS_74423661_X4_Y2_1786338313_0/a_4100_462# VDD 9.016370e-18
C792 SCM_PMOS_74423661_X4_Y2_1786338313_0/a_4100_462# m1_2290_2744# 8.192680e-18
C793 SCM_PMOS_74423661_X4_Y2_1786338313_0/a_4186_1638# VDD 1.105490e-17
C794 SCM_PMOS_74423661_X4_Y2_1786338313_0/a_4186_1638# m2_2208_2735# 5.533090e-18
C795 SCM_PMOS_74423661_X4_Y2_1786338313_0/a_4186_462# VDD 1.167600e-17
C796 SCM_PMOS_74423661_X4_Y2_1786338313_0/a_4186_462# m1_2290_2744# 5.533090e-18
C797 SCM_PMOS_74423661_X4_Y2_1786338313_0/a_488_1638# VDD 8.395320e-18
C798 SCM_PMOS_74423661_X4_Y2_1786338313_0/a_488_1638# m1_2290_2744# 2.594430e-18
C799 SCM_PMOS_74423661_X4_Y2_1786338313_0/a_488_1638# m2_2208_2735# 8.192680e-18
C800 SCM_PMOS_74423661_X4_Y2_1786338313_0/a_488_462# VDD 8.395320e-18
C801 SCM_PMOS_74423661_X4_Y2_1786338313_0/a_488_462# m1_2290_2744# 1.078710e-17
C802 SCM_PMOS_74423661_X4_Y2_1786338313_0/a_574_1638# VDD 1.105490e-17
C803 SCM_PMOS_74423661_X4_Y2_1786338313_0/a_574_1638# m1_2290_2744# 2.773050e-18
C804 SCM_PMOS_74423661_X4_Y2_1786338313_0/a_574_1638# m2_2208_2735# 5.533090e-18
C805 SCM_PMOS_74423661_X4_Y2_1786338313_0/a_574_462# VDD 1.105490e-17
C806 SCM_PMOS_74423661_X4_Y2_1786338313_0/a_574_462# m1_2290_2744# 8.306140e-18
C807 SCM_PMOS_74423661_X4_Y2_1786338313_0/a_746_1638# VDD 1.105490e-17
C808 SCM_PMOS_74423661_X4_Y2_1786338313_0/a_746_1638# m1_2290_2744# 8.373600e-18
C809 SCM_PMOS_74423661_X4_Y2_1786338313_0/a_746_462# VDD 1.105490e-17
C810 SCM_PMOS_74423661_X4_Y2_1786338313_0/a_746_462# m1_2290_2744# 2.840520e-18
C811 SCM_PMOS_74423661_X4_Y2_1786338313_0/a_746_462# m2_2208_2735# 5.533090e-18
C812 SCM_PMOS_74423661_X4_Y2_1786338313_0/a_832_1638# VDD 8.395320e-18
C813 SCM_PMOS_74423661_X4_Y2_1786338313_0/a_832_1638# m1_2290_2744# 1.107600e-17
C814 SCM_PMOS_74423661_X4_Y2_1786338313_0/a_832_462# VDD 8.395320e-18
C815 SCM_PMOS_74423661_X4_Y2_1786338313_0/a_832_462# m1_2290_2744# 2.883300e-18
C816 SCM_PMOS_74423661_X4_Y2_1786338313_0/a_832_462# m2_2208_2735# 8.192680e-18
C817 VDD VSS 3.544900e-14
C818 VDD m1_2290_2744# 2.567150e-14
C819 VDD m2_2208_2735# 7.370320e-15
C820 m1_2290_2744# VSS 2.870880e-15
C821 m1_2290_2744# m2_2208_2735# 5.380630e-15
C822 m2_2208_2735# VSS 6.634380e-17
.ends
