* NGSPICE PEX netlist for OPAMP_ADC_0 (sky130A)
* Devices/hierarchy: magic `ext2spice lvs` (LVS-clean)
* Parasitic capacitors: annotated from magic .ext database by lvs_work/ext2pex.py
*   - node records   -> caps to cell substrate (Csub*)
*   - cap records    -> coupling caps (Ccpl*)
* sky130A extraction excludes FET gate/diffusion caps (kept in BSIM
* ad/as/pd/ps terms), so no double counting. Caps in farads.

.subckt NMOS_S_72323505_X4_Y2_1785374628 a_230_462# a_200_252# a_147_462#
X0 a_230_462# a_200_252# a_147_462# a_147_462# sky130_fd_pr__nfet_01v8 ad=0.147 pd=1.33 as=0.147 ps=1.33 w=1.05 l=0.15
X1 a_147_462# a_200_252# a_230_462# a_147_462# sky130_fd_pr__nfet_01v8 ad=0.147 pd=1.33 as=0.147 ps=1.33 w=1.05 l=0.15
X2 a_230_462# a_200_252# a_147_462# a_147_462# sky130_fd_pr__nfet_01v8 ad=0.147 pd=1.33 as=0.27825 ps=2.63 w=1.05 l=0.15
X3 a_230_462# a_200_252# a_147_462# a_147_462# sky130_fd_pr__nfet_01v8 ad=0.147 pd=1.33 as=0.147 ps=1.33 w=1.05 l=0.15
X4 a_147_462# a_200_252# a_230_462# a_147_462# sky130_fd_pr__nfet_01v8 ad=0.27825 pd=2.63 as=0.147 ps=1.33 w=1.05 l=0.15
X5 a_147_462# a_200_252# a_230_462# a_147_462# sky130_fd_pr__nfet_01v8 ad=0.147 pd=1.33 as=0.147 ps=1.33 w=1.05 l=0.15
X6 a_230_462# a_200_252# a_147_462# a_147_462# sky130_fd_pr__nfet_01v8 ad=0.147 pd=1.33 as=0.147 ps=1.33 w=1.05 l=0.15
X7 a_147_462# a_200_252# a_230_462# a_147_462# sky130_fd_pr__nfet_01v8 ad=0.147 pd=1.33 as=0.147 ps=1.33 w=1.05 l=0.15
X8 a_230_462# a_200_252# a_147_462# a_147_462# sky130_fd_pr__nfet_01v8 ad=0.147 pd=1.33 as=0.147 ps=1.33 w=1.05 l=0.15
X9 a_230_462# a_200_252# a_147_462# a_147_462# sky130_fd_pr__nfet_01v8 ad=0.147 pd=1.33 as=0.147 ps=1.33 w=1.05 l=0.15
X10 a_147_462# a_200_252# a_230_462# a_147_462# sky130_fd_pr__nfet_01v8 ad=0.147 pd=1.33 as=0.147 ps=1.33 w=1.05 l=0.15
X11 a_147_462# a_200_252# a_230_462# a_147_462# sky130_fd_pr__nfet_01v8 ad=0.27825 pd=2.63 as=0.147 ps=1.33 w=1.05 l=0.15
X12 a_230_462# a_200_252# a_147_462# a_147_462# sky130_fd_pr__nfet_01v8 ad=0.147 pd=1.33 as=0.147 ps=1.33 w=1.05 l=0.15
X13 a_230_462# a_200_252# a_147_462# a_147_462# sky130_fd_pr__nfet_01v8 ad=0.147 pd=1.33 as=0.27825 ps=2.63 w=1.05 l=0.15
X14 a_147_462# a_200_252# a_230_462# a_147_462# sky130_fd_pr__nfet_01v8 ad=0.147 pd=1.33 as=0.147 ps=1.33 w=1.05 l=0.15
X15 a_147_462# a_200_252# a_230_462# a_147_462# sky130_fd_pr__nfet_01v8 ad=0.147 pd=1.33 as=0.147 ps=1.33 w=1.05 l=0.15
Csub0 a_200_252# a_147_462# 5.671360e-15
Csub1 a_230_462# a_147_462# 6.736170e-15
Ccpl2 a_200_252# a_230_462# 1.230540e-15
* cell NMOS_S_72323505_X4_Y2_1785374628: 2 substrate caps (12.4075 fF), 1 coupling caps (1.2305 fF)
.ends

.subckt NMOS_4T_95495835_X1_Y1_1785374626 a_230_462# a_200_252# a_147_462# a_241_1232#
X0 a_230_462# a_200_252# a_147_462# a_241_1232# sky130_fd_pr__nfet_01v8 ad=0.147 pd=1.33 as=0.27825 ps=2.63 w=1.05 l=0.15
X1 a_147_462# a_200_252# a_230_462# a_241_1232# sky130_fd_pr__nfet_01v8 ad=0.27825 pd=2.63 as=0.147 ps=1.33 w=1.05 l=0.15
Csub0 a_147_462# a_241_1232# 4.328010e-16
Csub1 a_200_252# a_241_1232# 7.252440e-16
Csub2 a_230_462# a_241_1232# 1.316880e-16
Ccpl3 a_147_462# a_200_252# 9.332410e-17
Ccpl4 a_147_462# a_230_462# 7.009300e-16
Ccpl5 a_200_252# a_230_462# 9.706250e-17
* cell NMOS_4T_95495835_X1_Y1_1785374626: 3 substrate caps (1.2897 fF), 3 coupling caps (0.8913 fF)
.ends

.subckt CAP_2T_96113034_1785374625 m3_53_172# m3_53_928#
X0 m3_53_172# m3_53_928# sky130_fd_pr__cap_mim_m3_1 l=1.05 w=1.05
Csub0 m3_53_172# 0 3.976620e-16
Csub1 m3_53_928# 0 4.161380e-16
Ccpl2 m3_53_172# m3_53_928# 2.238100e-16
* cell CAP_2T_96113034_1785374625: 2 substrate caps (0.8138 fF), 1 coupling caps (0.2238 fF)
.ends

.subckt PMOS_S_62671986_X8_Y1_1785374630 a_230_462# a_200_252# w_0_0#
X0 a_230_462# a_200_252# w_0_0# w_0_0# sky130_fd_pr__pfet_01v8 ad=0.147 pd=1.33 as=0.147 ps=1.33 w=1.05 l=0.15
X1 w_0_0# a_200_252# a_230_462# w_0_0# sky130_fd_pr__pfet_01v8 ad=0.147 pd=1.33 as=0.147 ps=1.33 w=1.05 l=0.15
X2 w_0_0# a_200_252# a_230_462# w_0_0# sky130_fd_pr__pfet_01v8 ad=0.147 pd=1.33 as=0.147 ps=1.33 w=1.05 l=0.15
X3 w_0_0# a_200_252# a_230_462# w_0_0# sky130_fd_pr__pfet_01v8 ad=0.147 pd=1.33 as=0.147 ps=1.33 w=1.05 l=0.15
X4 a_230_462# a_200_252# w_0_0# w_0_0# sky130_fd_pr__pfet_01v8 ad=0.147 pd=1.33 as=0.147 ps=1.33 w=1.05 l=0.15
X5 a_230_462# a_200_252# w_0_0# w_0_0# sky130_fd_pr__pfet_01v8 ad=0.147 pd=1.33 as=0.147 ps=1.33 w=1.05 l=0.15
X6 a_230_462# a_200_252# w_0_0# w_0_0# sky130_fd_pr__pfet_01v8 ad=0.147 pd=1.33 as=0.147 ps=1.33 w=1.05 l=0.15
X7 w_0_0# a_200_252# a_230_462# w_0_0# sky130_fd_pr__pfet_01v8 ad=0.147 pd=1.33 as=0.147 ps=1.33 w=1.05 l=0.15
X8 w_0_0# a_200_252# a_230_462# w_0_0# sky130_fd_pr__pfet_01v8 ad=0.147 pd=1.33 as=0.147 ps=1.33 w=1.05 l=0.15
X9 a_230_462# a_200_252# w_0_0# w_0_0# sky130_fd_pr__pfet_01v8 ad=0.147 pd=1.33 as=0.27825 ps=2.63 w=1.05 l=0.15
X10 w_0_0# a_200_252# a_230_462# w_0_0# sky130_fd_pr__pfet_01v8 ad=0.147 pd=1.33 as=0.147 ps=1.33 w=1.05 l=0.15
X11 w_0_0# a_200_252# a_230_462# w_0_0# sky130_fd_pr__pfet_01v8 ad=0.147 pd=1.33 as=0.147 ps=1.33 w=1.05 l=0.15
X12 a_230_462# a_200_252# w_0_0# w_0_0# sky130_fd_pr__pfet_01v8 ad=0.147 pd=1.33 as=0.147 ps=1.33 w=1.05 l=0.15
X13 a_230_462# a_200_252# w_0_0# w_0_0# sky130_fd_pr__pfet_01v8 ad=0.147 pd=1.33 as=0.147 ps=1.33 w=1.05 l=0.15
X14 w_0_0# a_200_252# a_230_462# w_0_0# sky130_fd_pr__pfet_01v8 ad=0.27825 pd=2.63 as=0.147 ps=1.33 w=1.05 l=0.15
X15 a_230_462# a_200_252# w_0_0# w_0_0# sky130_fd_pr__pfet_01v8 ad=0.147 pd=1.33 as=0.147 ps=1.33 w=1.05 l=0.15
Csub0 a_200_252# 0 4.668310e-16
Csub1 a_230_462# 0 3.269910e-16
Csub2 w_0_0# 0 8.112460e-15
Ccpl3 a_200_252# a_230_462# 7.414300e-16
Ccpl4 a_200_252# w_0_0# 4.122640e-15
Ccpl5 a_230_462# w_0_0# 5.981060e-15
* cell PMOS_S_62671986_X8_Y1_1785374630: 3 substrate caps (8.9063 fF), 3 coupling caps (10.8451 fF)
.ends

.subckt NMOS_S_98719586_X4_Y1_1785374629 a_230_462# a_200_252# a_147_462#
X0 a_230_462# a_200_252# a_147_462# a_147_462# sky130_fd_pr__nfet_01v8 ad=0.147 pd=1.33 as=0.147 ps=1.33 w=1.05 l=0.15
X1 a_230_462# a_200_252# a_147_462# a_147_462# sky130_fd_pr__nfet_01v8 ad=0.147 pd=1.33 as=0.147 ps=1.33 w=1.05 l=0.15
X2 a_147_462# a_200_252# a_230_462# a_147_462# sky130_fd_pr__nfet_01v8 ad=0.147 pd=1.33 as=0.147 ps=1.33 w=1.05 l=0.15
X3 a_147_462# a_200_252# a_230_462# a_147_462# sky130_fd_pr__nfet_01v8 ad=0.27825 pd=2.63 as=0.147 ps=1.33 w=1.05 l=0.15
X4 a_230_462# a_200_252# a_147_462# a_147_462# sky130_fd_pr__nfet_01v8 ad=0.147 pd=1.33 as=0.147 ps=1.33 w=1.05 l=0.15
X5 a_230_462# a_200_252# a_147_462# a_147_462# sky130_fd_pr__nfet_01v8 ad=0.147 pd=1.33 as=0.27825 ps=2.63 w=1.05 l=0.15
X6 a_147_462# a_200_252# a_230_462# a_147_462# sky130_fd_pr__nfet_01v8 ad=0.147 pd=1.33 as=0.147 ps=1.33 w=1.05 l=0.15
X7 a_147_462# a_200_252# a_230_462# a_147_462# sky130_fd_pr__nfet_01v8 ad=0.147 pd=1.33 as=0.147 ps=1.33 w=1.05 l=0.15
Csub0 a_200_252# a_147_462# 2.456690e-15
Csub1 a_230_462# a_147_462# 3.146470e-15
Ccpl2 a_200_252# a_230_462# 3.705100e-16
* cell NMOS_S_98719586_X4_Y1_1785374629: 2 substrate caps (5.6032 fF), 1 coupling caps (0.3705 fF)
.ends

.subckt SCM_PMOS_2270758_X8_Y1_1785374631 a_200_252# a_402_462# w_0_0#
X0 a_200_252# a_200_252# w_0_0# w_0_0# sky130_fd_pr__pfet_01v8 ad=0.147 pd=1.33 as=0.147 ps=1.33 w=1.05 l=0.15
X1 a_200_252# a_200_252# w_0_0# w_0_0# sky130_fd_pr__pfet_01v8 ad=0.147 pd=1.33 as=0.147 ps=1.33 w=1.05 l=0.15
X2 w_0_0# a_200_252# a_402_462# w_0_0# sky130_fd_pr__pfet_01v8 ad=0.147 pd=1.33 as=0.147 ps=1.33 w=1.05 l=0.15
X3 a_200_252# a_200_252# w_0_0# w_0_0# sky130_fd_pr__pfet_01v8 ad=0.147 pd=1.33 as=0.147 ps=1.33 w=1.05 l=0.15
X4 a_402_462# a_200_252# w_0_0# w_0_0# sky130_fd_pr__pfet_01v8 ad=0.147 pd=1.33 as=0.147 ps=1.33 w=1.05 l=0.15
X5 w_0_0# a_200_252# a_402_462# w_0_0# sky130_fd_pr__pfet_01v8 ad=0.147 pd=1.33 as=0.147 ps=1.33 w=1.05 l=0.15
X6 a_200_252# a_200_252# w_0_0# w_0_0# sky130_fd_pr__pfet_01v8 ad=0.147 pd=1.33 as=0.147 ps=1.33 w=1.05 l=0.15
X7 w_0_0# a_200_252# a_402_462# w_0_0# sky130_fd_pr__pfet_01v8 ad=0.147 pd=1.33 as=0.147 ps=1.33 w=1.05 l=0.15
X8 w_0_0# a_200_252# a_200_252# w_0_0# sky130_fd_pr__pfet_01v8 ad=0.147 pd=1.33 as=0.147 ps=1.33 w=1.05 l=0.15
X9 a_402_462# a_200_252# w_0_0# w_0_0# sky130_fd_pr__pfet_01v8 ad=0.147 pd=1.33 as=0.147 ps=1.33 w=1.05 l=0.15
X10 a_200_252# a_200_252# w_0_0# w_0_0# sky130_fd_pr__pfet_01v8 ad=0.147 pd=1.33 as=0.147 ps=1.33 w=1.05 l=0.15
X11 w_0_0# a_200_252# a_200_252# w_0_0# sky130_fd_pr__pfet_01v8 ad=0.27825 pd=2.63 as=0.147 ps=1.33 w=1.05 l=0.15
X12 a_402_462# a_200_252# w_0_0# w_0_0# sky130_fd_pr__pfet_01v8 ad=0.147 pd=1.33 as=0.147 ps=1.33 w=1.05 l=0.15
X13 w_0_0# a_200_252# a_200_252# w_0_0# sky130_fd_pr__pfet_01v8 ad=0.147 pd=1.33 as=0.147 ps=1.33 w=1.05 l=0.15
X14 a_402_462# a_200_252# w_0_0# w_0_0# sky130_fd_pr__pfet_01v8 ad=0.147 pd=1.33 as=0.147 ps=1.33 w=1.05 l=0.15
X15 w_0_0# a_200_252# a_200_252# w_0_0# sky130_fd_pr__pfet_01v8 ad=0.147 pd=1.33 as=0.147 ps=1.33 w=1.05 l=0.15
X16 w_0_0# a_200_252# a_402_462# w_0_0# sky130_fd_pr__pfet_01v8 ad=0.147 pd=1.33 as=0.147 ps=1.33 w=1.05 l=0.15
X17 w_0_0# a_200_252# a_200_252# w_0_0# sky130_fd_pr__pfet_01v8 ad=0.147 pd=1.33 as=0.147 ps=1.33 w=1.05 l=0.15
X18 w_0_0# a_200_252# a_402_462# w_0_0# sky130_fd_pr__pfet_01v8 ad=0.147 pd=1.33 as=0.147 ps=1.33 w=1.05 l=0.15
X19 a_200_252# a_200_252# w_0_0# w_0_0# sky130_fd_pr__pfet_01v8 ad=0.147 pd=1.33 as=0.27825 ps=2.63 w=1.05 l=0.15
X20 a_402_462# a_200_252# w_0_0# w_0_0# sky130_fd_pr__pfet_01v8 ad=0.147 pd=1.33 as=0.147 ps=1.33 w=1.05 l=0.15
X21 w_0_0# a_200_252# a_200_252# w_0_0# sky130_fd_pr__pfet_01v8 ad=0.147 pd=1.33 as=0.147 ps=1.33 w=1.05 l=0.15
X22 a_200_252# a_200_252# w_0_0# w_0_0# sky130_fd_pr__pfet_01v8 ad=0.147 pd=1.33 as=0.147 ps=1.33 w=1.05 l=0.15
X23 w_0_0# a_200_252# a_402_462# w_0_0# sky130_fd_pr__pfet_01v8 ad=0.147 pd=1.33 as=0.147 ps=1.33 w=1.05 l=0.15
X24 a_402_462# a_200_252# w_0_0# w_0_0# sky130_fd_pr__pfet_01v8 ad=0.147 pd=1.33 as=0.147 ps=1.33 w=1.05 l=0.15
X25 w_0_0# a_200_252# a_402_462# w_0_0# sky130_fd_pr__pfet_01v8 ad=0.147 pd=1.33 as=0.147 ps=1.33 w=1.05 l=0.15
X26 a_402_462# a_200_252# w_0_0# w_0_0# sky130_fd_pr__pfet_01v8 ad=0.147 pd=1.33 as=0.147 ps=1.33 w=1.05 l=0.15
X27 a_200_252# a_200_252# w_0_0# w_0_0# sky130_fd_pr__pfet_01v8 ad=0.147 pd=1.33 as=0.147 ps=1.33 w=1.05 l=0.15
X28 w_0_0# a_200_252# a_200_252# w_0_0# sky130_fd_pr__pfet_01v8 ad=0.147 pd=1.33 as=0.147 ps=1.33 w=1.05 l=0.15
X29 w_0_0# a_200_252# a_402_462# w_0_0# sky130_fd_pr__pfet_01v8 ad=0.147 pd=1.33 as=0.147 ps=1.33 w=1.05 l=0.15
X30 a_402_462# a_200_252# w_0_0# w_0_0# sky130_fd_pr__pfet_01v8 ad=0.147 pd=1.33 as=0.147 ps=1.33 w=1.05 l=0.15
X31 w_0_0# a_200_252# a_200_252# w_0_0# sky130_fd_pr__pfet_01v8 ad=0.147 pd=1.33 as=0.147 ps=1.33 w=1.05 l=0.15
Csub0 a_200_252# 0 1.409700e-15
Csub1 a_402_462# 0 8.002160e-17
Csub2 w_0_0# 0 1.427550e-14
Ccpl3 a_200_252# a_402_462# 2.347210e-15
Ccpl4 a_200_252# w_0_0# 1.389960e-14
Ccpl5 a_402_462# w_0_0# 6.659290e-15
* cell SCM_PMOS_2270758_X8_Y1_1785374631: 3 substrate caps (15.7652 fF), 3 coupling caps (22.9061 fF)
.ends

.subckt NMOS_S_67890029_X2_Y1_1785374627 a_230_462# a_200_252# a_147_462#
X0 a_230_462# a_200_252# a_147_462# a_147_462# sky130_fd_pr__nfet_01v8 ad=0.147 pd=1.33 as=0.147 ps=1.33 w=1.05 l=0.15
X1 a_147_462# a_200_252# a_230_462# a_147_462# sky130_fd_pr__nfet_01v8 ad=0.27825 pd=2.63 as=0.147 ps=1.33 w=1.05 l=0.15
X2 a_230_462# a_200_252# a_147_462# a_147_462# sky130_fd_pr__nfet_01v8 ad=0.147 pd=1.33 as=0.27825 ps=2.63 w=1.05 l=0.15
X3 a_147_462# a_200_252# a_230_462# a_147_462# sky130_fd_pr__nfet_01v8 ad=0.147 pd=1.33 as=0.147 ps=1.33 w=1.05 l=0.15
Csub0 a_200_252# a_147_462# 1.366340e-15
Csub1 a_230_462# a_147_462# 1.554520e-15
Ccpl2 a_200_252# a_230_462# 1.850510e-16
* cell NMOS_S_67890029_X2_Y1_1785374627: 2 substrate caps (2.9209 fF), 1 coupling caps (0.1851 fF)
.ends

.subckt NMOS_S_66450264_X1_Y1_1785374624_1785374624 a_230_462# a_200_252# a_147_462#
X0 a_230_462# a_200_252# a_147_462# a_147_462# sky130_fd_pr__nfet_01v8 ad=0.147 pd=1.33 as=0.27825 ps=2.63 w=1.05 l=0.15
X1 a_147_462# a_200_252# a_230_462# a_147_462# sky130_fd_pr__nfet_01v8 ad=0.27825 pd=2.63 as=0.147 ps=1.33 w=1.05 l=0.15
Csub0 a_200_252# a_147_462# 8.560650e-16
Csub1 a_230_462# a_147_462# 8.486980e-16
Ccpl2 a_200_252# a_230_462# 9.706250e-17
* cell NMOS_S_66450264_X1_Y1_1785374624_1785374624: 2 substrate caps (1.7048 fF), 1 coupling caps (0.0971 fF)
.ends

.subckt PMOS_S_5293867_X2_Y1_1785374625_1785374624 a_230_462# a_200_252# w_0_0#
X0 w_0_0# a_200_252# a_230_462# w_0_0# sky130_fd_pr__pfet_01v8 ad=0.27825 pd=2.63 as=0.147 ps=1.33 w=1.05 l=0.15
X1 a_230_462# a_200_252# w_0_0# w_0_0# sky130_fd_pr__pfet_01v8 ad=0.147 pd=1.33 as=0.27825 ps=2.63 w=1.05 l=0.15
X2 w_0_0# a_200_252# a_230_462# w_0_0# sky130_fd_pr__pfet_01v8 ad=0.147 pd=1.33 as=0.147 ps=1.33 w=1.05 l=0.15
X3 a_230_462# a_200_252# w_0_0# w_0_0# sky130_fd_pr__pfet_01v8 ad=0.147 pd=1.33 as=0.147 ps=1.33 w=1.05 l=0.15
Csub0 a_200_252# 0 2.186250e-16
Csub1 a_230_462# 0 7.872840e-17
Csub2 w_0_0# 0 3.692110e-15
Ccpl3 a_200_252# a_230_462# 1.850510e-16
Ccpl4 a_200_252# w_0_0# 1.147720e-15
Ccpl5 a_230_462# w_0_0# 1.475790e-15
* cell PMOS_S_5293867_X2_Y1_1785374625_1785374624: 3 substrate caps (3.9895 fF), 3 coupling caps (2.8086 fF)
.ends

.subckt INV_65002554_0_1785374624 PMOS_S_5293867_X2_Y1_1785374625_1785374624_0/w_0_0# m1_226_1400# m1_312_560# SUB
XNMOS_S_66450264_X1_Y1_1785374624_1785374624_0 m1_226_1400# m1_312_560# SUB NMOS_S_66450264_X1_Y1_1785374624_1785374624
XPMOS_S_5293867_X2_Y1_1785374625_1785374624_0 m1_226_1400# m1_312_560# PMOS_S_5293867_X2_Y1_1785374625_1785374624_0/w_0_0# PMOS_S_5293867_X2_Y1_1785374625_1785374624
Csub0 m1_226_1400# SUB 1.498300e-16
Csub1 m1_312_560# SUB 8.465830e-16
Ccpl2 PMOS_S_5293867_X2_Y1_1785374625_1785374624_0/w_0_0# SUB 1.429702e-17
Ccpl3 PMOS_S_5293867_X2_Y1_1785374625_1785374624_0/w_0_0# m1_226_1400# 3.525100e-17
Ccpl4 PMOS_S_5293867_X2_Y1_1785374625_1785374624_0/w_0_0# m1_312_560# 5.717783e-16
Ccpl5 SUB m1_226_1400# 3.455306e-17
Ccpl6 SUB m1_312_560# 4.992345e-16
Ccpl7 m1_226_1400# m1_312_560# 2.436128e-16
* cell INV_65002554_0_1785374624: 2 substrate caps (0.9964 fF), 6 coupling caps (1.3987 fF)
.ends

.subckt SCM_PMOS_89224135_X2_Y1_1785374632 a_200_252# a_402_462# w_0_0#
X0 a_200_252# a_200_252# w_0_0# w_0_0# sky130_fd_pr__pfet_01v8 ad=0.147 pd=1.33 as=0.147 ps=1.33 w=1.05 l=0.15
X1 w_0_0# a_200_252# a_402_462# w_0_0# sky130_fd_pr__pfet_01v8 ad=0.147 pd=1.33 as=0.147 ps=1.33 w=1.05 l=0.15
X2 w_0_0# a_200_252# a_200_252# w_0_0# sky130_fd_pr__pfet_01v8 ad=0.27825 pd=2.63 as=0.147 ps=1.33 w=1.05 l=0.15
X3 a_402_462# a_200_252# w_0_0# w_0_0# sky130_fd_pr__pfet_01v8 ad=0.147 pd=1.33 as=0.147 ps=1.33 w=1.05 l=0.15
X4 a_200_252# a_200_252# w_0_0# w_0_0# sky130_fd_pr__pfet_01v8 ad=0.147 pd=1.33 as=0.27825 ps=2.63 w=1.05 l=0.15
X5 w_0_0# a_200_252# a_200_252# w_0_0# sky130_fd_pr__pfet_01v8 ad=0.147 pd=1.33 as=0.147 ps=1.33 w=1.05 l=0.15
X6 w_0_0# a_200_252# a_402_462# w_0_0# sky130_fd_pr__pfet_01v8 ad=0.147 pd=1.33 as=0.147 ps=1.33 w=1.05 l=0.15
X7 a_402_462# a_200_252# w_0_0# w_0_0# sky130_fd_pr__pfet_01v8 ad=0.147 pd=1.33 as=0.147 ps=1.33 w=1.05 l=0.15
Csub0 a_200_252# 0 5.677430e-16
Csub1 a_402_462# 0 2.841330e-17
Csub2 w_0_0# 0 5.084450e-15
Ccpl3 a_200_252# a_402_462# 4.124300e-16
Ccpl4 a_200_252# w_0_0# 3.969370e-15
Ccpl5 a_402_462# w_0_0# 1.465700e-15
* cell SCM_PMOS_89224135_X2_Y1_1785374632: 3 substrate caps (5.6806 fF), 3 coupling caps (5.8475 fF)
.ends

.subckt OPAMP_ADC_0 VDD VSS VINP VINN VBIAS VREF VOUT DOUT
XNMOS_S_72323505_X4_Y2_1785374628_0 m1_946_1652# VBIAS VSS NMOS_S_72323505_X4_Y2_1785374628
XNMOS_4T_95495835_X1_Y1_1785374626_0 li_921_4687# VREF m1_1978_4340# VSS NMOS_4T_95495835_X1_Y1_1785374626
XNMOS_4T_95495835_X1_Y1_1785374626_1 m1_1688_4424# VOUT m1_1978_4340# VSS NMOS_4T_95495835_X1_Y1_1785374626
XNMOS_4T_95495835_X1_Y1_1785374626_2 m1_1172_1316# VINP m1_946_1652# VSS NMOS_4T_95495835_X1_Y1_1785374626
XNMOS_4T_95495835_X1_Y1_1785374626_3 li_1007_1495# VINN m1_946_1652# VSS NMOS_4T_95495835_X1_Y1_1785374626
XCAP_2T_96113034_1785374625_0 m1_1172_1316# VOUT CAP_2T_96113034_1785374625
XPMOS_S_62671986_X8_Y1_1785374630_0 VOUT VBIAS VDD PMOS_S_62671986_X8_Y1_1785374630
XNMOS_S_98719586_X4_Y1_1785374629_0 VOUT m1_1172_1316# VSS NMOS_S_98719586_X4_Y1_1785374629
XSCM_PMOS_2270758_X8_Y1_1785374631_0 li_1007_1495# m1_1172_1316# VDD SCM_PMOS_2270758_X8_Y1_1785374631
XNMOS_S_67890029_X2_Y1_1785374627_0 m1_1978_4340# VBIAS VSS NMOS_S_67890029_X2_Y1_1785374627
XINV_65002554_0_1785374624_0 VDD DOUT li_921_4687# VSS INV_65002554_0_1785374624
XSCM_PMOS_89224135_X2_Y1_1785374632_0 m1_1688_4424# li_921_4687# VDD SCM_PMOS_89224135_X2_Y1_1785374632
Csub0 VBIAS VSS 1.565642e-15
Csub1 VDD VSS 1.779290e-15
Csub2 VOUT VSS 1.420365e-15
Csub3 li_1007_1495# VSS 2.736290e-16
Csub4 li_921_4687# VSS 8.921640e-16
Csub5 m1_1172_1316# VSS 8.794690e-16
Csub6 m1_1688_4424# VSS 2.122080e-16
Csub7 m1_1978_4340# VSS 3.644879e-16
Csub8 m1_946_1652# VSS 1.000500e-15
Ccpl9 DOUT VDD -6.188875e-18
Ccpl10 DOUT VOUT 1.528317e-19
Ccpl11 DOUT VSS 1.558680e-19
Ccpl12 DOUT li_921_4687# 3.384930e-17
Ccpl13 DOUT m1_1688_4424# 5.496516e-18
Ccpl14 DOUT m1_1978_4340# 4.274539e-18
Ccpl15 VBIAS VDD 5.516165e-16
Ccpl16 VBIAS VINP 3.524527e-18
Ccpl17 VBIAS VOUT 3.845637e-16
Ccpl18 VBIAS VREF 5.961866e-17
Ccpl19 VBIAS VSS 6.267973e-16
Ccpl20 VBIAS li_1007_1495# 7.274240e-19
Ccpl21 VBIAS li_921_4687# 6.370295e-17
Ccpl22 VBIAS m1_1172_1316# 2.488227e-17
Ccpl23 VBIAS m1_1688_4424# 6.721170e-17
Ccpl24 VBIAS m1_1978_4340# 7.023655e-17
Ccpl25 VBIAS m1_946_1652# 3.857414e-17
Ccpl26 VDD VINN 4.803820e-18
Ccpl27 VDD VINP 2.038979e-17
Ccpl28 VDD VOUT 9.051980e-16
Ccpl29 VDD VREF 5.786052e-18
Ccpl30 VDD VSS 6.602375e-16
Ccpl31 VDD li_1007_1495# 1.761160e-16
Ccpl32 VDD li_921_4687# 1.597603e-15
Ccpl33 VDD m1_1172_1316# 3.171438e-16
Ccpl34 VDD m1_1688_4424# 8.972272e-16
Ccpl35 VDD m1_1978_4340# 4.305075e-16
Ccpl36 VDD m1_946_1652# 3.429058e-16
Ccpl37 VINN VINP 4.929920e-17
Ccpl38 VINN VOUT 5.860940e-17
Ccpl39 VINN VSS -2.651782e-17
Ccpl40 VINN li_1007_1495# -2.346849e-18
Ccpl41 VINN m1_1172_1316# 2.950800e-17
Ccpl42 VINN m1_946_1652# 6.319148e-18
Ccpl43 VINP VOUT 5.113274e-17
Ccpl44 VINP VSS -8.583053e-18
Ccpl45 VINP li_1007_1495# 2.573774e-18
Ccpl46 VINP m1_1172_1316# 6.668200e-17
Ccpl47 VINP m1_946_1652# -9.542695e-18
Ccpl48 VOUT VREF 5.890145e-17
Ccpl49 VOUT VSS 9.312774e-16
Ccpl50 VOUT li_1007_1495# 1.246292e-17
Ccpl51 VOUT li_921_4687# 1.304112e-16
Ccpl52 VOUT m1_1172_1316# 5.997498e-17
Ccpl53 VOUT m1_1688_4424# 3.685370e-17
Ccpl54 VOUT m1_1978_4340# 4.067683e-16
Ccpl55 VOUT m1_946_1652# 3.473137e-17
Ccpl56 VREF VSS 1.178722e-17
Ccpl57 VREF li_921_4687# -4.461150e-18
Ccpl58 VREF m1_1172_1316# 1.875173e-18
Ccpl59 VREF m1_1978_4340# 6.290940e-18
Ccpl60 VREF m1_946_1652# 3.330230e-19
Ccpl61 VSS li_1007_1495# 1.335777e-16
Ccpl62 VSS li_921_4687# 1.600653e-17
Ccpl63 VSS m1_1172_1316# 3.873015e-17
Ccpl64 VSS m1_1688_4424# 1.260844e-18
Ccpl65 VSS m1_1978_4340# 2.431061e-16
Ccpl66 VSS m1_946_1652# 4.715780e-16
Ccpl67 li_1007_1495# m1_1172_1316# 3.731373e-16
Ccpl68 li_1007_1495# m1_946_1652# 3.110829e-16
Ccpl69 li_921_4687# m1_1172_1316# 5.734460e-19
Ccpl70 li_921_4687# m1_1688_4424# 3.471928e-16
Ccpl71 li_921_4687# m1_1978_4340# 7.966620e-17
Ccpl72 m1_1172_1316# m1_1978_4340# 1.779280e-20
Ccpl73 m1_1172_1316# m1_946_1652# 4.689758e-16
Ccpl74 m1_1688_4424# m1_1978_4340# 2.448743e-16
* cell OPAMP_ADC_0: 9 substrate caps (8.3878 fF), 66 coupling caps (11.9212 fF)
.ends
