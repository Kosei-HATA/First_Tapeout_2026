* afe_ln variant OTA: parameterized copy of eeg_fd_ota_chopped_full2 (nodsl)
* for low-noise experiments. Canonical files untouched.
* S1W/S1NF: stage-1 input pair W/nf (core in afe_ln_core_soft.spice)
* S2W/S2NF: stage-2 input pair (XM21/22) W/nf (canonical 12/2, unit 6u)
* S2LW/S2LNF: stage-2 PMOS loads (XM23/24) W/nf (canonical 48/8, unit 6u)
.subckt afe_ln_cmfb_amp_dl2 VCM_SENSE VCM_REF VBN VBP VDD18 VSS params: W9=5 L9=4 W10=12
XM6 NLEFT VCM_SENSE NTAIL VSS sky130_fd_pr__nfet_01v8 L=2 W=2 nf=1
XM7 VBP VCM_REF NTAIL VSS sky130_fd_pr__nfet_01v8 L=2 W=2 nf=1
XM8 NLEFT NLEFT VDD18 VDD18 sky130_fd_pr__pfet_01v8 L=2 W=2 nf=1
XM9 VBP VBP VDD18 VDD18 sky130_fd_pr__pfet_01v8 L={L9} W={W9} nf=1
XM10 NTAIL VBN VSS VSS sky130_fd_pr__nfet_01v8 L=4 W={W10} nf=2
.ends

.subckt afe_ln_ota_chopped_full2 INP INN VCM_REF OUTP OUTN PHII NPHII PHIBI NPHIBI PHIM NPHIM PHIBM NPHIBM VDD18 VSS params: W91=4 L91=4 W92=0.5 L92=4 W10=12 RLOAD=2Meg CC=10p RZ=20k RSET=25k RFILT=10Meg CFILT=100p DVOS=0 CDSLV=2n S1W=240 S1NF=24 S2W=12 S2NF=2 S2LW=48 S2LNF=8 S1RLOAD=2Meg S1RCM=5Meg S2RCM=5Meg
XBG VBNRAW VBN VBP_BIAS VDD18 VSS eeg_bias_gen RSET={RSET} RFILT={RFILT} CFILT={CFILT}
XCHIN INP INN INP_M INN_M PHII NPHII PHIBI NPHIBI VDD18 VSS eeg_cmos_chopper_lowq
VOS1 INP_M INP_MX {DVOS}
XSTG1 INP_MX INN_M VBP1 VBN N1P N1N VCM1 VCM_REF VDD18 VSS afe_ln_core_soft RLOAD={S1RLOAD} RCM={S1RCM} S1W={S1W} S1NF={S1NF}
XCM1 VCM1 VCM_REF VBN VBP1 VDD18 VSS afe_ln_cmfb_amp_dl2 W9={W91} L9={L91} W10={W10}
XCHMID N1P N1N N2P N2N PHIM NPHIM PHIBM NPHIBM VDD18 VSS eeg_cmos_chopper_lowq
XM21 OUTP N2P VSS VSS sky130_fd_pr__nfet_01v8 L=12 W={S2W} nf={S2NF}
XM22 OUTN N2N VSS VSS sky130_fd_pr__nfet_01v8 L=12 W={S2W} nf={S2NF}
XM23 OUTP VBP2 VDD18 VDD18 sky130_fd_pr__pfet_01v8 L=12 W={S2LW} nf={S2LNF}
XM24 OUTN VBP2 VDD18 VDD18 sky130_fd_pr__pfet_01v8 L=12 W={S2LW} nf={S2LNF}
RCMO1 OUTP VCM2 {S2RCM}
RCMO2 OUTN VCM2 {S2RCM}
RLOADO1 OUTP VCM_REF {RLOAD}
RLOADO2 OUTN VCM_REF {RLOAD}
XCM2 VCM2 VCM_REF VBN VBP2 VDD18 VSS afe_ln_cmfb_amp_dl2 W9={W92} L9={L92} W10={W10}
RZP N2P NZP {RZ}
CCP NZP OUTP {CC}
RZN N2N NZN {RZ}
CCN NZN OUTN {CC}
.ends
