* afe_ln CM step response (frozen straight choppers, closed loop x32)
.lib /Users/noah/.volare/volare/sky130/versions/0fe599b2afb6708d281543108caf8310912f54af/sky130A/libs.tech/ngspice/sky130.lib.spice tt
.include eeg_tg_lowq.spice
.include afe_ln_core_soft.spice
.include eeg_pseudo_res.spice
.include eeg_bias_gen.spice
.include afe_ln_ota_full2.spice
.param VDD=1.80
VDD_SRC VDD18 0 {VDD}
VREF VCM_REF 0 PULSE(0.9 0.91 100u 1u 1u 10 10)
VPHI PHI 0 {VDD}
VPHIB PHIB 0 0
BNPHI NPHI 0 V={VDD}-v(PHI)
BNPHIB NPHIB 0 V={VDD}-v(PHIB)
VSIGP SIGP 0 DC 0.9 AC 0.5 0
VSIGN SIGN 0 DC 0.9 AC 0.5 180
CINP SIGP INP 32p
CINN SIGN INN 32p
CFP OUTN INP 1p
CFN OUTP INN 1p
RBIASP INP VCM_REF 1T
RBIASN INN VCM_REF 1T
CLOADP OUTP 0 5p
CLOADN OUTN 0 5p
.control
set noaskquit
save time v(OUTP) v(OUTN)
tran 1u 3m
wrdata ../results/afe_ln_cm_@TAG@.csv time v(OUTP) v(OUTN)
quit
.endc
.end
