* Standard verification bench: internal-chopper PGA x32, pseudo-R bias, RST.
* 2026-09-05 design point: f_chop=1 kHz (was 8 kHz). Rationale: chopped-Cf
* intrinsic HP corner fc~f_chop/770; at 8 kHz fc~5 Hz caused -22% gain at
* 8 Hz. DSL/Rf/PFL alternatives were all evaluated and rejected (noise /
* beta-collapse / 4-8 Hz resonance). Residual: fc~1.3 Hz rolloff.
* Lessons baked in: RST clears the t=0 op garbage; pseudo-R settles it in
* ~0.3-1 s; measure with LS-fit (scripts/lsfit_gain.py), not windowed FFT.
* sed tokens: tt 1.80 27 @TAG@  (TT: tt 1.80 27)
.lib /Users/noah/.volare/volare/sky130/versions/0fe599b2afb6708d281543108caf8310912f54af/sky130A/libs.tech/ngspice/sky130.lib.spice tt
.temp 27
.include eeg_tg_lowq.spice
.include afe_ln_core_soft.spice
.include eeg_bias_gen.spice
.include afe_ln_ota_full2.spice
.include eeg_pseudo_res.spice
.param VDD=1.80 VCM={1.80/2} TCHOP=1m
VDD_SRC VDD18 0 {VDD}
VREF VCM_REF 0 {VCM}
VPHI PHI 0 PULSE(0 {VDD} 50n 20n 20n 499.85u {TCHOP})
VPHIB PHIB 0 PULSE(0 {VDD} 500.05u 20n 20n 499.85u {TCHOP})
BNPHI NPHI 0 V={VDD}-v(PHI)
BNPHIB NPHIB 0 V={VDD}-v(PHIB)
VSIGP SIGP 0 SIN({VCM} 100u 8)
VSIGN SIGN 0 SIN({VCM} 100u 8 0 0 180)
CINP SIGP INP 32p
CINN SIGN INN 32p
CFP OUTN INP 1p
CFN OUTP INN 1p
XPRP INP VCM_REF eeg_pseudo_res
XPRN INN VCM_REF eeg_pseudo_res
VRST RST 0 PULSE({VDD} 0 5m 100n 100n 1 1)
BRSTN NRST 0 V={VDD}-v(RST)
XRSTP INP VCM_REF RST NRST VDD18 0 eeg_tg_lowq
XRSTN INN VCM_REF RST NRST VDD18 0 eeg_tg_lowq
XAFE INP INN VCM_REF OUTP OUTN PHI NPHI PHIB NPHIB PHI NPHI PHIB NPHIB VDD18 0 afe_ln_ota_chopped_full2 S1RLOAD=20Meg RLOAD=20Meg
CLOADP OUTP 0 5p
CLOADN OUTN 0 5p
* settled-state guide (from the 3 s settle run, TT)
.nodeset v(INP)=0.9 v(INN)=0.9 v(XAFE.INP_M)=0.9 v(XAFE.INN_M)=0.9 v(XAFE.N1P)=0.932 v(XAFE.N1N)=0.932 v(XAFE.N2P)=0.932 v(XAFE.N2N)=0.932 v(XAFE.VBP1)=0.6155 v(XAFE.VBP2)=0.3848 v(OUTP)=0.9267 v(OUTN)=0.9267
.control
set noaskquit
* limit saved vectors: full-batch save of all nodes needs >10 GB RAM per run
save time v(OUTP) v(OUTN) i(VDD_SRC)
tran 100n 0.25s
wrdata ../results/afe_ln_real_vr.csv time v(OUTP) v(OUTN)
let idd=-i(VDD_SRC)
meas tran idd_avg avg idd from=0.2s to=0.25s
let vcmout=(v(OUTP)+v(OUTN))/2
meas tran vcm_avg avg vcmout from=0.2s to=0.25s
quit
.endc
.end
