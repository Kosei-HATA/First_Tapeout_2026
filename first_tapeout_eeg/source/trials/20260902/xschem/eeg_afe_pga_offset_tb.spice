* Tapeout AFE top (x32): pseudo-R bias, +300 mV electrode differential offset,
* 100 Hz EEG signal, chopped operation.
.lib /Users/noah/.volare/volare/sky130/versions/0fe599b2afb6708d281543108caf8310912f54af/sky130A/libs.tech/ngspice/sky130.lib.spice tt
.include eeg_tg_lowq.spice
.include eeg_fd_ota_core_soft.spice
.include eeg_bias_gen.spice
.include eeg_fd_ota_chopped_full2.spice
.include eeg_pseudo_res.spice
.include eeg_afe_pga.spice
.param VDD=1.80 VCM=0.9 TCHOP=125u
VDD_SRC VDD18 0 {VDD}
VREF VCM_REF 0 {VCM}
VPHI PHI 0 PULSE(0 {VDD} 50n 20n 20n 62.35u {TCHOP})
VPHIB PHIB 0 PULSE(0 {VDD} 62.55u 20n 20n 62.35u {TCHOP})
BNPHI NPHI 0 V={VDD}-v(PHI)
BNPHIB NPHIB 0 V={VDD}-v(PHIB)
* electrodes: 300 mV differential offset + 500 uV 100 Hz signal
VELP ELP 0 {VCM+150m}
VELN ELN 0 {VCM-150m}
VSGP ELP ELP2 SIN(0 500u 100)
VSGN ELN ELN2 SIN(0 500u 100 0 0 180)
VS8 S8N 0 0
VS16 S16N 0 0
VS32 S32N 0 {VDD}
VS64 S64N 0 0
VRST RSTN 0 PULSE({VDD} 0 2m 100n 100n 1 1)
XAFE ELP2 ELN2 VCM_REF OUTP OUTN PHI NPHI PHIB NPHIB PHI NPHI PHIB NPHIB S8N S16N S32N S64N RSTN VDD18 0 eeg_afe_pga
CLOADP OUTP 0 5p
CLOADN OUTN 0 5p
.control
set noaskquit
tran 50n 25m 5m
let voutd=v(OUTP)-v(OUTN)
let vcmout=(v(OUTP)+v(OUTN))/2
meas tran vcm_avg avg vcmout from=20m to=25m
meas tran vcm_pp pp vcmout from=15m to=25m
meas tran inp_dc find v(XAFE.INP) at=24m
wrdata ../results/afe_pga_offset.csv time voutd vcmout v(XAFE.INP) v(XAFE.INN)
quit
.endc
.end
