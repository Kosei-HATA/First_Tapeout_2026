* NGSPICE flat PEX netlist for eeg_afe_pga (sky130A)
* Devices: magic `ext2spice lvs` netlist, hierarchy inlined by ext2pex.py
* (parallel fingers/unit devices merged: exact BSIM equivalence);
* Parasitic capacitors: magic .ext database (node->substrate, cap->coupling)
* sky130A extraction excludes FET gate/diffusion caps (kept in BSIM
* ad/as/pd/ps terms), so no double counting. Caps in farads.
* totals: 544 devices (346 parallel merged), 3282 caps (4087.236 fF substrate + 11459.673 fF coupling)

.subckt eeg_afe_pga S16 NPHIBM OUTP OUTN NPHII S32 S64 PHIM NPHIM PHIBI ELP ELN VDD18 RST VSS S8 PHII PHIBM VCM_REF NPHIBI
X0 VDD18 eeg_fd_ota_chopped_full2_0/eeg_bias_gen_0/VBP eeg_fd_ota_chopped_full2_0/eeg_bias_gen_0/VBN VDD18 sky130_fd_pr__pfet_01v8 ad=5.1 pd=12.04 as=1.25 ps=5.5 w=5 l=4 nf=1
X1 eeg_fd_ota_chopped_full2_0/eeg_bias_gen_0/VBN eeg_fd_ota_chopped_full2_0/eeg_bias_gen_0/VBP VDD18 VDD18 sky130_fd_pr__pfet_01v8 ad=1.25 pd=5.5 as=5.1 ps=12.04 w=5 l=4 nf=1
R2 eeg_fd_ota_chopped_full2_0/eeg_bias_gen_0/m1_6341_n27552# eeg_fd_ota_chopped_full2_0/eeg_bias_gen_0/m1_6741_n20245# 100000
X3 eeg_fd_ota_chopped_full2_0/eeg_bias_gen_0/VBN eeg_fd_ota_chopped_full2_0/eeg_bias_gen_0/eeg_pseudo_res_0/m1_68_66# eeg_fd_ota_chopped_full2_0/eeg_bias_gen_0/eeg_pseudo_res_0/m1_68_66# eeg_fd_ota_chopped_full2_0/eeg_bias_gen_0/VBN sky130_fd_pr__pfet_01v8 ad=1.02 pd=4.04 as=1.02 ps=4.04 w=1 l=4 nf=1
X4 VDD18 eeg_fd_ota_chopped_full2_0/eeg_bias_gen_0/eeg_pseudo_res_0/m1_68_66# eeg_fd_ota_chopped_full2_0/eeg_bias_gen_0/eeg_pseudo_res_0/m1_68_66# VDD18 sky130_fd_pr__pfet_01v8 ad=1.02 pd=4.04 as=1.02 ps=4.04 w=1 l=4 nf=1
R5 eeg_fd_ota_chopped_full2_0/eeg_bias_gen_0/m1_10859_n29089# eeg_fd_ota_chopped_full2_0/eeg_bias_gen_0/m1_10459_n36396# 100000
X6 eeg_fd_ota_chopped_full2_0/eeg_bias_gen_0/VBN eeg_fd_ota_chopped_full2_0/eeg_bias_gen_0/VBN VSS VSS sky130_fd_pr__nfet_01v8 ad=1.25 pd=5.5 as=5.1 ps=12.04 w=5 l=4 nf=1
X7 VSS eeg_fd_ota_chopped_full2_0/eeg_bias_gen_0/VBN eeg_fd_ota_chopped_full2_0/eeg_bias_gen_0/VBN VSS sky130_fd_pr__nfet_01v8 ad=5.1 pd=12.04 as=1.25 ps=5.5 w=5 l=4 nf=1
R8 eeg_fd_ota_chopped_full2_0/eeg_bias_gen_0/m1_5941_n20245# eeg_fd_ota_chopped_full2_0/eeg_bias_gen_0/m1_6341_n27552# 100000
R9 eeg_fd_ota_chopped_full2_0/eeg_bias_gen_0/m1_10341_n27552# eeg_fd_ota_chopped_full2_0/eeg_bias_gen_0/m1_10741_n20245# 100000
R10 eeg_fd_ota_chopped_full2_0/eeg_bias_gen_0/m1_2524_466# VSS 24985.5
R11 eeg_fd_ota_chopped_full2_0/eeg_bias_gen_0/m1_11259_n36396# eeg_fd_ota_chopped_full2_0/eeg_bias_gen_0/m1_10859_n29089# 100000
R12 eeg_fd_ota_chopped_full2_0/eeg_bias_gen_0/m1_11141_n9864# eeg_fd_ota_chopped_full2_0/eeg_bias_gen_0/VBNF 100000
R13 eeg_fd_ota_chopped_full2_0/eeg_bias_gen_0/m1_11541_n37933# eeg_fd_ota_chopped_full2_0/eeg_bias_gen_0/m1_11259_n36396# 100000
R14 eeg_fd_ota_chopped_full2_0/eeg_bias_gen_0/m1_5541_n27552# eeg_fd_ota_chopped_full2_0/eeg_bias_gen_0/m1_5941_n20245# 100000
R15 eeg_fd_ota_chopped_full2_0/eeg_bias_gen_0/m1_9941_n20245# eeg_fd_ota_chopped_full2_0/eeg_bias_gen_0/m1_10341_n27552# 100000
R16 eeg_fd_ota_chopped_full2_0/eeg_bias_gen_0/m1_10741_n2557# eeg_fd_ota_chopped_full2_0/eeg_bias_gen_0/m1_11141_n9864# 100000
R17 eeg_fd_ota_chopped_full2_0/eeg_bias_gen_0/m1_5141_n20245# eeg_fd_ota_chopped_full2_0/eeg_bias_gen_0/m1_5541_n27552# 100000
R18 eeg_fd_ota_chopped_full2_0/eeg_bias_gen_0/m1_9541_n27552# eeg_fd_ota_chopped_full2_0/eeg_bias_gen_0/m1_9941_n20245# 100000
R19 eeg_fd_ota_chopped_full2_0/eeg_bias_gen_0/m1_5259_n11401# eeg_fd_ota_chopped_full2_0/eeg_bias_gen_0/m1_4859_n18708# 100000
R20 eeg_fd_ota_chopped_full2_0/eeg_bias_gen_0/m1_11141_n45240# eeg_fd_ota_chopped_full2_0/eeg_bias_gen_0/m1_11541_n37933# 100000
R21 eeg_fd_ota_chopped_full2_0/eeg_bias_gen_0/m1_10341_n9864# eeg_fd_ota_chopped_full2_0/eeg_bias_gen_0/m1_10741_n2557# 100000
R22 eeg_fd_ota_chopped_full2_0/eeg_bias_gen_0/m1_4741_n27552# eeg_fd_ota_chopped_full2_0/eeg_bias_gen_0/m1_5141_n20245# 100000
R23 eeg_fd_ota_chopped_full2_0/eeg_bias_gen_0/m1_9141_n20245# eeg_fd_ota_chopped_full2_0/eeg_bias_gen_0/m1_9541_n27552# 100000
R24 eeg_fd_ota_chopped_full2_0/eeg_bias_gen_0/m1_5659_n18708# eeg_fd_ota_chopped_full2_0/eeg_bias_gen_0/m1_5259_n11401# 100000
R25 eeg_fd_ota_chopped_full2_0/eeg_bias_gen_0/m1_5941_n2557# eeg_fd_ota_chopped_full2_0/eeg_bias_gen_0/m1_6341_n9864# 100000
R26 eeg_fd_ota_chopped_full2_0/eeg_bias_gen_0/m1_10741_n37933# eeg_fd_ota_chopped_full2_0/eeg_bias_gen_0/m1_11141_n45240# 100000
R27 eeg_fd_ota_chopped_full2_0/eeg_bias_gen_0/m1_4341_n20245# eeg_fd_ota_chopped_full2_0/eeg_bias_gen_0/m1_4741_n27552# 100000
R28 eeg_fd_ota_chopped_full2_0/eeg_bias_gen_0/m1_8741_n27552# eeg_fd_ota_chopped_full2_0/eeg_bias_gen_0/m1_9141_n20245# 100000
R29 eeg_fd_ota_chopped_full2_0/eeg_bias_gen_0/m1_6059_n11401# eeg_fd_ota_chopped_full2_0/eeg_bias_gen_0/m1_5659_n18708# 100000
R30 eeg_fd_ota_chopped_full2_0/eeg_bias_gen_0/m1_10059_n11401# eeg_fd_ota_chopped_full2_0/eeg_bias_gen_0/m1_9659_n18708# 100000
R31 eeg_fd_ota_chopped_full2_0/eeg_bias_gen_0/m1_10859_n11401# eeg_fd_ota_chopped_full2_0/eeg_bias_gen_0/m1_10459_n18708# 100000
R32 eeg_fd_ota_chopped_full2_0/eeg_bias_gen_0/m1_5541_n9864# eeg_fd_ota_chopped_full2_0/eeg_bias_gen_0/m1_5941_n2557# 100000
R33 eeg_fd_ota_chopped_full2_0/eeg_bias_gen_0/m1_10341_n45240# eeg_fd_ota_chopped_full2_0/eeg_bias_gen_0/m1_10741_n37933# 100000
X34 VDD18 eeg_fd_ota_chopped_full2_0/eeg_bias_gen_0/VBP eeg_fd_ota_chopped_full2_0/eeg_bias_gen_0/VBP VDD18 sky130_fd_pr__pfet_01v8 ad=5.1 pd=12.04 as=1.25 ps=5.5 w=5 l=4 nf=1
X35 eeg_fd_ota_chopped_full2_0/eeg_bias_gen_0/VBP eeg_fd_ota_chopped_full2_0/eeg_bias_gen_0/VBP VDD18 VDD18 sky130_fd_pr__pfet_01v8 ad=1.25 pd=5.5 as=5.1 ps=12.04 w=5 l=4 nf=1
R36 eeg_fd_ota_chopped_full2_0/eeg_bias_gen_0/m1_5941_n37933# eeg_fd_ota_chopped_full2_0/eeg_bias_gen_0/m1_6341_n45240# 100000
R37 eeg_fd_ota_chopped_full2_0/eeg_bias_gen_0/m1_3941_n27552# eeg_fd_ota_chopped_full2_0/eeg_bias_gen_0/m1_4341_n20245# 100000
R38 eeg_fd_ota_chopped_full2_0/eeg_bias_gen_0/m1_8341_n20245# eeg_fd_ota_chopped_full2_0/eeg_bias_gen_0/m1_8741_n27552# 100000
R39 eeg_fd_ota_chopped_full2_0/eeg_bias_gen_0/m1_6459_n18708# eeg_fd_ota_chopped_full2_0/eeg_bias_gen_0/m1_6059_n11401# 100000
R40 eeg_fd_ota_chopped_full2_0/eeg_bias_gen_0/m1_11259_n18708# eeg_fd_ota_chopped_full2_0/eeg_bias_gen_0/m1_10859_n11401# 100000
R41 eeg_fd_ota_chopped_full2_0/eeg_bias_gen_0/m1_5141_n2557# eeg_fd_ota_chopped_full2_0/eeg_bias_gen_0/m1_5541_n9864# 100000
R42 eeg_fd_ota_chopped_full2_0/eeg_bias_gen_0/m1_9541_n9864# eeg_fd_ota_chopped_full2_0/eeg_bias_gen_0/m1_9941_n2557# 100000
R43 eeg_fd_ota_chopped_full2_0/eeg_bias_gen_0/m1_5259_n29089# eeg_fd_ota_chopped_full2_0/eeg_bias_gen_0/m1_4859_n36396# 100000
R44 eeg_fd_ota_chopped_full2_0/eeg_bias_gen_0/VBN eeg_fd_ota_chopped_full2_0/eeg_bias_gen_0/m1_3941_n45240# 100000
R45 eeg_fd_ota_chopped_full2_0/eeg_bias_gen_0/m1_5541_n45240# eeg_fd_ota_chopped_full2_0/eeg_bias_gen_0/m1_5941_n37933# 100000
R46 eeg_fd_ota_chopped_full2_0/eeg_bias_gen_0/m1_3701_n29089# eeg_fd_ota_chopped_full2_0/eeg_bias_gen_0/m1_3941_n27552# 100000
R47 eeg_fd_ota_chopped_full2_0/eeg_bias_gen_0/m1_7941_n27552# eeg_fd_ota_chopped_full2_0/eeg_bias_gen_0/m1_8341_n20245# 100000
R48 eeg_fd_ota_chopped_full2_0/eeg_bias_gen_0/m1_6859_n11401# eeg_fd_ota_chopped_full2_0/eeg_bias_gen_0/m1_6459_n18708# 100000
R49 eeg_fd_ota_chopped_full2_0/eeg_bias_gen_0/m1_11541_n20245# eeg_fd_ota_chopped_full2_0/eeg_bias_gen_0/m1_11259_n18708# 100000
R50 eeg_fd_ota_chopped_full2_0/eeg_bias_gen_0/m1_4741_n9864# eeg_fd_ota_chopped_full2_0/eeg_bias_gen_0/m1_5141_n2557# 100000
R51 eeg_fd_ota_chopped_full2_0/eeg_bias_gen_0/m1_9141_n2557# eeg_fd_ota_chopped_full2_0/eeg_bias_gen_0/m1_9541_n9864# 100000
R52 eeg_fd_ota_chopped_full2_0/eeg_bias_gen_0/m1_5659_n36396# eeg_fd_ota_chopped_full2_0/eeg_bias_gen_0/m1_5259_n29089# 100000
R53 eeg_fd_ota_chopped_full2_0/eeg_bias_gen_0/m1_9941_n2557# eeg_fd_ota_chopped_full2_0/eeg_bias_gen_0/m1_10341_n9864# 100000
R54 eeg_fd_ota_chopped_full2_0/eeg_bias_gen_0/m1_5141_n37933# eeg_fd_ota_chopped_full2_0/eeg_bias_gen_0/m1_5541_n45240# 100000
R55 eeg_fd_ota_chopped_full2_0/eeg_bias_gen_0/m1_9541_n45240# eeg_fd_ota_chopped_full2_0/eeg_bias_gen_0/m1_9941_n37933# 100000
R56 eeg_fd_ota_chopped_full2_0/eeg_bias_gen_0/m1_6859_n29089# eeg_fd_ota_chopped_full2_0/eeg_bias_gen_0/m1_6459_n36396# 100000
R57 eeg_fd_ota_chopped_full2_0/eeg_bias_gen_0/m1_10459_n36396# eeg_fd_ota_chopped_full2_0/eeg_bias_gen_0/m1_10059_n29089# 100000
R58 eeg_fd_ota_chopped_full2_0/eeg_bias_gen_0/m1_7541_n20245# eeg_fd_ota_chopped_full2_0/eeg_bias_gen_0/m1_7941_n27552# 100000
R59 eeg_fd_ota_chopped_full2_0/eeg_bias_gen_0/m1_7259_n18708# eeg_fd_ota_chopped_full2_0/eeg_bias_gen_0/m1_6859_n11401# 100000
R60 eeg_fd_ota_chopped_full2_0/eeg_bias_gen_0/m1_4341_n2557# eeg_fd_ota_chopped_full2_0/eeg_bias_gen_0/m1_4741_n9864# 100000
R61 eeg_fd_ota_chopped_full2_0/eeg_bias_gen_0/m1_8741_n9864# eeg_fd_ota_chopped_full2_0/eeg_bias_gen_0/m1_9141_n2557# 100000
R62 eeg_fd_ota_chopped_full2_0/eeg_bias_gen_0/m1_6059_n29089# eeg_fd_ota_chopped_full2_0/eeg_bias_gen_0/m1_5659_n36396# 100000
R63 eeg_fd_ota_chopped_full2_0/eeg_bias_gen_0/m1_4741_n45240# eeg_fd_ota_chopped_full2_0/eeg_bias_gen_0/m1_5141_n37933# 100000
R64 eeg_fd_ota_chopped_full2_0/eeg_bias_gen_0/m1_9141_n37933# eeg_fd_ota_chopped_full2_0/eeg_bias_gen_0/m1_9541_n45240# 100000
R65 eeg_fd_ota_chopped_full2_0/eeg_bias_gen_0/m1_9941_n37933# eeg_fd_ota_chopped_full2_0/eeg_bias_gen_0/m1_10341_n45240# 100000
R66 eeg_fd_ota_chopped_full2_0/eeg_bias_gen_0/m1_7259_n36396# eeg_fd_ota_chopped_full2_0/eeg_bias_gen_0/m1_6859_n29089# 100000
R67 eeg_fd_ota_chopped_full2_0/eeg_bias_gen_0/m1_7141_n27552# eeg_fd_ota_chopped_full2_0/eeg_bias_gen_0/m1_7541_n20245# 100000
R68 eeg_fd_ota_chopped_full2_0/eeg_bias_gen_0/m1_7659_n11401# eeg_fd_ota_chopped_full2_0/eeg_bias_gen_0/m1_7259_n18708# 100000
R69 eeg_fd_ota_chopped_full2_0/eeg_bias_gen_0/m1_10459_n18708# eeg_fd_ota_chopped_full2_0/eeg_bias_gen_0/m1_10059_n11401# 100000
R70 eeg_fd_ota_chopped_full2_0/eeg_bias_gen_0/m1_3941_n9864# eeg_fd_ota_chopped_full2_0/eeg_bias_gen_0/m1_4341_n2557# 100000
R71 eeg_fd_ota_chopped_full2_0/eeg_bias_gen_0/m1_8341_n2557# eeg_fd_ota_chopped_full2_0/eeg_bias_gen_0/m1_8741_n9864# 100000
R72 eeg_fd_ota_chopped_full2_0/eeg_bias_gen_0/m1_6459_n36396# eeg_fd_ota_chopped_full2_0/eeg_bias_gen_0/m1_6059_n29089# 100000
R73 eeg_fd_ota_chopped_full2_0/eeg_bias_gen_0/m1_4341_n37933# eeg_fd_ota_chopped_full2_0/eeg_bias_gen_0/m1_4741_n45240# 100000
R74 eeg_fd_ota_chopped_full2_0/eeg_bias_gen_0/m1_8741_n45240# eeg_fd_ota_chopped_full2_0/eeg_bias_gen_0/m1_9141_n37933# 100000
R75 eeg_fd_ota_chopped_full2_0/eeg_bias_gen_0/m1_7659_n29089# eeg_fd_ota_chopped_full2_0/eeg_bias_gen_0/m1_7259_n36396# 100000
R76 eeg_fd_ota_chopped_full2_0/eeg_bias_gen_0/m1_6741_n20245# eeg_fd_ota_chopped_full2_0/eeg_bias_gen_0/m1_7141_n27552# 100000
R77 eeg_fd_ota_chopped_full2_0/eeg_bias_gen_0/m1_11141_n27552# eeg_fd_ota_chopped_full2_0/eeg_bias_gen_0/m1_11541_n20245# 100000
R78 eeg_fd_ota_chopped_full2_0/eeg_bias_gen_0/m1_8059_n18708# eeg_fd_ota_chopped_full2_0/eeg_bias_gen_0/m1_7659_n11401# 100000
R79 eeg_fd_ota_chopped_full2_0/eeg_bias_gen_0/m1_3701_n11401# eeg_fd_ota_chopped_full2_0/eeg_bias_gen_0/m1_3941_n9864# 100000
R80 eeg_fd_ota_chopped_full2_0/eeg_bias_gen_0/m1_7941_n9864# eeg_fd_ota_chopped_full2_0/eeg_bias_gen_0/m1_8341_n2557# 100000
R81 eeg_fd_ota_chopped_full2_0/eeg_bias_gen_0/m1_8341_n37933# eeg_fd_ota_chopped_full2_0/eeg_bias_gen_0/m1_8741_n45240# 100000
R82 eeg_fd_ota_chopped_full2_0/eeg_bias_gen_0/m1_4059_n36396# eeg_fd_ota_chopped_full2_0/eeg_bias_gen_0/m1_3701_n29089# 100000
R83 eeg_fd_ota_chopped_full2_0/eeg_bias_gen_0/m1_8059_n36396# eeg_fd_ota_chopped_full2_0/eeg_bias_gen_0/m1_7659_n29089# 100000
R84 eeg_fd_ota_chopped_full2_0/eeg_bias_gen_0/m1_10741_n20245# eeg_fd_ota_chopped_full2_0/eeg_bias_gen_0/m1_11141_n27552# 100000
R85 eeg_fd_ota_chopped_full2_0/eeg_bias_gen_0/m1_4059_n18708# eeg_fd_ota_chopped_full2_0/eeg_bias_gen_0/m1_3701_n11401# 100000
R86 eeg_fd_ota_chopped_full2_0/eeg_bias_gen_0/m1_8459_n11401# eeg_fd_ota_chopped_full2_0/eeg_bias_gen_0/m1_8059_n18708# 100000
R87 eeg_fd_ota_chopped_full2_0/eeg_bias_gen_0/m1_7541_n2557# eeg_fd_ota_chopped_full2_0/eeg_bias_gen_0/m1_7941_n9864# 100000
R88 eeg_fd_ota_chopped_full2_0/eeg_bias_gen_0/m1_7941_n45240# eeg_fd_ota_chopped_full2_0/eeg_bias_gen_0/m1_8341_n37933# 100000
R89 eeg_fd_ota_chopped_full2_0/eeg_bias_gen_0/m1_4459_n29089# eeg_fd_ota_chopped_full2_0/eeg_bias_gen_0/m1_4059_n36396# 100000
R90 eeg_fd_ota_chopped_full2_0/eeg_bias_gen_0/m1_8459_n29089# eeg_fd_ota_chopped_full2_0/eeg_bias_gen_0/m1_8059_n36396# 100000
R91 eeg_fd_ota_chopped_full2_0/eeg_bias_gen_0/m1_4459_n11401# eeg_fd_ota_chopped_full2_0/eeg_bias_gen_0/m1_4059_n18708# 100000
R92 eeg_fd_ota_chopped_full2_0/eeg_bias_gen_0/m1_8859_n18708# eeg_fd_ota_chopped_full2_0/eeg_bias_gen_0/m1_8459_n11401# 100000
R93 eeg_fd_ota_chopped_full2_0/eeg_bias_gen_0/m1_7141_n9864# eeg_fd_ota_chopped_full2_0/eeg_bias_gen_0/m1_7541_n2557# 100000
R94 eeg_fd_ota_chopped_full2_0/eeg_bias_gen_0/m1_7541_n37933# eeg_fd_ota_chopped_full2_0/eeg_bias_gen_0/m1_7941_n45240# 100000
R95 eeg_fd_ota_chopped_full2_0/eeg_bias_gen_0/m1_4859_n36396# eeg_fd_ota_chopped_full2_0/eeg_bias_gen_0/m1_4459_n29089# 100000
R96 eeg_fd_ota_chopped_full2_0/eeg_bias_gen_0/m1_8859_n36396# eeg_fd_ota_chopped_full2_0/eeg_bias_gen_0/m1_8459_n29089# 100000
R97 eeg_fd_ota_chopped_full2_0/eeg_bias_gen_0/m1_4859_n18708# eeg_fd_ota_chopped_full2_0/eeg_bias_gen_0/m1_4459_n11401# 100000
R98 eeg_fd_ota_chopped_full2_0/eeg_bias_gen_0/m1_6741_n2557# eeg_fd_ota_chopped_full2_0/eeg_bias_gen_0/m1_7141_n9864# 100000
R99 eeg_fd_ota_chopped_full2_0/eeg_bias_gen_0/m1_7141_n45240# eeg_fd_ota_chopped_full2_0/eeg_bias_gen_0/m1_7541_n37933# 100000
R100 eeg_fd_ota_chopped_full2_0/eeg_bias_gen_0/m1_9259_n29089# eeg_fd_ota_chopped_full2_0/eeg_bias_gen_0/m1_8859_n36396# 100000
R101 eeg_fd_ota_chopped_full2_0/eeg_bias_gen_0/m1_9259_n11401# eeg_fd_ota_chopped_full2_0/eeg_bias_gen_0/m1_8859_n18708# 100000
R102 eeg_fd_ota_chopped_full2_0/eeg_bias_gen_0/m1_6341_n9864# eeg_fd_ota_chopped_full2_0/eeg_bias_gen_0/m1_6741_n2557# 100000
R103 eeg_fd_ota_chopped_full2_0/eeg_bias_gen_0/m1_6741_n37933# eeg_fd_ota_chopped_full2_0/eeg_bias_gen_0/m1_7141_n45240# 100000
R104 eeg_fd_ota_chopped_full2_0/eeg_bias_gen_0/m1_9659_n36396# eeg_fd_ota_chopped_full2_0/eeg_bias_gen_0/m1_9259_n29089# 100000
R105 eeg_fd_ota_chopped_full2_0/eeg_bias_gen_0/m1_9659_n18708# eeg_fd_ota_chopped_full2_0/eeg_bias_gen_0/m1_9259_n11401# 100000
R106 eeg_fd_ota_chopped_full2_0/eeg_bias_gen_0/m1_6341_n45240# eeg_fd_ota_chopped_full2_0/eeg_bias_gen_0/m1_6741_n37933# 100000
R107 eeg_fd_ota_chopped_full2_0/eeg_bias_gen_0/m1_10059_n29089# eeg_fd_ota_chopped_full2_0/eeg_bias_gen_0/m1_9659_n36396# 100000
R108 eeg_fd_ota_chopped_full2_0/eeg_bias_gen_0/m1_3941_n45240# eeg_fd_ota_chopped_full2_0/eeg_bias_gen_0/m1_4341_n37933# 100000
X109 eeg_fd_ota_chopped_full2_0/eeg_bias_gen_0/VBP eeg_fd_ota_chopped_full2_0/eeg_bias_gen_0/VBN eeg_fd_ota_chopped_full2_0/eeg_bias_gen_0/m1_2524_466# VSS sky130_fd_pr__nfet_01v8 ad=5 pd=22 as=8.85 ps=28.54 w=20 l=4 nf=4
X112 eeg_fd_ota_chopped_full2_0/eeg_bias_gen_0/m1_2524_466# eeg_fd_ota_chopped_full2_0/eeg_bias_gen_0/VBN eeg_fd_ota_chopped_full2_0/eeg_bias_gen_0/VBP VSS sky130_fd_pr__nfet_01v8 ad=8.85 pd=28.54 as=5 ps=22 w=20 l=4 nf=4
CMIM117 eeg_fd_ota_chopped_full2_0/eeg_bias_gen_0/VBNF VSS 1.000000e-10
X242 eeg_fd_ota_chopped_full2_0/eeg_cmfb_amp_dl2_s2_0/m1_370_1493# eeg_fd_ota_chopped_full2_0/eeg_cmfb_amp_dl2_s2_0/m1_370_1493# VDD18 VDD18 sky130_fd_pr__pfet_01v8 ad=2.04 pd=6.04 as=2.04 ps=6.04 w=2 l=2 nf=1
X243 eeg_fd_ota_chopped_full2_0/eeg_cmfb_amp_dl2_s2_0/m1_370_1493# eeg_fd_ota_chopped_full2_0/stage2_0/VCM2 eeg_fd_ota_chopped_full2_0/eeg_cmfb_amp_dl2_s2_0/m1_68_166# VSS sky130_fd_pr__nfet_01v8 ad=2.04 pd=6.04 as=2.04 ps=6.04 w=2 l=2 nf=1
X244 eeg_fd_ota_chopped_full2_0/eeg_cmfb_amp_dl2_s2_0/m1_68_166# eeg_fd_ota_chopped_full2_0/eeg_bias_gen_0/VBNF VSS VSS sky130_fd_pr__nfet_01v8 ad=1.5 pd=6.5 as=6.12 ps=14.04 w=6 l=4 nf=1
X245 VSS eeg_fd_ota_chopped_full2_0/eeg_bias_gen_0/VBNF eeg_fd_ota_chopped_full2_0/eeg_cmfb_amp_dl2_s2_0/m1_68_166# VSS sky130_fd_pr__nfet_01v8 ad=6.12 pd=14.04 as=1.5 ps=6.5 w=6 l=4 nf=1
X246 eeg_fd_ota_chopped_full2_0/stage2_0/VBP2 eeg_fd_ota_chopped_full2_0/stage2_0/VBP2 VDD18 VDD18 sky130_fd_pr__pfet_01v8 ad=0.15 pd=1.6 as=0.15 ps=1.6 w=0.5 l=4 nf=1
X247 eeg_fd_ota_chopped_full2_0/stage2_0/VBP2 VCM_REF eeg_fd_ota_chopped_full2_0/eeg_cmfb_amp_dl2_s2_0/m1_68_166# VSS sky130_fd_pr__nfet_01v8 ad=2.04 pd=6.04 as=2.04 ps=6.04 w=2 l=2 nf=1
X248 eeg_fd_ota_chopped_full2_0/eeg_cmfb_amp_dl2_0/VBP eeg_fd_ota_chopped_full2_0/eeg_cmfb_amp_dl2_0/VBP VDD18 VDD18 sky130_fd_pr__pfet_01v8 ad=4.08 pd=10.04 as=4.08 ps=10.04 w=4 l=4 nf=1
X249 eeg_fd_ota_chopped_full2_0/eeg_cmfb_amp_dl2_0/VBP VCM_REF eeg_fd_ota_chopped_full2_0/eeg_cmfb_amp_dl2_0/m1_68_166# VSS sky130_fd_pr__nfet_01v8 ad=2.04 pd=6.04 as=2.04 ps=6.04 w=2 l=2 nf=1
X250 eeg_fd_ota_chopped_full2_0/eeg_cmfb_amp_dl2_0/m1_68_166# eeg_fd_ota_chopped_full2_0/eeg_bias_gen_0/VBNF VSS VSS sky130_fd_pr__nfet_01v8 ad=1.5 pd=6.5 as=6.12 ps=14.04 w=6 l=4 nf=1
X251 VSS eeg_fd_ota_chopped_full2_0/eeg_bias_gen_0/VBNF eeg_fd_ota_chopped_full2_0/eeg_cmfb_amp_dl2_0/m1_68_166# VSS sky130_fd_pr__nfet_01v8 ad=6.12 pd=14.04 as=1.5 ps=6.5 w=6 l=4 nf=1
X252 eeg_fd_ota_chopped_full2_0/eeg_cmfb_amp_dl2_0/m1_370_1493# eeg_fd_ota_chopped_full2_0/eeg_cmfb_amp_dl2_0/m1_370_1493# VDD18 VDD18 sky130_fd_pr__pfet_01v8 ad=2.04 pd=6.04 as=2.04 ps=6.04 w=2 l=2 nf=1
X253 eeg_fd_ota_chopped_full2_0/eeg_cmfb_amp_dl2_0/m1_370_1493# eeg_fd_ota_chopped_full2_0/eeg_cmfb_amp_dl2_0/VCM_SENSE eeg_fd_ota_chopped_full2_0/eeg_cmfb_amp_dl2_0/m1_68_166# VSS sky130_fd_pr__nfet_01v8 ad=2.04 pd=6.04 as=2.04 ps=6.04 w=2 l=2 nf=1
R254 eeg_fd_ota_chopped_full2_0/stage2_0/m1_58341_n8557# eeg_fd_ota_chopped_full2_0/stage2_0/m1_58741_n15864# 100000
R255 eeg_fd_ota_chopped_full2_0/stage2_0/m1_24741_n15864# eeg_fd_ota_chopped_full2_0/stage2_0/m1_25141_n8557# 100000
R256 eeg_fd_ota_chopped_full2_0/stage2_0/m1_20341_n8557# eeg_fd_ota_chopped_full2_0/stage2_0/m1_20741_n15864# 100000
R257 eeg_fd_ota_chopped_full2_0/stage2_0/m1_35941_n15864# eeg_fd_ota_chopped_full2_0/stage2_0/m1_36341_n8557# 100000
R258 eeg_fd_ota_chopped_full2_0/stage2_0/m1_79941_n8557# eeg_fd_ota_chopped_full2_0/stage2_0/m1_80341_n15864# 100000
R259 eeg_fd_ota_chopped_full2_0/stage2_0/m1_75541_n15864# eeg_fd_ota_chopped_full2_0/stage2_0/m1_75941_n8557# 100000
R260 eeg_fd_ota_chopped_full2_0/stage2_0/m1_69141_n8557# eeg_fd_ota_chopped_full2_0/stage2_0/m1_69541_n15864# 100000
R261 eeg_fd_ota_chopped_full2_0/stage2_0/m1_64741_n15864# eeg_fd_ota_chopped_full2_0/stage2_0/m1_65141_n8557# 100000
R262 eeg_fd_ota_chopped_full2_0/stage2_0/m1_57941_n15864# eeg_fd_ota_chopped_full2_0/stage2_0/m1_58341_n8557# 100000
R263 eeg_fd_ota_chopped_full2_0/stage2_0/m1_28741_n15864# eeg_fd_ota_chopped_full2_0/stage2_0/m1_29141_n8557# 100000
R264 eeg_fd_ota_chopped_full2_0/stage2_0/m1_24341_n8557# eeg_fd_ota_chopped_full2_0/stage2_0/m1_24741_n15864# 100000
R265 eeg_fd_ota_chopped_full2_0/stage2_0/m1_19941_n15864# eeg_fd_ota_chopped_full2_0/stage2_0/m1_20341_n8557# 100000
R266 eeg_fd_ota_chopped_full2_0/stage2_0/m1_35541_n8557# eeg_fd_ota_chopped_full2_0/stage2_0/m1_35941_n15864# 100000
R267 eeg_fd_ota_chopped_full2_0/stage2_0/m1_79541_n15864# eeg_fd_ota_chopped_full2_0/stage2_0/m1_79941_n8557# 100000
R268 eeg_fd_ota_chopped_full2_0/stage2_0/m1_75141_n8557# eeg_fd_ota_chopped_full2_0/stage2_0/m1_75541_n15864# 100000
R269 eeg_fd_ota_chopped_full2_0/stage2_0/m1_68741_n15864# eeg_fd_ota_chopped_full2_0/stage2_0/m1_69141_n8557# 100000
R270 eeg_fd_ota_chopped_full2_0/stage2_0/m1_64341_n8557# eeg_fd_ota_chopped_full2_0/stage2_0/m1_64741_n15864# 100000
R271 eeg_fd_ota_chopped_full2_0/stage2_0/m1_57541_n8557# eeg_fd_ota_chopped_full2_0/stage2_0/m1_57941_n15864# 100000
R272 eeg_fd_ota_chopped_full2_0/stage2_0/m1_28341_n8557# eeg_fd_ota_chopped_full2_0/stage2_0/m1_28741_n15864# 100000
R273 eeg_fd_ota_chopped_full2_0/stage2_0/m1_23941_n15864# eeg_fd_ota_chopped_full2_0/stage2_0/m1_24341_n8557# 100000
R274 OUTP eeg_fd_ota_chopped_full2_0/stage2_0/m1_19941_n15864# 100000
R275 eeg_fd_ota_chopped_full2_0/stage2_0/m1_35141_n15864# eeg_fd_ota_chopped_full2_0/stage2_0/m1_35541_n8557# 100000
R276 eeg_fd_ota_chopped_full2_0/stage2_0/m1_79141_n8557# eeg_fd_ota_chopped_full2_0/stage2_0/m1_79541_n15864# 100000
R277 eeg_fd_ota_chopped_full2_0/stage2_0/m1_74741_n15864# eeg_fd_ota_chopped_full2_0/stage2_0/m1_75141_n8557# 100000
R278 eeg_fd_ota_chopped_full2_0/stage2_0/m1_68341_n8557# eeg_fd_ota_chopped_full2_0/stage2_0/m1_68741_n15864# 100000
R279 eeg_fd_ota_chopped_full2_0/stage2_0/m1_63941_n15864# eeg_fd_ota_chopped_full2_0/stage2_0/m1_64341_n8557# 100000
R280 eeg_fd_ota_chopped_full2_0/stage2_0/m1_27941_n15864# eeg_fd_ota_chopped_full2_0/stage2_0/m1_28341_n8557# 100000
R281 eeg_fd_ota_chopped_full2_0/stage2_0/m1_23541_n8557# eeg_fd_ota_chopped_full2_0/stage2_0/m1_23941_n15864# 100000
R282 eeg_fd_ota_chopped_full2_0/stage2_0/m1_39141_n15864# eeg_fd_ota_chopped_full2_0/stage2_0/VCM2 100000
R283 eeg_fd_ota_chopped_full2_0/stage2_0/m1_34741_n8557# eeg_fd_ota_chopped_full2_0/stage2_0/m1_35141_n15864# 100000
R284 eeg_fd_ota_chopped_full2_0/stage2_0/m1_78741_n15864# eeg_fd_ota_chopped_full2_0/stage2_0/m1_79141_n8557# 100000
R285 eeg_fd_ota_chopped_full2_0/stage2_0/m1_74341_n8557# eeg_fd_ota_chopped_full2_0/stage2_0/m1_74741_n15864# 100000
R286 eeg_fd_ota_chopped_full2_0/stage2_0/m1_67941_n15864# eeg_fd_ota_chopped_full2_0/stage2_0/m1_68341_n8557# 100000
R287 OUTP eeg_fd_ota_chopped_full2_0/stage2_0/m1_63941_n15864# 100000
R288 eeg_fd_ota_chopped_full2_0/stage2_0/m1_27541_n8557# eeg_fd_ota_chopped_full2_0/stage2_0/m1_27941_n15864# 100000
R289 eeg_fd_ota_chopped_full2_0/stage2_0/m1_23141_n15864# eeg_fd_ota_chopped_full2_0/stage2_0/m1_23541_n8557# 100000
R290 eeg_fd_ota_chopped_full2_0/stage2_0/m1_38741_n8557# eeg_fd_ota_chopped_full2_0/stage2_0/m1_39141_n15864# 100000
R291 eeg_fd_ota_chopped_full2_0/stage2_0/m1_34341_n15864# eeg_fd_ota_chopped_full2_0/stage2_0/m1_34741_n8557# 100000
R292 eeg_fd_ota_chopped_full2_0/stage2_0/m1_78341_n8557# eeg_fd_ota_chopped_full2_0/stage2_0/m1_78741_n15864# 100000
R293 eeg_fd_ota_chopped_full2_0/stage2_0/m1_73941_n15864# eeg_fd_ota_chopped_full2_0/stage2_0/m1_74341_n8557# 100000
R294 eeg_fd_ota_chopped_full2_0/stage2_0/m1_67541_n8557# eeg_fd_ota_chopped_full2_0/stage2_0/m1_67941_n15864# 100000
R295 eeg_fd_ota_chopped_full2_0/stage2_0/m1_27141_n15864# eeg_fd_ota_chopped_full2_0/stage2_0/m1_27541_n8557# 100000
R296 eeg_fd_ota_chopped_full2_0/stage2_0/m1_22741_n8557# eeg_fd_ota_chopped_full2_0/stage2_0/m1_23141_n15864# 100000
R297 eeg_fd_ota_chopped_full2_0/stage2_0/m1_38341_n15864# eeg_fd_ota_chopped_full2_0/stage2_0/m1_38741_n8557# 100000
R298 eeg_fd_ota_chopped_full2_0/stage2_0/m1_33941_n8557# eeg_fd_ota_chopped_full2_0/stage2_0/m1_34341_n15864# 100000
R299 eeg_fd_ota_chopped_full2_0/stage2_0/m1_77941_n15864# eeg_fd_ota_chopped_full2_0/stage2_0/m1_78341_n8557# 100000
R300 OUTN eeg_fd_ota_chopped_full2_0/stage2_0/m1_73941_n15864# 100000
R301 eeg_fd_ota_chopped_full2_0/stage2_0/m1_26741_n8557# eeg_fd_ota_chopped_full2_0/stage2_0/m1_27141_n15864# 100000
R302 eeg_fd_ota_chopped_full2_0/stage2_0/m1_22341_n15864# eeg_fd_ota_chopped_full2_0/stage2_0/m1_22741_n8557# 100000
R303 eeg_fd_ota_chopped_full2_0/stage2_0/m1_37941_n8557# eeg_fd_ota_chopped_full2_0/stage2_0/m1_38341_n15864# 100000
R304 eeg_fd_ota_chopped_full2_0/stage2_0/m1_33541_n15864# eeg_fd_ota_chopped_full2_0/stage2_0/m1_33941_n8557# 100000
R305 eeg_fd_ota_chopped_full2_0/stage2_0/m1_77541_n8557# eeg_fd_ota_chopped_full2_0/stage2_0/m1_77941_n15864# 100000
R306 eeg_fd_ota_chopped_full2_0/stage2_0/m1_26341_n15864# eeg_fd_ota_chopped_full2_0/stage2_0/m1_26741_n8557# 100000
R307 eeg_fd_ota_chopped_full2_0/stage2_0/m1_21941_n8557# eeg_fd_ota_chopped_full2_0/stage2_0/m1_22341_n15864# 100000
R308 eeg_fd_ota_chopped_full2_0/stage2_0/m1_37541_n15864# eeg_fd_ota_chopped_full2_0/stage2_0/m1_37941_n8557# 100000
R309 eeg_fd_ota_chopped_full2_0/stage2_0/m1_33141_n8557# eeg_fd_ota_chopped_full2_0/stage2_0/m1_33541_n15864# 100000
R310 eeg_fd_ota_chopped_full2_0/stage2_0/m1_25941_n8557# eeg_fd_ota_chopped_full2_0/stage2_0/m1_26341_n15864# 100000
R311 eeg_fd_ota_chopped_full2_0/stage2_0/m1_21541_n15864# eeg_fd_ota_chopped_full2_0/stage2_0/m1_21941_n8557# 100000
R312 eeg_fd_ota_chopped_full2_0/stage2_0/m1_37141_n8557# eeg_fd_ota_chopped_full2_0/stage2_0/m1_37541_n15864# 100000
R313 eeg_fd_ota_chopped_full2_0/stage2_0/m1_25541_n15864# eeg_fd_ota_chopped_full2_0/stage2_0/m1_25941_n8557# 100000
R314 eeg_fd_ota_chopped_full2_0/stage2_0/m1_21141_n8557# eeg_fd_ota_chopped_full2_0/stage2_0/m1_21541_n15864# 100000
R315 eeg_fd_ota_chopped_full2_0/stage2_0/m1_25141_n8557# eeg_fd_ota_chopped_full2_0/stage2_0/m1_25541_n15864# 100000
X316 OUTN eeg_fd_ota_chopped_full2_0/stage2_0/VBP2 VDD18 VDD18 sky130_fd_pr__pfet_01v8 ad=6 pd=26 as=10.62 ps=33.54 w=24 l=12 nf=4
X317 VDD18 eeg_fd_ota_chopped_full2_0/stage2_0/VBP2 OUTN VDD18 sky130_fd_pr__pfet_01v8 ad=10.62 pd=33.54 as=6 ps=26 w=24 l=12 nf=4
R324 eeg_fd_ota_chopped_full2_0/stage2_0/m1_32741_n15864# eeg_fd_ota_chopped_full2_0/stage2_0/m1_33141_n8557# 100000
X325 OUTN eeg_fd_ota_chopped_full2_0/stage2_0/N2N VSS VSS sky130_fd_pr__nfet_01v8 ad=1.5 pd=6.5 as=6.12 ps=14.04 w=6 l=12 nf=1
X326 VSS eeg_fd_ota_chopped_full2_0/stage2_0/N2N OUTN VSS sky130_fd_pr__nfet_01v8 ad=6.12 pd=14.04 as=1.5 ps=6.5 w=6 l=12 nf=1
R327 eeg_fd_ota_chopped_full2_0/stage2_0/m1_32341_n8557# eeg_fd_ota_chopped_full2_0/stage2_0/m1_32741_n15864# 100000
R328 eeg_fd_ota_chopped_full2_0/stage2_0/m1_31941_n15864# eeg_fd_ota_chopped_full2_0/stage2_0/m1_32341_n8557# 100000
R329 eeg_fd_ota_chopped_full2_0/stage2_0/m1_31541_n8557# eeg_fd_ota_chopped_full2_0/stage2_0/m1_31941_n15864# 100000
R330 eeg_fd_ota_chopped_full2_0/stage2_0/m1_31141_n15864# eeg_fd_ota_chopped_full2_0/stage2_0/m1_31541_n8557# 100000
R331 eeg_fd_ota_chopped_full2_0/stage2_0/m1_30741_n8557# eeg_fd_ota_chopped_full2_0/stage2_0/m1_31141_n15864# 100000
R332 eeg_fd_ota_chopped_full2_0/stage2_0/m1_30341_n15864# eeg_fd_ota_chopped_full2_0/stage2_0/m1_30741_n8557# 100000
R333 eeg_fd_ota_chopped_full2_0/stage2_0/N2N eeg_fd_ota_chopped_full2_0/stage2_0/m1_12966_n5928# 20000
R334 eeg_fd_ota_chopped_full2_0/stage2_0/m1_29941_n8557# eeg_fd_ota_chopped_full2_0/stage2_0/m1_30341_n15864# 100000
R335 eeg_fd_ota_chopped_full2_0/stage2_0/m1_45141_n15864# eeg_fd_ota_chopped_full2_0/stage2_0/m1_45541_n8557# 100000
R336 eeg_fd_ota_chopped_full2_0/stage2_0/N2P eeg_fd_ota_chopped_full2_0/stage2_0/m1_3966_n5928# 20000
R337 eeg_fd_ota_chopped_full2_0/stage2_0/m1_29541_n15864# eeg_fd_ota_chopped_full2_0/stage2_0/m1_29941_n8557# 100000
R338 eeg_fd_ota_chopped_full2_0/stage2_0/m1_44741_n8557# eeg_fd_ota_chopped_full2_0/stage2_0/m1_45141_n15864# 100000
R339 eeg_fd_ota_chopped_full2_0/stage2_0/m1_49141_n15864# eeg_fd_ota_chopped_full2_0/stage2_0/m1_49541_n8557# 100000
R340 eeg_fd_ota_chopped_full2_0/stage2_0/m1_29141_n8557# eeg_fd_ota_chopped_full2_0/stage2_0/m1_29541_n15864# 100000
R341 eeg_fd_ota_chopped_full2_0/stage2_0/m1_44341_n15864# eeg_fd_ota_chopped_full2_0/stage2_0/m1_44741_n8557# 100000
R342 eeg_fd_ota_chopped_full2_0/stage2_0/m1_48741_n8557# eeg_fd_ota_chopped_full2_0/stage2_0/m1_49141_n15864# 100000
R343 eeg_fd_ota_chopped_full2_0/stage2_0/m1_53141_n15864# eeg_fd_ota_chopped_full2_0/stage2_0/m1_53541_n8557# 100000
R344 eeg_fd_ota_chopped_full2_0/stage2_0/m1_43941_n8557# eeg_fd_ota_chopped_full2_0/stage2_0/m1_44341_n15864# 100000
R345 eeg_fd_ota_chopped_full2_0/stage2_0/m1_48341_n15864# eeg_fd_ota_chopped_full2_0/stage2_0/m1_48741_n8557# 100000
R346 eeg_fd_ota_chopped_full2_0/stage2_0/m1_52741_n8557# eeg_fd_ota_chopped_full2_0/stage2_0/m1_53141_n15864# 100000
R347 eeg_fd_ota_chopped_full2_0/stage2_0/m1_57141_n15864# eeg_fd_ota_chopped_full2_0/stage2_0/m1_57541_n8557# 100000
R348 eeg_fd_ota_chopped_full2_0/stage2_0/m1_43541_n15864# eeg_fd_ota_chopped_full2_0/stage2_0/m1_43941_n8557# 100000
R349 eeg_fd_ota_chopped_full2_0/stage2_0/m1_47941_n8557# eeg_fd_ota_chopped_full2_0/stage2_0/m1_48341_n15864# 100000
R350 eeg_fd_ota_chopped_full2_0/stage2_0/m1_52341_n15864# eeg_fd_ota_chopped_full2_0/stage2_0/m1_52741_n8557# 100000
R351 eeg_fd_ota_chopped_full2_0/stage2_0/m1_56741_n8557# eeg_fd_ota_chopped_full2_0/stage2_0/m1_57141_n15864# 100000
R352 eeg_fd_ota_chopped_full2_0/stage2_0/m1_43141_n8557# eeg_fd_ota_chopped_full2_0/stage2_0/m1_43541_n15864# 100000
R353 eeg_fd_ota_chopped_full2_0/stage2_0/m1_47541_n15864# eeg_fd_ota_chopped_full2_0/stage2_0/m1_47941_n8557# 100000
R354 eeg_fd_ota_chopped_full2_0/stage2_0/m1_51941_n8557# eeg_fd_ota_chopped_full2_0/stage2_0/m1_52341_n15864# 100000
R355 eeg_fd_ota_chopped_full2_0/stage2_0/m1_56341_n15864# eeg_fd_ota_chopped_full2_0/stage2_0/m1_56741_n8557# 100000
R356 eeg_fd_ota_chopped_full2_0/stage2_0/m1_42741_n15864# eeg_fd_ota_chopped_full2_0/stage2_0/m1_43141_n8557# 100000
R357 eeg_fd_ota_chopped_full2_0/stage2_0/m1_47141_n8557# eeg_fd_ota_chopped_full2_0/stage2_0/m1_47541_n15864# 100000
R358 eeg_fd_ota_chopped_full2_0/stage2_0/m1_51541_n15864# eeg_fd_ota_chopped_full2_0/stage2_0/m1_51941_n8557# 100000
R359 eeg_fd_ota_chopped_full2_0/stage2_0/m1_55941_n8557# eeg_fd_ota_chopped_full2_0/stage2_0/m1_56341_n15864# 100000
R360 eeg_fd_ota_chopped_full2_0/stage2_0/m1_61141_n15864# eeg_fd_ota_chopped_full2_0/stage2_0/VCM2 100000
R361 eeg_fd_ota_chopped_full2_0/stage2_0/m1_42341_n8557# eeg_fd_ota_chopped_full2_0/stage2_0/m1_42741_n15864# 100000
R362 eeg_fd_ota_chopped_full2_0/stage2_0/m1_46741_n15864# eeg_fd_ota_chopped_full2_0/stage2_0/m1_47141_n8557# 100000
R363 eeg_fd_ota_chopped_full2_0/stage2_0/m1_51141_n8557# eeg_fd_ota_chopped_full2_0/stage2_0/m1_51541_n15864# 100000
R364 eeg_fd_ota_chopped_full2_0/stage2_0/m1_55541_n15864# eeg_fd_ota_chopped_full2_0/stage2_0/m1_55941_n8557# 100000
R365 eeg_fd_ota_chopped_full2_0/stage2_0/m1_60741_n8557# eeg_fd_ota_chopped_full2_0/stage2_0/m1_61141_n15864# 100000
R366 eeg_fd_ota_chopped_full2_0/stage2_0/m1_67141_n15864# eeg_fd_ota_chopped_full2_0/stage2_0/m1_67541_n8557# 100000
R367 eeg_fd_ota_chopped_full2_0/stage2_0/m1_41941_n15864# eeg_fd_ota_chopped_full2_0/stage2_0/m1_42341_n8557# 100000
R368 eeg_fd_ota_chopped_full2_0/stage2_0/m1_46341_n8557# eeg_fd_ota_chopped_full2_0/stage2_0/m1_46741_n15864# 100000
R369 eeg_fd_ota_chopped_full2_0/stage2_0/m1_50741_n15864# eeg_fd_ota_chopped_full2_0/stage2_0/m1_51141_n8557# 100000
R370 eeg_fd_ota_chopped_full2_0/stage2_0/m1_55141_n8557# eeg_fd_ota_chopped_full2_0/stage2_0/m1_55541_n15864# 100000
R371 eeg_fd_ota_chopped_full2_0/stage2_0/m1_60341_n15864# eeg_fd_ota_chopped_full2_0/stage2_0/m1_60741_n8557# 100000
R372 eeg_fd_ota_chopped_full2_0/stage2_0/m1_71141_n15864# VCM_REF 100000
R373 eeg_fd_ota_chopped_full2_0/stage2_0/m1_66741_n8557# eeg_fd_ota_chopped_full2_0/stage2_0/m1_67141_n15864# 100000
R374 OUTN eeg_fd_ota_chopped_full2_0/stage2_0/m1_41941_n15864# 100000
R375 eeg_fd_ota_chopped_full2_0/stage2_0/m1_45941_n15864# eeg_fd_ota_chopped_full2_0/stage2_0/m1_46341_n8557# 100000
R376 eeg_fd_ota_chopped_full2_0/stage2_0/m1_50341_n8557# eeg_fd_ota_chopped_full2_0/stage2_0/m1_50741_n15864# 100000
R377 eeg_fd_ota_chopped_full2_0/stage2_0/m1_54741_n15864# eeg_fd_ota_chopped_full2_0/stage2_0/m1_55141_n8557# 100000
R378 eeg_fd_ota_chopped_full2_0/stage2_0/m1_59941_n8557# eeg_fd_ota_chopped_full2_0/stage2_0/m1_60341_n15864# 100000
R379 eeg_fd_ota_chopped_full2_0/stage2_0/m1_77141_n15864# eeg_fd_ota_chopped_full2_0/stage2_0/m1_77541_n8557# 100000
R380 eeg_fd_ota_chopped_full2_0/stage2_0/m1_70741_n8557# eeg_fd_ota_chopped_full2_0/stage2_0/m1_71141_n15864# 100000
R381 eeg_fd_ota_chopped_full2_0/stage2_0/m1_66341_n15864# eeg_fd_ota_chopped_full2_0/stage2_0/m1_66741_n8557# 100000
X382 OUTP eeg_fd_ota_chopped_full2_0/stage2_0/VBP2 VDD18 VDD18 sky130_fd_pr__pfet_01v8 ad=6 pd=26 as=10.62 ps=33.54 w=24 l=12 nf=4
X383 VDD18 eeg_fd_ota_chopped_full2_0/stage2_0/VBP2 OUTP VDD18 sky130_fd_pr__pfet_01v8 ad=10.62 pd=33.54 as=6 ps=26 w=24 l=12 nf=4
R390 eeg_fd_ota_chopped_full2_0/stage2_0/m1_45541_n8557# eeg_fd_ota_chopped_full2_0/stage2_0/m1_45941_n15864# 100000
R391 eeg_fd_ota_chopped_full2_0/stage2_0/m1_49941_n15864# eeg_fd_ota_chopped_full2_0/stage2_0/m1_50341_n8557# 100000
R392 eeg_fd_ota_chopped_full2_0/stage2_0/m1_54341_n8557# eeg_fd_ota_chopped_full2_0/stage2_0/m1_54741_n15864# 100000
R393 eeg_fd_ota_chopped_full2_0/stage2_0/m1_59541_n15864# eeg_fd_ota_chopped_full2_0/stage2_0/m1_59941_n8557# 100000
R394 eeg_fd_ota_chopped_full2_0/stage2_0/m1_81141_n15864# VCM_REF 100000
R395 eeg_fd_ota_chopped_full2_0/stage2_0/m1_76741_n8557# eeg_fd_ota_chopped_full2_0/stage2_0/m1_77141_n15864# 100000
R396 eeg_fd_ota_chopped_full2_0/stage2_0/m1_70341_n15864# eeg_fd_ota_chopped_full2_0/stage2_0/m1_70741_n8557# 100000
R397 eeg_fd_ota_chopped_full2_0/stage2_0/m1_65941_n8557# eeg_fd_ota_chopped_full2_0/stage2_0/m1_66341_n15864# 100000
R398 eeg_fd_ota_chopped_full2_0/stage2_0/m1_49541_n8557# eeg_fd_ota_chopped_full2_0/stage2_0/m1_49941_n15864# 100000
R399 eeg_fd_ota_chopped_full2_0/stage2_0/m1_53941_n15864# eeg_fd_ota_chopped_full2_0/stage2_0/m1_54341_n8557# 100000
R400 eeg_fd_ota_chopped_full2_0/stage2_0/m1_59141_n8557# eeg_fd_ota_chopped_full2_0/stage2_0/m1_59541_n15864# 100000
R401 eeg_fd_ota_chopped_full2_0/stage2_0/m1_36741_n15864# eeg_fd_ota_chopped_full2_0/stage2_0/m1_37141_n8557# 100000
R402 eeg_fd_ota_chopped_full2_0/stage2_0/m1_80741_n8557# eeg_fd_ota_chopped_full2_0/stage2_0/m1_81141_n15864# 100000
R403 eeg_fd_ota_chopped_full2_0/stage2_0/m1_76341_n15864# eeg_fd_ota_chopped_full2_0/stage2_0/m1_76741_n8557# 100000
R404 eeg_fd_ota_chopped_full2_0/stage2_0/m1_69941_n8557# eeg_fd_ota_chopped_full2_0/stage2_0/m1_70341_n15864# 100000
R405 eeg_fd_ota_chopped_full2_0/stage2_0/m1_65541_n15864# eeg_fd_ota_chopped_full2_0/stage2_0/m1_65941_n8557# 100000
R406 eeg_fd_ota_chopped_full2_0/stage2_0/m1_53541_n8557# eeg_fd_ota_chopped_full2_0/stage2_0/m1_53941_n15864# 100000
R407 eeg_fd_ota_chopped_full2_0/stage2_0/m1_58741_n15864# eeg_fd_ota_chopped_full2_0/stage2_0/m1_59141_n8557# 100000
R408 eeg_fd_ota_chopped_full2_0/stage2_0/m1_20741_n15864# eeg_fd_ota_chopped_full2_0/stage2_0/m1_21141_n8557# 100000
R409 eeg_fd_ota_chopped_full2_0/stage2_0/m1_36341_n8557# eeg_fd_ota_chopped_full2_0/stage2_0/m1_36741_n15864# 100000
R410 eeg_fd_ota_chopped_full2_0/stage2_0/m1_80341_n15864# eeg_fd_ota_chopped_full2_0/stage2_0/m1_80741_n8557# 100000
R411 eeg_fd_ota_chopped_full2_0/stage2_0/m1_75941_n8557# eeg_fd_ota_chopped_full2_0/stage2_0/m1_76341_n15864# 100000
R412 eeg_fd_ota_chopped_full2_0/stage2_0/m1_69541_n15864# eeg_fd_ota_chopped_full2_0/stage2_0/m1_69941_n8557# 100000
R413 eeg_fd_ota_chopped_full2_0/stage2_0/m1_65141_n8557# eeg_fd_ota_chopped_full2_0/stage2_0/m1_65541_n15864# 100000
X414 OUTP eeg_fd_ota_chopped_full2_0/stage2_0/N2P VSS VSS sky130_fd_pr__nfet_01v8 ad=1.5 pd=6.5 as=6.12 ps=14.04 w=6 l=12 nf=1
X415 VSS eeg_fd_ota_chopped_full2_0/stage2_0/N2P OUTP VSS sky130_fd_pr__nfet_01v8 ad=6.12 pd=14.04 as=1.5 ps=6.5 w=6 l=12 nf=1
CMIM416 eeg_fd_ota_chopped_full2_0/stage2_0/m1_3966_n5928# OUTP 1.000000e-11
CMIM417 eeg_fd_ota_chopped_full2_0/stage2_0/m1_12966_n5928# OUTN 1.000000e-11
X456 eeg_fd_ota_chopped_full2_0/stage2_0/N2P PHIBM eeg_fd_ota_chopped_full2_0/stage2_0/N2P VDD18 sky130_fd_pr__pfet_01v8 ad=0.5544 pd=3 as=0.5544 ps=3 w=0.84 l=0.15 nf=1
X457 eeg_fd_ota_chopped_full2_0/eeg_fd_ota_core_soft_0/OUTN NPHIBM eeg_fd_ota_chopped_full2_0/eeg_fd_ota_core_soft_0/OUTN VSS sky130_fd_pr__nfet_01v8 ad=0.126 pd=1.44 as=0.126 ps=1.44 w=0.42 l=0.15 nf=1
X458 eeg_fd_ota_chopped_full2_0/stage2_0/N2P NPHIBM eeg_fd_ota_chopped_full2_0/stage2_0/N2P VSS sky130_fd_pr__nfet_01v8 ad=0.126 pd=1.44 as=0.126 ps=1.44 w=0.42 l=0.15 nf=1
X459 eeg_fd_ota_chopped_full2_0/stage2_0/N2P NPHIBM eeg_fd_ota_chopped_full2_0/eeg_fd_ota_core_soft_0/OUTN VDD18 sky130_fd_pr__pfet_01v8 ad=1.7136 pd=5.4 as=1.7136 ps=5.4 w=1.68 l=0.15 nf=1
X460 eeg_fd_ota_chopped_full2_0/eeg_fd_ota_core_soft_0/OUTN PHIBM eeg_fd_ota_chopped_full2_0/eeg_fd_ota_core_soft_0/OUTN VDD18 sky130_fd_pr__pfet_01v8 ad=0.5544 pd=3 as=0.5544 ps=3 w=0.84 l=0.15 nf=1
X461 eeg_fd_ota_chopped_full2_0/stage2_0/N2P PHIBM eeg_fd_ota_chopped_full2_0/eeg_fd_ota_core_soft_0/OUTN VSS sky130_fd_pr__nfet_01v8 ad=0.5544 pd=3 as=0.5544 ps=3 w=0.84 l=0.15 nf=1
X462 eeg_fd_ota_chopped_full2_0/stage2_0/N2N PHIBM eeg_fd_ota_chopped_full2_0/stage2_0/N2N VDD18 sky130_fd_pr__pfet_01v8 ad=0.5544 pd=3 as=0.5544 ps=3 w=0.84 l=0.15 nf=1
X463 eeg_fd_ota_chopped_full2_0/eeg_fd_ota_core_soft_0/OUTP NPHIBM eeg_fd_ota_chopped_full2_0/eeg_fd_ota_core_soft_0/OUTP VSS sky130_fd_pr__nfet_01v8 ad=0.126 pd=1.44 as=0.126 ps=1.44 w=0.42 l=0.15 nf=1
X464 eeg_fd_ota_chopped_full2_0/stage2_0/N2N NPHIBM eeg_fd_ota_chopped_full2_0/stage2_0/N2N VSS sky130_fd_pr__nfet_01v8 ad=0.126 pd=1.44 as=0.126 ps=1.44 w=0.42 l=0.15 nf=1
X465 eeg_fd_ota_chopped_full2_0/stage2_0/N2N NPHIBM eeg_fd_ota_chopped_full2_0/eeg_fd_ota_core_soft_0/OUTP VDD18 sky130_fd_pr__pfet_01v8 ad=1.7136 pd=5.4 as=1.7136 ps=5.4 w=1.68 l=0.15 nf=1
X466 eeg_fd_ota_chopped_full2_0/eeg_fd_ota_core_soft_0/OUTP PHIBM eeg_fd_ota_chopped_full2_0/eeg_fd_ota_core_soft_0/OUTP VDD18 sky130_fd_pr__pfet_01v8 ad=0.5544 pd=3 as=0.5544 ps=3 w=0.84 l=0.15 nf=1
X467 eeg_fd_ota_chopped_full2_0/stage2_0/N2N PHIBM eeg_fd_ota_chopped_full2_0/eeg_fd_ota_core_soft_0/OUTP VSS sky130_fd_pr__nfet_01v8 ad=0.5544 pd=3 as=0.5544 ps=3 w=0.84 l=0.15 nf=1
X468 eeg_fd_ota_chopped_full2_0/stage2_0/N2N PHIM eeg_fd_ota_chopped_full2_0/stage2_0/N2N VDD18 sky130_fd_pr__pfet_01v8 ad=0.5544 pd=3 as=0.5544 ps=3 w=0.84 l=0.15 nf=1
X469 eeg_fd_ota_chopped_full2_0/eeg_fd_ota_core_soft_0/OUTN NPHIM eeg_fd_ota_chopped_full2_0/eeg_fd_ota_core_soft_0/OUTN VSS sky130_fd_pr__nfet_01v8 ad=0.126 pd=1.44 as=0.126 ps=1.44 w=0.42 l=0.15 nf=1
X470 eeg_fd_ota_chopped_full2_0/stage2_0/N2N NPHIM eeg_fd_ota_chopped_full2_0/stage2_0/N2N VSS sky130_fd_pr__nfet_01v8 ad=0.126 pd=1.44 as=0.126 ps=1.44 w=0.42 l=0.15 nf=1
X471 eeg_fd_ota_chopped_full2_0/stage2_0/N2N NPHIM eeg_fd_ota_chopped_full2_0/eeg_fd_ota_core_soft_0/OUTN VDD18 sky130_fd_pr__pfet_01v8 ad=1.7136 pd=5.4 as=1.7136 ps=5.4 w=1.68 l=0.15 nf=1
X472 eeg_fd_ota_chopped_full2_0/eeg_fd_ota_core_soft_0/OUTN PHIM eeg_fd_ota_chopped_full2_0/eeg_fd_ota_core_soft_0/OUTN VDD18 sky130_fd_pr__pfet_01v8 ad=0.5544 pd=3 as=0.5544 ps=3 w=0.84 l=0.15 nf=1
X473 eeg_fd_ota_chopped_full2_0/stage2_0/N2N PHIM eeg_fd_ota_chopped_full2_0/eeg_fd_ota_core_soft_0/OUTN VSS sky130_fd_pr__nfet_01v8 ad=0.5544 pd=3 as=0.5544 ps=3 w=0.84 l=0.15 nf=1
X474 eeg_fd_ota_chopped_full2_0/stage2_0/N2P PHIM eeg_fd_ota_chopped_full2_0/stage2_0/N2P VDD18 sky130_fd_pr__pfet_01v8 ad=0.5544 pd=3 as=0.5544 ps=3 w=0.84 l=0.15 nf=1
X475 eeg_fd_ota_chopped_full2_0/eeg_fd_ota_core_soft_0/OUTP NPHIM eeg_fd_ota_chopped_full2_0/eeg_fd_ota_core_soft_0/OUTP VSS sky130_fd_pr__nfet_01v8 ad=0.126 pd=1.44 as=0.126 ps=1.44 w=0.42 l=0.15 nf=1
X476 eeg_fd_ota_chopped_full2_0/stage2_0/N2P NPHIM eeg_fd_ota_chopped_full2_0/stage2_0/N2P VSS sky130_fd_pr__nfet_01v8 ad=0.126 pd=1.44 as=0.126 ps=1.44 w=0.42 l=0.15 nf=1
X477 eeg_fd_ota_chopped_full2_0/stage2_0/N2P NPHIM eeg_fd_ota_chopped_full2_0/eeg_fd_ota_core_soft_0/OUTP VDD18 sky130_fd_pr__pfet_01v8 ad=1.7136 pd=5.4 as=1.7136 ps=5.4 w=1.68 l=0.15 nf=1
X478 eeg_fd_ota_chopped_full2_0/eeg_fd_ota_core_soft_0/OUTP PHIM eeg_fd_ota_chopped_full2_0/eeg_fd_ota_core_soft_0/OUTP VDD18 sky130_fd_pr__pfet_01v8 ad=0.5544 pd=3 as=0.5544 ps=3 w=0.84 l=0.15 nf=1
X479 eeg_fd_ota_chopped_full2_0/stage2_0/N2P PHIM eeg_fd_ota_chopped_full2_0/eeg_fd_ota_core_soft_0/OUTP VSS sky130_fd_pr__nfet_01v8 ad=0.5544 pd=3 as=0.5544 ps=3 w=0.84 l=0.15 nf=1
X480 eeg_fd_ota_chopped_full2_0/eeg_fd_ota_core_soft_0/INP PHIBI eeg_fd_ota_chopped_full2_0/eeg_fd_ota_core_soft_0/INP VDD18 sky130_fd_pr__pfet_01v8 ad=0.5544 pd=3 as=0.5544 ps=3 w=0.84 l=0.15 nf=1
X481 eeg_tg_lowq_3/B NPHIBI eeg_tg_lowq_3/B VSS sky130_fd_pr__nfet_01v8 ad=0.126 pd=1.44 as=0.126 ps=1.44 w=0.42 l=0.15 nf=1
X482 eeg_fd_ota_chopped_full2_0/eeg_fd_ota_core_soft_0/INP NPHIBI eeg_fd_ota_chopped_full2_0/eeg_fd_ota_core_soft_0/INP VSS sky130_fd_pr__nfet_01v8 ad=0.126 pd=1.44 as=0.126 ps=1.44 w=0.42 l=0.15 nf=1
X483 eeg_fd_ota_chopped_full2_0/eeg_fd_ota_core_soft_0/INP NPHIBI eeg_tg_lowq_3/B VDD18 sky130_fd_pr__pfet_01v8 ad=1.7136 pd=5.4 as=1.7136 ps=5.4 w=1.68 l=0.15 nf=1
X484 eeg_tg_lowq_3/B PHIBI eeg_tg_lowq_3/B VDD18 sky130_fd_pr__pfet_01v8 ad=0.5544 pd=3 as=0.5544 ps=3 w=0.84 l=0.15 nf=1
X485 eeg_fd_ota_chopped_full2_0/eeg_fd_ota_core_soft_0/INP PHIBI eeg_tg_lowq_3/B VSS sky130_fd_pr__nfet_01v8 ad=0.5544 pd=3 as=0.5544 ps=3 w=0.84 l=0.15 nf=1
X486 eeg_fd_ota_chopped_full2_0/eeg_fd_ota_core_soft_0/INN PHIBI eeg_fd_ota_chopped_full2_0/eeg_fd_ota_core_soft_0/INN VDD18 sky130_fd_pr__pfet_01v8 ad=0.5544 pd=3 as=0.5544 ps=3 w=0.84 l=0.15 nf=1
X487 eeg_tg_lowq_7/B NPHIBI eeg_tg_lowq_7/B VSS sky130_fd_pr__nfet_01v8 ad=0.126 pd=1.44 as=0.126 ps=1.44 w=0.42 l=0.15 nf=1
X488 eeg_fd_ota_chopped_full2_0/eeg_fd_ota_core_soft_0/INN NPHIBI eeg_fd_ota_chopped_full2_0/eeg_fd_ota_core_soft_0/INN VSS sky130_fd_pr__nfet_01v8 ad=0.126 pd=1.44 as=0.126 ps=1.44 w=0.42 l=0.15 nf=1
X489 eeg_fd_ota_chopped_full2_0/eeg_fd_ota_core_soft_0/INN NPHIBI eeg_tg_lowq_7/B VDD18 sky130_fd_pr__pfet_01v8 ad=1.7136 pd=5.4 as=1.7136 ps=5.4 w=1.68 l=0.15 nf=1
X490 eeg_tg_lowq_7/B PHIBI eeg_tg_lowq_7/B VDD18 sky130_fd_pr__pfet_01v8 ad=0.5544 pd=3 as=0.5544 ps=3 w=0.84 l=0.15 nf=1
X491 eeg_fd_ota_chopped_full2_0/eeg_fd_ota_core_soft_0/INN PHIBI eeg_tg_lowq_7/B VSS sky130_fd_pr__nfet_01v8 ad=0.5544 pd=3 as=0.5544 ps=3 w=0.84 l=0.15 nf=1
X492 eeg_fd_ota_chopped_full2_0/eeg_fd_ota_core_soft_0/INN PHII eeg_fd_ota_chopped_full2_0/eeg_fd_ota_core_soft_0/INN VDD18 sky130_fd_pr__pfet_01v8 ad=0.5544 pd=3 as=0.5544 ps=3 w=0.84 l=0.15 nf=1
X493 eeg_tg_lowq_3/B NPHII eeg_tg_lowq_3/B VSS sky130_fd_pr__nfet_01v8 ad=0.126 pd=1.44 as=0.126 ps=1.44 w=0.42 l=0.15 nf=1
X494 eeg_fd_ota_chopped_full2_0/eeg_fd_ota_core_soft_0/INN NPHII eeg_fd_ota_chopped_full2_0/eeg_fd_ota_core_soft_0/INN VSS sky130_fd_pr__nfet_01v8 ad=0.126 pd=1.44 as=0.126 ps=1.44 w=0.42 l=0.15 nf=1
X495 eeg_fd_ota_chopped_full2_0/eeg_fd_ota_core_soft_0/INN NPHII eeg_tg_lowq_3/B VDD18 sky130_fd_pr__pfet_01v8 ad=1.7136 pd=5.4 as=1.7136 ps=5.4 w=1.68 l=0.15 nf=1
X496 eeg_tg_lowq_3/B PHII eeg_tg_lowq_3/B VDD18 sky130_fd_pr__pfet_01v8 ad=0.5544 pd=3 as=0.5544 ps=3 w=0.84 l=0.15 nf=1
X497 eeg_fd_ota_chopped_full2_0/eeg_fd_ota_core_soft_0/INN PHII eeg_tg_lowq_3/B VSS sky130_fd_pr__nfet_01v8 ad=0.5544 pd=3 as=0.5544 ps=3 w=0.84 l=0.15 nf=1
X498 eeg_fd_ota_chopped_full2_0/eeg_fd_ota_core_soft_0/INP PHII eeg_fd_ota_chopped_full2_0/eeg_fd_ota_core_soft_0/INP VDD18 sky130_fd_pr__pfet_01v8 ad=0.5544 pd=3 as=0.5544 ps=3 w=0.84 l=0.15 nf=1
X499 eeg_tg_lowq_7/B NPHII eeg_tg_lowq_7/B VSS sky130_fd_pr__nfet_01v8 ad=0.126 pd=1.44 as=0.126 ps=1.44 w=0.42 l=0.15 nf=1
X500 eeg_fd_ota_chopped_full2_0/eeg_fd_ota_core_soft_0/INP NPHII eeg_fd_ota_chopped_full2_0/eeg_fd_ota_core_soft_0/INP VSS sky130_fd_pr__nfet_01v8 ad=0.126 pd=1.44 as=0.126 ps=1.44 w=0.42 l=0.15 nf=1
X501 eeg_fd_ota_chopped_full2_0/eeg_fd_ota_core_soft_0/INP NPHII eeg_tg_lowq_7/B VDD18 sky130_fd_pr__pfet_01v8 ad=1.7136 pd=5.4 as=1.7136 ps=5.4 w=1.68 l=0.15 nf=1
X502 eeg_tg_lowq_7/B PHII eeg_tg_lowq_7/B VDD18 sky130_fd_pr__pfet_01v8 ad=0.5544 pd=3 as=0.5544 ps=3 w=0.84 l=0.15 nf=1
X503 eeg_fd_ota_chopped_full2_0/eeg_fd_ota_core_soft_0/INP PHII eeg_tg_lowq_7/B VSS sky130_fd_pr__nfet_01v8 ad=0.5544 pd=3 as=0.5544 ps=3 w=0.84 l=0.15 nf=1
R504 eeg_fd_ota_chopped_full2_0/eeg_fd_ota_core_soft_0/m1_n51659_3443# eeg_fd_ota_chopped_full2_0/eeg_fd_ota_core_soft_0/m1_n51259_n3864# 100000
R505 eeg_fd_ota_chopped_full2_0/eeg_fd_ota_core_soft_0/m1_n52059_n3864# eeg_fd_ota_chopped_full2_0/eeg_fd_ota_core_soft_0/m1_n51659_3443# 100000
R506 eeg_fd_ota_chopped_full2_0/eeg_fd_ota_core_soft_0/m1_n52459_3443# eeg_fd_ota_chopped_full2_0/eeg_fd_ota_core_soft_0/m1_n52059_n3864# 100000
R507 eeg_fd_ota_chopped_full2_0/eeg_fd_ota_core_soft_0/m1_n52859_n3864# eeg_fd_ota_chopped_full2_0/eeg_fd_ota_core_soft_0/m1_n52459_3443# 100000
R508 eeg_fd_ota_chopped_full2_0/eeg_fd_ota_core_soft_0/m1_n53259_3443# eeg_fd_ota_chopped_full2_0/eeg_fd_ota_core_soft_0/m1_n52859_n3864# 100000
X509 VSS eeg_fd_ota_chopped_full2_0/eeg_bias_gen_0/VBNF eeg_fd_ota_chopped_full2_0/eeg_fd_ota_core_soft_0/m1_n22658_111# VSS sky130_fd_pr__nfet_01v8 ad=16.62 pd=59.54 as=12 ps=52 w=48 l=4 nf=8
X510 eeg_fd_ota_chopped_full2_0/eeg_fd_ota_core_soft_0/m1_n22658_111# eeg_fd_ota_chopped_full2_0/eeg_bias_gen_0/VBNF VSS VSS sky130_fd_pr__nfet_01v8 ad=12 pd=52 as=16.62 ps=59.54 w=48 l=4 nf=8
R525 eeg_fd_ota_chopped_full2_0/eeg_fd_ota_core_soft_0/m1_n53659_n3864# eeg_fd_ota_chopped_full2_0/eeg_fd_ota_core_soft_0/m1_n53259_3443# 100000
R526 eeg_fd_ota_chopped_full2_0/eeg_fd_ota_core_soft_0/m1_31541_n3864# eeg_fd_ota_chopped_full2_0/eeg_fd_ota_core_soft_0/m1_31941_3443# 100000
R527 eeg_fd_ota_chopped_full2_0/eeg_fd_ota_core_soft_0/m1_n54059_3443# eeg_fd_ota_chopped_full2_0/eeg_fd_ota_core_soft_0/m1_n53659_n3864# 100000
R528 eeg_fd_ota_chopped_full2_0/eeg_fd_ota_core_soft_0/m1_31141_3443# eeg_fd_ota_chopped_full2_0/eeg_fd_ota_core_soft_0/m1_31541_n3864# 100000
R529 eeg_fd_ota_chopped_full2_0/eeg_fd_ota_core_soft_0/m1_35541_n3864# eeg_fd_ota_chopped_full2_0/eeg_fd_ota_core_soft_0/m1_35941_3443# 100000
R530 eeg_fd_ota_chopped_full2_0/eeg_fd_ota_core_soft_0/m1_n54459_n3864# eeg_fd_ota_chopped_full2_0/eeg_fd_ota_core_soft_0/m1_n54059_3443# 100000
R531 eeg_fd_ota_chopped_full2_0/eeg_fd_ota_core_soft_0/m1_39541_n3864# eeg_fd_ota_chopped_full2_0/eeg_fd_ota_core_soft_0/m1_39941_3443# 100000
R532 eeg_fd_ota_chopped_full2_0/eeg_fd_ota_core_soft_0/m1_30741_n3864# eeg_fd_ota_chopped_full2_0/eeg_fd_ota_core_soft_0/m1_31141_3443# 100000
R533 eeg_fd_ota_chopped_full2_0/eeg_fd_ota_core_soft_0/m1_35141_3443# eeg_fd_ota_chopped_full2_0/eeg_fd_ota_core_soft_0/m1_35541_n3864# 100000
R534 eeg_fd_ota_chopped_full2_0/eeg_fd_ota_core_soft_0/m1_n54859_3443# eeg_fd_ota_chopped_full2_0/eeg_fd_ota_core_soft_0/m1_n54459_n3864# 100000
R535 eeg_fd_ota_chopped_full2_0/eeg_fd_ota_core_soft_0/m1_43541_n3864# eeg_fd_ota_chopped_full2_0/eeg_fd_ota_core_soft_0/m1_43941_3443# 100000
R536 eeg_fd_ota_chopped_full2_0/eeg_fd_ota_core_soft_0/m1_39141_3443# eeg_fd_ota_chopped_full2_0/eeg_fd_ota_core_soft_0/m1_39541_n3864# 100000
R537 eeg_fd_ota_chopped_full2_0/eeg_fd_ota_core_soft_0/m1_30341_3443# eeg_fd_ota_chopped_full2_0/eeg_fd_ota_core_soft_0/m1_30741_n3864# 100000
R538 eeg_fd_ota_chopped_full2_0/eeg_fd_ota_core_soft_0/m1_34741_n3864# eeg_fd_ota_chopped_full2_0/eeg_fd_ota_core_soft_0/m1_35141_3443# 100000
R539 eeg_fd_ota_chopped_full2_0/eeg_fd_ota_core_soft_0/m1_n55259_n3864# eeg_fd_ota_chopped_full2_0/eeg_fd_ota_core_soft_0/m1_n54859_3443# 100000
R540 eeg_fd_ota_chopped_full2_0/eeg_fd_ota_core_soft_0/m1_43141_3443# eeg_fd_ota_chopped_full2_0/eeg_fd_ota_core_soft_0/m1_43541_n3864# 100000
R541 eeg_fd_ota_chopped_full2_0/eeg_fd_ota_core_soft_0/m1_38741_n3864# eeg_fd_ota_chopped_full2_0/eeg_fd_ota_core_soft_0/m1_39141_3443# 100000
R542 eeg_fd_ota_chopped_full2_0/eeg_fd_ota_core_soft_0/m1_29941_n3864# eeg_fd_ota_chopped_full2_0/eeg_fd_ota_core_soft_0/m1_30341_3443# 100000
R543 eeg_fd_ota_chopped_full2_0/eeg_fd_ota_core_soft_0/m1_34341_3443# eeg_fd_ota_chopped_full2_0/eeg_fd_ota_core_soft_0/m1_34741_n3864# 100000
R544 eeg_fd_ota_chopped_full2_0/eeg_fd_ota_core_soft_0/m1_42741_n3864# eeg_fd_ota_chopped_full2_0/eeg_fd_ota_core_soft_0/m1_43141_3443# 100000
R545 eeg_fd_ota_chopped_full2_0/eeg_fd_ota_core_soft_0/m1_38341_3443# eeg_fd_ota_chopped_full2_0/eeg_fd_ota_core_soft_0/m1_38741_n3864# 100000
R546 eeg_fd_ota_chopped_full2_0/eeg_fd_ota_core_soft_0/m1_29541_3443# eeg_fd_ota_chopped_full2_0/eeg_fd_ota_core_soft_0/m1_29941_n3864# 100000
R547 eeg_fd_ota_chopped_full2_0/eeg_fd_ota_core_soft_0/m1_33941_n3864# eeg_fd_ota_chopped_full2_0/eeg_fd_ota_core_soft_0/m1_34341_3443# 100000
X548 eeg_fd_ota_chopped_full2_0/eeg_fd_ota_core_soft_0/OUTP eeg_fd_ota_chopped_full2_0/eeg_fd_ota_core_soft_0/INP eeg_fd_ota_chopped_full2_0/eeg_fd_ota_core_soft_0/m1_n22658_111# VSS sky130_fd_pr__nfet_01v8 ad=30 pd=126 as=30 ps=126 w=120 l=4 nf=12
X549 eeg_fd_ota_chopped_full2_0/eeg_fd_ota_core_soft_0/m1_n22658_111# eeg_fd_ota_chopped_full2_0/eeg_fd_ota_core_soft_0/INN eeg_fd_ota_chopped_full2_0/eeg_fd_ota_core_soft_0/OUTN VSS sky130_fd_pr__nfet_01v8 ad=30 pd=126 as=30 ps=126 w=120 l=4 nf=12
X550 eeg_fd_ota_chopped_full2_0/eeg_fd_ota_core_soft_0/m1_n22658_111# eeg_fd_ota_chopped_full2_0/eeg_fd_ota_core_soft_0/INP eeg_fd_ota_chopped_full2_0/eeg_fd_ota_core_soft_0/OUTP VSS sky130_fd_pr__nfet_01v8 ad=30 pd=126 as=30 ps=126 w=120 l=4 nf=12
X551 eeg_fd_ota_chopped_full2_0/eeg_fd_ota_core_soft_0/OUTN eeg_fd_ota_chopped_full2_0/eeg_fd_ota_core_soft_0/INN eeg_fd_ota_chopped_full2_0/eeg_fd_ota_core_soft_0/m1_n22658_111# VSS sky130_fd_pr__nfet_01v8 ad=30 pd=126 as=30 ps=126 w=120 l=4 nf=12
X560 eeg_fd_ota_chopped_full2_0/eeg_fd_ota_core_soft_0/m1_n22658_111# VSS eeg_fd_ota_chopped_full2_0/eeg_fd_ota_core_soft_0/OUTP VSS sky130_fd_pr__nfet_01v8 ad=17.4 pd=23.48 as=2.5 ps=10.5 w=10 l=4 nf=1
X592 eeg_fd_ota_chopped_full2_0/eeg_fd_ota_core_soft_0/OUTP VSS eeg_fd_ota_chopped_full2_0/eeg_fd_ota_core_soft_0/m1_n22658_111# VSS sky130_fd_pr__nfet_01v8 ad=2.5 pd=10.5 as=17.4 ps=23.48 w=10 l=4 nf=1
R598 eeg_fd_ota_chopped_full2_0/eeg_fd_ota_core_soft_0/m1_42341_3443# eeg_fd_ota_chopped_full2_0/eeg_fd_ota_core_soft_0/m1_42741_n3864# 100000
R599 eeg_fd_ota_chopped_full2_0/eeg_fd_ota_core_soft_0/m1_37941_n3864# eeg_fd_ota_chopped_full2_0/eeg_fd_ota_core_soft_0/m1_38341_3443# 100000
R600 eeg_fd_ota_chopped_full2_0/eeg_fd_ota_core_soft_0/m1_29141_n3864# eeg_fd_ota_chopped_full2_0/eeg_fd_ota_core_soft_0/m1_29541_3443# 100000
R601 eeg_fd_ota_chopped_full2_0/eeg_fd_ota_core_soft_0/m1_33541_3443# eeg_fd_ota_chopped_full2_0/eeg_fd_ota_core_soft_0/m1_33941_n3864# 100000
R602 eeg_fd_ota_chopped_full2_0/eeg_fd_ota_core_soft_0/m1_41941_n3864# eeg_fd_ota_chopped_full2_0/eeg_fd_ota_core_soft_0/m1_42341_3443# 100000
R603 eeg_fd_ota_chopped_full2_0/eeg_fd_ota_core_soft_0/m1_37541_3443# eeg_fd_ota_chopped_full2_0/eeg_fd_ota_core_soft_0/m1_37941_n3864# 100000
R604 eeg_fd_ota_chopped_full2_0/eeg_fd_ota_core_soft_0/m1_28741_3443# eeg_fd_ota_chopped_full2_0/eeg_fd_ota_core_soft_0/m1_29141_n3864# 100000
R605 eeg_fd_ota_chopped_full2_0/eeg_fd_ota_core_soft_0/m1_33141_n3864# eeg_fd_ota_chopped_full2_0/eeg_fd_ota_core_soft_0/m1_33541_3443# 100000
R606 eeg_fd_ota_chopped_full2_0/eeg_fd_ota_core_soft_0/m1_41541_3443# eeg_fd_ota_chopped_full2_0/eeg_fd_ota_core_soft_0/m1_41941_n3864# 100000
R607 eeg_fd_ota_chopped_full2_0/eeg_fd_ota_core_soft_0/m1_37141_n3864# eeg_fd_ota_chopped_full2_0/eeg_fd_ota_core_soft_0/m1_37541_3443# 100000
R608 eeg_fd_ota_chopped_full2_0/eeg_fd_ota_core_soft_0/m1_28341_n3864# eeg_fd_ota_chopped_full2_0/eeg_fd_ota_core_soft_0/m1_28741_3443# 100000
R609 eeg_fd_ota_chopped_full2_0/eeg_fd_ota_core_soft_0/m1_32741_3443# eeg_fd_ota_chopped_full2_0/eeg_fd_ota_core_soft_0/m1_33141_n3864# 100000
R610 eeg_fd_ota_chopped_full2_0/eeg_fd_ota_core_soft_0/m1_47541_n3864# eeg_fd_ota_chopped_full2_0/eeg_fd_ota_core_soft_0/OUTN 100000
R611 eeg_fd_ota_chopped_full2_0/eeg_fd_ota_core_soft_0/m1_41141_n3864# eeg_fd_ota_chopped_full2_0/eeg_fd_ota_core_soft_0/m1_41541_3443# 100000
R612 eeg_fd_ota_chopped_full2_0/eeg_cmfb_amp_dl2_0/VCM_SENSE eeg_fd_ota_chopped_full2_0/eeg_fd_ota_core_soft_0/m1_28341_n3864# 100000
R613 eeg_fd_ota_chopped_full2_0/eeg_fd_ota_core_soft_0/m1_32341_n3864# eeg_fd_ota_chopped_full2_0/eeg_fd_ota_core_soft_0/m1_32741_3443# 100000
R614 eeg_fd_ota_chopped_full2_0/eeg_fd_ota_core_soft_0/m1_36741_3443# eeg_fd_ota_chopped_full2_0/eeg_fd_ota_core_soft_0/m1_37141_n3864# 100000
R615 eeg_fd_ota_chopped_full2_0/eeg_fd_ota_core_soft_0/m1_53941_n3864# eeg_fd_ota_chopped_full2_0/eeg_fd_ota_core_soft_0/m1_54341_3443# 100000
R616 eeg_fd_ota_chopped_full2_0/eeg_fd_ota_core_soft_0/m1_47141_3443# eeg_fd_ota_chopped_full2_0/eeg_fd_ota_core_soft_0/m1_47541_n3864# 100000
R617 eeg_fd_ota_chopped_full2_0/eeg_fd_ota_core_soft_0/m1_40741_3443# eeg_fd_ota_chopped_full2_0/eeg_fd_ota_core_soft_0/m1_41141_n3864# 100000
R618 eeg_fd_ota_chopped_full2_0/eeg_fd_ota_core_soft_0/m1_36341_n3864# eeg_fd_ota_chopped_full2_0/eeg_fd_ota_core_soft_0/m1_36741_3443# 100000
R619 eeg_fd_ota_chopped_full2_0/eeg_fd_ota_core_soft_0/m1_31941_3443# eeg_fd_ota_chopped_full2_0/eeg_fd_ota_core_soft_0/m1_32341_n3864# 100000
R620 eeg_fd_ota_chopped_full2_0/eeg_fd_ota_core_soft_0/m1_57941_n3864# eeg_fd_ota_chopped_full2_0/eeg_fd_ota_core_soft_0/OUTN 100000
R621 eeg_fd_ota_chopped_full2_0/eeg_fd_ota_core_soft_0/m1_53541_3443# eeg_fd_ota_chopped_full2_0/eeg_fd_ota_core_soft_0/m1_53941_n3864# 100000
R622 eeg_fd_ota_chopped_full2_0/eeg_fd_ota_core_soft_0/m1_46741_n3864# eeg_fd_ota_chopped_full2_0/eeg_fd_ota_core_soft_0/m1_47141_3443# 100000
R623 eeg_fd_ota_chopped_full2_0/eeg_fd_ota_core_soft_0/m1_40341_n3864# eeg_fd_ota_chopped_full2_0/eeg_fd_ota_core_soft_0/m1_40741_3443# 100000
R624 eeg_fd_ota_chopped_full2_0/eeg_fd_ota_core_soft_0/m1_35941_3443# eeg_fd_ota_chopped_full2_0/eeg_fd_ota_core_soft_0/m1_36341_n3864# 100000
R625 eeg_fd_ota_chopped_full2_0/eeg_fd_ota_core_soft_0/m1_57541_3443# eeg_fd_ota_chopped_full2_0/eeg_fd_ota_core_soft_0/m1_57941_n3864# 100000
R626 eeg_fd_ota_chopped_full2_0/eeg_fd_ota_core_soft_0/m1_53141_n3864# eeg_fd_ota_chopped_full2_0/eeg_fd_ota_core_soft_0/m1_53541_3443# 100000
R627 eeg_fd_ota_chopped_full2_0/eeg_fd_ota_core_soft_0/m1_46341_3443# eeg_fd_ota_chopped_full2_0/eeg_fd_ota_core_soft_0/m1_46741_n3864# 100000
R628 eeg_fd_ota_chopped_full2_0/eeg_fd_ota_core_soft_0/m1_n45259_3443# eeg_fd_ota_chopped_full2_0/eeg_fd_ota_core_soft_0/m1_n44859_n3864# 100000
R629 eeg_fd_ota_chopped_full2_0/eeg_fd_ota_core_soft_0/m1_39941_3443# eeg_fd_ota_chopped_full2_0/eeg_fd_ota_core_soft_0/m1_40341_n3864# 100000
R630 eeg_fd_ota_chopped_full2_0/eeg_fd_ota_core_soft_0/m1_57141_n3864# eeg_fd_ota_chopped_full2_0/eeg_fd_ota_core_soft_0/m1_57541_3443# 100000
R631 eeg_fd_ota_chopped_full2_0/eeg_fd_ota_core_soft_0/m1_52741_3443# eeg_fd_ota_chopped_full2_0/eeg_fd_ota_core_soft_0/m1_53141_n3864# 100000
R632 eeg_fd_ota_chopped_full2_0/eeg_fd_ota_core_soft_0/m1_45941_n3864# eeg_fd_ota_chopped_full2_0/eeg_fd_ota_core_soft_0/m1_46341_3443# 100000
R633 eeg_fd_ota_chopped_full2_0/eeg_fd_ota_core_soft_0/m1_n45659_n3864# eeg_fd_ota_chopped_full2_0/eeg_fd_ota_core_soft_0/m1_n45259_3443# 100000
R634 eeg_fd_ota_chopped_full2_0/eeg_fd_ota_core_soft_0/m1_n41259_3443# eeg_fd_ota_chopped_full2_0/eeg_fd_ota_core_soft_0/m1_n40859_n3864# 100000
R635 eeg_fd_ota_chopped_full2_0/eeg_fd_ota_core_soft_0/m1_56741_3443# eeg_fd_ota_chopped_full2_0/eeg_fd_ota_core_soft_0/m1_57141_n3864# 100000
R636 eeg_fd_ota_chopped_full2_0/eeg_fd_ota_core_soft_0/m1_52341_n3864# eeg_fd_ota_chopped_full2_0/eeg_fd_ota_core_soft_0/m1_52741_3443# 100000
R637 eeg_fd_ota_chopped_full2_0/eeg_fd_ota_core_soft_0/m1_45541_3443# eeg_fd_ota_chopped_full2_0/eeg_fd_ota_core_soft_0/m1_45941_n3864# 100000
R638 eeg_fd_ota_chopped_full2_0/eeg_fd_ota_core_soft_0/m1_n46059_3443# eeg_fd_ota_chopped_full2_0/eeg_fd_ota_core_soft_0/m1_n45659_n3864# 100000
R639 eeg_fd_ota_chopped_full2_0/eeg_fd_ota_core_soft_0/m1_n41659_n3864# eeg_fd_ota_chopped_full2_0/eeg_fd_ota_core_soft_0/m1_n41259_3443# 100000
R640 eeg_fd_ota_chopped_full2_0/eeg_fd_ota_core_soft_0/m1_n37259_3443# eeg_fd_ota_chopped_full2_0/eeg_fd_ota_core_soft_0/m1_n36859_n3864# 100000
R641 eeg_fd_ota_chopped_full2_0/eeg_fd_ota_core_soft_0/m1_56341_n3864# eeg_fd_ota_chopped_full2_0/eeg_fd_ota_core_soft_0/m1_56741_3443# 100000
R642 eeg_fd_ota_chopped_full2_0/eeg_fd_ota_core_soft_0/m1_51941_3443# eeg_fd_ota_chopped_full2_0/eeg_fd_ota_core_soft_0/m1_52341_n3864# 100000
R643 eeg_fd_ota_chopped_full2_0/eeg_fd_ota_core_soft_0/m1_45141_n3864# eeg_fd_ota_chopped_full2_0/eeg_fd_ota_core_soft_0/m1_45541_3443# 100000
R644 eeg_fd_ota_chopped_full2_0/eeg_fd_ota_core_soft_0/m1_n46459_n3864# eeg_fd_ota_chopped_full2_0/eeg_fd_ota_core_soft_0/m1_n46059_3443# 100000
R645 eeg_fd_ota_chopped_full2_0/eeg_fd_ota_core_soft_0/m1_n42059_3443# eeg_fd_ota_chopped_full2_0/eeg_fd_ota_core_soft_0/m1_n41659_n3864# 100000
R646 eeg_fd_ota_chopped_full2_0/eeg_fd_ota_core_soft_0/m1_n37659_n3864# eeg_fd_ota_chopped_full2_0/eeg_fd_ota_core_soft_0/m1_n37259_3443# 100000
R647 eeg_fd_ota_chopped_full2_0/eeg_fd_ota_core_soft_0/m1_n33259_3443# eeg_fd_ota_chopped_full2_0/eeg_fd_ota_core_soft_0/m1_n32859_n3864# 100000
R648 eeg_fd_ota_chopped_full2_0/eeg_fd_ota_core_soft_0/m1_55941_3443# eeg_fd_ota_chopped_full2_0/eeg_fd_ota_core_soft_0/m1_56341_n3864# 100000
R649 eeg_fd_ota_chopped_full2_0/eeg_fd_ota_core_soft_0/m1_51541_n3864# eeg_fd_ota_chopped_full2_0/eeg_fd_ota_core_soft_0/m1_51941_3443# 100000
R650 eeg_fd_ota_chopped_full2_0/eeg_fd_ota_core_soft_0/m1_44741_3443# eeg_fd_ota_chopped_full2_0/eeg_fd_ota_core_soft_0/m1_45141_n3864# 100000
R651 eeg_fd_ota_chopped_full2_0/eeg_fd_ota_core_soft_0/m1_n46859_3443# eeg_fd_ota_chopped_full2_0/eeg_fd_ota_core_soft_0/m1_n46459_n3864# 100000
R652 eeg_fd_ota_chopped_full2_0/eeg_fd_ota_core_soft_0/m1_n42459_n3864# eeg_fd_ota_chopped_full2_0/eeg_fd_ota_core_soft_0/m1_n42059_3443# 100000
R653 eeg_fd_ota_chopped_full2_0/eeg_fd_ota_core_soft_0/m1_n38059_3443# eeg_fd_ota_chopped_full2_0/eeg_fd_ota_core_soft_0/m1_n37659_n3864# 100000
R654 eeg_fd_ota_chopped_full2_0/eeg_fd_ota_core_soft_0/m1_n33659_n3864# eeg_fd_ota_chopped_full2_0/eeg_fd_ota_core_soft_0/m1_n33259_3443# 100000
R655 eeg_fd_ota_chopped_full2_0/eeg_fd_ota_core_soft_0/m1_n29259_3443# eeg_fd_ota_chopped_full2_0/eeg_fd_ota_core_soft_0/m1_n28859_n3864# 100000
X656 eeg_fd_ota_chopped_full2_0/eeg_fd_ota_core_soft_0/OUTP eeg_fd_ota_chopped_full2_0/eeg_cmfb_amp_dl2_0/VBP VDD18 VDD18 sky130_fd_pr__pfet_01v8 ad=6 pd=26 as=10.62 ps=33.54 w=24 l=4 nf=4
X657 VDD18 eeg_fd_ota_chopped_full2_0/eeg_cmfb_amp_dl2_0/VBP eeg_fd_ota_chopped_full2_0/eeg_fd_ota_core_soft_0/OUTP VDD18 sky130_fd_pr__pfet_01v8 ad=10.62 pd=33.54 as=6 ps=26 w=24 l=4 nf=4
R664 eeg_fd_ota_chopped_full2_0/eeg_fd_ota_core_soft_0/m1_55541_n3864# eeg_fd_ota_chopped_full2_0/eeg_fd_ota_core_soft_0/m1_55941_3443# 100000
R665 eeg_fd_ota_chopped_full2_0/eeg_fd_ota_core_soft_0/m1_51141_3443# eeg_fd_ota_chopped_full2_0/eeg_fd_ota_core_soft_0/m1_51541_n3864# 100000
R666 eeg_fd_ota_chopped_full2_0/eeg_fd_ota_core_soft_0/m1_44341_n3864# eeg_fd_ota_chopped_full2_0/eeg_fd_ota_core_soft_0/m1_44741_3443# 100000
R667 eeg_fd_ota_chopped_full2_0/eeg_fd_ota_core_soft_0/m1_n55659_3443# eeg_fd_ota_chopped_full2_0/eeg_fd_ota_core_soft_0/m1_n55259_n3864# 100000
R668 eeg_fd_ota_chopped_full2_0/eeg_fd_ota_core_soft_0/m1_n47259_n3864# eeg_fd_ota_chopped_full2_0/eeg_fd_ota_core_soft_0/m1_n46859_3443# 100000
R669 eeg_fd_ota_chopped_full2_0/eeg_fd_ota_core_soft_0/m1_n42859_3443# eeg_fd_ota_chopped_full2_0/eeg_fd_ota_core_soft_0/m1_n42459_n3864# 100000
R670 eeg_fd_ota_chopped_full2_0/eeg_fd_ota_core_soft_0/m1_n38459_n3864# eeg_fd_ota_chopped_full2_0/eeg_fd_ota_core_soft_0/m1_n38059_3443# 100000
R671 eeg_fd_ota_chopped_full2_0/eeg_fd_ota_core_soft_0/m1_n34059_3443# eeg_fd_ota_chopped_full2_0/eeg_fd_ota_core_soft_0/m1_n33659_n3864# 100000
R672 eeg_fd_ota_chopped_full2_0/eeg_fd_ota_core_soft_0/m1_n29659_n3864# eeg_fd_ota_chopped_full2_0/eeg_fd_ota_core_soft_0/m1_n29259_3443# 100000
R673 eeg_fd_ota_chopped_full2_0/eeg_fd_ota_core_soft_0/m1_55141_3443# eeg_fd_ota_chopped_full2_0/eeg_fd_ota_core_soft_0/m1_55541_n3864# 100000
R674 eeg_fd_ota_chopped_full2_0/eeg_fd_ota_core_soft_0/m1_50741_n3864# eeg_fd_ota_chopped_full2_0/eeg_fd_ota_core_soft_0/m1_51141_3443# 100000
R675 eeg_fd_ota_chopped_full2_0/eeg_fd_ota_core_soft_0/m1_43941_3443# eeg_fd_ota_chopped_full2_0/eeg_fd_ota_core_soft_0/m1_44341_n3864# 100000
R676 eeg_fd_ota_chopped_full2_0/eeg_fd_ota_core_soft_0/m1_n56059_n3864# eeg_fd_ota_chopped_full2_0/eeg_fd_ota_core_soft_0/m1_n55659_3443# 100000
R677 eeg_fd_ota_chopped_full2_0/eeg_fd_ota_core_soft_0/m1_n47659_3443# eeg_fd_ota_chopped_full2_0/eeg_fd_ota_core_soft_0/m1_n47259_n3864# 100000
R678 eeg_fd_ota_chopped_full2_0/eeg_fd_ota_core_soft_0/m1_n43259_n3864# eeg_fd_ota_chopped_full2_0/eeg_fd_ota_core_soft_0/m1_n42859_3443# 100000
R679 eeg_fd_ota_chopped_full2_0/eeg_fd_ota_core_soft_0/m1_n38859_3443# eeg_fd_ota_chopped_full2_0/eeg_fd_ota_core_soft_0/m1_n38459_n3864# 100000
R680 eeg_fd_ota_chopped_full2_0/eeg_fd_ota_core_soft_0/m1_n34459_n3864# eeg_fd_ota_chopped_full2_0/eeg_fd_ota_core_soft_0/m1_n34059_3443# 100000
R681 eeg_fd_ota_chopped_full2_0/eeg_fd_ota_core_soft_0/m1_n30059_3443# eeg_fd_ota_chopped_full2_0/eeg_fd_ota_core_soft_0/m1_n29659_n3864# 100000
R682 eeg_fd_ota_chopped_full2_0/eeg_fd_ota_core_soft_0/m1_54741_n3864# eeg_fd_ota_chopped_full2_0/eeg_fd_ota_core_soft_0/m1_55141_3443# 100000
R683 VCM_REF eeg_fd_ota_chopped_full2_0/eeg_fd_ota_core_soft_0/m1_50741_n3864# 100000
R684 eeg_fd_ota_chopped_full2_0/eeg_fd_ota_core_soft_0/m1_n56459_3443# eeg_fd_ota_chopped_full2_0/eeg_fd_ota_core_soft_0/m1_n56059_n3864# 100000
R685 eeg_fd_ota_chopped_full2_0/eeg_fd_ota_core_soft_0/m1_n48059_n3864# eeg_fd_ota_chopped_full2_0/eeg_fd_ota_core_soft_0/m1_n47659_3443# 100000
R686 eeg_fd_ota_chopped_full2_0/eeg_fd_ota_core_soft_0/m1_n43659_3443# eeg_fd_ota_chopped_full2_0/eeg_fd_ota_core_soft_0/m1_n43259_n3864# 100000
R687 eeg_fd_ota_chopped_full2_0/eeg_fd_ota_core_soft_0/m1_n39259_n3864# eeg_fd_ota_chopped_full2_0/eeg_fd_ota_core_soft_0/m1_n38859_3443# 100000
R688 eeg_fd_ota_chopped_full2_0/eeg_fd_ota_core_soft_0/m1_n34859_3443# eeg_fd_ota_chopped_full2_0/eeg_fd_ota_core_soft_0/m1_n34459_n3864# 100000
R689 eeg_fd_ota_chopped_full2_0/eeg_fd_ota_core_soft_0/m1_n30459_n3864# eeg_fd_ota_chopped_full2_0/eeg_fd_ota_core_soft_0/m1_n30059_3443# 100000
R690 eeg_fd_ota_chopped_full2_0/eeg_fd_ota_core_soft_0/m1_54341_3443# eeg_fd_ota_chopped_full2_0/eeg_fd_ota_core_soft_0/m1_54741_n3864# 100000
R691 eeg_fd_ota_chopped_full2_0/eeg_fd_ota_core_soft_0/m1_n56859_n3864# eeg_fd_ota_chopped_full2_0/eeg_fd_ota_core_soft_0/m1_n56459_3443# 100000
R692 eeg_fd_ota_chopped_full2_0/eeg_fd_ota_core_soft_0/OUTP eeg_fd_ota_chopped_full2_0/eeg_fd_ota_core_soft_0/m1_n48059_n3864# 100000
R693 eeg_fd_ota_chopped_full2_0/eeg_fd_ota_core_soft_0/m1_n44059_n3864# eeg_fd_ota_chopped_full2_0/eeg_fd_ota_core_soft_0/m1_n43659_3443# 100000
R694 eeg_fd_ota_chopped_full2_0/eeg_fd_ota_core_soft_0/m1_n39659_3443# eeg_fd_ota_chopped_full2_0/eeg_fd_ota_core_soft_0/m1_n39259_n3864# 100000
R695 eeg_fd_ota_chopped_full2_0/eeg_fd_ota_core_soft_0/m1_n35259_n3864# eeg_fd_ota_chopped_full2_0/eeg_fd_ota_core_soft_0/m1_n34859_3443# 100000
R696 eeg_fd_ota_chopped_full2_0/eeg_fd_ota_core_soft_0/m1_n30859_3443# eeg_fd_ota_chopped_full2_0/eeg_fd_ota_core_soft_0/m1_n30459_n3864# 100000
R697 eeg_fd_ota_chopped_full2_0/eeg_fd_ota_core_soft_0/m1_n57259_3443# eeg_fd_ota_chopped_full2_0/eeg_fd_ota_core_soft_0/m1_n56859_n3864# 100000
R698 eeg_fd_ota_chopped_full2_0/eeg_fd_ota_core_soft_0/m1_n51259_n3864# VCM_REF 100000
R699 eeg_fd_ota_chopped_full2_0/eeg_fd_ota_core_soft_0/m1_n44459_3443# eeg_fd_ota_chopped_full2_0/eeg_fd_ota_core_soft_0/m1_n44059_n3864# 100000
R700 eeg_fd_ota_chopped_full2_0/eeg_fd_ota_core_soft_0/m1_n40059_n3864# eeg_fd_ota_chopped_full2_0/eeg_fd_ota_core_soft_0/m1_n39659_3443# 100000
R701 eeg_fd_ota_chopped_full2_0/eeg_fd_ota_core_soft_0/m1_n35659_3443# eeg_fd_ota_chopped_full2_0/eeg_fd_ota_core_soft_0/m1_n35259_n3864# 100000
R702 eeg_fd_ota_chopped_full2_0/eeg_fd_ota_core_soft_0/m1_n31259_n3864# eeg_fd_ota_chopped_full2_0/eeg_fd_ota_core_soft_0/m1_n30859_3443# 100000
R703 eeg_fd_ota_chopped_full2_0/eeg_fd_ota_core_soft_0/m1_n57659_n3864# eeg_fd_ota_chopped_full2_0/eeg_fd_ota_core_soft_0/m1_n57259_3443# 100000
R704 eeg_fd_ota_chopped_full2_0/eeg_fd_ota_core_soft_0/m1_n44859_n3864# eeg_fd_ota_chopped_full2_0/eeg_fd_ota_core_soft_0/m1_n44459_3443# 100000
R705 eeg_fd_ota_chopped_full2_0/eeg_fd_ota_core_soft_0/m1_n40459_3443# eeg_fd_ota_chopped_full2_0/eeg_fd_ota_core_soft_0/m1_n40059_n3864# 100000
R706 eeg_fd_ota_chopped_full2_0/eeg_fd_ota_core_soft_0/m1_n36059_n3864# eeg_fd_ota_chopped_full2_0/eeg_fd_ota_core_soft_0/m1_n35659_3443# 100000
R707 eeg_fd_ota_chopped_full2_0/eeg_fd_ota_core_soft_0/m1_n31659_3443# eeg_fd_ota_chopped_full2_0/eeg_fd_ota_core_soft_0/m1_n31259_n3864# 100000
X708 eeg_fd_ota_chopped_full2_0/eeg_fd_ota_core_soft_0/OUTN eeg_fd_ota_chopped_full2_0/eeg_cmfb_amp_dl2_0/VBP VDD18 VDD18 sky130_fd_pr__pfet_01v8 ad=6 pd=26 as=10.62 ps=33.54 w=24 l=4 nf=4
X709 VDD18 eeg_fd_ota_chopped_full2_0/eeg_cmfb_amp_dl2_0/VBP eeg_fd_ota_chopped_full2_0/eeg_fd_ota_core_soft_0/OUTN VDD18 sky130_fd_pr__pfet_01v8 ad=10.62 pd=33.54 as=6 ps=26 w=24 l=4 nf=4
R716 eeg_fd_ota_chopped_full2_0/eeg_fd_ota_core_soft_0/m1_n58059_3443# eeg_fd_ota_chopped_full2_0/eeg_fd_ota_core_soft_0/m1_n57659_n3864# 100000
R717 eeg_fd_ota_chopped_full2_0/eeg_fd_ota_core_soft_0/m1_n40859_n3864# eeg_fd_ota_chopped_full2_0/eeg_fd_ota_core_soft_0/m1_n40459_3443# 100000
R718 eeg_fd_ota_chopped_full2_0/eeg_fd_ota_core_soft_0/m1_n36459_3443# eeg_fd_ota_chopped_full2_0/eeg_fd_ota_core_soft_0/m1_n36059_n3864# 100000
R719 eeg_fd_ota_chopped_full2_0/eeg_fd_ota_core_soft_0/m1_n32059_n3864# eeg_fd_ota_chopped_full2_0/eeg_fd_ota_core_soft_0/m1_n31659_3443# 100000
R720 eeg_fd_ota_chopped_full2_0/eeg_fd_ota_core_soft_0/m1_n58459_n3864# eeg_fd_ota_chopped_full2_0/eeg_fd_ota_core_soft_0/m1_n58059_3443# 100000
R721 eeg_fd_ota_chopped_full2_0/eeg_fd_ota_core_soft_0/m1_n36859_n3864# eeg_fd_ota_chopped_full2_0/eeg_fd_ota_core_soft_0/m1_n36459_3443# 100000
R722 eeg_fd_ota_chopped_full2_0/eeg_fd_ota_core_soft_0/m1_n32459_3443# eeg_fd_ota_chopped_full2_0/eeg_fd_ota_core_soft_0/m1_n32059_n3864# 100000
R723 eeg_fd_ota_chopped_full2_0/eeg_fd_ota_core_soft_0/OUTP eeg_fd_ota_chopped_full2_0/eeg_fd_ota_core_soft_0/m1_n58459_n3864# 100000
R724 eeg_fd_ota_chopped_full2_0/eeg_fd_ota_core_soft_0/m1_n32859_n3864# eeg_fd_ota_chopped_full2_0/eeg_fd_ota_core_soft_0/m1_n32459_3443# 100000
R725 eeg_fd_ota_chopped_full2_0/eeg_fd_ota_core_soft_0/m1_n28859_n3864# eeg_fd_ota_chopped_full2_0/eeg_cmfb_amp_dl2_0/VCM_SENSE 100000
X726 VCM_REF eeg_pseudo_res_0/m1_68_66# eeg_pseudo_res_0/m1_68_66# VCM_REF sky130_fd_pr__pfet_01v8 ad=1.02 pd=4.04 as=1.02 ps=4.04 w=1 l=4 nf=1
X727 eeg_tg_lowq_3/B eeg_pseudo_res_0/m1_68_66# eeg_pseudo_res_0/m1_68_66# eeg_tg_lowq_3/B sky130_fd_pr__pfet_01v8 ad=1.02 pd=4.04 as=1.02 ps=4.04 w=1 l=4 nf=1
X728 VCM_REF eeg_pseudo_res_1/m1_68_66# eeg_pseudo_res_1/m1_68_66# VCM_REF sky130_fd_pr__pfet_01v8 ad=1.02 pd=4.04 as=1.02 ps=4.04 w=1 l=4 nf=1
X729 eeg_tg_lowq_7/B eeg_pseudo_res_1/m1_68_66# eeg_pseudo_res_1/m1_68_66# eeg_tg_lowq_7/B sky130_fd_pr__pfet_01v8 ad=1.02 pd=4.04 as=1.02 ps=4.04 w=1 l=4 nf=1
X730 eeg_tg_lowq_3/B S16 eeg_tg_lowq_3/B VDD18 sky130_fd_pr__pfet_01v8 ad=0.5544 pd=3 as=0.5544 ps=3 w=0.84 l=0.15 nf=1
X731 eeg_tg_lowq_0/A eeg_inv_2/Y eeg_tg_lowq_0/A VSS sky130_fd_pr__nfet_01v8 ad=0.126 pd=1.44 as=0.126 ps=1.44 w=0.42 l=0.15 nf=1
X732 eeg_tg_lowq_3/B eeg_inv_2/Y eeg_tg_lowq_3/B VSS sky130_fd_pr__nfet_01v8 ad=0.126 pd=1.44 as=0.126 ps=1.44 w=0.42 l=0.15 nf=1
X733 eeg_tg_lowq_3/B eeg_inv_2/Y eeg_tg_lowq_0/A VDD18 sky130_fd_pr__pfet_01v8 ad=1.7136 pd=5.4 as=1.7136 ps=5.4 w=1.68 l=0.15 nf=1
X734 eeg_tg_lowq_0/A S16 eeg_tg_lowq_0/A VDD18 sky130_fd_pr__pfet_01v8 ad=0.5544 pd=3 as=0.5544 ps=3 w=0.84 l=0.15 nf=1
X735 eeg_tg_lowq_3/B S16 eeg_tg_lowq_0/A VSS sky130_fd_pr__nfet_01v8 ad=0.5544 pd=3 as=0.5544 ps=3 w=0.84 l=0.15 nf=1
X736 eeg_tg_lowq_3/B S8 eeg_tg_lowq_3/B VDD18 sky130_fd_pr__pfet_01v8 ad=0.5544 pd=3 as=0.5544 ps=3 w=0.84 l=0.15 nf=1
X737 eeg_tg_lowq_1/A eeg_inv_3/Y eeg_tg_lowq_1/A VSS sky130_fd_pr__nfet_01v8 ad=0.126 pd=1.44 as=0.126 ps=1.44 w=0.42 l=0.15 nf=1
X738 eeg_tg_lowq_3/B eeg_inv_3/Y eeg_tg_lowq_3/B VSS sky130_fd_pr__nfet_01v8 ad=0.126 pd=1.44 as=0.126 ps=1.44 w=0.42 l=0.15 nf=1
X739 eeg_tg_lowq_3/B eeg_inv_3/Y eeg_tg_lowq_1/A VDD18 sky130_fd_pr__pfet_01v8 ad=1.7136 pd=5.4 as=1.7136 ps=5.4 w=1.68 l=0.15 nf=1
X740 eeg_tg_lowq_1/A S8 eeg_tg_lowq_1/A VDD18 sky130_fd_pr__pfet_01v8 ad=0.5544 pd=3 as=0.5544 ps=3 w=0.84 l=0.15 nf=1
X741 eeg_tg_lowq_3/B S8 eeg_tg_lowq_1/A VSS sky130_fd_pr__nfet_01v8 ad=0.5544 pd=3 as=0.5544 ps=3 w=0.84 l=0.15 nf=1
X742 VCM_REF RST VCM_REF VDD18 sky130_fd_pr__pfet_01v8 ad=1.1088 pd=6 as=1.1088 ps=6 w=1.68 l=0.15 nf=2
X743 eeg_tg_lowq_3/B eeg_inv_0/Y eeg_tg_lowq_3/B VSS sky130_fd_pr__nfet_01v8 ad=0.126 pd=1.44 as=0.126 ps=1.44 w=0.42 l=0.15 nf=1
X744 VCM_REF eeg_inv_0/Y VCM_REF VSS sky130_fd_pr__nfet_01v8 ad=0.252 pd=2.88 as=0.252 ps=2.88 w=0.84 l=0.15 nf=2
X745 VCM_REF eeg_inv_0/Y eeg_tg_lowq_3/B VDD18 sky130_fd_pr__pfet_01v8 ad=1.7136 pd=5.4 as=1.7136 ps=5.4 w=1.68 l=0.15 nf=1
X746 eeg_tg_lowq_3/B RST eeg_tg_lowq_3/B VDD18 sky130_fd_pr__pfet_01v8 ad=0.5544 pd=3 as=0.5544 ps=3 w=0.84 l=0.15 nf=1
X747 VCM_REF RST eeg_tg_lowq_3/B VSS sky130_fd_pr__nfet_01v8 ad=0.5544 pd=3 as=0.5544 ps=3 w=0.84 l=0.15 nf=1
X748 eeg_tg_lowq_3/B S32 eeg_tg_lowq_3/B VDD18 sky130_fd_pr__pfet_01v8 ad=0.5544 pd=3 as=0.5544 ps=3 w=0.84 l=0.15 nf=1
X749 eeg_tg_lowq_3/A eeg_inv_1/Y eeg_tg_lowq_3/A VSS sky130_fd_pr__nfet_01v8 ad=0.126 pd=1.44 as=0.126 ps=1.44 w=0.42 l=0.15 nf=1
X750 eeg_tg_lowq_3/B eeg_inv_1/Y eeg_tg_lowq_3/B VSS sky130_fd_pr__nfet_01v8 ad=0.126 pd=1.44 as=0.126 ps=1.44 w=0.42 l=0.15 nf=1
X751 eeg_tg_lowq_3/B eeg_inv_1/Y eeg_tg_lowq_3/A VDD18 sky130_fd_pr__pfet_01v8 ad=1.7136 pd=5.4 as=1.7136 ps=5.4 w=1.68 l=0.15 nf=1
X752 eeg_tg_lowq_3/A S32 eeg_tg_lowq_3/A VDD18 sky130_fd_pr__pfet_01v8 ad=0.5544 pd=3 as=0.5544 ps=3 w=0.84 l=0.15 nf=1
X753 eeg_tg_lowq_3/B S32 eeg_tg_lowq_3/A VSS sky130_fd_pr__nfet_01v8 ad=0.5544 pd=3 as=0.5544 ps=3 w=0.84 l=0.15 nf=1
X755 eeg_tg_lowq_7/B eeg_inv_0/Y eeg_tg_lowq_7/B VSS sky130_fd_pr__nfet_01v8 ad=0.126 pd=1.44 as=0.126 ps=1.44 w=0.42 l=0.15 nf=1
X757 VCM_REF eeg_inv_0/Y eeg_tg_lowq_7/B VDD18 sky130_fd_pr__pfet_01v8 ad=1.7136 pd=5.4 as=1.7136 ps=5.4 w=1.68 l=0.15 nf=1
X758 eeg_tg_lowq_7/B RST eeg_tg_lowq_7/B VDD18 sky130_fd_pr__pfet_01v8 ad=0.5544 pd=3 as=0.5544 ps=3 w=0.84 l=0.15 nf=1
X759 VCM_REF RST eeg_tg_lowq_7/B VSS sky130_fd_pr__nfet_01v8 ad=0.5544 pd=3 as=0.5544 ps=3 w=0.84 l=0.15 nf=1
X760 eeg_tg_lowq_7/B S8 eeg_tg_lowq_7/B VDD18 sky130_fd_pr__pfet_01v8 ad=0.5544 pd=3 as=0.5544 ps=3 w=0.84 l=0.15 nf=1
X761 eeg_tg_lowq_5/A eeg_inv_3/Y eeg_tg_lowq_5/A VSS sky130_fd_pr__nfet_01v8 ad=0.126 pd=1.44 as=0.126 ps=1.44 w=0.42 l=0.15 nf=1
X762 eeg_tg_lowq_7/B eeg_inv_3/Y eeg_tg_lowq_7/B VSS sky130_fd_pr__nfet_01v8 ad=0.126 pd=1.44 as=0.126 ps=1.44 w=0.42 l=0.15 nf=1
X763 eeg_tg_lowq_7/B eeg_inv_3/Y eeg_tg_lowq_5/A VDD18 sky130_fd_pr__pfet_01v8 ad=1.7136 pd=5.4 as=1.7136 ps=5.4 w=1.68 l=0.15 nf=1
X764 eeg_tg_lowq_5/A S8 eeg_tg_lowq_5/A VDD18 sky130_fd_pr__pfet_01v8 ad=0.5544 pd=3 as=0.5544 ps=3 w=0.84 l=0.15 nf=1
X765 eeg_tg_lowq_7/B S8 eeg_tg_lowq_5/A VSS sky130_fd_pr__nfet_01v8 ad=0.5544 pd=3 as=0.5544 ps=3 w=0.84 l=0.15 nf=1
X766 eeg_tg_lowq_7/B S16 eeg_tg_lowq_7/B VDD18 sky130_fd_pr__pfet_01v8 ad=0.5544 pd=3 as=0.5544 ps=3 w=0.84 l=0.15 nf=1
X767 eeg_tg_lowq_6/A eeg_inv_2/Y eeg_tg_lowq_6/A VSS sky130_fd_pr__nfet_01v8 ad=0.126 pd=1.44 as=0.126 ps=1.44 w=0.42 l=0.15 nf=1
X768 eeg_tg_lowq_7/B eeg_inv_2/Y eeg_tg_lowq_7/B VSS sky130_fd_pr__nfet_01v8 ad=0.126 pd=1.44 as=0.126 ps=1.44 w=0.42 l=0.15 nf=1
X769 eeg_tg_lowq_7/B eeg_inv_2/Y eeg_tg_lowq_6/A VDD18 sky130_fd_pr__pfet_01v8 ad=1.7136 pd=5.4 as=1.7136 ps=5.4 w=1.68 l=0.15 nf=1
X770 eeg_tg_lowq_6/A S16 eeg_tg_lowq_6/A VDD18 sky130_fd_pr__pfet_01v8 ad=0.5544 pd=3 as=0.5544 ps=3 w=0.84 l=0.15 nf=1
X771 eeg_tg_lowq_7/B S16 eeg_tg_lowq_6/A VSS sky130_fd_pr__nfet_01v8 ad=0.5544 pd=3 as=0.5544 ps=3 w=0.84 l=0.15 nf=1
X772 eeg_tg_lowq_7/B S32 eeg_tg_lowq_7/B VDD18 sky130_fd_pr__pfet_01v8 ad=0.5544 pd=3 as=0.5544 ps=3 w=0.84 l=0.15 nf=1
X773 eeg_tg_lowq_7/A eeg_inv_1/Y eeg_tg_lowq_7/A VSS sky130_fd_pr__nfet_01v8 ad=0.126 pd=1.44 as=0.126 ps=1.44 w=0.42 l=0.15 nf=1
X774 eeg_tg_lowq_7/B eeg_inv_1/Y eeg_tg_lowq_7/B VSS sky130_fd_pr__nfet_01v8 ad=0.126 pd=1.44 as=0.126 ps=1.44 w=0.42 l=0.15 nf=1
X775 eeg_tg_lowq_7/B eeg_inv_1/Y eeg_tg_lowq_7/A VDD18 sky130_fd_pr__pfet_01v8 ad=1.7136 pd=5.4 as=1.7136 ps=5.4 w=1.68 l=0.15 nf=1
X776 eeg_tg_lowq_7/A S32 eeg_tg_lowq_7/A VDD18 sky130_fd_pr__pfet_01v8 ad=0.5544 pd=3 as=0.5544 ps=3 w=0.84 l=0.15 nf=1
X777 eeg_tg_lowq_7/B S32 eeg_tg_lowq_7/A VSS sky130_fd_pr__nfet_01v8 ad=0.5544 pd=3 as=0.5544 ps=3 w=0.84 l=0.15 nf=1
X778 VDD18 RST eeg_inv_0/Y VDD18 sky130_fd_pr__pfet_01v8 ad=2.04 pd=6.04 as=2.04 ps=6.04 w=2 l=0.15 nf=1
X779 VSS RST eeg_inv_0/Y VSS sky130_fd_pr__nfet_01v8 ad=1.02 pd=4.04 as=1.02 ps=4.04 w=1 l=0.15 nf=1
X780 VDD18 S32 eeg_inv_1/Y VDD18 sky130_fd_pr__pfet_01v8 ad=2.04 pd=6.04 as=2.04 ps=6.04 w=2 l=0.15 nf=1
X781 VSS S32 eeg_inv_1/Y VSS sky130_fd_pr__nfet_01v8 ad=1.02 pd=4.04 as=1.02 ps=4.04 w=1 l=0.15 nf=1
X782 VDD18 S16 eeg_inv_2/Y VDD18 sky130_fd_pr__pfet_01v8 ad=2.04 pd=6.04 as=2.04 ps=6.04 w=2 l=0.15 nf=1
X783 VSS S16 eeg_inv_2/Y VSS sky130_fd_pr__nfet_01v8 ad=1.02 pd=4.04 as=1.02 ps=4.04 w=1 l=0.15 nf=1
X784 VDD18 S8 eeg_inv_3/Y VDD18 sky130_fd_pr__pfet_01v8 ad=2.04 pd=6.04 as=2.04 ps=6.04 w=2 l=0.15 nf=1
X785 VSS S8 eeg_inv_3/Y VSS sky130_fd_pr__nfet_01v8 ad=1.02 pd=4.04 as=1.02 ps=4.04 w=1 l=0.15 nf=1
CMIM786 eeg_tg_lowq_3/B ELN 3.200000e-11
CMIM788 eeg_tg_lowq_7/B ELP 3.200000e-11
CMIM792 eeg_tg_lowq_5/A OUTN 3.500000e-12
CMIM793 eeg_tg_lowq_0/A OUTP 1.500000e-12
CMIM815 eeg_tg_lowq_6/A OUTN 1.500000e-12
CMIM819 eeg_tg_lowq_3/B OUTP 5.000000e-13
CMIM823 eeg_tg_lowq_1/A OUTP 3.500000e-12
CMIM827 eeg_tg_lowq_7/A OUTN 5.000000e-13
CMIM842 eeg_tg_lowq_3/A OUTP 5.000000e-13
CMIM864 eeg_tg_lowq_7/B OUTN 5.000000e-13
C0 ELN VSS 2.638090e-13
C1 ELN eeg_tg_lowq_3/B 1.649640e-12
C3 ELP OUTP 4.077110e-17
C4 ELP VSS 2.637180e-13
C5 ELP eeg_tg_lowq_7/B 1.649630e-12
C6 NPHIBM OUTN 7.152395e-15
C10 OUTN OUTP 4.993308e-14
C13 OUTN VCM_REF 1.401636e-15
C14 OUTN VDD18 4.215517e-16
C15 OUTN VSS 1.659602e-13
C16 OUTN eeg_fd_ota_chopped_full2_0/eeg_bias_gen_0/VBN 1.426901e-15
C17 OUTN eeg_fd_ota_chopped_full2_0/eeg_bias_gen_0/VBNF 7.085244e-16
C18 OUTN eeg_fd_ota_chopped_full2_0/eeg_bias_gen_0/VBP 1.088385e-15
C19 OUTN eeg_fd_ota_chopped_full2_0/eeg_bias_gen_0/m1_2524_466# 2.249370e-16
C20 OUTN eeg_fd_ota_chopped_full2_0/stage2_0/VBP2 1.189328e-15
C21 OUTN eeg_tg_lowq_0/A 1.531580e-15
C22 OUTN eeg_tg_lowq_1/A 1.215850e-14
C23 OUTN eeg_tg_lowq_3/A 1.520450e-15
C25 OUTN eeg_tg_lowq_5/A 1.872870e-13
C26 OUTN eeg_tg_lowq_6/A 7.889160e-14
C27 OUTN eeg_tg_lowq_7/A 2.359180e-14
C28 OUTN eeg_tg_lowq_7/B 2.421910e-14
C34 OUTP VCM_REF 5.351555e-15
C35 OUTP VDD18 3.299253e-16
C36 OUTP VSS 2.031691e-13
C37 OUTP eeg_fd_ota_chopped_full2_0/eeg_bias_gen_0/VBN 2.810870e-16
C38 OUTP eeg_fd_ota_chopped_full2_0/eeg_bias_gen_0/VBNF 5.446466e-16
C39 OUTP eeg_fd_ota_chopped_full2_0/eeg_bias_gen_0/VBP 1.778339e-16
C40 OUTP eeg_fd_ota_chopped_full2_0/eeg_bias_gen_0/m1_2524_466# 4.808215e-17
C41 OUTP eeg_fd_ota_chopped_full2_0/stage2_0/VBP2 2.745872e-16
C42 OUTP eeg_fd_ota_chopped_full2_0/stage2_0/VCM2 4.872794e-16
C47 OUTP eeg_tg_lowq_0/A 7.468640e-14
C48 OUTP eeg_tg_lowq_1/A 1.869058e-13
C49 OUTP eeg_tg_lowq_3/A 2.326716e-14
C50 OUTP eeg_tg_lowq_3/B 2.348810e-14
C51 OUTP eeg_tg_lowq_5/A 9.308394e-16
C52 OUTP eeg_tg_lowq_6/A 9.388685e-16
C53 OUTP eeg_tg_lowq_7/A 9.581515e-16
C54 OUTP eeg_tg_lowq_7/B 1.189056e-15
C57 PHIM VCM_REF 3.178203e-15
C58 RST S16 9.702061e-16
C59 RST S32 2.897180e-15
C60 RST S8 1.286165e-16
C61 RST VCM_REF 9.536742e-17
C62 RST VDD18 7.804802e-16
C63 RST VSS 1.572318e-14
C64 RST eeg_inv_0/Y 1.602129e-15
C65 RST eeg_inv_1/Y 2.388070e-16
C66 RST eeg_inv_2/Y 7.948240e-16
C67 RST eeg_inv_3/Y 1.607270e-15
C68 RST eeg_tg_lowq_0/A 6.842932e-17
C71 RST eeg_tg_lowq_3/B 3.921161e-16
C72 RST eeg_tg_lowq_7/B 2.400537e-16
C73 S16 S32 2.965713e-15
C74 S16 S8 2.936220e-15
C75 S16 VCM_REF 2.334550e-16
C76 S16 VDD18 8.569851e-16
C77 S16 VSS 1.263913e-14
C78 S16 eeg_inv_0/Y 5.250760e-16
C79 S16 eeg_inv_1/Y 1.635210e-16
C80 S16 eeg_inv_2/Y 3.874150e-15
C81 S16 eeg_inv_3/Y 1.963939e-16
C84 S16 eeg_tg_lowq_3/B 4.070530e-16
C88 S16 eeg_tg_lowq_7/B 1.862787e-16
C89 S32 S8 2.830191e-16
C90 S32 VDD18 5.584713e-16
C91 S32 VSS 6.205403e-15
C92 S32 eeg_inv_0/Y 8.054320e-17
C93 S32 eeg_inv_1/Y 3.842403e-15
C94 S32 eeg_inv_2/Y 1.807890e-16
C95 S32 eeg_inv_3/Y 2.594502e-16
C96 S32 eeg_tg_lowq_3/A 2.504586e-16
C97 S32 eeg_tg_lowq_3/B 6.058147e-16
C100 S32 eeg_tg_lowq_7/B 2.202522e-16
C101 S64 VSS 1.829050e-16
C102 S64 eeg_inv_0/Y 2.522730e-17
C103 S8 VDD18 4.441547e-16
C104 S8 VSS 8.630804e-15
C105 S8 eeg_inv_0/Y 9.197810e-17
C106 S8 eeg_inv_1/Y 1.969573e-16
C107 S8 eeg_inv_2/Y 1.710919e-16
C108 S8 eeg_inv_3/Y 3.687484e-15
C110 S8 eeg_tg_lowq_1/A 2.528970e-16
C111 S8 eeg_tg_lowq_3/B 1.831371e-16
C114 S8 eeg_tg_lowq_7/B 3.632385e-16
C115 VCM_REF VDD18 5.403918e-15
C116 VCM_REF VSS 5.251564e-14
C117 VCM_REF eeg_inv_0/Y 1.134379e-16
C118 VCM_REF eeg_inv_2/Y 2.559587e-16
C119 VCM_REF eeg_pseudo_res_0/m1_68_66# 8.033591e-17
C121 VCM_REF eeg_tg_lowq_0/A 1.151090e-16
C122 VCM_REF eeg_tg_lowq_1/A 1.158659e-16
C124 VCM_REF eeg_tg_lowq_3/B 1.703838e-15
C125 VCM_REF eeg_tg_lowq_5/A 1.152887e-16
C126 VCM_REF eeg_tg_lowq_6/A 3.273310e-16
C128 VCM_REF eeg_tg_lowq_7/B 1.258160e-15
C129 VDD18 VSS 3.783017e-14
C131 VDD18 eeg_inv_0/Y 1.144057e-15
C132 VDD18 eeg_inv_1/Y 3.732202e-16
C133 VDD18 eeg_inv_2/Y 8.589415e-16
C134 VDD18 eeg_inv_3/Y 4.824141e-16
C135 VDD18 eeg_pseudo_res_0/m1_68_66# 3.773776e-17
C137 VDD18 eeg_tg_lowq_0/A 1.288053e-16
C138 VDD18 eeg_tg_lowq_1/A 2.765245e-16
C139 VDD18 eeg_tg_lowq_3/A 2.494412e-16
C140 VDD18 eeg_tg_lowq_3/B 2.300143e-15
C144 VDD18 eeg_tg_lowq_7/B 2.110887e-15
C150 VSS eeg_inv_0/Y 9.260413e-16
C151 VSS eeg_inv_1/Y 7.524579e-16
C152 VSS eeg_inv_2/Y 9.434388e-16
C153 VSS eeg_inv_3/Y 7.548584e-16
C154 VSS eeg_pseudo_res_0/m1_68_66# 1.014106e-16
C155 VSS eeg_pseudo_res_1/m1_68_66# 1.013884e-16
C156 VSS eeg_tg_lowq_0/A 1.089996e-16
C157 VSS eeg_tg_lowq_1/A 2.171794e-16
C158 VSS eeg_tg_lowq_3/A 2.160947e-16
C159 VSS eeg_tg_lowq_3/B 1.046869e-15
C163 VSS eeg_tg_lowq_7/B 1.153756e-15
C167 eeg_inv_0/Y VSS 1.661140e-14
C168 eeg_inv_0/Y eeg_inv_1/Y 2.847579e-15
C169 eeg_inv_0/Y eeg_inv_2/Y 3.177184e-15
C170 eeg_inv_0/Y eeg_inv_3/Y 1.808354e-16
C171 eeg_inv_0/Y eeg_pseudo_res_1/m1_68_66# 2.454043e-17
C172 eeg_inv_0/Y eeg_tg_lowq_3/B 5.508493e-16
C173 eeg_inv_0/Y eeg_tg_lowq_7/B 5.955675e-16
C174 eeg_inv_1/Y VSS 6.503700e-15
C175 eeg_inv_1/Y eeg_inv_2/Y 2.945199e-15
C176 eeg_inv_1/Y eeg_inv_3/Y 2.199884e-16
C177 eeg_inv_1/Y eeg_tg_lowq_3/A 1.831984e-16
C178 eeg_inv_1/Y eeg_tg_lowq_3/B 5.751400e-16
C180 eeg_inv_1/Y eeg_tg_lowq_7/B 4.810019e-16
C181 eeg_inv_2/Y VSS 1.035860e-14
C182 eeg_inv_2/Y eeg_inv_3/Y 3.285369e-15
C184 eeg_inv_2/Y eeg_tg_lowq_3/B 3.442526e-16
C186 eeg_inv_2/Y eeg_tg_lowq_7/B 1.837304e-16
C187 eeg_inv_3/Y VSS 7.444670e-15
C189 eeg_inv_3/Y eeg_tg_lowq_1/A 1.931899e-16
C190 eeg_inv_3/Y eeg_tg_lowq_3/B 1.869698e-16
C192 eeg_inv_3/Y eeg_tg_lowq_7/B 2.928868e-16
C193 eeg_pseudo_res_0/m1_68_66# eeg_pseudo_res_1/m1_68_66# 5.733833e-17
C198 eeg_tg_lowq_0/A VSS 2.551130e-14
C199 eeg_tg_lowq_0/A eeg_tg_lowq_1/A 3.736297e-16
C200 eeg_tg_lowq_0/A eeg_tg_lowq_3/B 4.501243e-17
C202 eeg_tg_lowq_0/A eeg_tg_lowq_7/B 5.672617e-16
C203 eeg_tg_lowq_1/A VSS 3.182830e-14
C204 eeg_tg_lowq_1/A eeg_tg_lowq_3/B 3.185743e-17
C205 eeg_tg_lowq_1/A eeg_tg_lowq_5/A 1.416121e-15
C206 eeg_tg_lowq_1/A eeg_tg_lowq_7/B 3.342168e-16
C207 eeg_tg_lowq_3/A VSS 2.189780e-14
C208 eeg_tg_lowq_3/A eeg_tg_lowq_3/B 5.800602e-16
C209 eeg_tg_lowq_3/A eeg_tg_lowq_7/A 3.495687e-16
C210 eeg_tg_lowq_3/A eeg_tg_lowq_7/B 4.334840e-16
C211 eeg_tg_lowq_3/B VSS 4.877290e-14
C212 eeg_tg_lowq_3/B eeg_tg_lowq_7/B 1.023261e-14
C213 eeg_tg_lowq_5/A VSS 2.132890e-14
C214 eeg_tg_lowq_5/A eeg_tg_lowq_6/A 3.984771e-17
C215 eeg_tg_lowq_5/A eeg_tg_lowq_7/B 3.369303e-17
C216 eeg_tg_lowq_6/A VSS 1.131540e-14
C217 eeg_tg_lowq_6/A eeg_tg_lowq_7/A 2.534778e-17
C219 eeg_tg_lowq_7/A VSS 4.047010e-15
C220 eeg_tg_lowq_7/A eeg_tg_lowq_7/B 1.355538e-16
C221 eeg_tg_lowq_7/B VSS 6.170890e-14
C224 NPHIBM NPHIM 1.278695e-16
C225 NPHIBM PHIBM 3.689518e-14
C226 NPHIBM PHIM 1.340413e-16
C227 NPHIBM VCM_REF 1.502170e-16
C228 NPHIBM VDD18 1.525209e-16
C229 NPHIBM VSS 3.774740e-14
C230 NPHIBM eeg_fd_ota_chopped_full2_0/eeg_bias_gen_0/VBNF 1.413920e-16
C232 NPHIBM eeg_fd_ota_chopped_full2_0/eeg_fd_ota_core_soft_0/OUTN 1.767125e-16
C233 NPHIBM eeg_fd_ota_chopped_full2_0/eeg_fd_ota_core_soft_0/OUTP 1.189021e-16
C239 NPHIM PHIBM 3.680056e-14
C240 NPHIM PHIM 3.702725e-14
C241 NPHIM VCM_REF 1.652870e-16
C242 NPHIM VDD18 1.530988e-16
C243 NPHIM VSS 8.383554e-15
C244 NPHIM eeg_fd_ota_chopped_full2_0/eeg_bias_gen_0/VBNF 1.364720e-16
C246 NPHIM eeg_fd_ota_chopped_full2_0/eeg_fd_ota_core_soft_0/OUTN 1.516516e-16
C247 NPHIM eeg_fd_ota_chopped_full2_0/eeg_fd_ota_core_soft_0/OUTP 1.024342e-15
C252 OUTN VSS 4.571667e-16
C253 OUTN eeg_fd_ota_chopped_full2_0/eeg_bias_gen_0/VBNF 1.365910e-16
C256 OUTN eeg_fd_ota_chopped_full2_0/stage2_0/VBP2 6.053202e-15
C257 OUTN eeg_fd_ota_chopped_full2_0/stage2_0/VCM2 1.365910e-16
C260 OUTP VSS 3.752509e-16
C261 OUTP eeg_fd_ota_chopped_full2_0/eeg_bias_gen_0/VBNF 2.070634e-16
C264 OUTP eeg_fd_ota_chopped_full2_0/stage2_0/VCM2 1.333710e-16
C268 PHIBM PHIM 1.120990e-16
C269 PHIBM VCM_REF 1.651930e-16
C270 PHIBM VDD18 1.567750e-16
C271 PHIBM VSS 9.079500e-15
C272 PHIBM eeg_fd_ota_chopped_full2_0/eeg_bias_gen_0/VBNF 1.386430e-16
C274 PHIBM eeg_fd_ota_chopped_full2_0/eeg_fd_ota_core_soft_0/OUTN 2.135593e-16
C275 PHIBM eeg_fd_ota_chopped_full2_0/eeg_fd_ota_core_soft_0/OUTP 8.573296e-16
C276 PHIBM eeg_fd_ota_chopped_full2_0/stage2_0/N2N 2.818096e-17
C281 PHIM VCM_REF 1.597600e-15
C282 PHIM VDD18 1.593344e-16
C283 PHIM VSS 2.788475e-14
C284 PHIM eeg_fd_ota_chopped_full2_0/eeg_bias_gen_0/VBNF 1.393190e-16
C285 PHIM eeg_fd_ota_chopped_full2_0/eeg_cmfb_amp_dl2_0/VBP 3.735676e-15
C286 PHIM eeg_fd_ota_chopped_full2_0/eeg_fd_ota_core_soft_0/OUTN 1.626646e-16
C287 PHIM eeg_fd_ota_chopped_full2_0/eeg_fd_ota_core_soft_0/OUTP 2.696166e-16
C290 VCM_REF VDD18 2.925411e-15
C291 VCM_REF VSS 4.378994e-14
C292 VCM_REF eeg_fd_ota_chopped_full2_0/eeg_bias_gen_0/VBNF 1.760523e-14
C293 VCM_REF eeg_fd_ota_chopped_full2_0/eeg_cmfb_amp_dl2_0/VBP 3.039269e-15
C294 VCM_REF eeg_fd_ota_chopped_full2_0/eeg_cmfb_amp_dl2_0/VCM_SENSE 2.946854e-16
C299 VCM_REF eeg_fd_ota_chopped_full2_0/eeg_fd_ota_core_soft_0/OUTN 1.978812e-16
C300 VCM_REF eeg_fd_ota_chopped_full2_0/eeg_fd_ota_core_soft_0/OUTP 3.238353e-16
C301 VCM_REF eeg_fd_ota_chopped_full2_0/stage2_0/VBP2 4.836588e-15
C302 VCM_REF eeg_fd_ota_chopped_full2_0/stage2_0/VCM2 1.339766e-16
C303 VDD18 VSS 1.098004e-13
C305 VDD18 eeg_fd_ota_chopped_full2_0/eeg_bias_gen_0/VBNF 2.280093e-14
C306 VDD18 eeg_fd_ota_chopped_full2_0/eeg_bias_gen_0/eeg_pseudo_res_0/m1_68_66# 9.173609e-17
C307 VDD18 eeg_fd_ota_chopped_full2_0/eeg_cmfb_amp_dl2_0/VBP 5.412926e-16
C308 VDD18 eeg_fd_ota_chopped_full2_0/eeg_cmfb_amp_dl2_0/VCM_SENSE 6.617475e-16
C313 VDD18 eeg_fd_ota_chopped_full2_0/eeg_fd_ota_core_soft_0/OUTN 1.485477e-16
C314 VDD18 eeg_fd_ota_chopped_full2_0/eeg_fd_ota_core_soft_0/OUTP 3.204062e-16
C315 VDD18 eeg_fd_ota_chopped_full2_0/stage2_0/N2N 8.484494e-17
C316 VDD18 eeg_fd_ota_chopped_full2_0/stage2_0/N2P 1.115579e-16
C317 VDD18 eeg_fd_ota_chopped_full2_0/stage2_0/VBP2 2.659302e-16
C321 VSS eeg_fd_ota_chopped_full2_0/eeg_bias_gen_0/VBN 6.624060e-17
C322 VSS eeg_fd_ota_chopped_full2_0/eeg_bias_gen_0/VBNF 7.394524e-15
C325 VSS eeg_fd_ota_chopped_full2_0/eeg_bias_gen_0/m1_3701_n11401# 5.414340e-17
C326 VSS eeg_fd_ota_chopped_full2_0/eeg_bias_gen_0/m1_4341_n2557# 6.618650e-17
C327 VSS eeg_fd_ota_chopped_full2_0/eeg_bias_gen_0/m1_5141_n2557# 6.618650e-17
C328 VSS eeg_fd_ota_chopped_full2_0/eeg_bias_gen_0/m1_5941_n2557# 6.618650e-17
C329 VSS eeg_fd_ota_chopped_full2_0/eeg_bias_gen_0/m1_6741_n2557# 6.618650e-17
C330 VSS eeg_fd_ota_chopped_full2_0/eeg_bias_gen_0/m1_7541_n2557# 6.637850e-17
C331 VSS eeg_fd_ota_chopped_full2_0/eeg_bias_gen_0/m1_8341_n2557# 7.296267e-17
C332 VSS eeg_fd_ota_chopped_full2_0/eeg_bias_gen_0/m1_9141_n2557# 8.982074e-17
C333 VSS eeg_fd_ota_chopped_full2_0/eeg_bias_gen_0/m1_9941_n2557# 3.857350e-17
C334 VSS eeg_fd_ota_chopped_full2_0/eeg_cmfb_amp_dl2_0/VCM_SENSE 2.286714e-16
C336 VSS eeg_fd_ota_chopped_full2_0/eeg_fd_ota_core_soft_0/INN 5.272137e-16
C337 VSS eeg_fd_ota_chopped_full2_0/eeg_fd_ota_core_soft_0/INP 2.553497e-16
C338 VSS eeg_fd_ota_chopped_full2_0/eeg_fd_ota_core_soft_0/OUTN 5.400498e-16
C339 VSS eeg_fd_ota_chopped_full2_0/eeg_fd_ota_core_soft_0/OUTP 2.642600e-16
C347 VSS eeg_fd_ota_chopped_full2_0/eeg_fd_ota_core_soft_0/m1_31941_3443# 5.111280e-17
C349 VSS eeg_fd_ota_chopped_full2_0/eeg_fd_ota_core_soft_0/m1_32741_3443# 3.687720e-17
C380 VSS eeg_fd_ota_chopped_full2_0/eeg_fd_ota_core_soft_0/m1_n22658_111# 4.238442e-16
C416 VSS eeg_fd_ota_chopped_full2_0/stage2_0/N2N 3.219981e-16
C417 VSS eeg_fd_ota_chopped_full2_0/stage2_0/N2P 2.741467e-16
C418 VSS eeg_fd_ota_chopped_full2_0/stage2_0/VBP2 5.043700e-15
C419 VSS eeg_fd_ota_chopped_full2_0/stage2_0/VCM2 6.769180e-16
C421 eeg_fd_ota_chopped_full2_0/eeg_bias_gen_0/VBN eeg_fd_ota_chopped_full2_0/eeg_bias_gen_0/VBNF 4.256316e-16
C422 eeg_fd_ota_chopped_full2_0/eeg_bias_gen_0/VBNF VSS 6.367410e-14
C424 eeg_fd_ota_chopped_full2_0/eeg_bias_gen_0/VBNF eeg_fd_ota_chopped_full2_0/eeg_bias_gen_0/eeg_pseudo_res_0/m1_68_66# 1.772757e-16
C428 eeg_fd_ota_chopped_full2_0/eeg_bias_gen_0/VBNF eeg_fd_ota_chopped_full2_0/eeg_cmfb_amp_dl2_0/VBP 2.452100e-16
C429 eeg_fd_ota_chopped_full2_0/eeg_bias_gen_0/VBNF eeg_fd_ota_chopped_full2_0/eeg_cmfb_amp_dl2_0/VCM_SENSE 2.222844e-16
C430 eeg_fd_ota_chopped_full2_0/eeg_bias_gen_0/VBNF eeg_fd_ota_chopped_full2_0/eeg_cmfb_amp_dl2_0/m1_370_1493# 4.385375e-17
C431 eeg_fd_ota_chopped_full2_0/eeg_bias_gen_0/VBNF eeg_fd_ota_chopped_full2_0/eeg_cmfb_amp_dl2_0/m1_68_166# 3.222660e-17
C432 eeg_fd_ota_chopped_full2_0/eeg_bias_gen_0/VBNF eeg_fd_ota_chopped_full2_0/eeg_cmfb_amp_dl2_s2_0/m1_370_1493# 4.385371e-17
C434 eeg_fd_ota_chopped_full2_0/eeg_bias_gen_0/VBNF eeg_fd_ota_chopped_full2_0/eeg_fd_ota_core_soft_0/OUTN 2.279440e-16
C435 eeg_fd_ota_chopped_full2_0/eeg_bias_gen_0/VBNF eeg_fd_ota_chopped_full2_0/eeg_fd_ota_core_soft_0/OUTP 3.766246e-16
C436 eeg_fd_ota_chopped_full2_0/eeg_bias_gen_0/VBNF eeg_fd_ota_chopped_full2_0/eeg_fd_ota_core_soft_0/m1_28341_n3864# 5.192510e-17
C437 eeg_fd_ota_chopped_full2_0/eeg_bias_gen_0/VBNF eeg_fd_ota_chopped_full2_0/eeg_fd_ota_core_soft_0/m1_29141_n3864# 5.057920e-17
C438 eeg_fd_ota_chopped_full2_0/eeg_bias_gen_0/VBNF eeg_fd_ota_chopped_full2_0/eeg_fd_ota_core_soft_0/m1_29941_n3864# 5.057930e-17
C439 eeg_fd_ota_chopped_full2_0/eeg_bias_gen_0/VBNF eeg_fd_ota_chopped_full2_0/eeg_fd_ota_core_soft_0/m1_30741_n3864# 5.057930e-17
C440 eeg_fd_ota_chopped_full2_0/eeg_bias_gen_0/VBNF eeg_fd_ota_chopped_full2_0/eeg_fd_ota_core_soft_0/m1_31541_n3864# 5.057930e-17
C441 eeg_fd_ota_chopped_full2_0/eeg_bias_gen_0/VBNF eeg_fd_ota_chopped_full2_0/eeg_fd_ota_core_soft_0/m1_32341_n3864# 5.057928e-17
C442 eeg_fd_ota_chopped_full2_0/eeg_bias_gen_0/VBNF eeg_fd_ota_chopped_full2_0/eeg_fd_ota_core_soft_0/m1_33141_n3864# 5.057930e-17
C443 eeg_fd_ota_chopped_full2_0/eeg_bias_gen_0/VBNF eeg_fd_ota_chopped_full2_0/eeg_fd_ota_core_soft_0/m1_33941_n3864# 5.057930e-17
C444 eeg_fd_ota_chopped_full2_0/eeg_bias_gen_0/VBNF eeg_fd_ota_chopped_full2_0/eeg_fd_ota_core_soft_0/m1_34741_n3864# 5.057920e-17
C445 eeg_fd_ota_chopped_full2_0/eeg_bias_gen_0/VBNF eeg_fd_ota_chopped_full2_0/eeg_fd_ota_core_soft_0/m1_35541_n3864# 5.057930e-17
C446 eeg_fd_ota_chopped_full2_0/eeg_bias_gen_0/VBNF eeg_fd_ota_chopped_full2_0/eeg_fd_ota_core_soft_0/m1_36341_n3864# 5.057930e-17
C447 eeg_fd_ota_chopped_full2_0/eeg_bias_gen_0/VBNF eeg_fd_ota_chopped_full2_0/eeg_fd_ota_core_soft_0/m1_37141_n3864# 5.057930e-17
C448 eeg_fd_ota_chopped_full2_0/eeg_bias_gen_0/VBNF eeg_fd_ota_chopped_full2_0/eeg_fd_ota_core_soft_0/m1_37941_n3864# 5.057928e-17
C449 eeg_fd_ota_chopped_full2_0/eeg_bias_gen_0/VBNF eeg_fd_ota_chopped_full2_0/eeg_fd_ota_core_soft_0/m1_38741_n3864# 5.057930e-17
C450 eeg_fd_ota_chopped_full2_0/eeg_bias_gen_0/VBNF eeg_fd_ota_chopped_full2_0/eeg_fd_ota_core_soft_0/m1_39541_n3864# 5.057930e-17
C451 eeg_fd_ota_chopped_full2_0/eeg_bias_gen_0/VBNF eeg_fd_ota_chopped_full2_0/eeg_fd_ota_core_soft_0/m1_40341_n3864# 5.057920e-17
C452 eeg_fd_ota_chopped_full2_0/eeg_bias_gen_0/VBNF eeg_fd_ota_chopped_full2_0/eeg_fd_ota_core_soft_0/m1_41141_n3864# 5.057930e-17
C453 eeg_fd_ota_chopped_full2_0/eeg_bias_gen_0/VBNF eeg_fd_ota_chopped_full2_0/eeg_fd_ota_core_soft_0/m1_41941_n3864# 5.057930e-17
C454 eeg_fd_ota_chopped_full2_0/eeg_bias_gen_0/VBNF eeg_fd_ota_chopped_full2_0/eeg_fd_ota_core_soft_0/m1_42741_n3864# 5.057930e-17
C455 eeg_fd_ota_chopped_full2_0/eeg_bias_gen_0/VBNF eeg_fd_ota_chopped_full2_0/eeg_fd_ota_core_soft_0/m1_43541_n3864# 5.057928e-17
C456 eeg_fd_ota_chopped_full2_0/eeg_bias_gen_0/VBNF eeg_fd_ota_chopped_full2_0/eeg_fd_ota_core_soft_0/m1_44341_n3864# 5.057930e-17
C457 eeg_fd_ota_chopped_full2_0/eeg_bias_gen_0/VBNF eeg_fd_ota_chopped_full2_0/eeg_fd_ota_core_soft_0/m1_45141_n3864# 5.057930e-17
C458 eeg_fd_ota_chopped_full2_0/eeg_bias_gen_0/VBNF eeg_fd_ota_chopped_full2_0/eeg_fd_ota_core_soft_0/m1_45941_n3864# 5.057920e-17
C459 eeg_fd_ota_chopped_full2_0/eeg_bias_gen_0/VBNF eeg_fd_ota_chopped_full2_0/eeg_fd_ota_core_soft_0/m1_46741_n3864# 5.057930e-17
C460 eeg_fd_ota_chopped_full2_0/eeg_bias_gen_0/VBNF eeg_fd_ota_chopped_full2_0/eeg_fd_ota_core_soft_0/m1_47541_n3864# 5.192520e-17
C461 eeg_fd_ota_chopped_full2_0/eeg_bias_gen_0/VBNF eeg_fd_ota_chopped_full2_0/eeg_fd_ota_core_soft_0/m1_50741_n3864# 5.192510e-17
C462 eeg_fd_ota_chopped_full2_0/eeg_bias_gen_0/VBNF eeg_fd_ota_chopped_full2_0/eeg_fd_ota_core_soft_0/m1_51541_n3864# 5.057920e-17
C463 eeg_fd_ota_chopped_full2_0/eeg_bias_gen_0/VBNF eeg_fd_ota_chopped_full2_0/eeg_fd_ota_core_soft_0/m1_52341_n3864# 5.057930e-17
C464 eeg_fd_ota_chopped_full2_0/eeg_bias_gen_0/VBNF eeg_fd_ota_chopped_full2_0/eeg_fd_ota_core_soft_0/m1_53141_n3864# 5.057930e-17
C465 eeg_fd_ota_chopped_full2_0/eeg_bias_gen_0/VBNF eeg_fd_ota_chopped_full2_0/eeg_fd_ota_core_soft_0/m1_53941_n3864# 5.057930e-17
C466 eeg_fd_ota_chopped_full2_0/eeg_bias_gen_0/VBNF eeg_fd_ota_chopped_full2_0/eeg_fd_ota_core_soft_0/m1_54741_n3864# 5.057928e-17
C467 eeg_fd_ota_chopped_full2_0/eeg_bias_gen_0/VBNF eeg_fd_ota_chopped_full2_0/eeg_fd_ota_core_soft_0/m1_55541_n3864# 5.057930e-17
C468 eeg_fd_ota_chopped_full2_0/eeg_bias_gen_0/VBNF eeg_fd_ota_chopped_full2_0/eeg_fd_ota_core_soft_0/m1_56341_n3864# 5.057930e-17
C469 eeg_fd_ota_chopped_full2_0/eeg_bias_gen_0/VBNF eeg_fd_ota_chopped_full2_0/eeg_fd_ota_core_soft_0/m1_57141_n3864# 5.057920e-17
C470 eeg_fd_ota_chopped_full2_0/eeg_bias_gen_0/VBNF eeg_fd_ota_chopped_full2_0/eeg_fd_ota_core_soft_0/m1_57941_n3864# 5.192510e-17
C472 eeg_fd_ota_chopped_full2_0/eeg_bias_gen_0/VBNF eeg_fd_ota_chopped_full2_0/stage2_0/N2N 1.432650e-16
C473 eeg_fd_ota_chopped_full2_0/eeg_bias_gen_0/VBNF eeg_fd_ota_chopped_full2_0/stage2_0/N2P 5.740518e-16
C474 eeg_fd_ota_chopped_full2_0/eeg_bias_gen_0/VBNF eeg_fd_ota_chopped_full2_0/stage2_0/VBP2 1.125264e-15
C475 eeg_fd_ota_chopped_full2_0/eeg_bias_gen_0/VBNF eeg_fd_ota_chopped_full2_0/stage2_0/VCM2 3.880654e-16
C476 eeg_fd_ota_chopped_full2_0/eeg_cmfb_amp_dl2_0/VBP VSS 8.757940e-15
C477 eeg_fd_ota_chopped_full2_0/eeg_cmfb_amp_dl2_0/VBP eeg_fd_ota_chopped_full2_0/eeg_cmfb_amp_dl2_0/VCM_SENSE 3.069697e-16
C479 eeg_fd_ota_chopped_full2_0/eeg_cmfb_amp_dl2_0/VBP eeg_fd_ota_chopped_full2_0/eeg_fd_ota_core_soft_0/INP 3.185804e-17
C480 eeg_fd_ota_chopped_full2_0/eeg_cmfb_amp_dl2_0/VBP eeg_fd_ota_chopped_full2_0/eeg_fd_ota_core_soft_0/OUTP 1.614594e-16
C481 eeg_fd_ota_chopped_full2_0/eeg_cmfb_amp_dl2_0/VCM_SENSE VSS 1.553050e-14
C482 eeg_fd_ota_chopped_full2_0/eeg_cmfb_amp_dl2_0/VCM_SENSE eeg_fd_ota_chopped_full2_0/eeg_cmfb_amp_dl2_0/m1_370_1493# 9.450030e-17
C483 eeg_fd_ota_chopped_full2_0/eeg_cmfb_amp_dl2_0/VCM_SENSE eeg_fd_ota_chopped_full2_0/eeg_cmfb_amp_dl2_0/m1_68_166# 1.874925e-16
C486 eeg_fd_ota_chopped_full2_0/eeg_cmfb_amp_dl2_0/VCM_SENSE eeg_fd_ota_chopped_full2_0/eeg_fd_ota_core_soft_0/OUTN 1.526407e-16
C487 eeg_fd_ota_chopped_full2_0/eeg_cmfb_amp_dl2_0/VCM_SENSE eeg_fd_ota_chopped_full2_0/eeg_fd_ota_core_soft_0/OUTP 3.196946e-16
C489 eeg_fd_ota_chopped_full2_0/eeg_cmfb_amp_dl2_0/m1_68_166# eeg_fd_ota_chopped_full2_0/eeg_fd_ota_core_soft_0/OUTP 2.370169e-17
C491 eeg_fd_ota_chopped_full2_0/eeg_cmfb_amp_dl2_s2_0/m1_68_166# eeg_fd_ota_chopped_full2_0/stage2_0/VCM2 3.437010e-17
C492 eeg_fd_ota_chopped_full2_0/eeg_fd_ota_core_soft_0/INN VSS 2.020630e-14
C493 eeg_fd_ota_chopped_full2_0/eeg_fd_ota_core_soft_0/INN eeg_fd_ota_chopped_full2_0/eeg_fd_ota_core_soft_0/INP 1.586935e-14
C494 eeg_fd_ota_chopped_full2_0/eeg_fd_ota_core_soft_0/INN eeg_fd_ota_chopped_full2_0/eeg_fd_ota_core_soft_0/OUTN 7.513171e-15
C495 eeg_fd_ota_chopped_full2_0/eeg_fd_ota_core_soft_0/INN eeg_fd_ota_chopped_full2_0/eeg_fd_ota_core_soft_0/OUTP 1.119515e-14
C497 eeg_fd_ota_chopped_full2_0/eeg_fd_ota_core_soft_0/INN eeg_fd_ota_chopped_full2_0/eeg_fd_ota_core_soft_0/m1_n29259_3443# 2.303073e-17
C498 eeg_fd_ota_chopped_full2_0/eeg_fd_ota_core_soft_0/INN eeg_fd_ota_chopped_full2_0/eeg_fd_ota_core_soft_0/m1_n30059_3443# 2.303071e-17
C499 eeg_fd_ota_chopped_full2_0/eeg_fd_ota_core_soft_0/INN eeg_fd_ota_chopped_full2_0/eeg_fd_ota_core_soft_0/m1_n30859_3443# 2.303073e-17
C500 eeg_fd_ota_chopped_full2_0/eeg_fd_ota_core_soft_0/INN eeg_fd_ota_chopped_full2_0/eeg_fd_ota_core_soft_0/m1_n31659_3443# 2.303071e-17
C501 eeg_fd_ota_chopped_full2_0/eeg_fd_ota_core_soft_0/INN eeg_fd_ota_chopped_full2_0/eeg_fd_ota_core_soft_0/m1_n32459_3443# 2.303071e-17
C502 eeg_fd_ota_chopped_full2_0/eeg_fd_ota_core_soft_0/INN eeg_fd_ota_chopped_full2_0/eeg_fd_ota_core_soft_0/m1_n33259_3443# 2.303071e-17
C503 eeg_fd_ota_chopped_full2_0/eeg_fd_ota_core_soft_0/INN eeg_fd_ota_chopped_full2_0/eeg_fd_ota_core_soft_0/m1_n34059_3443# 2.303071e-17
C504 eeg_fd_ota_chopped_full2_0/eeg_fd_ota_core_soft_0/INN eeg_fd_ota_chopped_full2_0/eeg_fd_ota_core_soft_0/m1_n34859_3443# 2.303073e-17
C505 eeg_fd_ota_chopped_full2_0/eeg_fd_ota_core_soft_0/INN eeg_fd_ota_chopped_full2_0/eeg_fd_ota_core_soft_0/m1_n35659_3443# 2.303071e-17
C506 eeg_fd_ota_chopped_full2_0/eeg_fd_ota_core_soft_0/INN eeg_fd_ota_chopped_full2_0/eeg_fd_ota_core_soft_0/m1_n36459_3443# 2.303073e-17
C507 eeg_fd_ota_chopped_full2_0/eeg_fd_ota_core_soft_0/INN eeg_fd_ota_chopped_full2_0/eeg_fd_ota_core_soft_0/m1_n37259_3443# 2.303071e-17
C508 eeg_fd_ota_chopped_full2_0/eeg_fd_ota_core_soft_0/INN eeg_fd_ota_chopped_full2_0/eeg_fd_ota_core_soft_0/m1_n38059_3443# 2.303071e-17
C509 eeg_fd_ota_chopped_full2_0/eeg_fd_ota_core_soft_0/INN eeg_fd_ota_chopped_full2_0/eeg_fd_ota_core_soft_0/m1_n38859_3443# 2.303071e-17
C510 eeg_fd_ota_chopped_full2_0/eeg_fd_ota_core_soft_0/INN eeg_fd_ota_chopped_full2_0/eeg_fd_ota_core_soft_0/m1_n39659_3443# 2.303071e-17
C511 eeg_fd_ota_chopped_full2_0/eeg_fd_ota_core_soft_0/INN eeg_fd_ota_chopped_full2_0/eeg_fd_ota_core_soft_0/m1_n40459_3443# 2.303073e-17
C512 eeg_fd_ota_chopped_full2_0/eeg_fd_ota_core_soft_0/INN eeg_fd_ota_chopped_full2_0/eeg_fd_ota_core_soft_0/m1_n41259_3443# 2.303071e-17
C513 eeg_fd_ota_chopped_full2_0/eeg_fd_ota_core_soft_0/INN eeg_fd_ota_chopped_full2_0/eeg_fd_ota_core_soft_0/m1_n42059_3443# 2.303073e-17
C514 eeg_fd_ota_chopped_full2_0/eeg_fd_ota_core_soft_0/INN eeg_fd_ota_chopped_full2_0/eeg_fd_ota_core_soft_0/m1_n42859_3443# 2.303071e-17
C515 eeg_fd_ota_chopped_full2_0/eeg_fd_ota_core_soft_0/INN eeg_fd_ota_chopped_full2_0/eeg_fd_ota_core_soft_0/m1_n43659_3443# 2.303071e-17
C516 eeg_fd_ota_chopped_full2_0/eeg_fd_ota_core_soft_0/INN eeg_fd_ota_chopped_full2_0/eeg_fd_ota_core_soft_0/m1_n44459_3443# 2.303071e-17
C517 eeg_fd_ota_chopped_full2_0/eeg_fd_ota_core_soft_0/INN eeg_fd_ota_chopped_full2_0/eeg_fd_ota_core_soft_0/m1_n45259_3443# 2.303071e-17
C518 eeg_fd_ota_chopped_full2_0/eeg_fd_ota_core_soft_0/INN eeg_fd_ota_chopped_full2_0/eeg_fd_ota_core_soft_0/m1_n46059_3443# 2.303073e-17
C519 eeg_fd_ota_chopped_full2_0/eeg_fd_ota_core_soft_0/INN eeg_fd_ota_chopped_full2_0/eeg_fd_ota_core_soft_0/m1_n46859_3443# 2.303071e-17
C520 eeg_fd_ota_chopped_full2_0/eeg_fd_ota_core_soft_0/INN eeg_fd_ota_chopped_full2_0/eeg_fd_ota_core_soft_0/m1_n47659_3443# 2.303073e-17
C521 eeg_fd_ota_chopped_full2_0/eeg_fd_ota_core_soft_0/INN eeg_fd_ota_chopped_full2_0/eeg_fd_ota_core_soft_0/m1_n51659_3443# 2.303073e-17
C522 eeg_fd_ota_chopped_full2_0/eeg_fd_ota_core_soft_0/INN eeg_fd_ota_chopped_full2_0/eeg_fd_ota_core_soft_0/m1_n52459_3443# 2.303071e-17
C523 eeg_fd_ota_chopped_full2_0/eeg_fd_ota_core_soft_0/INN eeg_fd_ota_chopped_full2_0/eeg_fd_ota_core_soft_0/m1_n53259_3443# 2.303073e-17
C524 eeg_fd_ota_chopped_full2_0/eeg_fd_ota_core_soft_0/INN eeg_fd_ota_chopped_full2_0/eeg_fd_ota_core_soft_0/m1_n54059_3443# 2.303071e-17
C525 eeg_fd_ota_chopped_full2_0/eeg_fd_ota_core_soft_0/INN eeg_fd_ota_chopped_full2_0/eeg_fd_ota_core_soft_0/m1_n54859_3443# 2.303071e-17
C526 eeg_fd_ota_chopped_full2_0/eeg_fd_ota_core_soft_0/INN eeg_fd_ota_chopped_full2_0/eeg_fd_ota_core_soft_0/m1_n55659_3443# 2.303071e-17
C527 eeg_fd_ota_chopped_full2_0/eeg_fd_ota_core_soft_0/INN eeg_fd_ota_chopped_full2_0/eeg_fd_ota_core_soft_0/m1_n56459_3443# 2.303071e-17
C528 eeg_fd_ota_chopped_full2_0/eeg_fd_ota_core_soft_0/INN eeg_fd_ota_chopped_full2_0/eeg_fd_ota_core_soft_0/m1_n57259_3443# 2.303073e-17
C529 eeg_fd_ota_chopped_full2_0/eeg_fd_ota_core_soft_0/INN eeg_fd_ota_chopped_full2_0/eeg_fd_ota_core_soft_0/m1_n58059_3443# 2.303071e-17
C531 eeg_fd_ota_chopped_full2_0/eeg_fd_ota_core_soft_0/INP VSS 2.075320e-14
C532 eeg_fd_ota_chopped_full2_0/eeg_fd_ota_core_soft_0/INP eeg_fd_ota_chopped_full2_0/eeg_fd_ota_core_soft_0/OUTN 1.573698e-15
C533 eeg_fd_ota_chopped_full2_0/eeg_fd_ota_core_soft_0/INP eeg_fd_ota_chopped_full2_0/eeg_fd_ota_core_soft_0/OUTP 1.386070e-15
C534 eeg_fd_ota_chopped_full2_0/eeg_fd_ota_core_soft_0/INP eeg_fd_ota_chopped_full2_0/eeg_fd_ota_core_soft_0/m1_n22658_111# 6.056700e-16
C570 eeg_fd_ota_chopped_full2_0/eeg_fd_ota_core_soft_0/OUTN VSS 2.208780e-14
C571 eeg_fd_ota_chopped_full2_0/eeg_fd_ota_core_soft_0/OUTN eeg_fd_ota_chopped_full2_0/eeg_fd_ota_core_soft_0/OUTP 8.022897e-15
C572 eeg_fd_ota_chopped_full2_0/eeg_fd_ota_core_soft_0/OUTN eeg_fd_ota_chopped_full2_0/stage2_0/N2N 5.693808e-17
C573 eeg_fd_ota_chopped_full2_0/eeg_fd_ota_core_soft_0/OUTN eeg_fd_ota_chopped_full2_0/stage2_0/N2P 2.063072e-17
C575 eeg_fd_ota_chopped_full2_0/eeg_fd_ota_core_soft_0/OUTP VSS 3.127310e-14
C578 eeg_fd_ota_chopped_full2_0/stage2_0/N2N VSS 2.694470e-15
C579 eeg_fd_ota_chopped_full2_0/stage2_0/N2N eeg_fd_ota_chopped_full2_0/stage2_0/N2P 2.211146e-15
C581 eeg_fd_ota_chopped_full2_0/stage2_0/N2P VSS 2.461200e-15
C582 eeg_fd_ota_chopped_full2_0/stage2_0/N2P eeg_fd_ota_chopped_full2_0/stage2_0/VBP2 9.732430e-17
C583 eeg_fd_ota_chopped_full2_0/stage2_0/VBP2 VSS 3.113330e-14
C584 eeg_fd_ota_chopped_full2_0/stage2_0/VBP2 eeg_fd_ota_chopped_full2_0/stage2_0/VCM2 1.483105e-16
C585 eeg_fd_ota_chopped_full2_0/stage2_0/VCM2 VSS 4.437230e-15
C586 VDD18 VSS 1.072390e-14
C587 VDD18 eeg_fd_ota_chopped_full2_0/eeg_bias_gen_0/VBN 1.083494e-15
C588 VDD18 eeg_fd_ota_chopped_full2_0/eeg_bias_gen_0/VBNF 1.335704e-15
C589 VDD18 eeg_fd_ota_chopped_full2_0/eeg_bias_gen_0/VBP 1.406448e-15
C590 VDD18 eeg_fd_ota_chopped_full2_0/eeg_bias_gen_0/eeg_pseudo_res_0/m1_68_66# 4.622759e-16
C591 VDD18 eeg_fd_ota_chopped_full2_0/eeg_bias_gen_0/m1_2524_466# 2.065494e-15
C592 VSS eeg_fd_ota_chopped_full2_0/eeg_bias_gen_0/VBN 1.960641e-15
C593 VSS eeg_fd_ota_chopped_full2_0/eeg_bias_gen_0/VBNF 5.192045e-12
C594 VSS eeg_fd_ota_chopped_full2_0/eeg_bias_gen_0/VBP 5.474732e-16
C595 VSS eeg_fd_ota_chopped_full2_0/eeg_bias_gen_0/m1_10341_n45240# 2.586160e-17
C597 VSS eeg_fd_ota_chopped_full2_0/eeg_bias_gen_0/m1_11141_n45240# 2.586160e-17
C599 VSS eeg_fd_ota_chopped_full2_0/eeg_bias_gen_0/m1_2524_466# 5.870937e-16
C601 VSS eeg_fd_ota_chopped_full2_0/eeg_bias_gen_0/m1_3941_n45240# 2.586160e-17
C603 VSS eeg_fd_ota_chopped_full2_0/eeg_bias_gen_0/m1_4741_n45240# 2.586160e-17
C605 VSS eeg_fd_ota_chopped_full2_0/eeg_bias_gen_0/m1_5541_n45240# 2.586160e-17
C607 VSS eeg_fd_ota_chopped_full2_0/eeg_bias_gen_0/m1_6341_n45240# 2.586160e-17
C609 VSS eeg_fd_ota_chopped_full2_0/eeg_bias_gen_0/m1_7141_n45240# 2.586160e-17
C611 VSS eeg_fd_ota_chopped_full2_0/eeg_bias_gen_0/m1_7941_n45240# 2.586160e-17
C613 VSS eeg_fd_ota_chopped_full2_0/eeg_bias_gen_0/m1_8741_n45240# 2.586160e-17
C615 VSS eeg_fd_ota_chopped_full2_0/eeg_bias_gen_0/m1_9541_n45240# 2.586160e-17
C617 eeg_fd_ota_chopped_full2_0/eeg_bias_gen_0/VBN VSS 2.467770e-14
C618 eeg_fd_ota_chopped_full2_0/eeg_bias_gen_0/VBN eeg_fd_ota_chopped_full2_0/eeg_bias_gen_0/VBNF 3.771753e-15
C619 eeg_fd_ota_chopped_full2_0/eeg_bias_gen_0/VBN eeg_fd_ota_chopped_full2_0/eeg_bias_gen_0/VBP 4.597047e-15
C620 eeg_fd_ota_chopped_full2_0/eeg_bias_gen_0/VBN eeg_fd_ota_chopped_full2_0/eeg_bias_gen_0/eeg_pseudo_res_0/m1_68_66# 4.676611e-16
C621 eeg_fd_ota_chopped_full2_0/eeg_bias_gen_0/VBN eeg_fd_ota_chopped_full2_0/eeg_bias_gen_0/m1_2524_466# 1.449157e-15
C622 eeg_fd_ota_chopped_full2_0/eeg_bias_gen_0/VBN eeg_fd_ota_chopped_full2_0/eeg_bias_gen_0/m1_3701_n11401# 9.237684e-16
C623 eeg_fd_ota_chopped_full2_0/eeg_bias_gen_0/VBN eeg_fd_ota_chopped_full2_0/eeg_bias_gen_0/m1_3701_n29089# 9.231557e-16
C624 eeg_fd_ota_chopped_full2_0/eeg_bias_gen_0/VBN eeg_fd_ota_chopped_full2_0/eeg_bias_gen_0/m1_3941_n27552# 3.117144e-16
C625 eeg_fd_ota_chopped_full2_0/eeg_bias_gen_0/VBN eeg_fd_ota_chopped_full2_0/eeg_bias_gen_0/m1_3941_n9864# 3.117144e-16
C626 eeg_fd_ota_chopped_full2_0/eeg_bias_gen_0/VBN eeg_fd_ota_chopped_full2_0/eeg_bias_gen_0/m1_4059_n18708# 3.117150e-16
C627 eeg_fd_ota_chopped_full2_0/eeg_bias_gen_0/VBN eeg_fd_ota_chopped_full2_0/eeg_bias_gen_0/m1_4059_n36396# 3.171103e-16
C630 eeg_fd_ota_chopped_full2_0/eeg_bias_gen_0/VBN eeg_fd_ota_chopped_full2_0/eeg_bias_gen_0/m1_4341_n37933# 7.669240e-17
C646 eeg_fd_ota_chopped_full2_0/eeg_bias_gen_0/VBNF VSS 7.281980e-14
C647 eeg_fd_ota_chopped_full2_0/eeg_bias_gen_0/VBNF eeg_fd_ota_chopped_full2_0/eeg_bias_gen_0/VBP 2.246044e-15
C648 eeg_fd_ota_chopped_full2_0/eeg_bias_gen_0/VBNF eeg_fd_ota_chopped_full2_0/eeg_bias_gen_0/m1_10059_n11401# 3.343550e-17
C649 eeg_fd_ota_chopped_full2_0/eeg_bias_gen_0/VBNF eeg_fd_ota_chopped_full2_0/eeg_bias_gen_0/m1_10059_n29089# 3.343556e-17
C650 eeg_fd_ota_chopped_full2_0/eeg_bias_gen_0/VBNF eeg_fd_ota_chopped_full2_0/eeg_bias_gen_0/m1_10341_n27552# 1.024404e-16
C651 eeg_fd_ota_chopped_full2_0/eeg_bias_gen_0/VBNF eeg_fd_ota_chopped_full2_0/eeg_bias_gen_0/m1_10341_n45240# 1.116124e-16
C652 eeg_fd_ota_chopped_full2_0/eeg_bias_gen_0/VBNF eeg_fd_ota_chopped_full2_0/eeg_bias_gen_0/m1_10341_n9864# 1.024404e-16
C653 eeg_fd_ota_chopped_full2_0/eeg_bias_gen_0/VBNF eeg_fd_ota_chopped_full2_0/eeg_bias_gen_0/m1_10459_n18708# 1.024404e-16
C654 eeg_fd_ota_chopped_full2_0/eeg_bias_gen_0/VBNF eeg_fd_ota_chopped_full2_0/eeg_bias_gen_0/m1_10459_n36396# 1.024404e-16
C655 eeg_fd_ota_chopped_full2_0/eeg_bias_gen_0/VBNF eeg_fd_ota_chopped_full2_0/eeg_bias_gen_0/m1_10741_n20245# 1.793252e-16
C656 eeg_fd_ota_chopped_full2_0/eeg_bias_gen_0/VBNF eeg_fd_ota_chopped_full2_0/eeg_bias_gen_0/m1_10741_n2557# 2.584588e-16
C657 eeg_fd_ota_chopped_full2_0/eeg_bias_gen_0/VBNF eeg_fd_ota_chopped_full2_0/eeg_bias_gen_0/m1_10741_n37933# 1.793251e-16
C658 eeg_fd_ota_chopped_full2_0/eeg_bias_gen_0/VBNF eeg_fd_ota_chopped_full2_0/eeg_bias_gen_0/m1_10859_n11401# 1.793252e-16
C659 eeg_fd_ota_chopped_full2_0/eeg_bias_gen_0/VBNF eeg_fd_ota_chopped_full2_0/eeg_bias_gen_0/m1_10859_n29089# 1.793253e-16
C660 eeg_fd_ota_chopped_full2_0/eeg_bias_gen_0/VBNF eeg_fd_ota_chopped_full2_0/eeg_bias_gen_0/m1_11141_n27552# 1.024404e-16
C661 eeg_fd_ota_chopped_full2_0/eeg_bias_gen_0/VBNF eeg_fd_ota_chopped_full2_0/eeg_bias_gen_0/m1_11141_n45240# 1.116125e-16
C662 eeg_fd_ota_chopped_full2_0/eeg_bias_gen_0/VBNF eeg_fd_ota_chopped_full2_0/eeg_bias_gen_0/m1_11141_n9864# 1.024404e-16
C663 eeg_fd_ota_chopped_full2_0/eeg_bias_gen_0/VBNF eeg_fd_ota_chopped_full2_0/eeg_bias_gen_0/m1_11259_n18708# 1.024404e-16
C664 eeg_fd_ota_chopped_full2_0/eeg_bias_gen_0/VBNF eeg_fd_ota_chopped_full2_0/eeg_bias_gen_0/m1_11259_n36396# 1.024404e-16
C665 eeg_fd_ota_chopped_full2_0/eeg_bias_gen_0/VBNF eeg_fd_ota_chopped_full2_0/eeg_bias_gen_0/m1_11541_n20245# 2.847116e-16
C666 eeg_fd_ota_chopped_full2_0/eeg_bias_gen_0/VBNF eeg_fd_ota_chopped_full2_0/eeg_bias_gen_0/m1_11541_n37933# 2.847116e-16
C667 eeg_fd_ota_chopped_full2_0/eeg_bias_gen_0/VBNF eeg_fd_ota_chopped_full2_0/eeg_bias_gen_0/m1_2524_466# 5.686547e-16
C675 eeg_fd_ota_chopped_full2_0/eeg_bias_gen_0/VBNF eeg_fd_ota_chopped_full2_0/eeg_bias_gen_0/m1_8741_n45240# 2.017146e-17
C685 eeg_fd_ota_chopped_full2_0/eeg_bias_gen_0/VBNF eeg_fd_ota_chopped_full2_0/eeg_bias_gen_0/m1_9541_n45240# 3.497385e-17
C689 eeg_fd_ota_chopped_full2_0/eeg_bias_gen_0/VBNF eeg_fd_ota_chopped_full2_0/eeg_bias_gen_0/m1_9941_n20245# 3.343550e-17
C690 eeg_fd_ota_chopped_full2_0/eeg_bias_gen_0/VBNF eeg_fd_ota_chopped_full2_0/eeg_bias_gen_0/m1_9941_n2557# 3.464034e-17
C691 eeg_fd_ota_chopped_full2_0/eeg_bias_gen_0/VBNF eeg_fd_ota_chopped_full2_0/eeg_bias_gen_0/m1_9941_n37933# 3.343550e-17
C692 eeg_fd_ota_chopped_full2_0/eeg_bias_gen_0/VBP VSS 5.243180e-15
C693 eeg_fd_ota_chopped_full2_0/eeg_bias_gen_0/VBP eeg_fd_ota_chopped_full2_0/eeg_bias_gen_0/m1_2524_466# 4.554927e-15
C694 eeg_fd_ota_chopped_full2_0/eeg_bias_gen_0/m1_10059_n11401# VSS 2.918310e-16
C696 eeg_fd_ota_chopped_full2_0/eeg_bias_gen_0/m1_10059_n11401# eeg_fd_ota_chopped_full2_0/eeg_bias_gen_0/m1_10859_n11401# 6.789047e-17
C698 eeg_fd_ota_chopped_full2_0/eeg_bias_gen_0/m1_10059_n11401# eeg_fd_ota_chopped_full2_0/eeg_bias_gen_0/m1_9259_n11401# 6.789047e-17
C700 eeg_fd_ota_chopped_full2_0/eeg_bias_gen_0/m1_10059_n29089# VSS 2.918310e-16
C702 eeg_fd_ota_chopped_full2_0/eeg_bias_gen_0/m1_10059_n29089# eeg_fd_ota_chopped_full2_0/eeg_bias_gen_0/m1_10859_n29089# 6.789043e-17
C704 eeg_fd_ota_chopped_full2_0/eeg_bias_gen_0/m1_10059_n29089# eeg_fd_ota_chopped_full2_0/eeg_bias_gen_0/m1_9259_n29089# 6.789040e-17
C706 eeg_fd_ota_chopped_full2_0/eeg_bias_gen_0/m1_10341_n27552# VSS 4.190540e-16
C708 eeg_fd_ota_chopped_full2_0/eeg_bias_gen_0/m1_10341_n27552# eeg_fd_ota_chopped_full2_0/eeg_bias_gen_0/m1_11141_n27552# 6.789050e-17
C709 eeg_fd_ota_chopped_full2_0/eeg_bias_gen_0/m1_10341_n27552# eeg_fd_ota_chopped_full2_0/eeg_bias_gen_0/m1_9541_n27552# 6.789050e-17
C710 eeg_fd_ota_chopped_full2_0/eeg_bias_gen_0/m1_10341_n45240# VSS 4.190540e-16
C711 eeg_fd_ota_chopped_full2_0/eeg_bias_gen_0/m1_10341_n45240# eeg_fd_ota_chopped_full2_0/eeg_bias_gen_0/m1_11141_n45240# 6.789050e-17
C712 eeg_fd_ota_chopped_full2_0/eeg_bias_gen_0/m1_10341_n45240# eeg_fd_ota_chopped_full2_0/eeg_bias_gen_0/m1_9541_n45240# 6.789050e-17
C713 eeg_fd_ota_chopped_full2_0/eeg_bias_gen_0/m1_10341_n9864# VSS 4.190540e-16
C715 eeg_fd_ota_chopped_full2_0/eeg_bias_gen_0/m1_10341_n9864# eeg_fd_ota_chopped_full2_0/eeg_bias_gen_0/m1_11141_n9864# 6.789050e-17
C716 eeg_fd_ota_chopped_full2_0/eeg_bias_gen_0/m1_10341_n9864# eeg_fd_ota_chopped_full2_0/eeg_bias_gen_0/m1_9541_n9864# 6.789050e-17
C717 eeg_fd_ota_chopped_full2_0/eeg_bias_gen_0/m1_10459_n18708# VSS 2.918310e-16
C719 eeg_fd_ota_chopped_full2_0/eeg_bias_gen_0/m1_10459_n18708# eeg_fd_ota_chopped_full2_0/eeg_bias_gen_0/m1_11259_n18708# 6.789040e-17
C721 eeg_fd_ota_chopped_full2_0/eeg_bias_gen_0/m1_10459_n18708# eeg_fd_ota_chopped_full2_0/eeg_bias_gen_0/m1_9659_n18708# 6.789043e-17
C723 eeg_fd_ota_chopped_full2_0/eeg_bias_gen_0/m1_10459_n36396# VSS 2.918310e-16
C725 eeg_fd_ota_chopped_full2_0/eeg_bias_gen_0/m1_10459_n36396# eeg_fd_ota_chopped_full2_0/eeg_bias_gen_0/m1_11259_n36396# 6.789050e-17
C727 eeg_fd_ota_chopped_full2_0/eeg_bias_gen_0/m1_10459_n36396# eeg_fd_ota_chopped_full2_0/eeg_bias_gen_0/m1_9659_n36396# 6.789043e-17
C729 eeg_fd_ota_chopped_full2_0/eeg_bias_gen_0/m1_10741_n20245# VSS 4.190540e-16
C731 eeg_fd_ota_chopped_full2_0/eeg_bias_gen_0/m1_10741_n20245# eeg_fd_ota_chopped_full2_0/eeg_bias_gen_0/m1_11541_n20245# 6.794053e-17
C732 eeg_fd_ota_chopped_full2_0/eeg_bias_gen_0/m1_10741_n20245# eeg_fd_ota_chopped_full2_0/eeg_bias_gen_0/m1_9941_n20245# 6.789050e-17
C733 eeg_fd_ota_chopped_full2_0/eeg_bias_gen_0/m1_10741_n2557# VSS 4.623640e-16
C734 eeg_fd_ota_chopped_full2_0/eeg_bias_gen_0/m1_10741_n2557# eeg_fd_ota_chopped_full2_0/eeg_bias_gen_0/m1_9941_n2557# 6.789050e-17
C735 eeg_fd_ota_chopped_full2_0/eeg_bias_gen_0/m1_10741_n37933# VSS 4.190540e-16
C737 eeg_fd_ota_chopped_full2_0/eeg_bias_gen_0/m1_10741_n37933# eeg_fd_ota_chopped_full2_0/eeg_bias_gen_0/m1_11541_n37933# 6.794053e-17
C738 eeg_fd_ota_chopped_full2_0/eeg_bias_gen_0/m1_10741_n37933# eeg_fd_ota_chopped_full2_0/eeg_bias_gen_0/m1_9941_n37933# 6.789050e-17
C739 eeg_fd_ota_chopped_full2_0/eeg_bias_gen_0/m1_10859_n11401# VSS 2.849110e-16
C741 eeg_fd_ota_chopped_full2_0/eeg_bias_gen_0/m1_10859_n11401# eeg_fd_ota_chopped_full2_0/eeg_bias_gen_0/m1_11541_n20245# 6.796552e-17
C742 eeg_fd_ota_chopped_full2_0/eeg_bias_gen_0/m1_10859_n29089# VSS 2.849110e-16
C744 eeg_fd_ota_chopped_full2_0/eeg_bias_gen_0/m1_10859_n29089# eeg_fd_ota_chopped_full2_0/eeg_bias_gen_0/m1_11541_n37933# 6.796554e-17
C745 eeg_fd_ota_chopped_full2_0/eeg_bias_gen_0/m1_11141_n27552# VSS 4.651810e-16
C747 eeg_fd_ota_chopped_full2_0/eeg_bias_gen_0/m1_11141_n45240# VSS 4.702790e-16
C748 eeg_fd_ota_chopped_full2_0/eeg_bias_gen_0/m1_11141_n9864# VSS 4.651810e-16
C750 eeg_fd_ota_chopped_full2_0/eeg_bias_gen_0/m1_11259_n18708# VSS 2.743410e-16
C751 eeg_fd_ota_chopped_full2_0/eeg_bias_gen_0/m1_11259_n18708# eeg_fd_ota_chopped_full2_0/eeg_bias_gen_0/m1_11541_n20245# 6.171110e-17
C752 eeg_fd_ota_chopped_full2_0/eeg_bias_gen_0/m1_11259_n36396# VSS 2.743410e-16
C753 eeg_fd_ota_chopped_full2_0/eeg_bias_gen_0/m1_11259_n36396# eeg_fd_ota_chopped_full2_0/eeg_bias_gen_0/m1_11541_n37933# 6.171107e-17
C754 eeg_fd_ota_chopped_full2_0/eeg_bias_gen_0/m1_11541_n20245# VSS 4.394320e-15
C756 eeg_fd_ota_chopped_full2_0/eeg_bias_gen_0/m1_11541_n37933# VSS 4.394320e-15
C758 eeg_fd_ota_chopped_full2_0/eeg_bias_gen_0/m1_2524_466# VSS 6.618010e-15
C759 eeg_fd_ota_chopped_full2_0/eeg_bias_gen_0/m1_3701_n11401# VSS 4.381540e-15
C760 eeg_fd_ota_chopped_full2_0/eeg_bias_gen_0/m1_3701_n11401# eeg_fd_ota_chopped_full2_0/eeg_bias_gen_0/m1_3941_n9864# 6.171105e-17
C761 eeg_fd_ota_chopped_full2_0/eeg_bias_gen_0/m1_3701_n11401# eeg_fd_ota_chopped_full2_0/eeg_bias_gen_0/m1_4341_n2557# 6.796550e-17
C762 eeg_fd_ota_chopped_full2_0/eeg_bias_gen_0/m1_3701_n11401# eeg_fd_ota_chopped_full2_0/eeg_bias_gen_0/m1_4459_n11401# 6.794051e-17
C766 eeg_fd_ota_chopped_full2_0/eeg_bias_gen_0/m1_3701_n29089# VSS 4.381540e-15
C767 eeg_fd_ota_chopped_full2_0/eeg_bias_gen_0/m1_3701_n29089# eeg_fd_ota_chopped_full2_0/eeg_bias_gen_0/m1_3941_n27552# 6.171109e-17
C769 eeg_fd_ota_chopped_full2_0/eeg_bias_gen_0/m1_3701_n29089# eeg_fd_ota_chopped_full2_0/eeg_bias_gen_0/m1_4341_n20245# 6.796550e-17
C770 eeg_fd_ota_chopped_full2_0/eeg_bias_gen_0/m1_3701_n29089# eeg_fd_ota_chopped_full2_0/eeg_bias_gen_0/m1_4459_n29089# 6.794050e-17
C774 eeg_fd_ota_chopped_full2_0/eeg_bias_gen_0/m1_3941_n27552# VSS 3.999630e-16
C776 eeg_fd_ota_chopped_full2_0/eeg_bias_gen_0/m1_3941_n27552# eeg_fd_ota_chopped_full2_0/eeg_bias_gen_0/m1_4741_n27552# 6.789050e-17
C777 eeg_fd_ota_chopped_full2_0/eeg_bias_gen_0/m1_3941_n45240# VSS 4.702790e-16
C778 eeg_fd_ota_chopped_full2_0/eeg_bias_gen_0/m1_3941_n45240# eeg_fd_ota_chopped_full2_0/eeg_bias_gen_0/m1_4741_n45240# 6.789050e-17
C779 eeg_fd_ota_chopped_full2_0/eeg_bias_gen_0/m1_3941_n9864# VSS 3.999630e-16
C781 eeg_fd_ota_chopped_full2_0/eeg_bias_gen_0/m1_3941_n9864# eeg_fd_ota_chopped_full2_0/eeg_bias_gen_0/m1_4741_n9864# 6.789050e-17
C782 eeg_fd_ota_chopped_full2_0/eeg_bias_gen_0/m1_4059_n18708# VSS 3.267770e-16
C784 eeg_fd_ota_chopped_full2_0/eeg_bias_gen_0/m1_4059_n18708# eeg_fd_ota_chopped_full2_0/eeg_bias_gen_0/m1_4859_n18708# 6.789043e-17
C785 eeg_fd_ota_chopped_full2_0/eeg_bias_gen_0/m1_4059_n36396# VSS 3.267770e-16
C787 eeg_fd_ota_chopped_full2_0/eeg_bias_gen_0/m1_4059_n36396# eeg_fd_ota_chopped_full2_0/eeg_bias_gen_0/m1_4859_n36396# 6.789043e-17
C788 eeg_fd_ota_chopped_full2_0/eeg_bias_gen_0/m1_4341_n20245# VSS 4.190540e-16
C790 eeg_fd_ota_chopped_full2_0/eeg_bias_gen_0/m1_4341_n20245# eeg_fd_ota_chopped_full2_0/eeg_bias_gen_0/m1_5141_n20245# 6.789050e-17
C791 eeg_fd_ota_chopped_full2_0/eeg_bias_gen_0/m1_4341_n2557# VSS 4.190540e-16
C792 eeg_fd_ota_chopped_full2_0/eeg_bias_gen_0/m1_4341_n2557# eeg_fd_ota_chopped_full2_0/eeg_bias_gen_0/m1_5141_n2557# 6.789050e-17
C793 eeg_fd_ota_chopped_full2_0/eeg_bias_gen_0/m1_4341_n37933# VSS 4.624800e-16
C795 eeg_fd_ota_chopped_full2_0/eeg_bias_gen_0/m1_4341_n37933# eeg_fd_ota_chopped_full2_0/eeg_bias_gen_0/m1_5141_n37933# 6.789050e-17
C796 eeg_fd_ota_chopped_full2_0/eeg_bias_gen_0/m1_4459_n11401# VSS 2.849110e-16
C798 eeg_fd_ota_chopped_full2_0/eeg_bias_gen_0/m1_4459_n11401# eeg_fd_ota_chopped_full2_0/eeg_bias_gen_0/m1_5259_n11401# 6.789047e-17
C799 eeg_fd_ota_chopped_full2_0/eeg_bias_gen_0/m1_4459_n29089# VSS 2.849110e-16
C801 eeg_fd_ota_chopped_full2_0/eeg_bias_gen_0/m1_4459_n29089# eeg_fd_ota_chopped_full2_0/eeg_bias_gen_0/m1_5259_n29089# 6.789043e-17
C802 eeg_fd_ota_chopped_full2_0/eeg_bias_gen_0/m1_4741_n27552# VSS 4.190540e-16
C804 eeg_fd_ota_chopped_full2_0/eeg_bias_gen_0/m1_4741_n27552# eeg_fd_ota_chopped_full2_0/eeg_bias_gen_0/m1_5541_n27552# 6.789050e-17
C805 eeg_fd_ota_chopped_full2_0/eeg_bias_gen_0/m1_4741_n45240# VSS 4.190540e-16
C806 eeg_fd_ota_chopped_full2_0/eeg_bias_gen_0/m1_4741_n45240# eeg_fd_ota_chopped_full2_0/eeg_bias_gen_0/m1_5541_n45240# 6.789050e-17
C807 eeg_fd_ota_chopped_full2_0/eeg_bias_gen_0/m1_4741_n9864# VSS 4.190540e-16
C809 eeg_fd_ota_chopped_full2_0/eeg_bias_gen_0/m1_4741_n9864# eeg_fd_ota_chopped_full2_0/eeg_bias_gen_0/m1_5541_n9864# 6.789050e-17
C810 eeg_fd_ota_chopped_full2_0/eeg_bias_gen_0/m1_4859_n18708# VSS 2.918310e-16
C812 eeg_fd_ota_chopped_full2_0/eeg_bias_gen_0/m1_4859_n18708# eeg_fd_ota_chopped_full2_0/eeg_bias_gen_0/m1_5659_n18708# 6.789040e-17
C813 eeg_fd_ota_chopped_full2_0/eeg_bias_gen_0/m1_4859_n36396# VSS 2.918310e-16
C815 eeg_fd_ota_chopped_full2_0/eeg_bias_gen_0/m1_4859_n36396# eeg_fd_ota_chopped_full2_0/eeg_bias_gen_0/m1_5659_n36396# 6.789050e-17
C816 eeg_fd_ota_chopped_full2_0/eeg_bias_gen_0/m1_5141_n20245# VSS 4.190540e-16
C818 eeg_fd_ota_chopped_full2_0/eeg_bias_gen_0/m1_5141_n20245# eeg_fd_ota_chopped_full2_0/eeg_bias_gen_0/m1_5941_n20245# 6.789050e-17
C819 eeg_fd_ota_chopped_full2_0/eeg_bias_gen_0/m1_5141_n2557# VSS 4.190540e-16
C820 eeg_fd_ota_chopped_full2_0/eeg_bias_gen_0/m1_5141_n2557# eeg_fd_ota_chopped_full2_0/eeg_bias_gen_0/m1_5941_n2557# 6.789050e-17
C821 eeg_fd_ota_chopped_full2_0/eeg_bias_gen_0/m1_5141_n37933# VSS 4.190540e-16
C823 eeg_fd_ota_chopped_full2_0/eeg_bias_gen_0/m1_5141_n37933# eeg_fd_ota_chopped_full2_0/eeg_bias_gen_0/m1_5941_n37933# 6.789050e-17
C824 eeg_fd_ota_chopped_full2_0/eeg_bias_gen_0/m1_5259_n11401# VSS 2.918310e-16
C826 eeg_fd_ota_chopped_full2_0/eeg_bias_gen_0/m1_5259_n11401# eeg_fd_ota_chopped_full2_0/eeg_bias_gen_0/m1_6059_n11401# 6.789047e-17
C827 eeg_fd_ota_chopped_full2_0/eeg_bias_gen_0/m1_5259_n29089# VSS 2.918310e-16
C829 eeg_fd_ota_chopped_full2_0/eeg_bias_gen_0/m1_5259_n29089# eeg_fd_ota_chopped_full2_0/eeg_bias_gen_0/m1_6059_n29089# 6.789040e-17
C830 eeg_fd_ota_chopped_full2_0/eeg_bias_gen_0/m1_5541_n27552# VSS 4.190540e-16
C832 eeg_fd_ota_chopped_full2_0/eeg_bias_gen_0/m1_5541_n27552# eeg_fd_ota_chopped_full2_0/eeg_bias_gen_0/m1_6341_n27552# 6.789040e-17
C833 eeg_fd_ota_chopped_full2_0/eeg_bias_gen_0/m1_5541_n45240# VSS 4.190540e-16
C834 eeg_fd_ota_chopped_full2_0/eeg_bias_gen_0/m1_5541_n45240# eeg_fd_ota_chopped_full2_0/eeg_bias_gen_0/m1_6341_n45240# 6.789040e-17
C835 eeg_fd_ota_chopped_full2_0/eeg_bias_gen_0/m1_5541_n9864# VSS 4.190540e-16
C837 eeg_fd_ota_chopped_full2_0/eeg_bias_gen_0/m1_5541_n9864# eeg_fd_ota_chopped_full2_0/eeg_bias_gen_0/m1_6341_n9864# 6.789040e-17
C838 eeg_fd_ota_chopped_full2_0/eeg_bias_gen_0/m1_5659_n18708# VSS 2.918310e-16
C840 eeg_fd_ota_chopped_full2_0/eeg_bias_gen_0/m1_5659_n18708# eeg_fd_ota_chopped_full2_0/eeg_bias_gen_0/m1_6459_n18708# 6.789050e-17
C841 eeg_fd_ota_chopped_full2_0/eeg_bias_gen_0/m1_5659_n36396# VSS 2.918310e-16
C843 eeg_fd_ota_chopped_full2_0/eeg_bias_gen_0/m1_5659_n36396# eeg_fd_ota_chopped_full2_0/eeg_bias_gen_0/m1_6459_n36396# 6.789046e-17
C844 eeg_fd_ota_chopped_full2_0/eeg_bias_gen_0/m1_5941_n20245# VSS 4.190540e-16
C846 eeg_fd_ota_chopped_full2_0/eeg_bias_gen_0/m1_5941_n20245# eeg_fd_ota_chopped_full2_0/eeg_bias_gen_0/m1_6741_n20245# 6.789050e-17
C847 eeg_fd_ota_chopped_full2_0/eeg_bias_gen_0/m1_5941_n2557# VSS 4.190540e-16
C848 eeg_fd_ota_chopped_full2_0/eeg_bias_gen_0/m1_5941_n2557# eeg_fd_ota_chopped_full2_0/eeg_bias_gen_0/m1_6741_n2557# 6.789050e-17
C849 eeg_fd_ota_chopped_full2_0/eeg_bias_gen_0/m1_5941_n37933# VSS 4.190540e-16
C851 eeg_fd_ota_chopped_full2_0/eeg_bias_gen_0/m1_5941_n37933# eeg_fd_ota_chopped_full2_0/eeg_bias_gen_0/m1_6741_n37933# 6.789050e-17
C852 eeg_fd_ota_chopped_full2_0/eeg_bias_gen_0/m1_6059_n11401# VSS 2.918310e-16
C854 eeg_fd_ota_chopped_full2_0/eeg_bias_gen_0/m1_6059_n11401# eeg_fd_ota_chopped_full2_0/eeg_bias_gen_0/m1_6859_n11401# 6.789047e-17
C855 eeg_fd_ota_chopped_full2_0/eeg_bias_gen_0/m1_6059_n29089# VSS 2.918310e-16
C857 eeg_fd_ota_chopped_full2_0/eeg_bias_gen_0/m1_6059_n29089# eeg_fd_ota_chopped_full2_0/eeg_bias_gen_0/m1_6859_n29089# 6.789040e-17
C858 eeg_fd_ota_chopped_full2_0/eeg_bias_gen_0/m1_6341_n27552# VSS 4.190540e-16
C860 eeg_fd_ota_chopped_full2_0/eeg_bias_gen_0/m1_6341_n27552# eeg_fd_ota_chopped_full2_0/eeg_bias_gen_0/m1_7141_n27552# 6.789050e-17
C861 eeg_fd_ota_chopped_full2_0/eeg_bias_gen_0/m1_6341_n45240# VSS 4.190540e-16
C862 eeg_fd_ota_chopped_full2_0/eeg_bias_gen_0/m1_6341_n45240# eeg_fd_ota_chopped_full2_0/eeg_bias_gen_0/m1_7141_n45240# 6.789050e-17
C863 eeg_fd_ota_chopped_full2_0/eeg_bias_gen_0/m1_6341_n9864# VSS 4.190540e-16
C865 eeg_fd_ota_chopped_full2_0/eeg_bias_gen_0/m1_6341_n9864# eeg_fd_ota_chopped_full2_0/eeg_bias_gen_0/m1_7141_n9864# 6.789050e-17
C866 eeg_fd_ota_chopped_full2_0/eeg_bias_gen_0/m1_6459_n18708# VSS 2.918310e-16
C868 eeg_fd_ota_chopped_full2_0/eeg_bias_gen_0/m1_6459_n18708# eeg_fd_ota_chopped_full2_0/eeg_bias_gen_0/m1_7259_n18708# 6.789040e-17
C869 eeg_fd_ota_chopped_full2_0/eeg_bias_gen_0/m1_6459_n36396# VSS 2.918310e-16
C871 eeg_fd_ota_chopped_full2_0/eeg_bias_gen_0/m1_6459_n36396# eeg_fd_ota_chopped_full2_0/eeg_bias_gen_0/m1_7259_n36396# 6.789050e-17
C872 eeg_fd_ota_chopped_full2_0/eeg_bias_gen_0/m1_6741_n20245# VSS 4.190540e-16
C874 eeg_fd_ota_chopped_full2_0/eeg_bias_gen_0/m1_6741_n20245# eeg_fd_ota_chopped_full2_0/eeg_bias_gen_0/m1_7541_n20245# 6.789050e-17
C875 eeg_fd_ota_chopped_full2_0/eeg_bias_gen_0/m1_6741_n2557# VSS 4.190540e-16
C876 eeg_fd_ota_chopped_full2_0/eeg_bias_gen_0/m1_6741_n2557# eeg_fd_ota_chopped_full2_0/eeg_bias_gen_0/m1_7541_n2557# 6.789050e-17
C877 eeg_fd_ota_chopped_full2_0/eeg_bias_gen_0/m1_6741_n37933# VSS 4.190540e-16
C879 eeg_fd_ota_chopped_full2_0/eeg_bias_gen_0/m1_6741_n37933# eeg_fd_ota_chopped_full2_0/eeg_bias_gen_0/m1_7541_n37933# 6.789050e-17
C880 eeg_fd_ota_chopped_full2_0/eeg_bias_gen_0/m1_6859_n11401# VSS 2.918310e-16
C882 eeg_fd_ota_chopped_full2_0/eeg_bias_gen_0/m1_6859_n11401# eeg_fd_ota_chopped_full2_0/eeg_bias_gen_0/m1_7659_n11401# 6.789047e-17
C883 eeg_fd_ota_chopped_full2_0/eeg_bias_gen_0/m1_6859_n29089# VSS 2.918310e-16
C885 eeg_fd_ota_chopped_full2_0/eeg_bias_gen_0/m1_6859_n29089# eeg_fd_ota_chopped_full2_0/eeg_bias_gen_0/m1_7659_n29089# 6.789043e-17
C886 eeg_fd_ota_chopped_full2_0/eeg_bias_gen_0/m1_7141_n27552# VSS 4.190540e-16
C888 eeg_fd_ota_chopped_full2_0/eeg_bias_gen_0/m1_7141_n27552# eeg_fd_ota_chopped_full2_0/eeg_bias_gen_0/m1_7941_n27552# 6.789050e-17
C889 eeg_fd_ota_chopped_full2_0/eeg_bias_gen_0/m1_7141_n45240# VSS 4.190540e-16
C890 eeg_fd_ota_chopped_full2_0/eeg_bias_gen_0/m1_7141_n45240# eeg_fd_ota_chopped_full2_0/eeg_bias_gen_0/m1_7941_n45240# 6.789050e-17
C891 eeg_fd_ota_chopped_full2_0/eeg_bias_gen_0/m1_7141_n9864# VSS 4.190540e-16
C893 eeg_fd_ota_chopped_full2_0/eeg_bias_gen_0/m1_7141_n9864# eeg_fd_ota_chopped_full2_0/eeg_bias_gen_0/m1_7941_n9864# 6.789050e-17
C894 eeg_fd_ota_chopped_full2_0/eeg_bias_gen_0/m1_7259_n18708# VSS 2.918310e-16
C896 eeg_fd_ota_chopped_full2_0/eeg_bias_gen_0/m1_7259_n18708# eeg_fd_ota_chopped_full2_0/eeg_bias_gen_0/m1_8059_n18708# 6.789043e-17
C897 eeg_fd_ota_chopped_full2_0/eeg_bias_gen_0/m1_7259_n36396# VSS 2.918310e-16
C899 eeg_fd_ota_chopped_full2_0/eeg_bias_gen_0/m1_7259_n36396# eeg_fd_ota_chopped_full2_0/eeg_bias_gen_0/m1_8059_n36396# 6.789043e-17
C900 eeg_fd_ota_chopped_full2_0/eeg_bias_gen_0/m1_7541_n20245# VSS 4.190540e-16
C902 eeg_fd_ota_chopped_full2_0/eeg_bias_gen_0/m1_7541_n20245# eeg_fd_ota_chopped_full2_0/eeg_bias_gen_0/m1_8341_n20245# 6.789050e-17
C903 eeg_fd_ota_chopped_full2_0/eeg_bias_gen_0/m1_7541_n2557# VSS 4.190540e-16
C904 eeg_fd_ota_chopped_full2_0/eeg_bias_gen_0/m1_7541_n2557# eeg_fd_ota_chopped_full2_0/eeg_bias_gen_0/m1_8341_n2557# 6.789050e-17
C905 eeg_fd_ota_chopped_full2_0/eeg_bias_gen_0/m1_7541_n37933# VSS 4.190540e-16
C907 eeg_fd_ota_chopped_full2_0/eeg_bias_gen_0/m1_7541_n37933# eeg_fd_ota_chopped_full2_0/eeg_bias_gen_0/m1_8341_n37933# 6.789050e-17
C908 eeg_fd_ota_chopped_full2_0/eeg_bias_gen_0/m1_7659_n11401# VSS 2.918310e-16
C910 eeg_fd_ota_chopped_full2_0/eeg_bias_gen_0/m1_7659_n11401# eeg_fd_ota_chopped_full2_0/eeg_bias_gen_0/m1_8459_n11401# 6.789047e-17
C911 eeg_fd_ota_chopped_full2_0/eeg_bias_gen_0/m1_7659_n29089# VSS 2.918310e-16
C913 eeg_fd_ota_chopped_full2_0/eeg_bias_gen_0/m1_7659_n29089# eeg_fd_ota_chopped_full2_0/eeg_bias_gen_0/m1_8459_n29089# 6.789040e-17
C914 eeg_fd_ota_chopped_full2_0/eeg_bias_gen_0/m1_7941_n27552# VSS 4.190540e-16
C916 eeg_fd_ota_chopped_full2_0/eeg_bias_gen_0/m1_7941_n27552# eeg_fd_ota_chopped_full2_0/eeg_bias_gen_0/m1_8741_n27552# 6.789050e-17
C917 eeg_fd_ota_chopped_full2_0/eeg_bias_gen_0/m1_7941_n45240# VSS 4.190540e-16
C918 eeg_fd_ota_chopped_full2_0/eeg_bias_gen_0/m1_7941_n45240# eeg_fd_ota_chopped_full2_0/eeg_bias_gen_0/m1_8741_n45240# 6.789050e-17
C919 eeg_fd_ota_chopped_full2_0/eeg_bias_gen_0/m1_7941_n9864# VSS 4.190540e-16
C921 eeg_fd_ota_chopped_full2_0/eeg_bias_gen_0/m1_7941_n9864# eeg_fd_ota_chopped_full2_0/eeg_bias_gen_0/m1_8741_n9864# 6.789050e-17
C922 eeg_fd_ota_chopped_full2_0/eeg_bias_gen_0/m1_8059_n18708# VSS 2.918310e-16
C924 eeg_fd_ota_chopped_full2_0/eeg_bias_gen_0/m1_8059_n18708# eeg_fd_ota_chopped_full2_0/eeg_bias_gen_0/m1_8859_n18708# 6.789040e-17
C925 eeg_fd_ota_chopped_full2_0/eeg_bias_gen_0/m1_8059_n36396# VSS 2.918310e-16
C927 eeg_fd_ota_chopped_full2_0/eeg_bias_gen_0/m1_8059_n36396# eeg_fd_ota_chopped_full2_0/eeg_bias_gen_0/m1_8859_n36396# 6.789050e-17
C928 eeg_fd_ota_chopped_full2_0/eeg_bias_gen_0/m1_8341_n20245# VSS 4.190540e-16
C930 eeg_fd_ota_chopped_full2_0/eeg_bias_gen_0/m1_8341_n20245# eeg_fd_ota_chopped_full2_0/eeg_bias_gen_0/m1_9141_n20245# 6.789040e-17
C931 eeg_fd_ota_chopped_full2_0/eeg_bias_gen_0/m1_8341_n2557# VSS 4.190540e-16
C932 eeg_fd_ota_chopped_full2_0/eeg_bias_gen_0/m1_8341_n2557# eeg_fd_ota_chopped_full2_0/eeg_bias_gen_0/m1_9141_n2557# 6.789040e-17
C933 eeg_fd_ota_chopped_full2_0/eeg_bias_gen_0/m1_8341_n37933# VSS 4.190540e-16
C935 eeg_fd_ota_chopped_full2_0/eeg_bias_gen_0/m1_8341_n37933# eeg_fd_ota_chopped_full2_0/eeg_bias_gen_0/m1_9141_n37933# 6.789052e-17
C936 eeg_fd_ota_chopped_full2_0/eeg_bias_gen_0/m1_8459_n11401# VSS 2.918310e-16
C938 eeg_fd_ota_chopped_full2_0/eeg_bias_gen_0/m1_8459_n11401# eeg_fd_ota_chopped_full2_0/eeg_bias_gen_0/m1_9259_n11401# 6.789036e-17
C939 eeg_fd_ota_chopped_full2_0/eeg_bias_gen_0/m1_8459_n29089# VSS 2.918310e-16
C941 eeg_fd_ota_chopped_full2_0/eeg_bias_gen_0/m1_8459_n29089# eeg_fd_ota_chopped_full2_0/eeg_bias_gen_0/m1_9259_n29089# 6.789050e-17
C942 eeg_fd_ota_chopped_full2_0/eeg_bias_gen_0/m1_8741_n27552# VSS 4.190540e-16
C944 eeg_fd_ota_chopped_full2_0/eeg_bias_gen_0/m1_8741_n27552# eeg_fd_ota_chopped_full2_0/eeg_bias_gen_0/m1_9541_n27552# 6.789050e-17
C945 eeg_fd_ota_chopped_full2_0/eeg_bias_gen_0/m1_8741_n45240# VSS 4.190540e-16
C946 eeg_fd_ota_chopped_full2_0/eeg_bias_gen_0/m1_8741_n45240# eeg_fd_ota_chopped_full2_0/eeg_bias_gen_0/m1_9541_n45240# 6.789050e-17
C947 eeg_fd_ota_chopped_full2_0/eeg_bias_gen_0/m1_8741_n9864# VSS 4.190540e-16
C949 eeg_fd_ota_chopped_full2_0/eeg_bias_gen_0/m1_8741_n9864# eeg_fd_ota_chopped_full2_0/eeg_bias_gen_0/m1_9541_n9864# 6.789050e-17
C950 eeg_fd_ota_chopped_full2_0/eeg_bias_gen_0/m1_8859_n18708# VSS 2.918310e-16
C952 eeg_fd_ota_chopped_full2_0/eeg_bias_gen_0/m1_8859_n18708# eeg_fd_ota_chopped_full2_0/eeg_bias_gen_0/m1_9659_n18708# 6.789040e-17
C953 eeg_fd_ota_chopped_full2_0/eeg_bias_gen_0/m1_8859_n36396# VSS 2.918310e-16
C955 eeg_fd_ota_chopped_full2_0/eeg_bias_gen_0/m1_8859_n36396# eeg_fd_ota_chopped_full2_0/eeg_bias_gen_0/m1_9659_n36396# 6.789050e-17
C956 eeg_fd_ota_chopped_full2_0/eeg_bias_gen_0/m1_9141_n20245# VSS 4.190540e-16
C958 eeg_fd_ota_chopped_full2_0/eeg_bias_gen_0/m1_9141_n20245# eeg_fd_ota_chopped_full2_0/eeg_bias_gen_0/m1_9941_n20245# 6.789050e-17
C959 eeg_fd_ota_chopped_full2_0/eeg_bias_gen_0/m1_9141_n2557# VSS 4.190540e-16
C960 eeg_fd_ota_chopped_full2_0/eeg_bias_gen_0/m1_9141_n2557# eeg_fd_ota_chopped_full2_0/eeg_bias_gen_0/m1_9941_n2557# 6.789050e-17
C961 eeg_fd_ota_chopped_full2_0/eeg_bias_gen_0/m1_9141_n37933# VSS 4.190540e-16
C963 eeg_fd_ota_chopped_full2_0/eeg_bias_gen_0/m1_9141_n37933# eeg_fd_ota_chopped_full2_0/eeg_bias_gen_0/m1_9941_n37933# 6.789050e-17
C964 eeg_fd_ota_chopped_full2_0/eeg_bias_gen_0/m1_9259_n11401# VSS 2.918310e-16
C966 eeg_fd_ota_chopped_full2_0/eeg_bias_gen_0/m1_9259_n29089# VSS 2.918310e-16
C968 eeg_fd_ota_chopped_full2_0/eeg_bias_gen_0/m1_9541_n27552# VSS 4.190540e-16
C969 eeg_fd_ota_chopped_full2_0/eeg_bias_gen_0/m1_9541_n45240# VSS 4.190540e-16
C970 eeg_fd_ota_chopped_full2_0/eeg_bias_gen_0/m1_9541_n9864# VSS 4.190540e-16
C971 eeg_fd_ota_chopped_full2_0/eeg_bias_gen_0/m1_9659_n18708# VSS 2.918310e-16
C973 eeg_fd_ota_chopped_full2_0/eeg_bias_gen_0/m1_9659_n36396# VSS 2.918310e-16
C975 eeg_fd_ota_chopped_full2_0/eeg_bias_gen_0/m1_9941_n20245# VSS 4.190540e-16
C976 eeg_fd_ota_chopped_full2_0/eeg_bias_gen_0/m1_9941_n2557# VSS 4.190540e-16
C977 eeg_fd_ota_chopped_full2_0/eeg_bias_gen_0/m1_9941_n37933# VSS 4.190540e-16
C978 VDD18 VSS 1.198063e-14
C979 VDD18 eeg_fd_ota_chopped_full2_0/eeg_bias_gen_0/VBN 2.562736e-16
C980 VDD18 eeg_fd_ota_chopped_full2_0/eeg_bias_gen_0/VBP 2.977050e-15
C981 eeg_fd_ota_chopped_full2_0/eeg_bias_gen_0/VBN eeg_fd_ota_chopped_full2_0/eeg_bias_gen_0/VBP 6.762340e-16
C982 eeg_fd_ota_chopped_full2_0/eeg_bias_gen_0/VBP VSS 6.072420e-16
C983 eeg_fd_ota_chopped_full2_0/eeg_bias_gen_0/m1_6341_n27552# VSS 6.746650e-16
C984 eeg_fd_ota_chopped_full2_0/eeg_bias_gen_0/m1_6741_n20245# VSS 6.746650e-16
C985 VDD18 VSS 8.414800e-16
C986 VDD18 eeg_fd_ota_chopped_full2_0/eeg_bias_gen_0/VBN 8.460309e-16
C987 VDD18 eeg_fd_ota_chopped_full2_0/eeg_bias_gen_0/eeg_pseudo_res_0/m1_68_66# 1.314672e-15
C988 eeg_fd_ota_chopped_full2_0/eeg_bias_gen_0/VBN VSS 1.699680e-15
C989 eeg_fd_ota_chopped_full2_0/eeg_bias_gen_0/VBN eeg_fd_ota_chopped_full2_0/eeg_bias_gen_0/eeg_pseudo_res_0/m1_68_66# 5.017998e-16
C990 eeg_fd_ota_chopped_full2_0/eeg_bias_gen_0/eeg_pseudo_res_0/m1_68_66# VSS 3.582030e-15
C991 eeg_fd_ota_chopped_full2_0/eeg_bias_gen_0/VBN VSS 3.678650e-15
C992 eeg_fd_ota_chopped_full2_0/eeg_bias_gen_0/VBN eeg_fd_ota_chopped_full2_0/eeg_bias_gen_0/eeg_pseudo_res_0/m1_68_66# 1.322042e-15
C993 eeg_fd_ota_chopped_full2_0/eeg_bias_gen_0/eeg_pseudo_res_0/m1_68_66# VSS 4.103261e-16
C994 VDD18 VSS 3.678650e-15
C995 VDD18 eeg_fd_ota_chopped_full2_0/eeg_bias_gen_0/eeg_pseudo_res_0/m1_68_66# 1.322042e-15
C996 eeg_fd_ota_chopped_full2_0/eeg_bias_gen_0/eeg_pseudo_res_0/m1_68_66# VSS 4.103261e-16
C997 eeg_fd_ota_chopped_full2_0/eeg_bias_gen_0/m1_10459_n36396# VSS 6.746650e-16
C998 eeg_fd_ota_chopped_full2_0/eeg_bias_gen_0/m1_10859_n29089# VSS 6.746650e-16
C999 VSS eeg_fd_ota_chopped_full2_0/eeg_bias_gen_0/VBN 8.327656e-16
C1000 eeg_fd_ota_chopped_full2_0/eeg_bias_gen_0/VBN VSS 2.737979e-15
C1001 eeg_fd_ota_chopped_full2_0/eeg_bias_gen_0/m1_5941_n20245# VSS 6.746650e-16
C1002 eeg_fd_ota_chopped_full2_0/eeg_bias_gen_0/m1_6341_n27552# VSS 6.746650e-16
C1003 eeg_fd_ota_chopped_full2_0/eeg_bias_gen_0/m1_10341_n27552# VSS 6.746650e-16
C1004 eeg_fd_ota_chopped_full2_0/eeg_bias_gen_0/m1_10741_n20245# VSS 6.746650e-16
C1005 eeg_fd_ota_chopped_full2_0/eeg_bias_gen_0/m1_2524_466# VSS 6.747650e-16
C1006 eeg_fd_ota_chopped_full2_0/eeg_bias_gen_0/m1_10859_n29089# VSS 6.746650e-16
C1007 eeg_fd_ota_chopped_full2_0/eeg_bias_gen_0/m1_11259_n36396# VSS 6.746650e-16
C1008 eeg_fd_ota_chopped_full2_0/eeg_bias_gen_0/VBNF VSS 6.746650e-16
C1009 eeg_fd_ota_chopped_full2_0/eeg_bias_gen_0/m1_11141_n9864# VSS 6.746650e-16
C1010 eeg_fd_ota_chopped_full2_0/eeg_bias_gen_0/m1_11259_n36396# VSS 6.746650e-16
C1011 eeg_fd_ota_chopped_full2_0/eeg_bias_gen_0/m1_11541_n37933# VSS 6.746650e-16
C1012 eeg_fd_ota_chopped_full2_0/eeg_bias_gen_0/m1_5541_n27552# VSS 6.746650e-16
C1013 eeg_fd_ota_chopped_full2_0/eeg_bias_gen_0/m1_5941_n20245# VSS 6.746650e-16
C1014 eeg_fd_ota_chopped_full2_0/eeg_bias_gen_0/m1_10341_n27552# VSS 6.746650e-16
C1015 eeg_fd_ota_chopped_full2_0/eeg_bias_gen_0/m1_9941_n20245# VSS 6.746650e-16
C1016 eeg_fd_ota_chopped_full2_0/eeg_bias_gen_0/m1_10741_n2557# VSS 6.746650e-16
C1017 eeg_fd_ota_chopped_full2_0/eeg_bias_gen_0/m1_11141_n9864# VSS 6.746650e-16
C1018 eeg_fd_ota_chopped_full2_0/eeg_bias_gen_0/m1_5141_n20245# VSS 6.746650e-16
C1019 eeg_fd_ota_chopped_full2_0/eeg_bias_gen_0/m1_5541_n27552# VSS 6.746650e-16
C1020 eeg_fd_ota_chopped_full2_0/eeg_bias_gen_0/m1_9541_n27552# VSS 6.746650e-16
C1021 eeg_fd_ota_chopped_full2_0/eeg_bias_gen_0/m1_9941_n20245# VSS 6.746650e-16
C1022 eeg_fd_ota_chopped_full2_0/eeg_bias_gen_0/m1_4859_n18708# VSS 6.746650e-16
C1023 eeg_fd_ota_chopped_full2_0/eeg_bias_gen_0/m1_5259_n11401# VSS 6.746650e-16
C1024 eeg_fd_ota_chopped_full2_0/eeg_bias_gen_0/m1_11141_n45240# VSS 6.746650e-16
C1025 eeg_fd_ota_chopped_full2_0/eeg_bias_gen_0/m1_11541_n37933# VSS 6.746650e-16
C1026 eeg_fd_ota_chopped_full2_0/eeg_bias_gen_0/m1_10341_n9864# VSS 6.746650e-16
C1027 eeg_fd_ota_chopped_full2_0/eeg_bias_gen_0/m1_10741_n2557# VSS 6.746650e-16
C1028 eeg_fd_ota_chopped_full2_0/eeg_bias_gen_0/m1_4741_n27552# VSS 6.746650e-16
C1029 eeg_fd_ota_chopped_full2_0/eeg_bias_gen_0/m1_5141_n20245# VSS 6.746650e-16
C1030 eeg_fd_ota_chopped_full2_0/eeg_bias_gen_0/m1_9141_n20245# VSS 6.746650e-16
C1031 eeg_fd_ota_chopped_full2_0/eeg_bias_gen_0/m1_9541_n27552# VSS 6.746650e-16
C1032 eeg_fd_ota_chopped_full2_0/eeg_bias_gen_0/m1_5259_n11401# VSS 6.746650e-16
C1033 eeg_fd_ota_chopped_full2_0/eeg_bias_gen_0/m1_5659_n18708# VSS 6.746650e-16
C1034 eeg_fd_ota_chopped_full2_0/eeg_bias_gen_0/m1_5941_n2557# VSS 6.746650e-16
C1035 eeg_fd_ota_chopped_full2_0/eeg_bias_gen_0/m1_6341_n9864# VSS 6.746650e-16
C1036 eeg_fd_ota_chopped_full2_0/eeg_bias_gen_0/m1_10741_n37933# VSS 6.746650e-16
C1037 eeg_fd_ota_chopped_full2_0/eeg_bias_gen_0/m1_11141_n45240# VSS 6.746650e-16
C1038 eeg_fd_ota_chopped_full2_0/eeg_bias_gen_0/m1_4341_n20245# VSS 6.746650e-16
C1039 eeg_fd_ota_chopped_full2_0/eeg_bias_gen_0/m1_4741_n27552# VSS 6.746650e-16
C1040 eeg_fd_ota_chopped_full2_0/eeg_bias_gen_0/m1_8741_n27552# VSS 6.746650e-16
C1041 eeg_fd_ota_chopped_full2_0/eeg_bias_gen_0/m1_9141_n20245# VSS 6.746650e-16
C1042 eeg_fd_ota_chopped_full2_0/eeg_bias_gen_0/m1_5659_n18708# VSS 6.746650e-16
C1043 eeg_fd_ota_chopped_full2_0/eeg_bias_gen_0/m1_6059_n11401# VSS 6.746650e-16
C1044 eeg_fd_ota_chopped_full2_0/eeg_bias_gen_0/m1_10059_n11401# VSS 6.746650e-16
C1045 eeg_fd_ota_chopped_full2_0/eeg_bias_gen_0/m1_9659_n18708# VSS 6.746650e-16
C1046 eeg_fd_ota_chopped_full2_0/eeg_bias_gen_0/m1_10459_n18708# VSS 6.746650e-16
C1047 eeg_fd_ota_chopped_full2_0/eeg_bias_gen_0/m1_10859_n11401# VSS 6.746650e-16
C1048 eeg_fd_ota_chopped_full2_0/eeg_bias_gen_0/m1_5541_n9864# VSS 6.746650e-16
C1049 eeg_fd_ota_chopped_full2_0/eeg_bias_gen_0/m1_5941_n2557# VSS 6.746650e-16
C1050 eeg_fd_ota_chopped_full2_0/eeg_bias_gen_0/m1_10341_n45240# VSS 6.746650e-16
C1051 eeg_fd_ota_chopped_full2_0/eeg_bias_gen_0/m1_10741_n37933# VSS 6.746650e-16
C1052 VDD18 VSS 1.198063e-14
C1053 VDD18 eeg_fd_ota_chopped_full2_0/eeg_bias_gen_0/VBP 3.233324e-15
C1054 eeg_fd_ota_chopped_full2_0/eeg_bias_gen_0/VBP VSS 6.072420e-16
C1055 eeg_fd_ota_chopped_full2_0/eeg_bias_gen_0/m1_5941_n37933# VSS 6.746650e-16
C1056 eeg_fd_ota_chopped_full2_0/eeg_bias_gen_0/m1_6341_n45240# VSS 6.746650e-16
C1057 eeg_fd_ota_chopped_full2_0/eeg_bias_gen_0/m1_3941_n27552# VSS 6.746650e-16
C1058 eeg_fd_ota_chopped_full2_0/eeg_bias_gen_0/m1_4341_n20245# VSS 6.746650e-16
C1059 eeg_fd_ota_chopped_full2_0/eeg_bias_gen_0/m1_8341_n20245# VSS 6.746650e-16
C1060 eeg_fd_ota_chopped_full2_0/eeg_bias_gen_0/m1_8741_n27552# VSS 6.746650e-16
C1061 eeg_fd_ota_chopped_full2_0/eeg_bias_gen_0/m1_6059_n11401# VSS 6.746650e-16
C1062 eeg_fd_ota_chopped_full2_0/eeg_bias_gen_0/m1_6459_n18708# VSS 6.746650e-16
C1063 eeg_fd_ota_chopped_full2_0/eeg_bias_gen_0/m1_10859_n11401# VSS 6.746650e-16
C1064 eeg_fd_ota_chopped_full2_0/eeg_bias_gen_0/m1_11259_n18708# VSS 6.746650e-16
C1065 eeg_fd_ota_chopped_full2_0/eeg_bias_gen_0/m1_5141_n2557# VSS 6.746650e-16
C1066 eeg_fd_ota_chopped_full2_0/eeg_bias_gen_0/m1_5541_n9864# VSS 6.746650e-16
C1067 eeg_fd_ota_chopped_full2_0/eeg_bias_gen_0/m1_9541_n9864# VSS 6.746650e-16
C1068 eeg_fd_ota_chopped_full2_0/eeg_bias_gen_0/m1_9941_n2557# VSS 6.746650e-16
C1069 eeg_fd_ota_chopped_full2_0/eeg_bias_gen_0/m1_4859_n36396# VSS 6.746650e-16
C1070 eeg_fd_ota_chopped_full2_0/eeg_bias_gen_0/m1_5259_n29089# VSS 6.746650e-16
C1071 eeg_fd_ota_chopped_full2_0/eeg_bias_gen_0/VBN VSS 6.746650e-16
C1072 eeg_fd_ota_chopped_full2_0/eeg_bias_gen_0/m1_3941_n45240# VSS 6.746650e-16
C1073 eeg_fd_ota_chopped_full2_0/eeg_bias_gen_0/m1_5541_n45240# VSS 6.746650e-16
C1074 eeg_fd_ota_chopped_full2_0/eeg_bias_gen_0/m1_5941_n37933# VSS 6.746650e-16
C1075 eeg_fd_ota_chopped_full2_0/eeg_bias_gen_0/m1_3701_n29089# VSS 6.746650e-16
C1076 eeg_fd_ota_chopped_full2_0/eeg_bias_gen_0/m1_3941_n27552# VSS 6.746650e-16
C1077 eeg_fd_ota_chopped_full2_0/eeg_bias_gen_0/m1_7941_n27552# VSS 6.746650e-16
C1078 eeg_fd_ota_chopped_full2_0/eeg_bias_gen_0/m1_8341_n20245# VSS 6.746650e-16
C1079 eeg_fd_ota_chopped_full2_0/eeg_bias_gen_0/m1_6459_n18708# VSS 6.746650e-16
C1080 eeg_fd_ota_chopped_full2_0/eeg_bias_gen_0/m1_6859_n11401# VSS 6.746650e-16
C1081 eeg_fd_ota_chopped_full2_0/eeg_bias_gen_0/m1_11259_n18708# VSS 6.746650e-16
C1082 eeg_fd_ota_chopped_full2_0/eeg_bias_gen_0/m1_11541_n20245# VSS 6.746650e-16
C1083 eeg_fd_ota_chopped_full2_0/eeg_bias_gen_0/m1_4741_n9864# VSS 6.746650e-16
C1084 eeg_fd_ota_chopped_full2_0/eeg_bias_gen_0/m1_5141_n2557# VSS 6.746650e-16
C1085 eeg_fd_ota_chopped_full2_0/eeg_bias_gen_0/m1_9141_n2557# VSS 6.746650e-16
C1086 eeg_fd_ota_chopped_full2_0/eeg_bias_gen_0/m1_9541_n9864# VSS 6.746650e-16
C1087 eeg_fd_ota_chopped_full2_0/eeg_bias_gen_0/m1_5259_n29089# VSS 6.746650e-16
C1088 eeg_fd_ota_chopped_full2_0/eeg_bias_gen_0/m1_5659_n36396# VSS 6.746650e-16
C1089 eeg_fd_ota_chopped_full2_0/eeg_bias_gen_0/m1_10341_n9864# VSS 6.746650e-16
C1090 eeg_fd_ota_chopped_full2_0/eeg_bias_gen_0/m1_9941_n2557# VSS 6.746650e-16
C1091 eeg_fd_ota_chopped_full2_0/eeg_bias_gen_0/m1_5141_n37933# VSS 6.746650e-16
C1092 eeg_fd_ota_chopped_full2_0/eeg_bias_gen_0/m1_5541_n45240# VSS 6.746650e-16
C1093 eeg_fd_ota_chopped_full2_0/eeg_bias_gen_0/m1_9541_n45240# VSS 6.746650e-16
C1094 eeg_fd_ota_chopped_full2_0/eeg_bias_gen_0/m1_9941_n37933# VSS 6.746650e-16
C1095 eeg_fd_ota_chopped_full2_0/eeg_bias_gen_0/m1_6459_n36396# VSS 6.746650e-16
C1096 eeg_fd_ota_chopped_full2_0/eeg_bias_gen_0/m1_6859_n29089# VSS 6.746650e-16
C1097 eeg_fd_ota_chopped_full2_0/eeg_bias_gen_0/m1_10059_n29089# VSS 6.746650e-16
C1098 eeg_fd_ota_chopped_full2_0/eeg_bias_gen_0/m1_10459_n36396# VSS 6.746650e-16
C1099 eeg_fd_ota_chopped_full2_0/eeg_bias_gen_0/m1_7541_n20245# VSS 6.746650e-16
C1100 eeg_fd_ota_chopped_full2_0/eeg_bias_gen_0/m1_7941_n27552# VSS 6.746650e-16
C1101 eeg_fd_ota_chopped_full2_0/eeg_bias_gen_0/m1_6859_n11401# VSS 6.746650e-16
C1102 eeg_fd_ota_chopped_full2_0/eeg_bias_gen_0/m1_7259_n18708# VSS 6.746650e-16
C1103 eeg_fd_ota_chopped_full2_0/eeg_bias_gen_0/m1_4341_n2557# VSS 6.746650e-16
C1104 eeg_fd_ota_chopped_full2_0/eeg_bias_gen_0/m1_4741_n9864# VSS 6.746650e-16
C1105 eeg_fd_ota_chopped_full2_0/eeg_bias_gen_0/m1_8741_n9864# VSS 6.746650e-16
C1106 eeg_fd_ota_chopped_full2_0/eeg_bias_gen_0/m1_9141_n2557# VSS 6.746650e-16
C1107 eeg_fd_ota_chopped_full2_0/eeg_bias_gen_0/m1_5659_n36396# VSS 6.746650e-16
C1108 eeg_fd_ota_chopped_full2_0/eeg_bias_gen_0/m1_6059_n29089# VSS 6.746650e-16
C1109 eeg_fd_ota_chopped_full2_0/eeg_bias_gen_0/m1_4741_n45240# VSS 6.746650e-16
C1110 eeg_fd_ota_chopped_full2_0/eeg_bias_gen_0/m1_5141_n37933# VSS 6.746650e-16
C1111 eeg_fd_ota_chopped_full2_0/eeg_bias_gen_0/m1_9141_n37933# VSS 6.746650e-16
C1112 eeg_fd_ota_chopped_full2_0/eeg_bias_gen_0/m1_9541_n45240# VSS 6.746650e-16
C1113 eeg_fd_ota_chopped_full2_0/eeg_bias_gen_0/m1_10341_n45240# VSS 6.746650e-16
C1114 eeg_fd_ota_chopped_full2_0/eeg_bias_gen_0/m1_9941_n37933# VSS 6.746650e-16
C1115 eeg_fd_ota_chopped_full2_0/eeg_bias_gen_0/m1_6859_n29089# VSS 6.746650e-16
C1116 eeg_fd_ota_chopped_full2_0/eeg_bias_gen_0/m1_7259_n36396# VSS 6.746650e-16
C1117 eeg_fd_ota_chopped_full2_0/eeg_bias_gen_0/m1_7141_n27552# VSS 6.746650e-16
C1118 eeg_fd_ota_chopped_full2_0/eeg_bias_gen_0/m1_7541_n20245# VSS 6.746650e-16
C1119 eeg_fd_ota_chopped_full2_0/eeg_bias_gen_0/m1_7259_n18708# VSS 6.746650e-16
C1120 eeg_fd_ota_chopped_full2_0/eeg_bias_gen_0/m1_7659_n11401# VSS 6.746650e-16
C1121 eeg_fd_ota_chopped_full2_0/eeg_bias_gen_0/m1_10059_n11401# VSS 6.746650e-16
C1122 eeg_fd_ota_chopped_full2_0/eeg_bias_gen_0/m1_10459_n18708# VSS 6.746650e-16
C1123 eeg_fd_ota_chopped_full2_0/eeg_bias_gen_0/m1_3941_n9864# VSS 6.746650e-16
C1124 eeg_fd_ota_chopped_full2_0/eeg_bias_gen_0/m1_4341_n2557# VSS 6.746650e-16
C1125 eeg_fd_ota_chopped_full2_0/eeg_bias_gen_0/m1_8341_n2557# VSS 6.746650e-16
C1126 eeg_fd_ota_chopped_full2_0/eeg_bias_gen_0/m1_8741_n9864# VSS 6.746650e-16
C1127 eeg_fd_ota_chopped_full2_0/eeg_bias_gen_0/m1_6059_n29089# VSS 6.746650e-16
C1128 eeg_fd_ota_chopped_full2_0/eeg_bias_gen_0/m1_6459_n36396# VSS 6.746650e-16
C1129 eeg_fd_ota_chopped_full2_0/eeg_bias_gen_0/m1_4341_n37933# VSS 6.746650e-16
C1130 eeg_fd_ota_chopped_full2_0/eeg_bias_gen_0/m1_4741_n45240# VSS 6.746650e-16
C1131 eeg_fd_ota_chopped_full2_0/eeg_bias_gen_0/m1_8741_n45240# VSS 6.746650e-16
C1132 eeg_fd_ota_chopped_full2_0/eeg_bias_gen_0/m1_9141_n37933# VSS 6.746650e-16
C1133 eeg_fd_ota_chopped_full2_0/eeg_bias_gen_0/m1_7259_n36396# VSS 6.746650e-16
C1134 eeg_fd_ota_chopped_full2_0/eeg_bias_gen_0/m1_7659_n29089# VSS 6.746650e-16
C1135 eeg_fd_ota_chopped_full2_0/eeg_bias_gen_0/m1_6741_n20245# VSS 6.746650e-16
C1136 eeg_fd_ota_chopped_full2_0/eeg_bias_gen_0/m1_7141_n27552# VSS 6.746650e-16
C1137 eeg_fd_ota_chopped_full2_0/eeg_bias_gen_0/m1_11141_n27552# VSS 6.746650e-16
C1138 eeg_fd_ota_chopped_full2_0/eeg_bias_gen_0/m1_11541_n20245# VSS 6.746650e-16
C1139 eeg_fd_ota_chopped_full2_0/eeg_bias_gen_0/m1_7659_n11401# VSS 6.746650e-16
C1140 eeg_fd_ota_chopped_full2_0/eeg_bias_gen_0/m1_8059_n18708# VSS 6.746650e-16
C1141 eeg_fd_ota_chopped_full2_0/eeg_bias_gen_0/m1_3701_n11401# VSS 6.746650e-16
C1142 eeg_fd_ota_chopped_full2_0/eeg_bias_gen_0/m1_3941_n9864# VSS 6.746650e-16
C1143 eeg_fd_ota_chopped_full2_0/eeg_bias_gen_0/m1_7941_n9864# VSS 6.746650e-16
C1144 eeg_fd_ota_chopped_full2_0/eeg_bias_gen_0/m1_8341_n2557# VSS 6.746650e-16
C1145 eeg_fd_ota_chopped_full2_0/eeg_bias_gen_0/m1_8341_n37933# VSS 6.746650e-16
C1146 eeg_fd_ota_chopped_full2_0/eeg_bias_gen_0/m1_8741_n45240# VSS 6.746650e-16
C1147 eeg_fd_ota_chopped_full2_0/eeg_bias_gen_0/m1_3701_n29089# VSS 6.746650e-16
C1148 eeg_fd_ota_chopped_full2_0/eeg_bias_gen_0/m1_4059_n36396# VSS 6.746650e-16
C1149 eeg_fd_ota_chopped_full2_0/eeg_bias_gen_0/m1_7659_n29089# VSS 6.746650e-16
C1150 eeg_fd_ota_chopped_full2_0/eeg_bias_gen_0/m1_8059_n36396# VSS 6.746650e-16
C1151 eeg_fd_ota_chopped_full2_0/eeg_bias_gen_0/m1_10741_n20245# VSS 6.746650e-16
C1152 eeg_fd_ota_chopped_full2_0/eeg_bias_gen_0/m1_11141_n27552# VSS 6.746650e-16
C1153 eeg_fd_ota_chopped_full2_0/eeg_bias_gen_0/m1_3701_n11401# VSS 6.746650e-16
C1154 eeg_fd_ota_chopped_full2_0/eeg_bias_gen_0/m1_4059_n18708# VSS 6.746650e-16
C1155 eeg_fd_ota_chopped_full2_0/eeg_bias_gen_0/m1_8059_n18708# VSS 6.746650e-16
C1156 eeg_fd_ota_chopped_full2_0/eeg_bias_gen_0/m1_8459_n11401# VSS 6.746650e-16
C1157 eeg_fd_ota_chopped_full2_0/eeg_bias_gen_0/m1_7541_n2557# VSS 6.746650e-16
C1158 eeg_fd_ota_chopped_full2_0/eeg_bias_gen_0/m1_7941_n9864# VSS 6.746650e-16
C1159 eeg_fd_ota_chopped_full2_0/eeg_bias_gen_0/m1_7941_n45240# VSS 6.746650e-16
C1160 eeg_fd_ota_chopped_full2_0/eeg_bias_gen_0/m1_8341_n37933# VSS 6.746650e-16
C1161 eeg_fd_ota_chopped_full2_0/eeg_bias_gen_0/m1_4059_n36396# VSS 6.746650e-16
C1162 eeg_fd_ota_chopped_full2_0/eeg_bias_gen_0/m1_4459_n29089# VSS 6.746650e-16
C1163 eeg_fd_ota_chopped_full2_0/eeg_bias_gen_0/m1_8059_n36396# VSS 6.746650e-16
C1164 eeg_fd_ota_chopped_full2_0/eeg_bias_gen_0/m1_8459_n29089# VSS 6.746650e-16
C1165 eeg_fd_ota_chopped_full2_0/eeg_bias_gen_0/m1_4059_n18708# VSS 6.746650e-16
C1166 eeg_fd_ota_chopped_full2_0/eeg_bias_gen_0/m1_4459_n11401# VSS 6.746650e-16
C1167 eeg_fd_ota_chopped_full2_0/eeg_bias_gen_0/m1_8459_n11401# VSS 6.746650e-16
C1168 eeg_fd_ota_chopped_full2_0/eeg_bias_gen_0/m1_8859_n18708# VSS 6.746650e-16
C1169 eeg_fd_ota_chopped_full2_0/eeg_bias_gen_0/m1_7141_n9864# VSS 6.746650e-16
C1170 eeg_fd_ota_chopped_full2_0/eeg_bias_gen_0/m1_7541_n2557# VSS 6.746650e-16
C1171 eeg_fd_ota_chopped_full2_0/eeg_bias_gen_0/m1_7541_n37933# VSS 6.746650e-16
C1172 eeg_fd_ota_chopped_full2_0/eeg_bias_gen_0/m1_7941_n45240# VSS 6.746650e-16
C1173 eeg_fd_ota_chopped_full2_0/eeg_bias_gen_0/m1_4459_n29089# VSS 6.746650e-16
C1174 eeg_fd_ota_chopped_full2_0/eeg_bias_gen_0/m1_4859_n36396# VSS 6.746650e-16
C1175 eeg_fd_ota_chopped_full2_0/eeg_bias_gen_0/m1_8459_n29089# VSS 6.746650e-16
C1176 eeg_fd_ota_chopped_full2_0/eeg_bias_gen_0/m1_8859_n36396# VSS 6.746650e-16
C1177 eeg_fd_ota_chopped_full2_0/eeg_bias_gen_0/m1_4459_n11401# VSS 6.746650e-16
C1178 eeg_fd_ota_chopped_full2_0/eeg_bias_gen_0/m1_4859_n18708# VSS 6.746650e-16
C1179 eeg_fd_ota_chopped_full2_0/eeg_bias_gen_0/m1_6741_n2557# VSS 6.746650e-16
C1180 eeg_fd_ota_chopped_full2_0/eeg_bias_gen_0/m1_7141_n9864# VSS 6.746650e-16
C1181 eeg_fd_ota_chopped_full2_0/eeg_bias_gen_0/m1_7141_n45240# VSS 6.746650e-16
C1182 eeg_fd_ota_chopped_full2_0/eeg_bias_gen_0/m1_7541_n37933# VSS 6.746650e-16
C1183 eeg_fd_ota_chopped_full2_0/eeg_bias_gen_0/m1_8859_n36396# VSS 6.746650e-16
C1184 eeg_fd_ota_chopped_full2_0/eeg_bias_gen_0/m1_9259_n29089# VSS 6.746650e-16
C1185 eeg_fd_ota_chopped_full2_0/eeg_bias_gen_0/m1_8859_n18708# VSS 6.746650e-16
C1186 eeg_fd_ota_chopped_full2_0/eeg_bias_gen_0/m1_9259_n11401# VSS 6.746650e-16
C1187 eeg_fd_ota_chopped_full2_0/eeg_bias_gen_0/m1_6341_n9864# VSS 6.746650e-16
C1188 eeg_fd_ota_chopped_full2_0/eeg_bias_gen_0/m1_6741_n2557# VSS 6.746650e-16
C1189 eeg_fd_ota_chopped_full2_0/eeg_bias_gen_0/m1_6741_n37933# VSS 6.746650e-16
C1190 eeg_fd_ota_chopped_full2_0/eeg_bias_gen_0/m1_7141_n45240# VSS 6.746650e-16
C1191 eeg_fd_ota_chopped_full2_0/eeg_bias_gen_0/m1_9259_n29089# VSS 6.746650e-16
C1192 eeg_fd_ota_chopped_full2_0/eeg_bias_gen_0/m1_9659_n36396# VSS 6.746650e-16
C1193 eeg_fd_ota_chopped_full2_0/eeg_bias_gen_0/m1_9259_n11401# VSS 6.746650e-16
C1194 eeg_fd_ota_chopped_full2_0/eeg_bias_gen_0/m1_9659_n18708# VSS 6.746650e-16
C1195 eeg_fd_ota_chopped_full2_0/eeg_bias_gen_0/m1_6341_n45240# VSS 6.746650e-16
C1196 eeg_fd_ota_chopped_full2_0/eeg_bias_gen_0/m1_6741_n37933# VSS 6.746650e-16
C1197 eeg_fd_ota_chopped_full2_0/eeg_bias_gen_0/m1_10059_n29089# VSS 6.746650e-16
C1198 eeg_fd_ota_chopped_full2_0/eeg_bias_gen_0/m1_9659_n36396# VSS 6.746650e-16
C1199 eeg_fd_ota_chopped_full2_0/eeg_bias_gen_0/m1_3941_n45240# VSS 6.746650e-16
C1200 eeg_fd_ota_chopped_full2_0/eeg_bias_gen_0/m1_4341_n37933# VSS 6.746650e-16
C1201 eeg_fd_ota_chopped_full2_0/eeg_bias_gen_0/VBN VSS 1.059610e-14
C1202 eeg_fd_ota_chopped_full2_0/eeg_bias_gen_0/VBN eeg_fd_ota_chopped_full2_0/eeg_bias_gen_0/VBP 2.704936e-15
C1203 eeg_fd_ota_chopped_full2_0/eeg_bias_gen_0/VBN eeg_fd_ota_chopped_full2_0/eeg_bias_gen_0/m1_2524_466# 2.781792e-15
C1204 eeg_fd_ota_chopped_full2_0/eeg_bias_gen_0/VBP VSS 1.199796e-16
C1205 eeg_fd_ota_chopped_full2_0/eeg_bias_gen_0/VBP eeg_fd_ota_chopped_full2_0/eeg_bias_gen_0/m1_2524_466# 3.225268e-16
C1206 eeg_fd_ota_chopped_full2_0/eeg_bias_gen_0/m1_2524_466# VSS 9.907064e-16
C1208 VCM_REF VSS 6.240538e-16
C1209 VCM_REF eeg_fd_ota_chopped_full2_0/eeg_bias_gen_0/VBNF 2.510694e-16
C1211 VCM_REF eeg_fd_ota_chopped_full2_0/eeg_cmfb_amp_dl2_s2_0/m1_68_166# 2.427824e-16
C1212 VCM_REF eeg_fd_ota_chopped_full2_0/stage2_0/VBP2 4.094696e-17
C1214 VDD18 VSS 2.668463e-15
C1215 VDD18 eeg_fd_ota_chopped_full2_0/eeg_cmfb_amp_dl2_s2_0/m1_370_1493# 2.840876e-16
C1217 VDD18 eeg_fd_ota_chopped_full2_0/stage2_0/VBP2 7.519594e-16
C1219 VSS eeg_fd_ota_chopped_full2_0/eeg_bias_gen_0/VBNF 2.369513e-15
C1220 VSS eeg_fd_ota_chopped_full2_0/eeg_cmfb_amp_dl2_s2_0/m1_370_1493# 5.700428e-17
C1221 VSS eeg_fd_ota_chopped_full2_0/eeg_cmfb_amp_dl2_s2_0/m1_68_166# 5.221927e-16
C1222 VSS eeg_fd_ota_chopped_full2_0/stage2_0/VBP2 3.413030e-17
C1223 VSS eeg_fd_ota_chopped_full2_0/stage2_0/VCM2 2.749285e-16
C1224 eeg_fd_ota_chopped_full2_0/eeg_bias_gen_0/VBNF VSS 1.604850e-15
C1226 eeg_fd_ota_chopped_full2_0/eeg_bias_gen_0/VBNF eeg_fd_ota_chopped_full2_0/eeg_cmfb_amp_dl2_s2_0/m1_68_166# 3.152511e-16
C1228 eeg_fd_ota_chopped_full2_0/eeg_bias_gen_0/VBNF eeg_fd_ota_chopped_full2_0/stage2_0/VCM2 3.744583e-17
C1229 eeg_fd_ota_chopped_full2_0/eeg_cmfb_amp_dl2_s2_0/m1_370_1493# VSS 9.817690e-16
C1230 eeg_fd_ota_chopped_full2_0/eeg_cmfb_amp_dl2_s2_0/m1_370_1493# eeg_fd_ota_chopped_full2_0/eeg_cmfb_amp_dl2_s2_0/m1_68_166# 4.867321e-17
C1231 eeg_fd_ota_chopped_full2_0/eeg_cmfb_amp_dl2_s2_0/m1_370_1493# eeg_fd_ota_chopped_full2_0/stage2_0/VBP2 4.354865e-17
C1232 eeg_fd_ota_chopped_full2_0/eeg_cmfb_amp_dl2_s2_0/m1_370_1493# eeg_fd_ota_chopped_full2_0/stage2_0/VCM2 3.677346e-17
C1233 eeg_fd_ota_chopped_full2_0/eeg_cmfb_amp_dl2_s2_0/m1_68_166# VSS 1.236880e-15
C1235 eeg_fd_ota_chopped_full2_0/eeg_cmfb_amp_dl2_s2_0/m1_68_166# eeg_fd_ota_chopped_full2_0/stage2_0/VCM2 3.012335e-16
C1236 eeg_fd_ota_chopped_full2_0/stage2_0/VBP2 VSS 1.787320e-15
C1237 eeg_fd_ota_chopped_full2_0/stage2_0/VCM2 VSS 3.299460e-16
C1238 VDD18 VSS 3.587888e-15
C1239 VDD18 eeg_fd_ota_chopped_full2_0/eeg_cmfb_amp_dl2_s2_0/m1_370_1493# 9.654664e-16
C1240 eeg_fd_ota_chopped_full2_0/eeg_cmfb_amp_dl2_s2_0/m1_370_1493# VSS 2.472537e-16
C1241 eeg_fd_ota_chopped_full2_0/eeg_cmfb_amp_dl2_s2_0/m1_370_1493# VSS 2.522110e-16
C1242 eeg_fd_ota_chopped_full2_0/eeg_cmfb_amp_dl2_s2_0/m1_370_1493# eeg_fd_ota_chopped_full2_0/eeg_cmfb_amp_dl2_s2_0/m1_68_166# 2.845540e-17
C1243 eeg_fd_ota_chopped_full2_0/eeg_cmfb_amp_dl2_s2_0/m1_370_1493# eeg_fd_ota_chopped_full2_0/stage2_0/VCM2 1.233540e-16
C1244 eeg_fd_ota_chopped_full2_0/eeg_cmfb_amp_dl2_s2_0/m1_68_166# VSS 2.522110e-16
C1245 eeg_fd_ota_chopped_full2_0/eeg_cmfb_amp_dl2_s2_0/m1_68_166# eeg_fd_ota_chopped_full2_0/stage2_0/VCM2 1.233540e-16
C1246 eeg_fd_ota_chopped_full2_0/stage2_0/VCM2 VSS 7.517030e-16
C1247 VSS eeg_fd_ota_chopped_full2_0/eeg_bias_gen_0/VBNF 9.287020e-16
C1248 VSS eeg_fd_ota_chopped_full2_0/eeg_cmfb_amp_dl2_s2_0/m1_68_166# 9.828080e-17
C1249 eeg_fd_ota_chopped_full2_0/eeg_bias_gen_0/VBNF VSS 2.698520e-15
C1250 eeg_fd_ota_chopped_full2_0/eeg_bias_gen_0/VBNF eeg_fd_ota_chopped_full2_0/eeg_cmfb_amp_dl2_s2_0/m1_68_166# 8.339500e-16
C1251 eeg_fd_ota_chopped_full2_0/eeg_cmfb_amp_dl2_s2_0/m1_68_166# VSS 2.771420e-17
C1252 VDD18 VSS 2.586521e-15
C1253 VDD18 eeg_fd_ota_chopped_full2_0/stage2_0/VBP2 1.198369e-15
C1254 eeg_fd_ota_chopped_full2_0/stage2_0/VBP2 VSS 3.939952e-16
C1255 VCM_REF VSS 7.517030e-16
C1256 VCM_REF eeg_fd_ota_chopped_full2_0/eeg_cmfb_amp_dl2_s2_0/m1_68_166# 1.233540e-16
C1257 VCM_REF eeg_fd_ota_chopped_full2_0/stage2_0/VBP2 1.233540e-16
C1258 eeg_fd_ota_chopped_full2_0/eeg_cmfb_amp_dl2_s2_0/m1_68_166# VSS 2.522110e-16
C1259 eeg_fd_ota_chopped_full2_0/eeg_cmfb_amp_dl2_s2_0/m1_68_166# eeg_fd_ota_chopped_full2_0/stage2_0/VBP2 2.845540e-17
C1260 eeg_fd_ota_chopped_full2_0/stage2_0/VBP2 VSS 2.522110e-16
C1262 VCM_REF VSS 6.276408e-16
C1263 VCM_REF eeg_fd_ota_chopped_full2_0/eeg_bias_gen_0/VBNF 2.510694e-16
C1264 VCM_REF eeg_fd_ota_chopped_full2_0/eeg_cmfb_amp_dl2_0/VBP 4.083846e-17
C1267 VCM_REF eeg_fd_ota_chopped_full2_0/eeg_cmfb_amp_dl2_0/m1_68_166# 2.427824e-16
C1268 VDD18 VSS 2.546487e-15
C1269 VDD18 eeg_fd_ota_chopped_full2_0/eeg_cmfb_amp_dl2_0/VBP 8.003207e-16
C1271 VDD18 eeg_fd_ota_chopped_full2_0/eeg_cmfb_amp_dl2_0/m1_370_1493# 2.821268e-16
C1273 VSS eeg_fd_ota_chopped_full2_0/eeg_bias_gen_0/VBNF 2.369513e-15
C1274 VSS eeg_fd_ota_chopped_full2_0/eeg_cmfb_amp_dl2_0/VBP 3.379078e-17
C1275 VSS eeg_fd_ota_chopped_full2_0/eeg_cmfb_amp_dl2_0/VCM_SENSE 2.749285e-16
C1276 VSS eeg_fd_ota_chopped_full2_0/eeg_cmfb_amp_dl2_0/m1_370_1493# 5.700428e-17
C1277 VSS eeg_fd_ota_chopped_full2_0/eeg_cmfb_amp_dl2_0/m1_68_166# 5.221927e-16
C1278 eeg_fd_ota_chopped_full2_0/eeg_bias_gen_0/VBNF VSS 1.604850e-15
C1280 eeg_fd_ota_chopped_full2_0/eeg_bias_gen_0/VBNF eeg_fd_ota_chopped_full2_0/eeg_cmfb_amp_dl2_0/VCM_SENSE 3.744583e-17
C1282 eeg_fd_ota_chopped_full2_0/eeg_bias_gen_0/VBNF eeg_fd_ota_chopped_full2_0/eeg_cmfb_amp_dl2_0/m1_68_166# 3.152511e-16
C1283 eeg_fd_ota_chopped_full2_0/eeg_cmfb_amp_dl2_0/VBP VSS 2.231260e-15
C1284 eeg_fd_ota_chopped_full2_0/eeg_cmfb_amp_dl2_0/VBP eeg_fd_ota_chopped_full2_0/eeg_cmfb_amp_dl2_0/m1_370_1493# 4.937477e-17
C1286 eeg_fd_ota_chopped_full2_0/eeg_cmfb_amp_dl2_0/VCM_SENSE VSS 3.299460e-16
C1287 eeg_fd_ota_chopped_full2_0/eeg_cmfb_amp_dl2_0/VCM_SENSE eeg_fd_ota_chopped_full2_0/eeg_cmfb_amp_dl2_0/m1_370_1493# 3.677346e-17
C1288 eeg_fd_ota_chopped_full2_0/eeg_cmfb_amp_dl2_0/VCM_SENSE eeg_fd_ota_chopped_full2_0/eeg_cmfb_amp_dl2_0/m1_68_166# 3.012335e-16
C1289 eeg_fd_ota_chopped_full2_0/eeg_cmfb_amp_dl2_0/m1_370_1493# VSS 9.932130e-16
C1290 eeg_fd_ota_chopped_full2_0/eeg_cmfb_amp_dl2_0/m1_370_1493# eeg_fd_ota_chopped_full2_0/eeg_cmfb_amp_dl2_0/m1_68_166# 4.867321e-17
C1291 eeg_fd_ota_chopped_full2_0/eeg_cmfb_amp_dl2_0/m1_68_166# VSS 1.237070e-15
C1292 VDD18 VSS 6.757137e-15
C1293 VDD18 eeg_fd_ota_chopped_full2_0/eeg_cmfb_amp_dl2_0/VBP 1.873828e-15
C1294 eeg_fd_ota_chopped_full2_0/eeg_cmfb_amp_dl2_0/VBP VSS 4.451080e-16
C1295 VCM_REF VSS 7.517030e-16
C1296 VCM_REF eeg_fd_ota_chopped_full2_0/eeg_cmfb_amp_dl2_0/VBP 1.233540e-16
C1297 VCM_REF eeg_fd_ota_chopped_full2_0/eeg_cmfb_amp_dl2_0/m1_68_166# 1.233540e-16
C1298 eeg_fd_ota_chopped_full2_0/eeg_cmfb_amp_dl2_0/VBP VSS 2.522110e-16
C1299 eeg_fd_ota_chopped_full2_0/eeg_cmfb_amp_dl2_0/VBP eeg_fd_ota_chopped_full2_0/eeg_cmfb_amp_dl2_0/m1_68_166# 2.845540e-17
C1300 eeg_fd_ota_chopped_full2_0/eeg_cmfb_amp_dl2_0/m1_68_166# VSS 2.522110e-16
C1301 VSS eeg_fd_ota_chopped_full2_0/eeg_bias_gen_0/VBNF 9.287020e-16
C1302 VSS eeg_fd_ota_chopped_full2_0/eeg_cmfb_amp_dl2_0/m1_68_166# 9.828080e-17
C1303 eeg_fd_ota_chopped_full2_0/eeg_bias_gen_0/VBNF VSS 2.698520e-15
C1304 eeg_fd_ota_chopped_full2_0/eeg_bias_gen_0/VBNF eeg_fd_ota_chopped_full2_0/eeg_cmfb_amp_dl2_0/m1_68_166# 8.339500e-16
C1305 eeg_fd_ota_chopped_full2_0/eeg_cmfb_amp_dl2_0/m1_68_166# VSS 2.771420e-17
C1306 VDD18 VSS 3.587888e-15
C1307 VDD18 eeg_fd_ota_chopped_full2_0/eeg_cmfb_amp_dl2_0/m1_370_1493# 9.654664e-16
C1308 eeg_fd_ota_chopped_full2_0/eeg_cmfb_amp_dl2_0/m1_370_1493# VSS 2.472537e-16
C1309 eeg_fd_ota_chopped_full2_0/eeg_cmfb_amp_dl2_0/VCM_SENSE VSS 7.517030e-16
C1310 eeg_fd_ota_chopped_full2_0/eeg_cmfb_amp_dl2_0/VCM_SENSE eeg_fd_ota_chopped_full2_0/eeg_cmfb_amp_dl2_0/m1_370_1493# 1.233540e-16
C1311 eeg_fd_ota_chopped_full2_0/eeg_cmfb_amp_dl2_0/VCM_SENSE eeg_fd_ota_chopped_full2_0/eeg_cmfb_amp_dl2_0/m1_68_166# 1.233540e-16
C1312 eeg_fd_ota_chopped_full2_0/eeg_cmfb_amp_dl2_0/m1_370_1493# VSS 2.522110e-16
C1313 eeg_fd_ota_chopped_full2_0/eeg_cmfb_amp_dl2_0/m1_370_1493# eeg_fd_ota_chopped_full2_0/eeg_cmfb_amp_dl2_0/m1_68_166# 2.845540e-17
C1314 eeg_fd_ota_chopped_full2_0/eeg_cmfb_amp_dl2_0/m1_68_166# VSS 2.522110e-16
C1315 OUTN OUTP 1.250905e-14
C1316 OUTN VCM_REF 1.571540e-15
C1317 OUTN VDD18 1.639622e-15
C1318 OUTN VSS 1.333233e-13
C1319 OUTN eeg_fd_ota_chopped_full2_0/stage2_0/N2N 2.525290e-16
C1321 OUTN eeg_fd_ota_chopped_full2_0/stage2_0/VBP2 9.326616e-15
C1322 OUTN eeg_fd_ota_chopped_full2_0/stage2_0/VCM2 7.778653e-16
C1323 OUTN eeg_fd_ota_chopped_full2_0/stage2_0/m1_12966_n5928# 5.354807e-13
C1324 OUTN eeg_fd_ota_chopped_full2_0/stage2_0/m1_42341_n8557# 7.669250e-17
C1330 OUTN eeg_fd_ota_chopped_full2_0/stage2_0/m1_47141_n8557# 3.123278e-16
C1331 OUTN eeg_fd_ota_chopped_full2_0/stage2_0/m1_47541_n15864# 3.201824e-16
C1333 OUTN eeg_fd_ota_chopped_full2_0/stage2_0/m1_48341_n15864# 3.866493e-17
C1335 OUTN eeg_fd_ota_chopped_full2_0/stage2_0/m1_49141_n15864# 3.442668e-17
C1336 OUTN eeg_fd_ota_chopped_full2_0/stage2_0/m1_49941_n15864# 3.405966e-17
C1337 OUTN eeg_fd_ota_chopped_full2_0/stage2_0/m1_50741_n15864# 3.405966e-17
C1338 OUTN eeg_fd_ota_chopped_full2_0/stage2_0/m1_51541_n15864# 3.405966e-17
C1339 OUTN eeg_fd_ota_chopped_full2_0/stage2_0/m1_52341_n15864# 3.405966e-17
C1340 OUTN eeg_fd_ota_chopped_full2_0/stage2_0/m1_53141_n15864# 3.405966e-17
C1341 OUTN eeg_fd_ota_chopped_full2_0/stage2_0/m1_53941_n15864# 3.405966e-17
C1342 OUTN eeg_fd_ota_chopped_full2_0/stage2_0/m1_54741_n15864# 3.405966e-17
C1343 OUTN eeg_fd_ota_chopped_full2_0/stage2_0/m1_55541_n15864# 3.405966e-17
C1344 OUTN eeg_fd_ota_chopped_full2_0/stage2_0/m1_56341_n15864# 3.405966e-17
C1345 OUTN eeg_fd_ota_chopped_full2_0/stage2_0/m1_57141_n15864# 3.405966e-17
C1346 OUTN eeg_fd_ota_chopped_full2_0/stage2_0/m1_57941_n15864# 3.405966e-17
C1347 OUTN eeg_fd_ota_chopped_full2_0/stage2_0/m1_58741_n15864# 3.405966e-17
C1348 OUTN eeg_fd_ota_chopped_full2_0/stage2_0/m1_59541_n15864# 3.405966e-17
C1349 OUTN eeg_fd_ota_chopped_full2_0/stage2_0/m1_60341_n15864# 3.405966e-17
C1350 OUTN eeg_fd_ota_chopped_full2_0/stage2_0/m1_61141_n15864# 3.405966e-17
C1351 OUTN eeg_fd_ota_chopped_full2_0/stage2_0/m1_63941_n15864# 3.405966e-17
C1352 OUTN eeg_fd_ota_chopped_full2_0/stage2_0/m1_64741_n15864# 3.405966e-17
C1353 OUTN eeg_fd_ota_chopped_full2_0/stage2_0/m1_65541_n15864# 3.405966e-17
C1354 OUTN eeg_fd_ota_chopped_full2_0/stage2_0/m1_66341_n15864# 3.405966e-17
C1355 OUTN eeg_fd_ota_chopped_full2_0/stage2_0/m1_67141_n15864# 3.405966e-17
C1356 OUTN eeg_fd_ota_chopped_full2_0/stage2_0/m1_67941_n15864# 3.405966e-17
C1357 OUTN eeg_fd_ota_chopped_full2_0/stage2_0/m1_68741_n15864# 3.405966e-17
C1358 OUTN eeg_fd_ota_chopped_full2_0/stage2_0/m1_69541_n15864# 3.210496e-17
C1359 OUTN eeg_fd_ota_chopped_full2_0/stage2_0/m1_74341_n8557# 7.669250e-17
C1361 OUTP VCM_REF 1.032390e-14
C1362 OUTP VDD18 2.589536e-15
C1363 OUTP VSS 1.257606e-13
C1364 OUTP eeg_fd_ota_chopped_full2_0/stage2_0/N2N 2.003715e-16
C1365 OUTP eeg_fd_ota_chopped_full2_0/stage2_0/N2P 4.623865e-16
C1366 OUTP eeg_fd_ota_chopped_full2_0/stage2_0/VBP2 4.266178e-15
C1367 OUTP eeg_fd_ota_chopped_full2_0/stage2_0/VCM2 1.597490e-16
C1368 OUTP eeg_fd_ota_chopped_full2_0/stage2_0/m1_12966_n5928# 2.275473e-16
C1369 OUTP eeg_fd_ota_chopped_full2_0/stage2_0/m1_19941_n15864# 5.389540e-17
C1370 OUTP eeg_fd_ota_chopped_full2_0/stage2_0/m1_20341_n8557# 7.866144e-17
C1371 OUTP eeg_fd_ota_chopped_full2_0/stage2_0/m1_20741_n15864# 3.615601e-17
C1373 OUTP eeg_fd_ota_chopped_full2_0/stage2_0/m1_21541_n15864# 3.405966e-17
C1374 OUTP eeg_fd_ota_chopped_full2_0/stage2_0/m1_22341_n15864# 3.405966e-17
C1375 OUTP eeg_fd_ota_chopped_full2_0/stage2_0/m1_23141_n15864# 3.405966e-17
C1376 OUTP eeg_fd_ota_chopped_full2_0/stage2_0/m1_23941_n15864# 3.405966e-17
C1377 OUTP eeg_fd_ota_chopped_full2_0/stage2_0/m1_24741_n15864# 3.405966e-17
C1378 OUTP eeg_fd_ota_chopped_full2_0/stage2_0/m1_25541_n15864# 3.405966e-17
C1379 OUTP eeg_fd_ota_chopped_full2_0/stage2_0/m1_26341_n15864# 3.405966e-17
C1380 OUTP eeg_fd_ota_chopped_full2_0/stage2_0/m1_27141_n15864# 3.405966e-17
C1381 OUTP eeg_fd_ota_chopped_full2_0/stage2_0/m1_27941_n15864# 3.405966e-17
C1382 OUTP eeg_fd_ota_chopped_full2_0/stage2_0/m1_28741_n15864# 3.405966e-17
C1383 OUTP eeg_fd_ota_chopped_full2_0/stage2_0/m1_29541_n15864# 3.405966e-17
C1384 OUTP eeg_fd_ota_chopped_full2_0/stage2_0/m1_30341_n15864# 3.405966e-17
C1385 OUTP eeg_fd_ota_chopped_full2_0/stage2_0/m1_31141_n15864# 3.405966e-17
C1386 OUTP eeg_fd_ota_chopped_full2_0/stage2_0/m1_31941_n15864# 3.405966e-17
C1387 OUTP eeg_fd_ota_chopped_full2_0/stage2_0/m1_32741_n15864# 3.405966e-17
C1388 OUTP eeg_fd_ota_chopped_full2_0/stage2_0/m1_33541_n15864# 3.405966e-17
C1389 OUTP eeg_fd_ota_chopped_full2_0/stage2_0/m1_34341_n15864# 3.405966e-17
C1390 OUTP eeg_fd_ota_chopped_full2_0/stage2_0/m1_35141_n15864# 3.405966e-17
C1391 OUTP eeg_fd_ota_chopped_full2_0/stage2_0/m1_35941_n15864# 3.405966e-17
C1392 OUTP eeg_fd_ota_chopped_full2_0/stage2_0/m1_36741_n15864# 3.405966e-17
C1393 OUTP eeg_fd_ota_chopped_full2_0/stage2_0/m1_37541_n15864# 3.405966e-17
C1394 OUTP eeg_fd_ota_chopped_full2_0/stage2_0/m1_38341_n15864# 3.405966e-17
C1395 OUTP eeg_fd_ota_chopped_full2_0/stage2_0/m1_39141_n15864# 3.405966e-17
C1396 OUTP eeg_fd_ota_chopped_full2_0/stage2_0/m1_3966_n5928# 5.354613e-13
C1398 OUTP eeg_fd_ota_chopped_full2_0/stage2_0/m1_64341_n8557# 7.669250e-17
C1400 VCM_REF VDD18 7.328797e-16
C1401 VCM_REF VSS 1.680760e-14
C1402 VCM_REF eeg_fd_ota_chopped_full2_0/stage2_0/VBP2 1.491687e-16
C1403 VCM_REF eeg_fd_ota_chopped_full2_0/stage2_0/VCM2 1.478800e-14
C1405 VCM_REF eeg_fd_ota_chopped_full2_0/stage2_0/m1_70741_n8557# 7.669250e-17
C1407 VCM_REF eeg_fd_ota_chopped_full2_0/stage2_0/m1_80741_n8557# 7.669250e-17
C1408 VDD18 VSS 2.038645e-14
C1411 VDD18 eeg_fd_ota_chopped_full2_0/stage2_0/VBP2 1.191804e-14
C1412 VDD18 eeg_fd_ota_chopped_full2_0/stage2_0/VCM2 1.675041e-15
C1413 VSS eeg_fd_ota_chopped_full2_0/stage2_0/N2N 8.833751e-15
C1414 VSS eeg_fd_ota_chopped_full2_0/stage2_0/N2P 1.288700e-15
C1416 VSS eeg_fd_ota_chopped_full2_0/stage2_0/VCM2 1.093840e-16
C1417 eeg_fd_ota_chopped_full2_0/stage2_0/N2N VSS 6.392800e-15
C1418 eeg_fd_ota_chopped_full2_0/stage2_0/N2N eeg_fd_ota_chopped_full2_0/stage2_0/N2P 8.621393e-15
C1419 eeg_fd_ota_chopped_full2_0/stage2_0/N2N eeg_fd_ota_chopped_full2_0/stage2_0/VBP2 3.636257e-17
C1420 eeg_fd_ota_chopped_full2_0/stage2_0/N2N eeg_fd_ota_chopped_full2_0/stage2_0/VCM2 9.762040e-17
C1422 eeg_fd_ota_chopped_full2_0/stage2_0/N2P VSS 1.400660e-14
C1423 eeg_fd_ota_chopped_full2_0/stage2_0/N2P eeg_fd_ota_chopped_full2_0/stage2_0/VBP2 3.636256e-17
C1424 eeg_fd_ota_chopped_full2_0/stage2_0/N2P eeg_fd_ota_chopped_full2_0/stage2_0/VCM2 1.093840e-16
C1426 eeg_fd_ota_chopped_full2_0/stage2_0/VBP2 VSS 2.125980e-14
C1427 eeg_fd_ota_chopped_full2_0/stage2_0/VBP2 eeg_fd_ota_chopped_full2_0/stage2_0/VCM2 4.555847e-15
C1428 eeg_fd_ota_chopped_full2_0/stage2_0/VCM2 VSS 2.633740e-14
C1429 eeg_fd_ota_chopped_full2_0/stage2_0/VCM2 eeg_fd_ota_chopped_full2_0/stage2_0/m1_12966_n5928# 1.237053e-16
C1431 eeg_fd_ota_chopped_full2_0/stage2_0/VCM2 eeg_fd_ota_chopped_full2_0/stage2_0/m1_38741_n8557# 7.669250e-17
C1433 eeg_fd_ota_chopped_full2_0/stage2_0/VCM2 eeg_fd_ota_chopped_full2_0/stage2_0/m1_60741_n8557# 7.669250e-17
C1434 eeg_fd_ota_chopped_full2_0/stage2_0/m1_12966_n5928# VSS 3.339850e-14
C1435 eeg_fd_ota_chopped_full2_0/stage2_0/m1_12966_n5928# eeg_fd_ota_chopped_full2_0/stage2_0/m1_20341_n8557# 2.101150e-17
C1436 eeg_fd_ota_chopped_full2_0/stage2_0/m1_12966_n5928# eeg_fd_ota_chopped_full2_0/stage2_0/m1_21141_n8557# 2.101150e-17
C1437 eeg_fd_ota_chopped_full2_0/stage2_0/m1_12966_n5928# eeg_fd_ota_chopped_full2_0/stage2_0/m1_21941_n8557# 2.101150e-17
C1438 eeg_fd_ota_chopped_full2_0/stage2_0/m1_12966_n5928# eeg_fd_ota_chopped_full2_0/stage2_0/m1_22741_n8557# 2.101150e-17
C1439 eeg_fd_ota_chopped_full2_0/stage2_0/m1_12966_n5928# eeg_fd_ota_chopped_full2_0/stage2_0/m1_23541_n8557# 2.101150e-17
C1440 eeg_fd_ota_chopped_full2_0/stage2_0/m1_12966_n5928# eeg_fd_ota_chopped_full2_0/stage2_0/m1_24341_n8557# 2.101150e-17
C1441 eeg_fd_ota_chopped_full2_0/stage2_0/m1_12966_n5928# eeg_fd_ota_chopped_full2_0/stage2_0/m1_25141_n8557# 2.101150e-17
C1442 eeg_fd_ota_chopped_full2_0/stage2_0/m1_12966_n5928# eeg_fd_ota_chopped_full2_0/stage2_0/m1_25941_n8557# 2.101150e-17
C1443 eeg_fd_ota_chopped_full2_0/stage2_0/m1_12966_n5928# eeg_fd_ota_chopped_full2_0/stage2_0/m1_26741_n8557# 2.101150e-17
C1444 eeg_fd_ota_chopped_full2_0/stage2_0/m1_12966_n5928# eeg_fd_ota_chopped_full2_0/stage2_0/m1_27541_n8557# 2.101150e-17
C1445 eeg_fd_ota_chopped_full2_0/stage2_0/m1_12966_n5928# eeg_fd_ota_chopped_full2_0/stage2_0/m1_28341_n8557# 2.101150e-17
C1446 eeg_fd_ota_chopped_full2_0/stage2_0/m1_12966_n5928# eeg_fd_ota_chopped_full2_0/stage2_0/m1_29141_n8557# 2.101150e-17
C1447 eeg_fd_ota_chopped_full2_0/stage2_0/m1_12966_n5928# eeg_fd_ota_chopped_full2_0/stage2_0/m1_29941_n8557# 2.101150e-17
C1448 eeg_fd_ota_chopped_full2_0/stage2_0/m1_12966_n5928# eeg_fd_ota_chopped_full2_0/stage2_0/m1_30741_n8557# 2.101150e-17
C1449 eeg_fd_ota_chopped_full2_0/stage2_0/m1_12966_n5928# eeg_fd_ota_chopped_full2_0/stage2_0/m1_31541_n8557# 2.101150e-17
C1450 eeg_fd_ota_chopped_full2_0/stage2_0/m1_12966_n5928# eeg_fd_ota_chopped_full2_0/stage2_0/m1_32341_n8557# 2.101150e-17
C1451 eeg_fd_ota_chopped_full2_0/stage2_0/m1_12966_n5928# eeg_fd_ota_chopped_full2_0/stage2_0/m1_33141_n8557# 2.101150e-17
C1452 eeg_fd_ota_chopped_full2_0/stage2_0/m1_12966_n5928# eeg_fd_ota_chopped_full2_0/stage2_0/m1_33941_n8557# 2.101150e-17
C1453 eeg_fd_ota_chopped_full2_0/stage2_0/m1_12966_n5928# eeg_fd_ota_chopped_full2_0/stage2_0/m1_34741_n8557# 2.101150e-17
C1454 eeg_fd_ota_chopped_full2_0/stage2_0/m1_12966_n5928# eeg_fd_ota_chopped_full2_0/stage2_0/m1_35541_n8557# 2.101150e-17
C1455 eeg_fd_ota_chopped_full2_0/stage2_0/m1_12966_n5928# eeg_fd_ota_chopped_full2_0/stage2_0/m1_36341_n8557# 2.101150e-17
C1456 eeg_fd_ota_chopped_full2_0/stage2_0/m1_12966_n5928# eeg_fd_ota_chopped_full2_0/stage2_0/m1_37141_n8557# 2.101150e-17
C1457 eeg_fd_ota_chopped_full2_0/stage2_0/m1_12966_n5928# eeg_fd_ota_chopped_full2_0/stage2_0/m1_37941_n8557# 2.101150e-17
C1458 eeg_fd_ota_chopped_full2_0/stage2_0/m1_12966_n5928# eeg_fd_ota_chopped_full2_0/stage2_0/m1_38741_n8557# 2.101150e-17
C1459 eeg_fd_ota_chopped_full2_0/stage2_0/m1_12966_n5928# eeg_fd_ota_chopped_full2_0/stage2_0/m1_3966_n5928# 2.125553e-15
C1460 eeg_fd_ota_chopped_full2_0/stage2_0/m1_12966_n5928# eeg_fd_ota_chopped_full2_0/stage2_0/m1_42341_n8557# 2.101150e-17
C1461 eeg_fd_ota_chopped_full2_0/stage2_0/m1_12966_n5928# eeg_fd_ota_chopped_full2_0/stage2_0/m1_43141_n8557# 2.101150e-17
C1462 eeg_fd_ota_chopped_full2_0/stage2_0/m1_12966_n5928# eeg_fd_ota_chopped_full2_0/stage2_0/m1_43941_n8557# 2.101150e-17
C1463 eeg_fd_ota_chopped_full2_0/stage2_0/m1_12966_n5928# eeg_fd_ota_chopped_full2_0/stage2_0/m1_44741_n8557# 2.101150e-17
C1464 eeg_fd_ota_chopped_full2_0/stage2_0/m1_12966_n5928# eeg_fd_ota_chopped_full2_0/stage2_0/m1_45541_n8557# 2.101150e-17
C1465 eeg_fd_ota_chopped_full2_0/stage2_0/m1_12966_n5928# eeg_fd_ota_chopped_full2_0/stage2_0/m1_46341_n8557# 2.101150e-17
C1468 eeg_fd_ota_chopped_full2_0/stage2_0/m1_12966_n5928# eeg_fd_ota_chopped_full2_0/stage2_0/m1_47941_n8557# 2.101150e-17
C1469 eeg_fd_ota_chopped_full2_0/stage2_0/m1_12966_n5928# eeg_fd_ota_chopped_full2_0/stage2_0/m1_48341_n15864# 2.092590e-17
C1470 eeg_fd_ota_chopped_full2_0/stage2_0/m1_12966_n5928# eeg_fd_ota_chopped_full2_0/stage2_0/m1_48741_n8557# 2.101150e-17
C1471 eeg_fd_ota_chopped_full2_0/stage2_0/m1_12966_n5928# eeg_fd_ota_chopped_full2_0/stage2_0/m1_49141_n15864# 2.092590e-17
C1472 eeg_fd_ota_chopped_full2_0/stage2_0/m1_12966_n5928# eeg_fd_ota_chopped_full2_0/stage2_0/m1_49541_n8557# 2.101150e-17
C1473 eeg_fd_ota_chopped_full2_0/stage2_0/m1_12966_n5928# eeg_fd_ota_chopped_full2_0/stage2_0/m1_49941_n15864# 2.092590e-17
C1474 eeg_fd_ota_chopped_full2_0/stage2_0/m1_12966_n5928# eeg_fd_ota_chopped_full2_0/stage2_0/m1_50341_n8557# 2.101150e-17
C1475 eeg_fd_ota_chopped_full2_0/stage2_0/m1_12966_n5928# eeg_fd_ota_chopped_full2_0/stage2_0/m1_50741_n15864# 2.092590e-17
C1476 eeg_fd_ota_chopped_full2_0/stage2_0/m1_12966_n5928# eeg_fd_ota_chopped_full2_0/stage2_0/m1_51141_n8557# 2.101150e-17
C1477 eeg_fd_ota_chopped_full2_0/stage2_0/m1_12966_n5928# eeg_fd_ota_chopped_full2_0/stage2_0/m1_51541_n15864# 2.092590e-17
C1478 eeg_fd_ota_chopped_full2_0/stage2_0/m1_12966_n5928# eeg_fd_ota_chopped_full2_0/stage2_0/m1_51941_n8557# 2.101150e-17
C1479 eeg_fd_ota_chopped_full2_0/stage2_0/m1_12966_n5928# eeg_fd_ota_chopped_full2_0/stage2_0/m1_52341_n15864# 2.092590e-17
C1480 eeg_fd_ota_chopped_full2_0/stage2_0/m1_12966_n5928# eeg_fd_ota_chopped_full2_0/stage2_0/m1_52741_n8557# 2.101150e-17
C1481 eeg_fd_ota_chopped_full2_0/stage2_0/m1_12966_n5928# eeg_fd_ota_chopped_full2_0/stage2_0/m1_53141_n15864# 2.092590e-17
C1482 eeg_fd_ota_chopped_full2_0/stage2_0/m1_12966_n5928# eeg_fd_ota_chopped_full2_0/stage2_0/m1_53541_n8557# 2.101150e-17
C1483 eeg_fd_ota_chopped_full2_0/stage2_0/m1_12966_n5928# eeg_fd_ota_chopped_full2_0/stage2_0/m1_53941_n15864# 2.092590e-17
C1484 eeg_fd_ota_chopped_full2_0/stage2_0/m1_12966_n5928# eeg_fd_ota_chopped_full2_0/stage2_0/m1_54341_n8557# 2.101150e-17
C1485 eeg_fd_ota_chopped_full2_0/stage2_0/m1_12966_n5928# eeg_fd_ota_chopped_full2_0/stage2_0/m1_54741_n15864# 2.092590e-17
C1486 eeg_fd_ota_chopped_full2_0/stage2_0/m1_12966_n5928# eeg_fd_ota_chopped_full2_0/stage2_0/m1_55141_n8557# 2.101150e-17
C1487 eeg_fd_ota_chopped_full2_0/stage2_0/m1_12966_n5928# eeg_fd_ota_chopped_full2_0/stage2_0/m1_55541_n15864# 2.092590e-17
C1488 eeg_fd_ota_chopped_full2_0/stage2_0/m1_12966_n5928# eeg_fd_ota_chopped_full2_0/stage2_0/m1_55941_n8557# 2.101150e-17
C1489 eeg_fd_ota_chopped_full2_0/stage2_0/m1_12966_n5928# eeg_fd_ota_chopped_full2_0/stage2_0/m1_56341_n15864# 2.092590e-17
C1490 eeg_fd_ota_chopped_full2_0/stage2_0/m1_12966_n5928# eeg_fd_ota_chopped_full2_0/stage2_0/m1_56741_n8557# 2.375360e-17
C1491 eeg_fd_ota_chopped_full2_0/stage2_0/m1_12966_n5928# eeg_fd_ota_chopped_full2_0/stage2_0/m1_57141_n15864# 3.119110e-17
C1492 eeg_fd_ota_chopped_full2_0/stage2_0/m1_12966_n5928# eeg_fd_ota_chopped_full2_0/stage2_0/m1_57541_n8557# 3.855600e-17
C1493 eeg_fd_ota_chopped_full2_0/stage2_0/m1_12966_n5928# eeg_fd_ota_chopped_full2_0/stage2_0/m1_57941_n15864# 5.436140e-17
C1494 eeg_fd_ota_chopped_full2_0/stage2_0/m1_12966_n5928# eeg_fd_ota_chopped_full2_0/stage2_0/m1_58341_n8557# 1.191254e-16
C1495 eeg_fd_ota_chopped_full2_0/stage2_0/m1_12966_n5928# eeg_fd_ota_chopped_full2_0/stage2_0/m1_58741_n15864# 1.705141e-16
C1496 eeg_fd_ota_chopped_full2_0/stage2_0/m1_12966_n5928# eeg_fd_ota_chopped_full2_0/stage2_0/m1_59141_n8557# 9.883835e-17
C1497 eeg_fd_ota_chopped_full2_0/stage2_0/m1_12966_n5928# eeg_fd_ota_chopped_full2_0/stage2_0/m1_59541_n15864# 5.436140e-17
C1499 eeg_fd_ota_chopped_full2_0/stage2_0/m1_12966_n5928# eeg_fd_ota_chopped_full2_0/stage2_0/m1_60341_n15864# 3.119110e-17
C1501 eeg_fd_ota_chopped_full2_0/stage2_0/m1_12966_n5928# eeg_fd_ota_chopped_full2_0/stage2_0/m1_61141_n15864# 2.092590e-17
C1502 eeg_fd_ota_chopped_full2_0/stage2_0/m1_12966_n5928# eeg_fd_ota_chopped_full2_0/stage2_0/m1_63941_n15864# 2.092590e-17
C1503 eeg_fd_ota_chopped_full2_0/stage2_0/m1_12966_n5928# eeg_fd_ota_chopped_full2_0/stage2_0/m1_64741_n15864# 2.092590e-17
C1504 eeg_fd_ota_chopped_full2_0/stage2_0/m1_12966_n5928# eeg_fd_ota_chopped_full2_0/stage2_0/m1_65541_n15864# 2.092590e-17
C1505 eeg_fd_ota_chopped_full2_0/stage2_0/m1_12966_n5928# eeg_fd_ota_chopped_full2_0/stage2_0/m1_66341_n15864# 2.092590e-17
C1506 eeg_fd_ota_chopped_full2_0/stage2_0/m1_12966_n5928# eeg_fd_ota_chopped_full2_0/stage2_0/m1_67141_n15864# 2.092590e-17
C1507 eeg_fd_ota_chopped_full2_0/stage2_0/m1_12966_n5928# eeg_fd_ota_chopped_full2_0/stage2_0/m1_67941_n15864# 2.092590e-17
C1508 eeg_fd_ota_chopped_full2_0/stage2_0/m1_12966_n5928# eeg_fd_ota_chopped_full2_0/stage2_0/m1_68741_n15864# 2.092590e-17
C1510 eeg_fd_ota_chopped_full2_0/stage2_0/m1_19941_n15864# VSS 4.702790e-16
C1511 eeg_fd_ota_chopped_full2_0/stage2_0/m1_19941_n15864# eeg_fd_ota_chopped_full2_0/stage2_0/m1_20741_n15864# 6.789059e-17
C1513 eeg_fd_ota_chopped_full2_0/stage2_0/m1_20341_n8557# VSS 4.623640e-16
C1514 eeg_fd_ota_chopped_full2_0/stage2_0/m1_20341_n8557# eeg_fd_ota_chopped_full2_0/stage2_0/m1_21141_n8557# 6.789040e-17
C1516 eeg_fd_ota_chopped_full2_0/stage2_0/m1_20741_n15864# VSS 4.190540e-16
C1517 eeg_fd_ota_chopped_full2_0/stage2_0/m1_20741_n15864# eeg_fd_ota_chopped_full2_0/stage2_0/m1_21541_n15864# 6.789049e-17
C1518 eeg_fd_ota_chopped_full2_0/stage2_0/m1_20741_n15864# eeg_fd_ota_chopped_full2_0/stage2_0/m1_3966_n5928# 2.092590e-17
C1519 eeg_fd_ota_chopped_full2_0/stage2_0/m1_21141_n8557# VSS 4.190540e-16
C1520 eeg_fd_ota_chopped_full2_0/stage2_0/m1_21141_n8557# eeg_fd_ota_chopped_full2_0/stage2_0/m1_21941_n8557# 6.789040e-17
C1522 eeg_fd_ota_chopped_full2_0/stage2_0/m1_21541_n15864# VSS 4.190540e-16
C1523 eeg_fd_ota_chopped_full2_0/stage2_0/m1_21541_n15864# eeg_fd_ota_chopped_full2_0/stage2_0/m1_22341_n15864# 6.789049e-17
C1524 eeg_fd_ota_chopped_full2_0/stage2_0/m1_21541_n15864# eeg_fd_ota_chopped_full2_0/stage2_0/m1_3966_n5928# 2.092590e-17
C1525 eeg_fd_ota_chopped_full2_0/stage2_0/m1_21941_n8557# VSS 4.190540e-16
C1526 eeg_fd_ota_chopped_full2_0/stage2_0/m1_21941_n8557# eeg_fd_ota_chopped_full2_0/stage2_0/m1_22741_n8557# 6.789040e-17
C1528 eeg_fd_ota_chopped_full2_0/stage2_0/m1_22341_n15864# VSS 4.190540e-16
C1529 eeg_fd_ota_chopped_full2_0/stage2_0/m1_22341_n15864# eeg_fd_ota_chopped_full2_0/stage2_0/m1_23141_n15864# 6.789049e-17
C1530 eeg_fd_ota_chopped_full2_0/stage2_0/m1_22341_n15864# eeg_fd_ota_chopped_full2_0/stage2_0/m1_3966_n5928# 2.092590e-17
C1531 eeg_fd_ota_chopped_full2_0/stage2_0/m1_22741_n8557# VSS 4.190540e-16
C1532 eeg_fd_ota_chopped_full2_0/stage2_0/m1_22741_n8557# eeg_fd_ota_chopped_full2_0/stage2_0/m1_23541_n8557# 6.789044e-17
C1534 eeg_fd_ota_chopped_full2_0/stage2_0/m1_23141_n15864# VSS 4.190540e-16
C1535 eeg_fd_ota_chopped_full2_0/stage2_0/m1_23141_n15864# eeg_fd_ota_chopped_full2_0/stage2_0/m1_23941_n15864# 6.789049e-17
C1536 eeg_fd_ota_chopped_full2_0/stage2_0/m1_23141_n15864# eeg_fd_ota_chopped_full2_0/stage2_0/m1_3966_n5928# 2.092590e-17
C1537 eeg_fd_ota_chopped_full2_0/stage2_0/m1_23541_n8557# VSS 4.190540e-16
C1538 eeg_fd_ota_chopped_full2_0/stage2_0/m1_23541_n8557# eeg_fd_ota_chopped_full2_0/stage2_0/m1_24341_n8557# 6.789040e-17
C1540 eeg_fd_ota_chopped_full2_0/stage2_0/m1_23941_n15864# VSS 4.190540e-16
C1541 eeg_fd_ota_chopped_full2_0/stage2_0/m1_23941_n15864# eeg_fd_ota_chopped_full2_0/stage2_0/m1_24741_n15864# 6.789049e-17
C1542 eeg_fd_ota_chopped_full2_0/stage2_0/m1_23941_n15864# eeg_fd_ota_chopped_full2_0/stage2_0/m1_3966_n5928# 2.092590e-17
C1543 eeg_fd_ota_chopped_full2_0/stage2_0/m1_24341_n8557# VSS 4.190540e-16
C1544 eeg_fd_ota_chopped_full2_0/stage2_0/m1_24341_n8557# eeg_fd_ota_chopped_full2_0/stage2_0/m1_25141_n8557# 6.789040e-17
C1546 eeg_fd_ota_chopped_full2_0/stage2_0/m1_24741_n15864# VSS 4.190540e-16
C1547 eeg_fd_ota_chopped_full2_0/stage2_0/m1_24741_n15864# eeg_fd_ota_chopped_full2_0/stage2_0/m1_25541_n15864# 6.789049e-17
C1548 eeg_fd_ota_chopped_full2_0/stage2_0/m1_24741_n15864# eeg_fd_ota_chopped_full2_0/stage2_0/m1_3966_n5928# 2.092590e-17
C1549 eeg_fd_ota_chopped_full2_0/stage2_0/m1_25141_n8557# VSS 4.190540e-16
C1550 eeg_fd_ota_chopped_full2_0/stage2_0/m1_25141_n8557# eeg_fd_ota_chopped_full2_0/stage2_0/m1_25941_n8557# 6.789040e-17
C1552 eeg_fd_ota_chopped_full2_0/stage2_0/m1_25541_n15864# VSS 4.190540e-16
C1553 eeg_fd_ota_chopped_full2_0/stage2_0/m1_25541_n15864# eeg_fd_ota_chopped_full2_0/stage2_0/m1_26341_n15864# 6.789059e-17
C1554 eeg_fd_ota_chopped_full2_0/stage2_0/m1_25541_n15864# eeg_fd_ota_chopped_full2_0/stage2_0/m1_3966_n5928# 2.092590e-17
C1555 eeg_fd_ota_chopped_full2_0/stage2_0/m1_25941_n8557# VSS 4.190540e-16
C1556 eeg_fd_ota_chopped_full2_0/stage2_0/m1_25941_n8557# eeg_fd_ota_chopped_full2_0/stage2_0/m1_26741_n8557# 6.789040e-17
C1558 eeg_fd_ota_chopped_full2_0/stage2_0/m1_26341_n15864# VSS 4.190540e-16
C1559 eeg_fd_ota_chopped_full2_0/stage2_0/m1_26341_n15864# eeg_fd_ota_chopped_full2_0/stage2_0/m1_27141_n15864# 6.789049e-17
C1560 eeg_fd_ota_chopped_full2_0/stage2_0/m1_26341_n15864# eeg_fd_ota_chopped_full2_0/stage2_0/m1_3966_n5928# 2.092590e-17
C1561 eeg_fd_ota_chopped_full2_0/stage2_0/m1_26741_n8557# VSS 4.190540e-16
C1562 eeg_fd_ota_chopped_full2_0/stage2_0/m1_26741_n8557# eeg_fd_ota_chopped_full2_0/stage2_0/m1_27541_n8557# 6.789040e-17
C1564 eeg_fd_ota_chopped_full2_0/stage2_0/m1_27141_n15864# VSS 4.190540e-16
C1565 eeg_fd_ota_chopped_full2_0/stage2_0/m1_27141_n15864# eeg_fd_ota_chopped_full2_0/stage2_0/m1_27941_n15864# 6.789049e-17
C1566 eeg_fd_ota_chopped_full2_0/stage2_0/m1_27141_n15864# eeg_fd_ota_chopped_full2_0/stage2_0/m1_3966_n5928# 2.092590e-17
C1567 eeg_fd_ota_chopped_full2_0/stage2_0/m1_27541_n8557# VSS 4.190540e-16
C1568 eeg_fd_ota_chopped_full2_0/stage2_0/m1_27541_n8557# eeg_fd_ota_chopped_full2_0/stage2_0/m1_28341_n8557# 6.789040e-17
C1570 eeg_fd_ota_chopped_full2_0/stage2_0/m1_27941_n15864# VSS 4.190540e-16
C1571 eeg_fd_ota_chopped_full2_0/stage2_0/m1_27941_n15864# eeg_fd_ota_chopped_full2_0/stage2_0/m1_28741_n15864# 6.789049e-17
C1572 eeg_fd_ota_chopped_full2_0/stage2_0/m1_27941_n15864# eeg_fd_ota_chopped_full2_0/stage2_0/m1_3966_n5928# 2.092590e-17
C1573 eeg_fd_ota_chopped_full2_0/stage2_0/m1_28341_n8557# VSS 4.190540e-16
C1574 eeg_fd_ota_chopped_full2_0/stage2_0/m1_28341_n8557# eeg_fd_ota_chopped_full2_0/stage2_0/m1_29141_n8557# 6.789044e-17
C1576 eeg_fd_ota_chopped_full2_0/stage2_0/m1_28741_n15864# VSS 4.190540e-16
C1577 eeg_fd_ota_chopped_full2_0/stage2_0/m1_28741_n15864# eeg_fd_ota_chopped_full2_0/stage2_0/m1_29541_n15864# 6.789049e-17
C1578 eeg_fd_ota_chopped_full2_0/stage2_0/m1_28741_n15864# eeg_fd_ota_chopped_full2_0/stage2_0/m1_3966_n5928# 2.366810e-17
C1579 eeg_fd_ota_chopped_full2_0/stage2_0/m1_29141_n8557# VSS 4.190540e-16
C1580 eeg_fd_ota_chopped_full2_0/stage2_0/m1_29141_n8557# eeg_fd_ota_chopped_full2_0/stage2_0/m1_29941_n8557# 6.789040e-17
C1582 eeg_fd_ota_chopped_full2_0/stage2_0/m1_29541_n15864# VSS 4.190540e-16
C1583 eeg_fd_ota_chopped_full2_0/stage2_0/m1_29541_n15864# eeg_fd_ota_chopped_full2_0/stage2_0/m1_30341_n15864# 6.789049e-17
C1584 eeg_fd_ota_chopped_full2_0/stage2_0/m1_29541_n15864# eeg_fd_ota_chopped_full2_0/stage2_0/m1_3966_n5928# 3.847050e-17
C1585 eeg_fd_ota_chopped_full2_0/stage2_0/m1_29941_n8557# VSS 4.190540e-16
C1586 eeg_fd_ota_chopped_full2_0/stage2_0/m1_29941_n8557# eeg_fd_ota_chopped_full2_0/stage2_0/m1_30741_n8557# 6.789040e-17
C1587 eeg_fd_ota_chopped_full2_0/stage2_0/m1_29941_n8557# eeg_fd_ota_chopped_full2_0/stage2_0/m1_3966_n5928# 3.505816e-17
C1588 eeg_fd_ota_chopped_full2_0/stage2_0/m1_30341_n15864# VSS 4.190540e-16
C1589 eeg_fd_ota_chopped_full2_0/stage2_0/m1_30341_n15864# eeg_fd_ota_chopped_full2_0/stage2_0/m1_31141_n15864# 6.789049e-17
C1590 eeg_fd_ota_chopped_full2_0/stage2_0/m1_30341_n15864# eeg_fd_ota_chopped_full2_0/stage2_0/m1_3966_n5928# 1.128845e-16
C1591 eeg_fd_ota_chopped_full2_0/stage2_0/m1_30741_n8557# VSS 4.190540e-16
C1592 eeg_fd_ota_chopped_full2_0/stage2_0/m1_30741_n8557# eeg_fd_ota_chopped_full2_0/stage2_0/m1_31541_n8557# 6.789040e-17
C1593 eeg_fd_ota_chopped_full2_0/stage2_0/m1_30741_n8557# eeg_fd_ota_chopped_full2_0/stage2_0/m1_3966_n5928# 1.758861e-16
C1594 eeg_fd_ota_chopped_full2_0/stage2_0/m1_31141_n15864# VSS 4.190540e-16
C1595 eeg_fd_ota_chopped_full2_0/stage2_0/m1_31141_n15864# eeg_fd_ota_chopped_full2_0/stage2_0/m1_31941_n15864# 6.789059e-17
C1596 eeg_fd_ota_chopped_full2_0/stage2_0/m1_31141_n15864# eeg_fd_ota_chopped_full2_0/stage2_0/m1_3966_n5928# 1.128845e-16
C1597 eeg_fd_ota_chopped_full2_0/stage2_0/m1_31541_n8557# VSS 4.190540e-16
C1598 eeg_fd_ota_chopped_full2_0/stage2_0/m1_31541_n8557# eeg_fd_ota_chopped_full2_0/stage2_0/m1_32341_n8557# 6.789040e-17
C1599 eeg_fd_ota_chopped_full2_0/stage2_0/m1_31541_n8557# eeg_fd_ota_chopped_full2_0/stage2_0/m1_3966_n5928# 3.343551e-17
C1600 eeg_fd_ota_chopped_full2_0/stage2_0/m1_31941_n15864# VSS 4.190540e-16
C1601 eeg_fd_ota_chopped_full2_0/stage2_0/m1_31941_n15864# eeg_fd_ota_chopped_full2_0/stage2_0/m1_32741_n15864# 6.789049e-17
C1602 eeg_fd_ota_chopped_full2_0/stage2_0/m1_31941_n15864# eeg_fd_ota_chopped_full2_0/stage2_0/m1_3966_n5928# 3.847050e-17
C1603 eeg_fd_ota_chopped_full2_0/stage2_0/m1_32341_n8557# VSS 4.190540e-16
C1604 eeg_fd_ota_chopped_full2_0/stage2_0/m1_32341_n8557# eeg_fd_ota_chopped_full2_0/stage2_0/m1_33141_n8557# 6.789040e-17
C1606 eeg_fd_ota_chopped_full2_0/stage2_0/m1_32741_n15864# VSS 4.190540e-16
C1607 eeg_fd_ota_chopped_full2_0/stage2_0/m1_32741_n15864# eeg_fd_ota_chopped_full2_0/stage2_0/m1_33541_n15864# 6.789049e-17
C1608 eeg_fd_ota_chopped_full2_0/stage2_0/m1_32741_n15864# eeg_fd_ota_chopped_full2_0/stage2_0/m1_3966_n5928# 2.366810e-17
C1609 eeg_fd_ota_chopped_full2_0/stage2_0/m1_33141_n8557# VSS 4.190540e-16
C1610 eeg_fd_ota_chopped_full2_0/stage2_0/m1_33141_n8557# eeg_fd_ota_chopped_full2_0/stage2_0/m1_33941_n8557# 6.789040e-17
C1611 eeg_fd_ota_chopped_full2_0/stage2_0/m1_33541_n15864# VSS 4.190540e-16
C1612 eeg_fd_ota_chopped_full2_0/stage2_0/m1_33541_n15864# eeg_fd_ota_chopped_full2_0/stage2_0/m1_34341_n15864# 6.789049e-17
C1613 eeg_fd_ota_chopped_full2_0/stage2_0/m1_33541_n15864# eeg_fd_ota_chopped_full2_0/stage2_0/m1_3966_n5928# 2.092590e-17
C1614 eeg_fd_ota_chopped_full2_0/stage2_0/m1_33941_n8557# VSS 4.190540e-16
C1615 eeg_fd_ota_chopped_full2_0/stage2_0/m1_33941_n8557# eeg_fd_ota_chopped_full2_0/stage2_0/m1_34741_n8557# 6.789044e-17
C1616 eeg_fd_ota_chopped_full2_0/stage2_0/m1_34341_n15864# VSS 4.190540e-16
C1617 eeg_fd_ota_chopped_full2_0/stage2_0/m1_34341_n15864# eeg_fd_ota_chopped_full2_0/stage2_0/m1_35141_n15864# 6.789049e-17
C1618 eeg_fd_ota_chopped_full2_0/stage2_0/m1_34341_n15864# eeg_fd_ota_chopped_full2_0/stage2_0/m1_3966_n5928# 2.092590e-17
C1619 eeg_fd_ota_chopped_full2_0/stage2_0/m1_34741_n8557# VSS 4.190540e-16
C1620 eeg_fd_ota_chopped_full2_0/stage2_0/m1_34741_n8557# eeg_fd_ota_chopped_full2_0/stage2_0/m1_35541_n8557# 6.789040e-17
C1621 eeg_fd_ota_chopped_full2_0/stage2_0/m1_35141_n15864# VSS 4.190540e-16
C1622 eeg_fd_ota_chopped_full2_0/stage2_0/m1_35141_n15864# eeg_fd_ota_chopped_full2_0/stage2_0/m1_35941_n15864# 6.789049e-17
C1623 eeg_fd_ota_chopped_full2_0/stage2_0/m1_35141_n15864# eeg_fd_ota_chopped_full2_0/stage2_0/m1_3966_n5928# 2.092590e-17
C1624 eeg_fd_ota_chopped_full2_0/stage2_0/m1_35541_n8557# VSS 4.190540e-16
C1625 eeg_fd_ota_chopped_full2_0/stage2_0/m1_35541_n8557# eeg_fd_ota_chopped_full2_0/stage2_0/m1_36341_n8557# 6.789040e-17
C1626 eeg_fd_ota_chopped_full2_0/stage2_0/m1_35941_n15864# VSS 4.190540e-16
C1627 eeg_fd_ota_chopped_full2_0/stage2_0/m1_35941_n15864# eeg_fd_ota_chopped_full2_0/stage2_0/m1_36741_n15864# 6.789049e-17
C1628 eeg_fd_ota_chopped_full2_0/stage2_0/m1_35941_n15864# eeg_fd_ota_chopped_full2_0/stage2_0/m1_3966_n5928# 2.092590e-17
C1629 eeg_fd_ota_chopped_full2_0/stage2_0/m1_36341_n8557# VSS 4.190540e-16
C1630 eeg_fd_ota_chopped_full2_0/stage2_0/m1_36341_n8557# eeg_fd_ota_chopped_full2_0/stage2_0/m1_37141_n8557# 6.789040e-17
C1631 eeg_fd_ota_chopped_full2_0/stage2_0/m1_36741_n15864# VSS 4.190540e-16
C1632 eeg_fd_ota_chopped_full2_0/stage2_0/m1_36741_n15864# eeg_fd_ota_chopped_full2_0/stage2_0/m1_37541_n15864# 6.789059e-17
C1633 eeg_fd_ota_chopped_full2_0/stage2_0/m1_36741_n15864# eeg_fd_ota_chopped_full2_0/stage2_0/m1_3966_n5928# 2.092590e-17
C1634 eeg_fd_ota_chopped_full2_0/stage2_0/m1_37141_n8557# VSS 4.190540e-16
C1635 eeg_fd_ota_chopped_full2_0/stage2_0/m1_37141_n8557# eeg_fd_ota_chopped_full2_0/stage2_0/m1_37941_n8557# 6.789040e-17
C1636 eeg_fd_ota_chopped_full2_0/stage2_0/m1_37541_n15864# VSS 4.190540e-16
C1637 eeg_fd_ota_chopped_full2_0/stage2_0/m1_37541_n15864# eeg_fd_ota_chopped_full2_0/stage2_0/m1_38341_n15864# 6.789049e-17
C1638 eeg_fd_ota_chopped_full2_0/stage2_0/m1_37541_n15864# eeg_fd_ota_chopped_full2_0/stage2_0/m1_3966_n5928# 2.092590e-17
C1639 eeg_fd_ota_chopped_full2_0/stage2_0/m1_37941_n8557# VSS 4.190540e-16
C1640 eeg_fd_ota_chopped_full2_0/stage2_0/m1_37941_n8557# eeg_fd_ota_chopped_full2_0/stage2_0/m1_38741_n8557# 6.789040e-17
C1641 eeg_fd_ota_chopped_full2_0/stage2_0/m1_38341_n15864# VSS 4.190540e-16
C1642 eeg_fd_ota_chopped_full2_0/stage2_0/m1_38341_n15864# eeg_fd_ota_chopped_full2_0/stage2_0/m1_39141_n15864# 6.789049e-17
C1643 eeg_fd_ota_chopped_full2_0/stage2_0/m1_38341_n15864# eeg_fd_ota_chopped_full2_0/stage2_0/m1_3966_n5928# 2.092590e-17
C1644 eeg_fd_ota_chopped_full2_0/stage2_0/m1_38741_n8557# VSS 4.623640e-16
C1645 eeg_fd_ota_chopped_full2_0/stage2_0/m1_39141_n15864# VSS 4.702790e-16
C1646 eeg_fd_ota_chopped_full2_0/stage2_0/m1_39141_n15864# eeg_fd_ota_chopped_full2_0/stage2_0/m1_3966_n5928# 2.092590e-17
C1647 eeg_fd_ota_chopped_full2_0/stage2_0/m1_3966_n5928# VSS 2.574590e-14
C1649 eeg_fd_ota_chopped_full2_0/stage2_0/m1_41941_n15864# VSS 4.702790e-16
C1650 eeg_fd_ota_chopped_full2_0/stage2_0/m1_41941_n15864# eeg_fd_ota_chopped_full2_0/stage2_0/m1_42741_n15864# 6.789049e-17
C1651 eeg_fd_ota_chopped_full2_0/stage2_0/m1_42341_n8557# VSS 4.623640e-16
C1652 eeg_fd_ota_chopped_full2_0/stage2_0/m1_42341_n8557# eeg_fd_ota_chopped_full2_0/stage2_0/m1_43141_n8557# 6.789044e-17
C1653 eeg_fd_ota_chopped_full2_0/stage2_0/m1_42741_n15864# VSS 4.190540e-16
C1654 eeg_fd_ota_chopped_full2_0/stage2_0/m1_42741_n15864# eeg_fd_ota_chopped_full2_0/stage2_0/m1_43541_n15864# 6.789049e-17
C1655 eeg_fd_ota_chopped_full2_0/stage2_0/m1_43141_n8557# VSS 4.190540e-16
C1656 eeg_fd_ota_chopped_full2_0/stage2_0/m1_43141_n8557# eeg_fd_ota_chopped_full2_0/stage2_0/m1_43941_n8557# 6.789040e-17
C1657 eeg_fd_ota_chopped_full2_0/stage2_0/m1_43541_n15864# VSS 4.190540e-16
C1658 eeg_fd_ota_chopped_full2_0/stage2_0/m1_43541_n15864# eeg_fd_ota_chopped_full2_0/stage2_0/m1_44341_n15864# 6.789049e-17
C1659 eeg_fd_ota_chopped_full2_0/stage2_0/m1_43941_n8557# VSS 4.190540e-16
C1660 eeg_fd_ota_chopped_full2_0/stage2_0/m1_43941_n8557# eeg_fd_ota_chopped_full2_0/stage2_0/m1_44741_n8557# 6.789040e-17
C1661 eeg_fd_ota_chopped_full2_0/stage2_0/m1_44341_n15864# VSS 4.190540e-16
C1662 eeg_fd_ota_chopped_full2_0/stage2_0/m1_44341_n15864# eeg_fd_ota_chopped_full2_0/stage2_0/m1_45141_n15864# 6.789049e-17
C1663 eeg_fd_ota_chopped_full2_0/stage2_0/m1_44741_n8557# VSS 4.190540e-16
C1664 eeg_fd_ota_chopped_full2_0/stage2_0/m1_44741_n8557# eeg_fd_ota_chopped_full2_0/stage2_0/m1_45541_n8557# 6.789040e-17
C1665 eeg_fd_ota_chopped_full2_0/stage2_0/m1_45141_n15864# VSS 4.190540e-16
C1666 eeg_fd_ota_chopped_full2_0/stage2_0/m1_45141_n15864# eeg_fd_ota_chopped_full2_0/stage2_0/m1_45941_n15864# 6.789059e-17
C1667 eeg_fd_ota_chopped_full2_0/stage2_0/m1_45541_n8557# VSS 4.190540e-16
C1668 eeg_fd_ota_chopped_full2_0/stage2_0/m1_45541_n8557# eeg_fd_ota_chopped_full2_0/stage2_0/m1_46341_n8557# 6.789040e-17
C1669 eeg_fd_ota_chopped_full2_0/stage2_0/m1_45941_n15864# VSS 4.190540e-16
C1670 eeg_fd_ota_chopped_full2_0/stage2_0/m1_45941_n15864# eeg_fd_ota_chopped_full2_0/stage2_0/m1_46741_n15864# 6.789049e-17
C1671 eeg_fd_ota_chopped_full2_0/stage2_0/m1_46341_n8557# VSS 4.190540e-16
C1672 eeg_fd_ota_chopped_full2_0/stage2_0/m1_46341_n8557# eeg_fd_ota_chopped_full2_0/stage2_0/m1_47141_n8557# 6.789040e-17
C1673 eeg_fd_ota_chopped_full2_0/stage2_0/m1_46741_n15864# VSS 4.190540e-16
C1674 eeg_fd_ota_chopped_full2_0/stage2_0/m1_46741_n15864# eeg_fd_ota_chopped_full2_0/stage2_0/m1_47541_n15864# 6.789049e-17
C1675 eeg_fd_ota_chopped_full2_0/stage2_0/m1_47141_n8557# VSS 4.190540e-16
C1676 eeg_fd_ota_chopped_full2_0/stage2_0/m1_47141_n8557# eeg_fd_ota_chopped_full2_0/stage2_0/m1_47941_n8557# 6.789040e-17
C1677 eeg_fd_ota_chopped_full2_0/stage2_0/m1_47541_n15864# VSS 4.190540e-16
C1678 eeg_fd_ota_chopped_full2_0/stage2_0/m1_47541_n15864# eeg_fd_ota_chopped_full2_0/stage2_0/m1_48341_n15864# 6.789049e-17
C1679 eeg_fd_ota_chopped_full2_0/stage2_0/m1_47941_n8557# VSS 4.190540e-16
C1680 eeg_fd_ota_chopped_full2_0/stage2_0/m1_47941_n8557# eeg_fd_ota_chopped_full2_0/stage2_0/m1_48741_n8557# 6.789044e-17
C1681 eeg_fd_ota_chopped_full2_0/stage2_0/m1_48341_n15864# VSS 4.190540e-16
C1682 eeg_fd_ota_chopped_full2_0/stage2_0/m1_48341_n15864# eeg_fd_ota_chopped_full2_0/stage2_0/m1_49141_n15864# 6.789049e-17
C1683 eeg_fd_ota_chopped_full2_0/stage2_0/m1_48741_n8557# VSS 4.190540e-16
C1684 eeg_fd_ota_chopped_full2_0/stage2_0/m1_48741_n8557# eeg_fd_ota_chopped_full2_0/stage2_0/m1_49541_n8557# 6.789040e-17
C1685 eeg_fd_ota_chopped_full2_0/stage2_0/m1_49141_n15864# VSS 4.190540e-16
C1686 eeg_fd_ota_chopped_full2_0/stage2_0/m1_49141_n15864# eeg_fd_ota_chopped_full2_0/stage2_0/m1_49941_n15864# 6.789049e-17
C1687 eeg_fd_ota_chopped_full2_0/stage2_0/m1_49541_n8557# VSS 4.190540e-16
C1688 eeg_fd_ota_chopped_full2_0/stage2_0/m1_49541_n8557# eeg_fd_ota_chopped_full2_0/stage2_0/m1_50341_n8557# 6.789040e-17
C1689 eeg_fd_ota_chopped_full2_0/stage2_0/m1_49941_n15864# VSS 4.190540e-16
C1690 eeg_fd_ota_chopped_full2_0/stage2_0/m1_49941_n15864# eeg_fd_ota_chopped_full2_0/stage2_0/m1_50741_n15864# 6.789049e-17
C1691 eeg_fd_ota_chopped_full2_0/stage2_0/m1_50341_n8557# VSS 4.190540e-16
C1692 eeg_fd_ota_chopped_full2_0/stage2_0/m1_50341_n8557# eeg_fd_ota_chopped_full2_0/stage2_0/m1_51141_n8557# 6.789040e-17
C1693 eeg_fd_ota_chopped_full2_0/stage2_0/m1_50741_n15864# VSS 4.190540e-16
C1694 eeg_fd_ota_chopped_full2_0/stage2_0/m1_50741_n15864# eeg_fd_ota_chopped_full2_0/stage2_0/m1_51541_n15864# 6.789059e-17
C1695 eeg_fd_ota_chopped_full2_0/stage2_0/m1_51141_n8557# VSS 4.190540e-16
C1696 eeg_fd_ota_chopped_full2_0/stage2_0/m1_51141_n8557# eeg_fd_ota_chopped_full2_0/stage2_0/m1_51941_n8557# 6.789040e-17
C1697 eeg_fd_ota_chopped_full2_0/stage2_0/m1_51541_n15864# VSS 4.190540e-16
C1698 eeg_fd_ota_chopped_full2_0/stage2_0/m1_51541_n15864# eeg_fd_ota_chopped_full2_0/stage2_0/m1_52341_n15864# 6.789049e-17
C1699 eeg_fd_ota_chopped_full2_0/stage2_0/m1_51941_n8557# VSS 4.190540e-16
C1700 eeg_fd_ota_chopped_full2_0/stage2_0/m1_51941_n8557# eeg_fd_ota_chopped_full2_0/stage2_0/m1_52741_n8557# 6.789040e-17
C1701 eeg_fd_ota_chopped_full2_0/stage2_0/m1_52341_n15864# VSS 4.190540e-16
C1702 eeg_fd_ota_chopped_full2_0/stage2_0/m1_52341_n15864# eeg_fd_ota_chopped_full2_0/stage2_0/m1_53141_n15864# 6.789049e-17
C1703 eeg_fd_ota_chopped_full2_0/stage2_0/m1_52741_n8557# VSS 4.190540e-16
C1704 eeg_fd_ota_chopped_full2_0/stage2_0/m1_52741_n8557# eeg_fd_ota_chopped_full2_0/stage2_0/m1_53541_n8557# 6.789040e-17
C1705 eeg_fd_ota_chopped_full2_0/stage2_0/m1_53141_n15864# VSS 4.190540e-16
C1706 eeg_fd_ota_chopped_full2_0/stage2_0/m1_53141_n15864# eeg_fd_ota_chopped_full2_0/stage2_0/m1_53941_n15864# 6.789049e-17
C1707 eeg_fd_ota_chopped_full2_0/stage2_0/m1_53541_n8557# VSS 4.190540e-16
C1708 eeg_fd_ota_chopped_full2_0/stage2_0/m1_53541_n8557# eeg_fd_ota_chopped_full2_0/stage2_0/m1_54341_n8557# 6.789044e-17
C1709 eeg_fd_ota_chopped_full2_0/stage2_0/m1_53941_n15864# VSS 4.190540e-16
C1710 eeg_fd_ota_chopped_full2_0/stage2_0/m1_53941_n15864# eeg_fd_ota_chopped_full2_0/stage2_0/m1_54741_n15864# 6.789049e-17
C1711 eeg_fd_ota_chopped_full2_0/stage2_0/m1_54341_n8557# VSS 4.190540e-16
C1712 eeg_fd_ota_chopped_full2_0/stage2_0/m1_54341_n8557# eeg_fd_ota_chopped_full2_0/stage2_0/m1_55141_n8557# 6.789040e-17
C1713 eeg_fd_ota_chopped_full2_0/stage2_0/m1_54741_n15864# VSS 4.190540e-16
C1714 eeg_fd_ota_chopped_full2_0/stage2_0/m1_54741_n15864# eeg_fd_ota_chopped_full2_0/stage2_0/m1_55541_n15864# 6.789049e-17
C1715 eeg_fd_ota_chopped_full2_0/stage2_0/m1_55141_n8557# VSS 4.190540e-16
C1716 eeg_fd_ota_chopped_full2_0/stage2_0/m1_55141_n8557# eeg_fd_ota_chopped_full2_0/stage2_0/m1_55941_n8557# 6.789040e-17
C1717 eeg_fd_ota_chopped_full2_0/stage2_0/m1_55541_n15864# VSS 4.190540e-16
C1718 eeg_fd_ota_chopped_full2_0/stage2_0/m1_55541_n15864# eeg_fd_ota_chopped_full2_0/stage2_0/m1_56341_n15864# 6.789049e-17
C1719 eeg_fd_ota_chopped_full2_0/stage2_0/m1_55941_n8557# VSS 4.190540e-16
C1720 eeg_fd_ota_chopped_full2_0/stage2_0/m1_55941_n8557# eeg_fd_ota_chopped_full2_0/stage2_0/m1_56741_n8557# 6.789040e-17
C1721 eeg_fd_ota_chopped_full2_0/stage2_0/m1_56341_n15864# VSS 4.190540e-16
C1722 eeg_fd_ota_chopped_full2_0/stage2_0/m1_56341_n15864# eeg_fd_ota_chopped_full2_0/stage2_0/m1_57141_n15864# 6.789059e-17
C1723 eeg_fd_ota_chopped_full2_0/stage2_0/m1_56741_n8557# VSS 4.190540e-16
C1724 eeg_fd_ota_chopped_full2_0/stage2_0/m1_56741_n8557# eeg_fd_ota_chopped_full2_0/stage2_0/m1_57541_n8557# 6.789040e-17
C1725 eeg_fd_ota_chopped_full2_0/stage2_0/m1_57141_n15864# VSS 4.190540e-16
C1726 eeg_fd_ota_chopped_full2_0/stage2_0/m1_57141_n15864# eeg_fd_ota_chopped_full2_0/stage2_0/m1_57941_n15864# 6.789049e-17
C1727 eeg_fd_ota_chopped_full2_0/stage2_0/m1_57541_n8557# VSS 4.190540e-16
C1728 eeg_fd_ota_chopped_full2_0/stage2_0/m1_57541_n8557# eeg_fd_ota_chopped_full2_0/stage2_0/m1_58341_n8557# 6.789040e-17
C1729 eeg_fd_ota_chopped_full2_0/stage2_0/m1_57941_n15864# VSS 4.190540e-16
C1730 eeg_fd_ota_chopped_full2_0/stage2_0/m1_57941_n15864# eeg_fd_ota_chopped_full2_0/stage2_0/m1_58741_n15864# 6.789049e-17
C1731 eeg_fd_ota_chopped_full2_0/stage2_0/m1_58341_n8557# VSS 4.190540e-16
C1732 eeg_fd_ota_chopped_full2_0/stage2_0/m1_58341_n8557# eeg_fd_ota_chopped_full2_0/stage2_0/m1_59141_n8557# 6.789040e-17
C1733 eeg_fd_ota_chopped_full2_0/stage2_0/m1_58741_n15864# VSS 4.190540e-16
C1734 eeg_fd_ota_chopped_full2_0/stage2_0/m1_58741_n15864# eeg_fd_ota_chopped_full2_0/stage2_0/m1_59541_n15864# 6.789049e-17
C1735 eeg_fd_ota_chopped_full2_0/stage2_0/m1_59141_n8557# VSS 4.190540e-16
C1736 eeg_fd_ota_chopped_full2_0/stage2_0/m1_59141_n8557# eeg_fd_ota_chopped_full2_0/stage2_0/m1_59941_n8557# 6.789044e-17
C1737 eeg_fd_ota_chopped_full2_0/stage2_0/m1_59541_n15864# VSS 4.190540e-16
C1738 eeg_fd_ota_chopped_full2_0/stage2_0/m1_59541_n15864# eeg_fd_ota_chopped_full2_0/stage2_0/m1_60341_n15864# 6.789049e-17
C1739 eeg_fd_ota_chopped_full2_0/stage2_0/m1_59941_n8557# VSS 4.190540e-16
C1740 eeg_fd_ota_chopped_full2_0/stage2_0/m1_59941_n8557# eeg_fd_ota_chopped_full2_0/stage2_0/m1_60741_n8557# 6.789040e-17
C1741 eeg_fd_ota_chopped_full2_0/stage2_0/m1_60341_n15864# VSS 4.190540e-16
C1742 eeg_fd_ota_chopped_full2_0/stage2_0/m1_60341_n15864# eeg_fd_ota_chopped_full2_0/stage2_0/m1_61141_n15864# 6.789049e-17
C1743 eeg_fd_ota_chopped_full2_0/stage2_0/m1_60741_n8557# VSS 4.623640e-16
C1744 eeg_fd_ota_chopped_full2_0/stage2_0/m1_61141_n15864# VSS 4.702790e-16
C1745 eeg_fd_ota_chopped_full2_0/stage2_0/m1_63941_n15864# VSS 4.702790e-16
C1746 eeg_fd_ota_chopped_full2_0/stage2_0/m1_63941_n15864# eeg_fd_ota_chopped_full2_0/stage2_0/m1_64741_n15864# 6.789049e-17
C1747 eeg_fd_ota_chopped_full2_0/stage2_0/m1_64341_n8557# VSS 4.623640e-16
C1748 eeg_fd_ota_chopped_full2_0/stage2_0/m1_64341_n8557# eeg_fd_ota_chopped_full2_0/stage2_0/m1_65141_n8557# 6.789040e-17
C1749 eeg_fd_ota_chopped_full2_0/stage2_0/m1_64741_n15864# VSS 4.190540e-16
C1750 eeg_fd_ota_chopped_full2_0/stage2_0/m1_64741_n15864# eeg_fd_ota_chopped_full2_0/stage2_0/m1_65541_n15864# 6.789059e-17
C1751 eeg_fd_ota_chopped_full2_0/stage2_0/m1_65141_n8557# VSS 4.190540e-16
C1752 eeg_fd_ota_chopped_full2_0/stage2_0/m1_65141_n8557# eeg_fd_ota_chopped_full2_0/stage2_0/m1_65941_n8557# 6.789040e-17
C1753 eeg_fd_ota_chopped_full2_0/stage2_0/m1_65541_n15864# VSS 4.190540e-16
C1754 eeg_fd_ota_chopped_full2_0/stage2_0/m1_65541_n15864# eeg_fd_ota_chopped_full2_0/stage2_0/m1_66341_n15864# 6.789049e-17
C1755 eeg_fd_ota_chopped_full2_0/stage2_0/m1_65941_n8557# VSS 4.190540e-16
C1756 eeg_fd_ota_chopped_full2_0/stage2_0/m1_65941_n8557# eeg_fd_ota_chopped_full2_0/stage2_0/m1_66741_n8557# 6.789040e-17
C1757 eeg_fd_ota_chopped_full2_0/stage2_0/m1_66341_n15864# VSS 4.190540e-16
C1758 eeg_fd_ota_chopped_full2_0/stage2_0/m1_66341_n15864# eeg_fd_ota_chopped_full2_0/stage2_0/m1_67141_n15864# 6.789049e-17
C1759 eeg_fd_ota_chopped_full2_0/stage2_0/m1_66741_n8557# VSS 4.190540e-16
C1760 eeg_fd_ota_chopped_full2_0/stage2_0/m1_66741_n8557# eeg_fd_ota_chopped_full2_0/stage2_0/m1_67541_n8557# 6.789040e-17
C1761 eeg_fd_ota_chopped_full2_0/stage2_0/m1_67141_n15864# VSS 4.190540e-16
C1762 eeg_fd_ota_chopped_full2_0/stage2_0/m1_67141_n15864# eeg_fd_ota_chopped_full2_0/stage2_0/m1_67941_n15864# 6.789049e-17
C1763 eeg_fd_ota_chopped_full2_0/stage2_0/m1_67541_n8557# VSS 4.190540e-16
C1764 eeg_fd_ota_chopped_full2_0/stage2_0/m1_67541_n8557# eeg_fd_ota_chopped_full2_0/stage2_0/m1_68341_n8557# 6.789044e-17
C1765 eeg_fd_ota_chopped_full2_0/stage2_0/m1_67941_n15864# VSS 4.190540e-16
C1766 eeg_fd_ota_chopped_full2_0/stage2_0/m1_67941_n15864# eeg_fd_ota_chopped_full2_0/stage2_0/m1_68741_n15864# 6.789049e-17
C1767 eeg_fd_ota_chopped_full2_0/stage2_0/m1_68341_n8557# VSS 4.190540e-16
C1768 eeg_fd_ota_chopped_full2_0/stage2_0/m1_68341_n8557# eeg_fd_ota_chopped_full2_0/stage2_0/m1_69141_n8557# 6.789040e-17
C1769 eeg_fd_ota_chopped_full2_0/stage2_0/m1_68741_n15864# VSS 4.190540e-16
C1770 eeg_fd_ota_chopped_full2_0/stage2_0/m1_68741_n15864# eeg_fd_ota_chopped_full2_0/stage2_0/m1_69541_n15864# 6.789049e-17
C1771 eeg_fd_ota_chopped_full2_0/stage2_0/m1_69141_n8557# VSS 4.190540e-16
C1772 eeg_fd_ota_chopped_full2_0/stage2_0/m1_69141_n8557# eeg_fd_ota_chopped_full2_0/stage2_0/m1_69941_n8557# 6.789040e-17
C1773 eeg_fd_ota_chopped_full2_0/stage2_0/m1_69541_n15864# VSS 4.190540e-16
C1774 eeg_fd_ota_chopped_full2_0/stage2_0/m1_69541_n15864# eeg_fd_ota_chopped_full2_0/stage2_0/m1_70341_n15864# 6.789049e-17
C1775 eeg_fd_ota_chopped_full2_0/stage2_0/m1_69941_n8557# VSS 4.190540e-16
C1776 eeg_fd_ota_chopped_full2_0/stage2_0/m1_69941_n8557# eeg_fd_ota_chopped_full2_0/stage2_0/m1_70741_n8557# 6.789040e-17
C1777 eeg_fd_ota_chopped_full2_0/stage2_0/m1_70341_n15864# VSS 4.190540e-16
C1778 eeg_fd_ota_chopped_full2_0/stage2_0/m1_70341_n15864# eeg_fd_ota_chopped_full2_0/stage2_0/m1_71141_n15864# 6.789059e-17
C1779 eeg_fd_ota_chopped_full2_0/stage2_0/m1_70741_n8557# VSS 4.623640e-16
C1780 eeg_fd_ota_chopped_full2_0/stage2_0/m1_71141_n15864# VSS 4.702790e-16
C1781 eeg_fd_ota_chopped_full2_0/stage2_0/m1_73941_n15864# VSS 4.702790e-16
C1782 eeg_fd_ota_chopped_full2_0/stage2_0/m1_73941_n15864# eeg_fd_ota_chopped_full2_0/stage2_0/m1_74741_n15864# 6.789049e-17
C1783 eeg_fd_ota_chopped_full2_0/stage2_0/m1_74341_n8557# VSS 4.623640e-16
C1784 eeg_fd_ota_chopped_full2_0/stage2_0/m1_74341_n8557# eeg_fd_ota_chopped_full2_0/stage2_0/m1_75141_n8557# 6.789040e-17
C1785 eeg_fd_ota_chopped_full2_0/stage2_0/m1_74741_n15864# VSS 4.190540e-16
C1786 eeg_fd_ota_chopped_full2_0/stage2_0/m1_74741_n15864# eeg_fd_ota_chopped_full2_0/stage2_0/m1_75541_n15864# 6.789049e-17
C1787 eeg_fd_ota_chopped_full2_0/stage2_0/m1_75141_n8557# VSS 4.190540e-16
C1788 eeg_fd_ota_chopped_full2_0/stage2_0/m1_75141_n8557# eeg_fd_ota_chopped_full2_0/stage2_0/m1_75941_n8557# 6.789040e-17
C1789 eeg_fd_ota_chopped_full2_0/stage2_0/m1_75541_n15864# VSS 4.190540e-16
C1790 eeg_fd_ota_chopped_full2_0/stage2_0/m1_75541_n15864# eeg_fd_ota_chopped_full2_0/stage2_0/m1_76341_n15864# 6.789049e-17
C1791 eeg_fd_ota_chopped_full2_0/stage2_0/m1_75941_n8557# VSS 4.190540e-16
C1792 eeg_fd_ota_chopped_full2_0/stage2_0/m1_75941_n8557# eeg_fd_ota_chopped_full2_0/stage2_0/m1_76741_n8557# 6.789044e-17
C1793 eeg_fd_ota_chopped_full2_0/stage2_0/m1_76341_n15864# VSS 4.190540e-16
C1794 eeg_fd_ota_chopped_full2_0/stage2_0/m1_76341_n15864# eeg_fd_ota_chopped_full2_0/stage2_0/m1_77141_n15864# 6.789049e-17
C1795 eeg_fd_ota_chopped_full2_0/stage2_0/m1_76741_n8557# VSS 4.190540e-16
C1796 eeg_fd_ota_chopped_full2_0/stage2_0/m1_76741_n8557# eeg_fd_ota_chopped_full2_0/stage2_0/m1_77541_n8557# 6.789040e-17
C1797 eeg_fd_ota_chopped_full2_0/stage2_0/m1_77141_n15864# VSS 4.190540e-16
C1798 eeg_fd_ota_chopped_full2_0/stage2_0/m1_77141_n15864# eeg_fd_ota_chopped_full2_0/stage2_0/m1_77941_n15864# 6.789049e-17
C1799 eeg_fd_ota_chopped_full2_0/stage2_0/m1_77541_n8557# VSS 4.190540e-16
C1800 eeg_fd_ota_chopped_full2_0/stage2_0/m1_77541_n8557# eeg_fd_ota_chopped_full2_0/stage2_0/m1_78341_n8557# 6.789040e-17
C1801 eeg_fd_ota_chopped_full2_0/stage2_0/m1_77941_n15864# VSS 4.190540e-16
C1802 eeg_fd_ota_chopped_full2_0/stage2_0/m1_77941_n15864# eeg_fd_ota_chopped_full2_0/stage2_0/m1_78741_n15864# 6.789049e-17
C1803 eeg_fd_ota_chopped_full2_0/stage2_0/m1_78341_n8557# VSS 4.190540e-16
C1804 eeg_fd_ota_chopped_full2_0/stage2_0/m1_78341_n8557# eeg_fd_ota_chopped_full2_0/stage2_0/m1_79141_n8557# 6.789040e-17
C1805 eeg_fd_ota_chopped_full2_0/stage2_0/m1_78741_n15864# VSS 4.190540e-16
C1806 eeg_fd_ota_chopped_full2_0/stage2_0/m1_78741_n15864# eeg_fd_ota_chopped_full2_0/stage2_0/m1_79541_n15864# 6.789059e-17
C1807 eeg_fd_ota_chopped_full2_0/stage2_0/m1_79141_n8557# VSS 4.190540e-16
C1808 eeg_fd_ota_chopped_full2_0/stage2_0/m1_79141_n8557# eeg_fd_ota_chopped_full2_0/stage2_0/m1_79941_n8557# 6.789040e-17
C1809 eeg_fd_ota_chopped_full2_0/stage2_0/m1_79541_n15864# VSS 4.190540e-16
C1810 eeg_fd_ota_chopped_full2_0/stage2_0/m1_79541_n15864# eeg_fd_ota_chopped_full2_0/stage2_0/m1_80341_n15864# 6.789049e-17
C1811 eeg_fd_ota_chopped_full2_0/stage2_0/m1_79941_n8557# VSS 4.190540e-16
C1812 eeg_fd_ota_chopped_full2_0/stage2_0/m1_79941_n8557# eeg_fd_ota_chopped_full2_0/stage2_0/m1_80741_n8557# 6.789040e-17
C1813 eeg_fd_ota_chopped_full2_0/stage2_0/m1_80341_n15864# VSS 4.190540e-16
C1814 eeg_fd_ota_chopped_full2_0/stage2_0/m1_80341_n15864# eeg_fd_ota_chopped_full2_0/stage2_0/m1_81141_n15864# 6.789049e-17
C1815 eeg_fd_ota_chopped_full2_0/stage2_0/m1_80741_n8557# VSS 4.623640e-16
C1816 eeg_fd_ota_chopped_full2_0/stage2_0/m1_81141_n15864# VSS 4.702790e-16
C1817 eeg_fd_ota_chopped_full2_0/stage2_0/m1_58341_n8557# VSS 6.746650e-16
C1818 eeg_fd_ota_chopped_full2_0/stage2_0/m1_58741_n15864# VSS 6.746650e-16
C1819 eeg_fd_ota_chopped_full2_0/stage2_0/m1_24741_n15864# VSS 6.746650e-16
C1820 eeg_fd_ota_chopped_full2_0/stage2_0/m1_25141_n8557# VSS 6.746650e-16
C1821 eeg_fd_ota_chopped_full2_0/stage2_0/m1_20341_n8557# VSS 6.746650e-16
C1822 eeg_fd_ota_chopped_full2_0/stage2_0/m1_20741_n15864# VSS 6.746650e-16
C1823 eeg_fd_ota_chopped_full2_0/stage2_0/m1_35941_n15864# VSS 6.746650e-16
C1824 eeg_fd_ota_chopped_full2_0/stage2_0/m1_36341_n8557# VSS 6.746650e-16
C1825 eeg_fd_ota_chopped_full2_0/stage2_0/m1_79941_n8557# VSS 6.746650e-16
C1826 eeg_fd_ota_chopped_full2_0/stage2_0/m1_80341_n15864# VSS 6.746650e-16
C1827 eeg_fd_ota_chopped_full2_0/stage2_0/m1_75541_n15864# VSS 6.746650e-16
C1828 eeg_fd_ota_chopped_full2_0/stage2_0/m1_75941_n8557# VSS 6.746650e-16
C1829 eeg_fd_ota_chopped_full2_0/stage2_0/m1_69141_n8557# VSS 6.746650e-16
C1830 eeg_fd_ota_chopped_full2_0/stage2_0/m1_69541_n15864# VSS 6.746650e-16
C1831 eeg_fd_ota_chopped_full2_0/stage2_0/m1_64741_n15864# VSS 6.746650e-16
C1832 eeg_fd_ota_chopped_full2_0/stage2_0/m1_65141_n8557# VSS 6.746650e-16
C1833 eeg_fd_ota_chopped_full2_0/stage2_0/m1_57941_n15864# VSS 6.746650e-16
C1834 eeg_fd_ota_chopped_full2_0/stage2_0/m1_58341_n8557# VSS 6.746650e-16
C1835 eeg_fd_ota_chopped_full2_0/stage2_0/m1_28741_n15864# VSS 6.746650e-16
C1836 eeg_fd_ota_chopped_full2_0/stage2_0/m1_29141_n8557# VSS 6.746650e-16
C1837 eeg_fd_ota_chopped_full2_0/stage2_0/m1_24341_n8557# VSS 6.746650e-16
C1838 eeg_fd_ota_chopped_full2_0/stage2_0/m1_24741_n15864# VSS 6.746650e-16
C1839 eeg_fd_ota_chopped_full2_0/stage2_0/m1_19941_n15864# VSS 6.746650e-16
C1840 eeg_fd_ota_chopped_full2_0/stage2_0/m1_20341_n8557# VSS 6.746650e-16
C1841 eeg_fd_ota_chopped_full2_0/stage2_0/m1_35541_n8557# VSS 6.746650e-16
C1842 eeg_fd_ota_chopped_full2_0/stage2_0/m1_35941_n15864# VSS 6.746650e-16
C1843 eeg_fd_ota_chopped_full2_0/stage2_0/m1_79541_n15864# VSS 6.746650e-16
C1844 eeg_fd_ota_chopped_full2_0/stage2_0/m1_79941_n8557# VSS 6.746650e-16
C1845 eeg_fd_ota_chopped_full2_0/stage2_0/m1_75141_n8557# VSS 6.746650e-16
C1846 eeg_fd_ota_chopped_full2_0/stage2_0/m1_75541_n15864# VSS 6.746650e-16
C1847 eeg_fd_ota_chopped_full2_0/stage2_0/m1_68741_n15864# VSS 6.746650e-16
C1848 eeg_fd_ota_chopped_full2_0/stage2_0/m1_69141_n8557# VSS 6.746650e-16
C1849 eeg_fd_ota_chopped_full2_0/stage2_0/m1_64341_n8557# VSS 6.746650e-16
C1850 eeg_fd_ota_chopped_full2_0/stage2_0/m1_64741_n15864# VSS 6.746650e-16
C1851 eeg_fd_ota_chopped_full2_0/stage2_0/m1_57541_n8557# VSS 6.746650e-16
C1852 eeg_fd_ota_chopped_full2_0/stage2_0/m1_57941_n15864# VSS 6.746650e-16
C1853 eeg_fd_ota_chopped_full2_0/stage2_0/m1_28341_n8557# VSS 6.746650e-16
C1854 eeg_fd_ota_chopped_full2_0/stage2_0/m1_28741_n15864# VSS 6.746650e-16
C1855 eeg_fd_ota_chopped_full2_0/stage2_0/m1_23941_n15864# VSS 6.746650e-16
C1856 eeg_fd_ota_chopped_full2_0/stage2_0/m1_24341_n8557# VSS 6.746650e-16
C1857 OUTP VSS 6.746650e-16
C1858 eeg_fd_ota_chopped_full2_0/stage2_0/m1_19941_n15864# VSS 6.746650e-16
C1859 eeg_fd_ota_chopped_full2_0/stage2_0/m1_35141_n15864# VSS 6.746650e-16
C1860 eeg_fd_ota_chopped_full2_0/stage2_0/m1_35541_n8557# VSS 6.746650e-16
C1861 eeg_fd_ota_chopped_full2_0/stage2_0/m1_79141_n8557# VSS 6.746650e-16
C1862 eeg_fd_ota_chopped_full2_0/stage2_0/m1_79541_n15864# VSS 6.746650e-16
C1863 eeg_fd_ota_chopped_full2_0/stage2_0/m1_74741_n15864# VSS 6.746650e-16
C1864 eeg_fd_ota_chopped_full2_0/stage2_0/m1_75141_n8557# VSS 6.746650e-16
C1865 eeg_fd_ota_chopped_full2_0/stage2_0/m1_68341_n8557# VSS 6.746650e-16
C1866 eeg_fd_ota_chopped_full2_0/stage2_0/m1_68741_n15864# VSS 6.746650e-16
C1867 eeg_fd_ota_chopped_full2_0/stage2_0/m1_63941_n15864# VSS 6.746650e-16
C1868 eeg_fd_ota_chopped_full2_0/stage2_0/m1_64341_n8557# VSS 6.746650e-16
C1869 eeg_fd_ota_chopped_full2_0/stage2_0/m1_27941_n15864# VSS 6.746650e-16
C1870 eeg_fd_ota_chopped_full2_0/stage2_0/m1_28341_n8557# VSS 6.746650e-16
C1871 eeg_fd_ota_chopped_full2_0/stage2_0/m1_23541_n8557# VSS 6.746650e-16
C1872 eeg_fd_ota_chopped_full2_0/stage2_0/m1_23941_n15864# VSS 6.746650e-16
C1873 eeg_fd_ota_chopped_full2_0/stage2_0/VCM2 VSS 6.746650e-16
C1874 eeg_fd_ota_chopped_full2_0/stage2_0/m1_39141_n15864# VSS 6.746650e-16
C1875 eeg_fd_ota_chopped_full2_0/stage2_0/m1_34741_n8557# VSS 6.746650e-16
C1876 eeg_fd_ota_chopped_full2_0/stage2_0/m1_35141_n15864# VSS 6.746650e-16
C1877 eeg_fd_ota_chopped_full2_0/stage2_0/m1_78741_n15864# VSS 6.746650e-16
C1878 eeg_fd_ota_chopped_full2_0/stage2_0/m1_79141_n8557# VSS 6.746650e-16
C1879 eeg_fd_ota_chopped_full2_0/stage2_0/m1_74341_n8557# VSS 6.746650e-16
C1880 eeg_fd_ota_chopped_full2_0/stage2_0/m1_74741_n15864# VSS 6.746650e-16
C1881 eeg_fd_ota_chopped_full2_0/stage2_0/m1_67941_n15864# VSS 6.746650e-16
C1882 eeg_fd_ota_chopped_full2_0/stage2_0/m1_68341_n8557# VSS 6.746650e-16
C1883 OUTP VSS 6.746650e-16
C1884 eeg_fd_ota_chopped_full2_0/stage2_0/m1_63941_n15864# VSS 6.746650e-16
C1885 eeg_fd_ota_chopped_full2_0/stage2_0/m1_27541_n8557# VSS 6.746650e-16
C1886 eeg_fd_ota_chopped_full2_0/stage2_0/m1_27941_n15864# VSS 6.746650e-16
C1887 eeg_fd_ota_chopped_full2_0/stage2_0/m1_23141_n15864# VSS 6.746650e-16
C1888 eeg_fd_ota_chopped_full2_0/stage2_0/m1_23541_n8557# VSS 6.746650e-16
C1889 eeg_fd_ota_chopped_full2_0/stage2_0/m1_38741_n8557# VSS 6.746650e-16
C1890 eeg_fd_ota_chopped_full2_0/stage2_0/m1_39141_n15864# VSS 6.746650e-16
C1891 eeg_fd_ota_chopped_full2_0/stage2_0/m1_34341_n15864# VSS 6.746650e-16
C1892 eeg_fd_ota_chopped_full2_0/stage2_0/m1_34741_n8557# VSS 6.746650e-16
C1893 eeg_fd_ota_chopped_full2_0/stage2_0/m1_78341_n8557# VSS 6.746650e-16
C1894 eeg_fd_ota_chopped_full2_0/stage2_0/m1_78741_n15864# VSS 6.746650e-16
C1895 eeg_fd_ota_chopped_full2_0/stage2_0/m1_73941_n15864# VSS 6.746650e-16
C1896 eeg_fd_ota_chopped_full2_0/stage2_0/m1_74341_n8557# VSS 6.746650e-16
C1897 eeg_fd_ota_chopped_full2_0/stage2_0/m1_67541_n8557# VSS 6.746650e-16
C1898 eeg_fd_ota_chopped_full2_0/stage2_0/m1_67941_n15864# VSS 6.746650e-16
C1899 eeg_fd_ota_chopped_full2_0/stage2_0/m1_27141_n15864# VSS 6.746650e-16
C1900 eeg_fd_ota_chopped_full2_0/stage2_0/m1_27541_n8557# VSS 6.746650e-16
C1901 eeg_fd_ota_chopped_full2_0/stage2_0/m1_22741_n8557# VSS 6.746650e-16
C1902 eeg_fd_ota_chopped_full2_0/stage2_0/m1_23141_n15864# VSS 6.746650e-16
C1903 eeg_fd_ota_chopped_full2_0/stage2_0/m1_38341_n15864# VSS 6.746650e-16
C1904 eeg_fd_ota_chopped_full2_0/stage2_0/m1_38741_n8557# VSS 6.746650e-16
C1905 eeg_fd_ota_chopped_full2_0/stage2_0/m1_33941_n8557# VSS 6.746650e-16
C1906 eeg_fd_ota_chopped_full2_0/stage2_0/m1_34341_n15864# VSS 6.746650e-16
C1907 eeg_fd_ota_chopped_full2_0/stage2_0/m1_77941_n15864# VSS 6.746650e-16
C1908 eeg_fd_ota_chopped_full2_0/stage2_0/m1_78341_n8557# VSS 6.746650e-16
C1909 OUTN VSS 6.746650e-16
C1910 eeg_fd_ota_chopped_full2_0/stage2_0/m1_73941_n15864# VSS 6.746650e-16
C1911 eeg_fd_ota_chopped_full2_0/stage2_0/m1_26741_n8557# VSS 6.746650e-16
C1912 eeg_fd_ota_chopped_full2_0/stage2_0/m1_27141_n15864# VSS 6.746650e-16
C1913 eeg_fd_ota_chopped_full2_0/stage2_0/m1_22341_n15864# VSS 6.746650e-16
C1914 eeg_fd_ota_chopped_full2_0/stage2_0/m1_22741_n8557# VSS 6.746650e-16
C1915 eeg_fd_ota_chopped_full2_0/stage2_0/m1_37941_n8557# VSS 6.746650e-16
C1916 eeg_fd_ota_chopped_full2_0/stage2_0/m1_38341_n15864# VSS 6.746650e-16
C1917 eeg_fd_ota_chopped_full2_0/stage2_0/m1_33541_n15864# VSS 6.746650e-16
C1918 eeg_fd_ota_chopped_full2_0/stage2_0/m1_33941_n8557# VSS 6.746650e-16
C1919 eeg_fd_ota_chopped_full2_0/stage2_0/m1_77541_n8557# VSS 6.746650e-16
C1920 eeg_fd_ota_chopped_full2_0/stage2_0/m1_77941_n15864# VSS 6.746650e-16
C1921 eeg_fd_ota_chopped_full2_0/stage2_0/m1_26341_n15864# VSS 6.746650e-16
C1922 eeg_fd_ota_chopped_full2_0/stage2_0/m1_26741_n8557# VSS 6.746650e-16
C1923 eeg_fd_ota_chopped_full2_0/stage2_0/m1_21941_n8557# VSS 6.746650e-16
C1924 eeg_fd_ota_chopped_full2_0/stage2_0/m1_22341_n15864# VSS 6.746650e-16
C1925 eeg_fd_ota_chopped_full2_0/stage2_0/m1_37541_n15864# VSS 6.746650e-16
C1926 eeg_fd_ota_chopped_full2_0/stage2_0/m1_37941_n8557# VSS 6.746650e-16
C1927 eeg_fd_ota_chopped_full2_0/stage2_0/m1_33141_n8557# VSS 6.746650e-16
C1928 eeg_fd_ota_chopped_full2_0/stage2_0/m1_33541_n15864# VSS 6.746650e-16
C1929 eeg_fd_ota_chopped_full2_0/stage2_0/m1_25941_n8557# VSS 6.746650e-16
C1930 eeg_fd_ota_chopped_full2_0/stage2_0/m1_26341_n15864# VSS 6.746650e-16
C1931 eeg_fd_ota_chopped_full2_0/stage2_0/m1_21541_n15864# VSS 6.746650e-16
C1932 eeg_fd_ota_chopped_full2_0/stage2_0/m1_21941_n8557# VSS 6.746650e-16
C1933 eeg_fd_ota_chopped_full2_0/stage2_0/m1_37141_n8557# VSS 6.746650e-16
C1934 eeg_fd_ota_chopped_full2_0/stage2_0/m1_37541_n15864# VSS 6.746650e-16
C1935 eeg_fd_ota_chopped_full2_0/stage2_0/m1_25541_n15864# VSS 6.746650e-16
C1936 eeg_fd_ota_chopped_full2_0/stage2_0/m1_25941_n8557# VSS 6.746650e-16
C1937 eeg_fd_ota_chopped_full2_0/stage2_0/m1_21141_n8557# VSS 6.746650e-16
C1938 eeg_fd_ota_chopped_full2_0/stage2_0/m1_21541_n15864# VSS 6.746650e-16
C1939 eeg_fd_ota_chopped_full2_0/stage2_0/m1_25141_n8557# VSS 6.746650e-16
C1940 eeg_fd_ota_chopped_full2_0/stage2_0/m1_25541_n15864# VSS 6.746650e-16
C1941 OUTN VDD18 9.216400e-16
C1942 OUTN VSS 4.856640e-16
C1943 OUTN eeg_fd_ota_chopped_full2_0/stage2_0/VBP2 3.596600e-15
C1944 VDD18 VSS 1.074004e-13
C1945 VDD18 eeg_fd_ota_chopped_full2_0/stage2_0/VBP2 2.903319e-14
C1946 eeg_fd_ota_chopped_full2_0/stage2_0/VBP2 VSS 7.027174e-15
C1947 eeg_fd_ota_chopped_full2_0/stage2_0/m1_32741_n15864# VSS 6.746650e-16
C1948 eeg_fd_ota_chopped_full2_0/stage2_0/m1_33141_n8557# VSS 6.746650e-16
C1949 OUTN VSS 1.639490e-16
C1950 OUTN eeg_fd_ota_chopped_full2_0/stage2_0/N2N 8.991500e-16
C1951 VSS eeg_fd_ota_chopped_full2_0/stage2_0/N2N 9.971760e-16
C1952 eeg_fd_ota_chopped_full2_0/stage2_0/N2N VSS 7.765320e-15
C1953 eeg_fd_ota_chopped_full2_0/stage2_0/m1_32341_n8557# VSS 6.746650e-16
C1954 eeg_fd_ota_chopped_full2_0/stage2_0/m1_32741_n15864# VSS 6.746650e-16
C1955 eeg_fd_ota_chopped_full2_0/stage2_0/m1_31941_n15864# VSS 6.746650e-16
C1956 eeg_fd_ota_chopped_full2_0/stage2_0/m1_32341_n8557# VSS 6.746650e-16
C1957 eeg_fd_ota_chopped_full2_0/stage2_0/m1_31541_n8557# VSS 6.746650e-16
C1958 eeg_fd_ota_chopped_full2_0/stage2_0/m1_31941_n15864# VSS 6.746650e-16
C1959 eeg_fd_ota_chopped_full2_0/stage2_0/m1_31141_n15864# VSS 6.746650e-16
C1960 eeg_fd_ota_chopped_full2_0/stage2_0/m1_31541_n8557# VSS 6.746650e-16
C1961 eeg_fd_ota_chopped_full2_0/stage2_0/m1_30741_n8557# VSS 6.746650e-16
C1962 eeg_fd_ota_chopped_full2_0/stage2_0/m1_31141_n15864# VSS 6.746650e-16
C1963 eeg_fd_ota_chopped_full2_0/stage2_0/m1_30341_n15864# VSS 6.746650e-16
C1964 eeg_fd_ota_chopped_full2_0/stage2_0/m1_30741_n8557# VSS 6.746650e-16
C1965 eeg_fd_ota_chopped_full2_0/stage2_0/N2N VSS 6.668820e-16
C1967 eeg_fd_ota_chopped_full2_0/stage2_0/m1_12966_n5928# VSS 6.668820e-16
C1968 eeg_fd_ota_chopped_full2_0/stage2_0/m1_29941_n8557# VSS 6.746650e-16
C1969 eeg_fd_ota_chopped_full2_0/stage2_0/m1_30341_n15864# VSS 6.746650e-16
C1970 eeg_fd_ota_chopped_full2_0/stage2_0/m1_45141_n15864# VSS 6.746650e-16
C1971 eeg_fd_ota_chopped_full2_0/stage2_0/m1_45541_n8557# VSS 6.746650e-16
C1972 eeg_fd_ota_chopped_full2_0/stage2_0/N2P VSS 6.668820e-16
C1974 eeg_fd_ota_chopped_full2_0/stage2_0/m1_3966_n5928# VSS 6.668820e-16
C1975 eeg_fd_ota_chopped_full2_0/stage2_0/m1_29541_n15864# VSS 6.746650e-16
C1976 eeg_fd_ota_chopped_full2_0/stage2_0/m1_29941_n8557# VSS 6.746650e-16
C1977 eeg_fd_ota_chopped_full2_0/stage2_0/m1_44741_n8557# VSS 6.746650e-16
C1978 eeg_fd_ota_chopped_full2_0/stage2_0/m1_45141_n15864# VSS 6.746650e-16
C1979 eeg_fd_ota_chopped_full2_0/stage2_0/m1_49141_n15864# VSS 6.746650e-16
C1980 eeg_fd_ota_chopped_full2_0/stage2_0/m1_49541_n8557# VSS 6.746650e-16
C1981 eeg_fd_ota_chopped_full2_0/stage2_0/m1_29141_n8557# VSS 6.746650e-16
C1982 eeg_fd_ota_chopped_full2_0/stage2_0/m1_29541_n15864# VSS 6.746650e-16
C1983 eeg_fd_ota_chopped_full2_0/stage2_0/m1_44341_n15864# VSS 6.746650e-16
C1984 eeg_fd_ota_chopped_full2_0/stage2_0/m1_44741_n8557# VSS 6.746650e-16
C1985 eeg_fd_ota_chopped_full2_0/stage2_0/m1_48741_n8557# VSS 6.746650e-16
C1986 eeg_fd_ota_chopped_full2_0/stage2_0/m1_49141_n15864# VSS 6.746650e-16
C1987 eeg_fd_ota_chopped_full2_0/stage2_0/m1_53141_n15864# VSS 6.746650e-16
C1988 eeg_fd_ota_chopped_full2_0/stage2_0/m1_53541_n8557# VSS 6.746650e-16
C1989 eeg_fd_ota_chopped_full2_0/stage2_0/m1_43941_n8557# VSS 6.746650e-16
C1990 eeg_fd_ota_chopped_full2_0/stage2_0/m1_44341_n15864# VSS 6.746650e-16
C1991 eeg_fd_ota_chopped_full2_0/stage2_0/m1_48341_n15864# VSS 6.746650e-16
C1992 eeg_fd_ota_chopped_full2_0/stage2_0/m1_48741_n8557# VSS 6.746650e-16
C1993 eeg_fd_ota_chopped_full2_0/stage2_0/m1_52741_n8557# VSS 6.746650e-16
C1994 eeg_fd_ota_chopped_full2_0/stage2_0/m1_53141_n15864# VSS 6.746650e-16
C1995 eeg_fd_ota_chopped_full2_0/stage2_0/m1_57141_n15864# VSS 6.746650e-16
C1996 eeg_fd_ota_chopped_full2_0/stage2_0/m1_57541_n8557# VSS 6.746650e-16
C1997 eeg_fd_ota_chopped_full2_0/stage2_0/m1_43541_n15864# VSS 6.746650e-16
C1998 eeg_fd_ota_chopped_full2_0/stage2_0/m1_43941_n8557# VSS 6.746650e-16
C1999 eeg_fd_ota_chopped_full2_0/stage2_0/m1_47941_n8557# VSS 6.746650e-16
C2000 eeg_fd_ota_chopped_full2_0/stage2_0/m1_48341_n15864# VSS 6.746650e-16
C2001 eeg_fd_ota_chopped_full2_0/stage2_0/m1_52341_n15864# VSS 6.746650e-16
C2002 eeg_fd_ota_chopped_full2_0/stage2_0/m1_52741_n8557# VSS 6.746650e-16
C2003 eeg_fd_ota_chopped_full2_0/stage2_0/m1_56741_n8557# VSS 6.746650e-16
C2004 eeg_fd_ota_chopped_full2_0/stage2_0/m1_57141_n15864# VSS 6.746650e-16
C2005 eeg_fd_ota_chopped_full2_0/stage2_0/m1_43141_n8557# VSS 6.746650e-16
C2006 eeg_fd_ota_chopped_full2_0/stage2_0/m1_43541_n15864# VSS 6.746650e-16
C2007 eeg_fd_ota_chopped_full2_0/stage2_0/m1_47541_n15864# VSS 6.746650e-16
C2008 eeg_fd_ota_chopped_full2_0/stage2_0/m1_47941_n8557# VSS 6.746650e-16
C2009 eeg_fd_ota_chopped_full2_0/stage2_0/m1_51941_n8557# VSS 6.746650e-16
C2010 eeg_fd_ota_chopped_full2_0/stage2_0/m1_52341_n15864# VSS 6.746650e-16
C2011 eeg_fd_ota_chopped_full2_0/stage2_0/m1_56341_n15864# VSS 6.746650e-16
C2012 eeg_fd_ota_chopped_full2_0/stage2_0/m1_56741_n8557# VSS 6.746650e-16
C2013 eeg_fd_ota_chopped_full2_0/stage2_0/m1_42741_n15864# VSS 6.746650e-16
C2014 eeg_fd_ota_chopped_full2_0/stage2_0/m1_43141_n8557# VSS 6.746650e-16
C2015 eeg_fd_ota_chopped_full2_0/stage2_0/m1_47141_n8557# VSS 6.746650e-16
C2016 eeg_fd_ota_chopped_full2_0/stage2_0/m1_47541_n15864# VSS 6.746650e-16
C2017 eeg_fd_ota_chopped_full2_0/stage2_0/m1_51541_n15864# VSS 6.746650e-16
C2018 eeg_fd_ota_chopped_full2_0/stage2_0/m1_51941_n8557# VSS 6.746650e-16
C2019 eeg_fd_ota_chopped_full2_0/stage2_0/m1_55941_n8557# VSS 6.746650e-16
C2020 eeg_fd_ota_chopped_full2_0/stage2_0/m1_56341_n15864# VSS 6.746650e-16
C2021 eeg_fd_ota_chopped_full2_0/stage2_0/VCM2 VSS 6.746650e-16
C2022 eeg_fd_ota_chopped_full2_0/stage2_0/m1_61141_n15864# VSS 6.746650e-16
C2023 eeg_fd_ota_chopped_full2_0/stage2_0/m1_42341_n8557# VSS 6.746650e-16
C2024 eeg_fd_ota_chopped_full2_0/stage2_0/m1_42741_n15864# VSS 6.746650e-16
C2025 eeg_fd_ota_chopped_full2_0/stage2_0/m1_46741_n15864# VSS 6.746650e-16
C2026 eeg_fd_ota_chopped_full2_0/stage2_0/m1_47141_n8557# VSS 6.746650e-16
C2027 eeg_fd_ota_chopped_full2_0/stage2_0/m1_51141_n8557# VSS 6.746650e-16
C2028 eeg_fd_ota_chopped_full2_0/stage2_0/m1_51541_n15864# VSS 6.746650e-16
C2029 eeg_fd_ota_chopped_full2_0/stage2_0/m1_55541_n15864# VSS 6.746650e-16
C2030 eeg_fd_ota_chopped_full2_0/stage2_0/m1_55941_n8557# VSS 6.746650e-16
C2031 eeg_fd_ota_chopped_full2_0/stage2_0/m1_60741_n8557# VSS 6.746650e-16
C2032 eeg_fd_ota_chopped_full2_0/stage2_0/m1_61141_n15864# VSS 6.746650e-16
C2033 eeg_fd_ota_chopped_full2_0/stage2_0/m1_67141_n15864# VSS 6.746650e-16
C2034 eeg_fd_ota_chopped_full2_0/stage2_0/m1_67541_n8557# VSS 6.746650e-16
C2035 eeg_fd_ota_chopped_full2_0/stage2_0/m1_41941_n15864# VSS 6.746650e-16
C2036 eeg_fd_ota_chopped_full2_0/stage2_0/m1_42341_n8557# VSS 6.746650e-16
C2037 eeg_fd_ota_chopped_full2_0/stage2_0/m1_46341_n8557# VSS 6.746650e-16
C2038 eeg_fd_ota_chopped_full2_0/stage2_0/m1_46741_n15864# VSS 6.746650e-16
C2039 eeg_fd_ota_chopped_full2_0/stage2_0/m1_50741_n15864# VSS 6.746650e-16
C2040 eeg_fd_ota_chopped_full2_0/stage2_0/m1_51141_n8557# VSS 6.746650e-16
C2041 eeg_fd_ota_chopped_full2_0/stage2_0/m1_55141_n8557# VSS 6.746650e-16
C2042 eeg_fd_ota_chopped_full2_0/stage2_0/m1_55541_n15864# VSS 6.746650e-16
C2043 eeg_fd_ota_chopped_full2_0/stage2_0/m1_60341_n15864# VSS 6.746650e-16
C2044 eeg_fd_ota_chopped_full2_0/stage2_0/m1_60741_n8557# VSS 6.746650e-16
C2045 VCM_REF VSS 6.746650e-16
C2046 eeg_fd_ota_chopped_full2_0/stage2_0/m1_71141_n15864# VSS 6.746650e-16
C2047 eeg_fd_ota_chopped_full2_0/stage2_0/m1_66741_n8557# VSS 6.746650e-16
C2048 eeg_fd_ota_chopped_full2_0/stage2_0/m1_67141_n15864# VSS 6.746650e-16
C2049 OUTN VSS 6.746650e-16
C2050 eeg_fd_ota_chopped_full2_0/stage2_0/m1_41941_n15864# VSS 6.746650e-16
C2051 eeg_fd_ota_chopped_full2_0/stage2_0/m1_45941_n15864# VSS 6.746650e-16
C2052 eeg_fd_ota_chopped_full2_0/stage2_0/m1_46341_n8557# VSS 6.746650e-16
C2053 eeg_fd_ota_chopped_full2_0/stage2_0/m1_50341_n8557# VSS 6.746650e-16
C2054 eeg_fd_ota_chopped_full2_0/stage2_0/m1_50741_n15864# VSS 6.746650e-16
C2055 eeg_fd_ota_chopped_full2_0/stage2_0/m1_54741_n15864# VSS 6.746650e-16
C2056 eeg_fd_ota_chopped_full2_0/stage2_0/m1_55141_n8557# VSS 6.746650e-16
C2057 eeg_fd_ota_chopped_full2_0/stage2_0/m1_59941_n8557# VSS 6.746650e-16
C2058 eeg_fd_ota_chopped_full2_0/stage2_0/m1_60341_n15864# VSS 6.746650e-16
C2059 eeg_fd_ota_chopped_full2_0/stage2_0/m1_77141_n15864# VSS 6.746650e-16
C2060 eeg_fd_ota_chopped_full2_0/stage2_0/m1_77541_n8557# VSS 6.746650e-16
C2061 eeg_fd_ota_chopped_full2_0/stage2_0/m1_70741_n8557# VSS 6.746650e-16
C2062 eeg_fd_ota_chopped_full2_0/stage2_0/m1_71141_n15864# VSS 6.746650e-16
C2063 eeg_fd_ota_chopped_full2_0/stage2_0/m1_66341_n15864# VSS 6.746650e-16
C2064 eeg_fd_ota_chopped_full2_0/stage2_0/m1_66741_n8557# VSS 6.746650e-16
C2065 OUTP VDD18 9.216400e-16
C2066 OUTP VSS 4.856640e-16
C2067 OUTP eeg_fd_ota_chopped_full2_0/stage2_0/VBP2 3.596600e-15
C2068 VDD18 VSS 1.074004e-13
C2069 VDD18 eeg_fd_ota_chopped_full2_0/stage2_0/VBP2 2.903319e-14
C2070 eeg_fd_ota_chopped_full2_0/stage2_0/VBP2 VSS 7.027174e-15
C2071 eeg_fd_ota_chopped_full2_0/stage2_0/m1_45541_n8557# VSS 6.746650e-16
C2072 eeg_fd_ota_chopped_full2_0/stage2_0/m1_45941_n15864# VSS 6.746650e-16
C2073 eeg_fd_ota_chopped_full2_0/stage2_0/m1_49941_n15864# VSS 6.746650e-16
C2074 eeg_fd_ota_chopped_full2_0/stage2_0/m1_50341_n8557# VSS 6.746650e-16
C2075 eeg_fd_ota_chopped_full2_0/stage2_0/m1_54341_n8557# VSS 6.746650e-16
C2076 eeg_fd_ota_chopped_full2_0/stage2_0/m1_54741_n15864# VSS 6.746650e-16
C2077 eeg_fd_ota_chopped_full2_0/stage2_0/m1_59541_n15864# VSS 6.746650e-16
C2078 eeg_fd_ota_chopped_full2_0/stage2_0/m1_59941_n8557# VSS 6.746650e-16
C2079 VCM_REF VSS 6.746650e-16
C2080 eeg_fd_ota_chopped_full2_0/stage2_0/m1_81141_n15864# VSS 6.746650e-16
C2081 eeg_fd_ota_chopped_full2_0/stage2_0/m1_76741_n8557# VSS 6.746650e-16
C2082 eeg_fd_ota_chopped_full2_0/stage2_0/m1_77141_n15864# VSS 6.746650e-16
C2083 eeg_fd_ota_chopped_full2_0/stage2_0/m1_70341_n15864# VSS 6.746650e-16
C2084 eeg_fd_ota_chopped_full2_0/stage2_0/m1_70741_n8557# VSS 6.746650e-16
C2085 eeg_fd_ota_chopped_full2_0/stage2_0/m1_65941_n8557# VSS 6.746650e-16
C2086 eeg_fd_ota_chopped_full2_0/stage2_0/m1_66341_n15864# VSS 6.746650e-16
C2087 eeg_fd_ota_chopped_full2_0/stage2_0/m1_49541_n8557# VSS 6.746650e-16
C2088 eeg_fd_ota_chopped_full2_0/stage2_0/m1_49941_n15864# VSS 6.746650e-16
C2089 eeg_fd_ota_chopped_full2_0/stage2_0/m1_53941_n15864# VSS 6.746650e-16
C2090 eeg_fd_ota_chopped_full2_0/stage2_0/m1_54341_n8557# VSS 6.746650e-16
C2091 eeg_fd_ota_chopped_full2_0/stage2_0/m1_59141_n8557# VSS 6.746650e-16
C2092 eeg_fd_ota_chopped_full2_0/stage2_0/m1_59541_n15864# VSS 6.746650e-16
C2093 eeg_fd_ota_chopped_full2_0/stage2_0/m1_36741_n15864# VSS 6.746650e-16
C2094 eeg_fd_ota_chopped_full2_0/stage2_0/m1_37141_n8557# VSS 6.746650e-16
C2095 eeg_fd_ota_chopped_full2_0/stage2_0/m1_80741_n8557# VSS 6.746650e-16
C2096 eeg_fd_ota_chopped_full2_0/stage2_0/m1_81141_n15864# VSS 6.746650e-16
C2097 eeg_fd_ota_chopped_full2_0/stage2_0/m1_76341_n15864# VSS 6.746650e-16
C2098 eeg_fd_ota_chopped_full2_0/stage2_0/m1_76741_n8557# VSS 6.746650e-16
C2099 eeg_fd_ota_chopped_full2_0/stage2_0/m1_69941_n8557# VSS 6.746650e-16
C2100 eeg_fd_ota_chopped_full2_0/stage2_0/m1_70341_n15864# VSS 6.746650e-16
C2101 eeg_fd_ota_chopped_full2_0/stage2_0/m1_65541_n15864# VSS 6.746650e-16
C2102 eeg_fd_ota_chopped_full2_0/stage2_0/m1_65941_n8557# VSS 6.746650e-16
C2103 eeg_fd_ota_chopped_full2_0/stage2_0/m1_53541_n8557# VSS 6.746650e-16
C2104 eeg_fd_ota_chopped_full2_0/stage2_0/m1_53941_n15864# VSS 6.746650e-16
C2105 eeg_fd_ota_chopped_full2_0/stage2_0/m1_58741_n15864# VSS 6.746650e-16
C2106 eeg_fd_ota_chopped_full2_0/stage2_0/m1_59141_n8557# VSS 6.746650e-16
C2107 eeg_fd_ota_chopped_full2_0/stage2_0/m1_20741_n15864# VSS 6.746650e-16
C2108 eeg_fd_ota_chopped_full2_0/stage2_0/m1_21141_n8557# VSS 6.746650e-16
C2109 eeg_fd_ota_chopped_full2_0/stage2_0/m1_36341_n8557# VSS 6.746650e-16
C2110 eeg_fd_ota_chopped_full2_0/stage2_0/m1_36741_n15864# VSS 6.746650e-16
C2111 eeg_fd_ota_chopped_full2_0/stage2_0/m1_80341_n15864# VSS 6.746650e-16
C2112 eeg_fd_ota_chopped_full2_0/stage2_0/m1_80741_n8557# VSS 6.746650e-16
C2113 eeg_fd_ota_chopped_full2_0/stage2_0/m1_75941_n8557# VSS 6.746650e-16
C2114 eeg_fd_ota_chopped_full2_0/stage2_0/m1_76341_n15864# VSS 6.746650e-16
C2115 eeg_fd_ota_chopped_full2_0/stage2_0/m1_69541_n15864# VSS 6.746650e-16
C2116 eeg_fd_ota_chopped_full2_0/stage2_0/m1_69941_n8557# VSS 6.746650e-16
C2117 eeg_fd_ota_chopped_full2_0/stage2_0/m1_65141_n8557# VSS 6.746650e-16
C2118 eeg_fd_ota_chopped_full2_0/stage2_0/m1_65541_n15864# VSS 6.746650e-16
C2119 OUTP VSS 1.639490e-16
C2120 OUTP eeg_fd_ota_chopped_full2_0/stage2_0/N2P 8.991500e-16
C2121 VSS eeg_fd_ota_chopped_full2_0/stage2_0/N2P 9.971760e-16
C2122 eeg_fd_ota_chopped_full2_0/stage2_0/N2P VSS 7.765320e-15
C2123 NPHIBM NPHIM 7.901830e-17
C2124 NPHIBM PHIBM 5.228216e-15
C2125 NPHIBM PHIM 5.833740e-17
C2126 NPHIBM VDD18 1.030131e-16
C2127 NPHIBM VSS 7.512014e-15
C2128 NPHIBM eeg_fd_ota_chopped_full2_0/eeg_fd_ota_core_soft_0/OUTN 1.811041e-16
C2129 NPHIBM eeg_fd_ota_chopped_full2_0/eeg_fd_ota_core_soft_0/OUTP 1.783654e-16
C2130 NPHIBM eeg_fd_ota_chopped_full2_0/stage2_0/N2N 3.459312e-16
C2131 NPHIBM eeg_fd_ota_chopped_full2_0/stage2_0/N2P 3.587603e-16
C2132 NPHIM PHIBM 4.712490e-15
C2133 NPHIM PHIM 5.200586e-15
C2134 NPHIM VDD18 1.018586e-16
C2135 NPHIM VSS 3.887486e-15
C2136 NPHIM eeg_fd_ota_chopped_full2_0/eeg_fd_ota_core_soft_0/OUTN 1.853562e-16
C2137 NPHIM eeg_fd_ota_chopped_full2_0/eeg_fd_ota_core_soft_0/OUTP 1.806746e-16
C2138 NPHIM eeg_fd_ota_chopped_full2_0/stage2_0/N2N 3.472566e-16
C2139 NPHIM eeg_fd_ota_chopped_full2_0/stage2_0/N2P 3.595253e-16
C2140 PHIBM PHIM 1.062601e-16
C2141 PHIBM VDD18 1.685133e-16
C2142 PHIBM VSS 3.602799e-15
C2143 PHIBM eeg_fd_ota_chopped_full2_0/eeg_fd_ota_core_soft_0/OUTN 7.703784e-16
C2144 PHIBM eeg_fd_ota_chopped_full2_0/eeg_fd_ota_core_soft_0/OUTP 7.157421e-16
C2145 PHIBM eeg_fd_ota_chopped_full2_0/stage2_0/N2N 4.286349e-16
C2146 PHIBM eeg_fd_ota_chopped_full2_0/stage2_0/N2P 4.066731e-16
C2147 PHIM VDD18 1.607790e-16
C2148 PHIM VSS 3.328204e-15
C2149 PHIM eeg_fd_ota_chopped_full2_0/eeg_fd_ota_core_soft_0/OUTN 5.418324e-15
C2150 PHIM eeg_fd_ota_chopped_full2_0/eeg_fd_ota_core_soft_0/OUTP 7.203664e-16
C2151 PHIM eeg_fd_ota_chopped_full2_0/stage2_0/N2N 4.307666e-16
C2152 PHIM eeg_fd_ota_chopped_full2_0/stage2_0/N2P 4.077701e-16
C2153 VDD18 VSS 5.270369e-15
C2162 eeg_fd_ota_chopped_full2_0/eeg_fd_ota_core_soft_0/OUTN VSS 2.830580e-15
C2163 eeg_fd_ota_chopped_full2_0/eeg_fd_ota_core_soft_0/OUTN eeg_fd_ota_chopped_full2_0/eeg_fd_ota_core_soft_0/OUTP 4.996116e-15
C2164 eeg_fd_ota_chopped_full2_0/eeg_fd_ota_core_soft_0/OUTN eeg_fd_ota_chopped_full2_0/stage2_0/N2N 4.971801e-16
C2165 eeg_fd_ota_chopped_full2_0/eeg_fd_ota_core_soft_0/OUTN eeg_fd_ota_chopped_full2_0/stage2_0/N2P 5.233646e-16
C2166 eeg_fd_ota_chopped_full2_0/eeg_fd_ota_core_soft_0/OUTP VSS 2.659180e-15
C2167 eeg_fd_ota_chopped_full2_0/eeg_fd_ota_core_soft_0/OUTP eeg_fd_ota_chopped_full2_0/stage2_0/N2N 5.135942e-15
C2168 eeg_fd_ota_chopped_full2_0/eeg_fd_ota_core_soft_0/OUTP eeg_fd_ota_chopped_full2_0/stage2_0/N2P 5.252581e-16
C2169 eeg_fd_ota_chopped_full2_0/stage2_0/N2N VSS 1.709720e-15
C2170 eeg_fd_ota_chopped_full2_0/stage2_0/N2N eeg_fd_ota_chopped_full2_0/stage2_0/N2P 4.747254e-15
C2171 eeg_fd_ota_chopped_full2_0/stage2_0/N2P VSS 4.881870e-15
C2172 NPHIBM PHIBM 1.215812e-15
C2173 NPHIBM VDD18 5.262242e-16
C2174 NPHIBM VSS 2.537269e-15
C2175 NPHIBM eeg_fd_ota_chopped_full2_0/eeg_fd_ota_core_soft_0/OUTN 4.755154e-17
C2176 NPHIBM eeg_fd_ota_chopped_full2_0/stage2_0/N2P 1.076105e-16
C2177 PHIBM VDD18 6.588032e-16
C2178 PHIBM VSS 1.789951e-15
C2179 PHIBM eeg_fd_ota_chopped_full2_0/eeg_fd_ota_core_soft_0/OUTN 1.181323e-16
C2180 PHIBM eeg_fd_ota_chopped_full2_0/stage2_0/N2P 2.857784e-16
C2181 VDD18 VSS 3.714735e-15
C2182 VDD18 eeg_fd_ota_chopped_full2_0/eeg_fd_ota_core_soft_0/OUTN 1.484229e-16
C2183 VDD18 eeg_fd_ota_chopped_full2_0/stage2_0/N2P 3.128723e-16
C2184 VSS eeg_fd_ota_chopped_full2_0/eeg_fd_ota_core_soft_0/OUTN 7.819878e-17
C2185 VSS eeg_fd_ota_chopped_full2_0/stage2_0/N2P 1.097210e-16
C2186 eeg_fd_ota_chopped_full2_0/eeg_fd_ota_core_soft_0/OUTN VSS 2.430800e-15
C2187 eeg_fd_ota_chopped_full2_0/eeg_fd_ota_core_soft_0/OUTN eeg_fd_ota_chopped_full2_0/stage2_0/N2P 1.492117e-15
C2188 eeg_fd_ota_chopped_full2_0/stage2_0/N2P VSS 1.462840e-15
C2189 PHIBM VDD18 1.564350e-16
C2190 PHIBM VSS 4.901000e-17
C2191 PHIBM eeg_fd_ota_chopped_full2_0/stage2_0/N2P 2.862080e-17
C2192 VDD18 VSS 1.561810e-15
C2193 VDD18 eeg_fd_ota_chopped_full2_0/stage2_0/N2P 1.697704e-16
C2194 eeg_fd_ota_chopped_full2_0/stage2_0/N2P VSS 8.867300e-17
C2195 NPHIBM VSS 2.062020e-16
C2196 NPHIBM eeg_fd_ota_chopped_full2_0/eeg_fd_ota_core_soft_0/OUTN 2.084120e-17
C2197 eeg_fd_ota_chopped_full2_0/eeg_fd_ota_core_soft_0/OUTN VSS 1.088312e-16
C2198 NPHIBM VSS 2.062020e-16
C2199 NPHIBM eeg_fd_ota_chopped_full2_0/stage2_0/N2P 2.084120e-17
C2200 eeg_fd_ota_chopped_full2_0/stage2_0/N2P VSS 1.088312e-16
C2201 NPHIBM VDD18 1.594600e-16
C2202 NPHIBM VSS 4.382640e-17
C2203 NPHIBM eeg_fd_ota_chopped_full2_0/eeg_fd_ota_core_soft_0/OUTN 2.402360e-17
C2204 NPHIBM eeg_fd_ota_chopped_full2_0/stage2_0/N2P 2.402360e-17
C2205 VDD18 VSS 2.327590e-15
C2206 VDD18 eeg_fd_ota_chopped_full2_0/eeg_fd_ota_core_soft_0/OUTN 1.554040e-16
C2207 VDD18 eeg_fd_ota_chopped_full2_0/stage2_0/N2P 1.554040e-16
C2208 eeg_fd_ota_chopped_full2_0/eeg_fd_ota_core_soft_0/OUTN VSS 7.837880e-17
C2209 eeg_fd_ota_chopped_full2_0/eeg_fd_ota_core_soft_0/OUTN eeg_fd_ota_chopped_full2_0/stage2_0/N2P 1.170160e-16
C2210 eeg_fd_ota_chopped_full2_0/stage2_0/N2P VSS 7.837880e-17
C2211 PHIBM VDD18 1.564350e-16
C2212 PHIBM VSS 4.901000e-17
C2213 PHIBM eeg_fd_ota_chopped_full2_0/eeg_fd_ota_core_soft_0/OUTN 2.862080e-17
C2214 VDD18 VSS 1.561810e-15
C2215 VDD18 eeg_fd_ota_chopped_full2_0/eeg_fd_ota_core_soft_0/OUTN 1.697704e-16
C2216 eeg_fd_ota_chopped_full2_0/eeg_fd_ota_core_soft_0/OUTN VSS 8.867300e-17
C2217 PHIBM VSS 2.027230e-16
C2220 eeg_fd_ota_chopped_full2_0/eeg_fd_ota_core_soft_0/OUTN VSS 1.267930e-16
C2221 eeg_fd_ota_chopped_full2_0/eeg_fd_ota_core_soft_0/OUTN eeg_fd_ota_chopped_full2_0/stage2_0/N2P 5.623600e-17
C2222 eeg_fd_ota_chopped_full2_0/stage2_0/N2P VSS 1.267930e-16
C2223 NPHIBM PHIBM 1.215812e-15
C2224 NPHIBM VDD18 5.262242e-16
C2225 NPHIBM VSS 2.537269e-15
C2226 NPHIBM eeg_fd_ota_chopped_full2_0/eeg_fd_ota_core_soft_0/OUTP 4.755154e-17
C2227 NPHIBM eeg_fd_ota_chopped_full2_0/stage2_0/N2N 1.076105e-16
C2228 PHIBM VDD18 6.588032e-16
C2229 PHIBM VSS 1.789951e-15
C2230 PHIBM eeg_fd_ota_chopped_full2_0/eeg_fd_ota_core_soft_0/OUTP 1.181323e-16
C2231 PHIBM eeg_fd_ota_chopped_full2_0/stage2_0/N2N 2.857784e-16
C2232 VDD18 VSS 3.714735e-15
C2233 VDD18 eeg_fd_ota_chopped_full2_0/eeg_fd_ota_core_soft_0/OUTP 1.484229e-16
C2234 VDD18 eeg_fd_ota_chopped_full2_0/stage2_0/N2N 3.128723e-16
C2235 VSS eeg_fd_ota_chopped_full2_0/eeg_fd_ota_core_soft_0/OUTP 7.819878e-17
C2236 VSS eeg_fd_ota_chopped_full2_0/stage2_0/N2N 1.097210e-16
C2237 eeg_fd_ota_chopped_full2_0/eeg_fd_ota_core_soft_0/OUTP VSS 2.430800e-15
C2238 eeg_fd_ota_chopped_full2_0/eeg_fd_ota_core_soft_0/OUTP eeg_fd_ota_chopped_full2_0/stage2_0/N2N 1.492117e-15
C2239 eeg_fd_ota_chopped_full2_0/stage2_0/N2N VSS 1.462840e-15
C2240 PHIBM VDD18 1.564350e-16
C2241 PHIBM VSS 4.901000e-17
C2242 PHIBM eeg_fd_ota_chopped_full2_0/stage2_0/N2N 2.862080e-17
C2243 VDD18 VSS 1.561810e-15
C2244 VDD18 eeg_fd_ota_chopped_full2_0/stage2_0/N2N 1.697704e-16
C2245 eeg_fd_ota_chopped_full2_0/stage2_0/N2N VSS 8.867300e-17
C2246 NPHIBM VSS 2.062020e-16
C2247 NPHIBM eeg_fd_ota_chopped_full2_0/eeg_fd_ota_core_soft_0/OUTP 2.084120e-17
C2248 eeg_fd_ota_chopped_full2_0/eeg_fd_ota_core_soft_0/OUTP VSS 1.088312e-16
C2249 NPHIBM VSS 2.062020e-16
C2250 NPHIBM eeg_fd_ota_chopped_full2_0/stage2_0/N2N 2.084120e-17
C2251 eeg_fd_ota_chopped_full2_0/stage2_0/N2N VSS 1.088312e-16
C2252 NPHIBM VDD18 1.594600e-16
C2253 NPHIBM VSS 4.382640e-17
C2254 NPHIBM eeg_fd_ota_chopped_full2_0/eeg_fd_ota_core_soft_0/OUTP 2.402360e-17
C2255 NPHIBM eeg_fd_ota_chopped_full2_0/stage2_0/N2N 2.402360e-17
C2256 VDD18 VSS 2.327590e-15
C2257 VDD18 eeg_fd_ota_chopped_full2_0/eeg_fd_ota_core_soft_0/OUTP 1.554040e-16
C2258 VDD18 eeg_fd_ota_chopped_full2_0/stage2_0/N2N 1.554040e-16
C2259 eeg_fd_ota_chopped_full2_0/eeg_fd_ota_core_soft_0/OUTP VSS 7.837880e-17
C2260 eeg_fd_ota_chopped_full2_0/eeg_fd_ota_core_soft_0/OUTP eeg_fd_ota_chopped_full2_0/stage2_0/N2N 1.170160e-16
C2261 eeg_fd_ota_chopped_full2_0/stage2_0/N2N VSS 7.837880e-17
C2262 PHIBM VDD18 1.564350e-16
C2263 PHIBM VSS 4.901000e-17
C2264 PHIBM eeg_fd_ota_chopped_full2_0/eeg_fd_ota_core_soft_0/OUTP 2.862080e-17
C2265 VDD18 VSS 1.561810e-15
C2266 VDD18 eeg_fd_ota_chopped_full2_0/eeg_fd_ota_core_soft_0/OUTP 1.697704e-16
C2267 eeg_fd_ota_chopped_full2_0/eeg_fd_ota_core_soft_0/OUTP VSS 8.867300e-17
C2268 PHIBM VSS 2.027230e-16
C2271 eeg_fd_ota_chopped_full2_0/eeg_fd_ota_core_soft_0/OUTP VSS 1.267930e-16
C2272 eeg_fd_ota_chopped_full2_0/eeg_fd_ota_core_soft_0/OUTP eeg_fd_ota_chopped_full2_0/stage2_0/N2N 5.623600e-17
C2273 eeg_fd_ota_chopped_full2_0/stage2_0/N2N VSS 1.267930e-16
C2274 NPHIM PHIM 1.215812e-15
C2275 NPHIM VDD18 5.262242e-16
C2276 NPHIM VSS 2.537269e-15
C2277 NPHIM eeg_fd_ota_chopped_full2_0/eeg_fd_ota_core_soft_0/OUTN 4.755154e-17
C2278 NPHIM eeg_fd_ota_chopped_full2_0/stage2_0/N2N 1.076105e-16
C2279 PHIM VDD18 6.588032e-16
C2280 PHIM VSS 1.789951e-15
C2281 PHIM eeg_fd_ota_chopped_full2_0/eeg_fd_ota_core_soft_0/OUTN 1.181323e-16
C2282 PHIM eeg_fd_ota_chopped_full2_0/stage2_0/N2N 2.857784e-16
C2283 VDD18 VSS 3.714735e-15
C2284 VDD18 eeg_fd_ota_chopped_full2_0/eeg_fd_ota_core_soft_0/OUTN 1.484229e-16
C2285 VDD18 eeg_fd_ota_chopped_full2_0/stage2_0/N2N 3.128723e-16
C2286 VSS eeg_fd_ota_chopped_full2_0/eeg_fd_ota_core_soft_0/OUTN 7.819878e-17
C2287 VSS eeg_fd_ota_chopped_full2_0/stage2_0/N2N 1.097210e-16
C2288 eeg_fd_ota_chopped_full2_0/eeg_fd_ota_core_soft_0/OUTN VSS 2.430800e-15
C2289 eeg_fd_ota_chopped_full2_0/eeg_fd_ota_core_soft_0/OUTN eeg_fd_ota_chopped_full2_0/stage2_0/N2N 1.492117e-15
C2290 eeg_fd_ota_chopped_full2_0/stage2_0/N2N VSS 1.462840e-15
C2291 PHIM VDD18 1.564350e-16
C2292 PHIM VSS 4.901000e-17
C2293 PHIM eeg_fd_ota_chopped_full2_0/stage2_0/N2N 2.862080e-17
C2294 VDD18 VSS 1.561810e-15
C2295 VDD18 eeg_fd_ota_chopped_full2_0/stage2_0/N2N 1.697704e-16
C2296 eeg_fd_ota_chopped_full2_0/stage2_0/N2N VSS 8.867300e-17
C2297 NPHIM VSS 2.062020e-16
C2298 NPHIM eeg_fd_ota_chopped_full2_0/eeg_fd_ota_core_soft_0/OUTN 2.084120e-17
C2299 eeg_fd_ota_chopped_full2_0/eeg_fd_ota_core_soft_0/OUTN VSS 1.088312e-16
C2300 NPHIM VSS 2.062020e-16
C2301 NPHIM eeg_fd_ota_chopped_full2_0/stage2_0/N2N 2.084120e-17
C2302 eeg_fd_ota_chopped_full2_0/stage2_0/N2N VSS 1.088312e-16
C2303 NPHIM VDD18 1.594600e-16
C2304 NPHIM VSS 4.382640e-17
C2305 NPHIM eeg_fd_ota_chopped_full2_0/eeg_fd_ota_core_soft_0/OUTN 2.402360e-17
C2306 NPHIM eeg_fd_ota_chopped_full2_0/stage2_0/N2N 2.402360e-17
C2307 VDD18 VSS 2.327590e-15
C2308 VDD18 eeg_fd_ota_chopped_full2_0/eeg_fd_ota_core_soft_0/OUTN 1.554040e-16
C2309 VDD18 eeg_fd_ota_chopped_full2_0/stage2_0/N2N 1.554040e-16
C2310 eeg_fd_ota_chopped_full2_0/eeg_fd_ota_core_soft_0/OUTN VSS 7.837880e-17
C2311 eeg_fd_ota_chopped_full2_0/eeg_fd_ota_core_soft_0/OUTN eeg_fd_ota_chopped_full2_0/stage2_0/N2N 1.170160e-16
C2312 eeg_fd_ota_chopped_full2_0/stage2_0/N2N VSS 7.837880e-17
C2313 PHIM VDD18 1.564350e-16
C2314 PHIM VSS 4.901000e-17
C2315 PHIM eeg_fd_ota_chopped_full2_0/eeg_fd_ota_core_soft_0/OUTN 2.862080e-17
C2316 VDD18 VSS 1.561810e-15
C2317 VDD18 eeg_fd_ota_chopped_full2_0/eeg_fd_ota_core_soft_0/OUTN 1.697704e-16
C2318 eeg_fd_ota_chopped_full2_0/eeg_fd_ota_core_soft_0/OUTN VSS 8.867300e-17
C2319 PHIM VSS 2.027230e-16
C2322 eeg_fd_ota_chopped_full2_0/eeg_fd_ota_core_soft_0/OUTN VSS 1.267930e-16
C2323 eeg_fd_ota_chopped_full2_0/eeg_fd_ota_core_soft_0/OUTN eeg_fd_ota_chopped_full2_0/stage2_0/N2N 5.623600e-17
C2324 eeg_fd_ota_chopped_full2_0/stage2_0/N2N VSS 1.267930e-16
C2325 NPHIM PHIM 1.215812e-15
C2326 NPHIM VDD18 5.262242e-16
C2327 NPHIM VSS 2.537269e-15
C2328 NPHIM eeg_fd_ota_chopped_full2_0/eeg_fd_ota_core_soft_0/OUTP 4.755154e-17
C2329 NPHIM eeg_fd_ota_chopped_full2_0/stage2_0/N2P 1.076105e-16
C2330 PHIM VDD18 6.588032e-16
C2331 PHIM VSS 1.789951e-15
C2332 PHIM eeg_fd_ota_chopped_full2_0/eeg_fd_ota_core_soft_0/OUTP 1.181323e-16
C2333 PHIM eeg_fd_ota_chopped_full2_0/stage2_0/N2P 2.857784e-16
C2334 VDD18 VSS 3.714735e-15
C2335 VDD18 eeg_fd_ota_chopped_full2_0/eeg_fd_ota_core_soft_0/OUTP 1.484229e-16
C2336 VDD18 eeg_fd_ota_chopped_full2_0/stage2_0/N2P 3.128723e-16
C2337 VSS eeg_fd_ota_chopped_full2_0/eeg_fd_ota_core_soft_0/OUTP 7.819878e-17
C2338 VSS eeg_fd_ota_chopped_full2_0/stage2_0/N2P 1.097210e-16
C2339 eeg_fd_ota_chopped_full2_0/eeg_fd_ota_core_soft_0/OUTP VSS 2.430800e-15
C2340 eeg_fd_ota_chopped_full2_0/eeg_fd_ota_core_soft_0/OUTP eeg_fd_ota_chopped_full2_0/stage2_0/N2P 1.492117e-15
C2341 eeg_fd_ota_chopped_full2_0/stage2_0/N2P VSS 1.462840e-15
C2342 PHIM VDD18 1.564350e-16
C2343 PHIM VSS 4.901000e-17
C2344 PHIM eeg_fd_ota_chopped_full2_0/stage2_0/N2P 2.862080e-17
C2345 VDD18 VSS 1.561810e-15
C2346 VDD18 eeg_fd_ota_chopped_full2_0/stage2_0/N2P 1.697704e-16
C2347 eeg_fd_ota_chopped_full2_0/stage2_0/N2P VSS 8.867300e-17
C2348 NPHIM VSS 2.062020e-16
C2349 NPHIM eeg_fd_ota_chopped_full2_0/eeg_fd_ota_core_soft_0/OUTP 2.084120e-17
C2350 eeg_fd_ota_chopped_full2_0/eeg_fd_ota_core_soft_0/OUTP VSS 1.088312e-16
C2351 NPHIM VSS 2.062020e-16
C2352 NPHIM eeg_fd_ota_chopped_full2_0/stage2_0/N2P 2.084120e-17
C2353 eeg_fd_ota_chopped_full2_0/stage2_0/N2P VSS 1.088312e-16
C2354 NPHIM VDD18 1.594600e-16
C2355 NPHIM VSS 4.382640e-17
C2356 NPHIM eeg_fd_ota_chopped_full2_0/eeg_fd_ota_core_soft_0/OUTP 2.402360e-17
C2357 NPHIM eeg_fd_ota_chopped_full2_0/stage2_0/N2P 2.402360e-17
C2358 VDD18 VSS 2.327590e-15
C2359 VDD18 eeg_fd_ota_chopped_full2_0/eeg_fd_ota_core_soft_0/OUTP 1.554040e-16
C2360 VDD18 eeg_fd_ota_chopped_full2_0/stage2_0/N2P 1.554040e-16
C2361 eeg_fd_ota_chopped_full2_0/eeg_fd_ota_core_soft_0/OUTP VSS 7.837880e-17
C2362 eeg_fd_ota_chopped_full2_0/eeg_fd_ota_core_soft_0/OUTP eeg_fd_ota_chopped_full2_0/stage2_0/N2P 1.170160e-16
C2363 eeg_fd_ota_chopped_full2_0/stage2_0/N2P VSS 7.837880e-17
C2364 PHIM VDD18 1.564350e-16
C2365 PHIM VSS 4.901000e-17
C2366 PHIM eeg_fd_ota_chopped_full2_0/eeg_fd_ota_core_soft_0/OUTP 2.862080e-17
C2367 VDD18 VSS 1.561810e-15
C2368 VDD18 eeg_fd_ota_chopped_full2_0/eeg_fd_ota_core_soft_0/OUTP 1.697704e-16
C2369 eeg_fd_ota_chopped_full2_0/eeg_fd_ota_core_soft_0/OUTP VSS 8.867300e-17
C2370 PHIM VSS 2.027230e-16
C2373 eeg_fd_ota_chopped_full2_0/eeg_fd_ota_core_soft_0/OUTP VSS 1.267930e-16
C2374 eeg_fd_ota_chopped_full2_0/eeg_fd_ota_core_soft_0/OUTP eeg_fd_ota_chopped_full2_0/stage2_0/N2P 5.623600e-17
C2375 eeg_fd_ota_chopped_full2_0/stage2_0/N2P VSS 1.267930e-16
C2376 NPHIBI NPHII 7.901830e-17
C2377 NPHIBI PHIBI 5.228216e-15
C2378 NPHIBI PHII 5.833740e-17
C2379 NPHIBI VDD18 1.030131e-16
C2380 NPHIBI VSS 7.512014e-15
C2381 NPHIBI eeg_fd_ota_chopped_full2_0/eeg_fd_ota_core_soft_0/INN 3.459312e-16
C2382 NPHIBI eeg_fd_ota_chopped_full2_0/eeg_fd_ota_core_soft_0/INP 3.587603e-16
C2383 NPHIBI eeg_tg_lowq_3/B 1.811041e-16
C2384 NPHIBI eeg_tg_lowq_7/B 1.783654e-16
C2385 NPHII PHIBI 4.712490e-15
C2386 NPHII PHII 5.200586e-15
C2387 NPHII VDD18 1.018586e-16
C2388 NPHII VSS 3.887486e-15
C2389 NPHII eeg_fd_ota_chopped_full2_0/eeg_fd_ota_core_soft_0/INN 3.472566e-16
C2390 NPHII eeg_fd_ota_chopped_full2_0/eeg_fd_ota_core_soft_0/INP 3.595253e-16
C2391 NPHII eeg_tg_lowq_3/B 1.853562e-16
C2392 NPHII eeg_tg_lowq_7/B 1.806746e-16
C2393 PHIBI PHII 1.062601e-16
C2394 PHIBI VDD18 1.685133e-16
C2395 PHIBI VSS 3.602799e-15
C2396 PHIBI eeg_fd_ota_chopped_full2_0/eeg_fd_ota_core_soft_0/INN 4.286349e-16
C2397 PHIBI eeg_fd_ota_chopped_full2_0/eeg_fd_ota_core_soft_0/INP 4.066731e-16
C2398 PHIBI eeg_tg_lowq_3/B 7.703784e-16
C2399 PHIBI eeg_tg_lowq_7/B 7.157421e-16
C2400 PHII VDD18 1.607790e-16
C2401 PHII VSS 3.328204e-15
C2402 PHII eeg_fd_ota_chopped_full2_0/eeg_fd_ota_core_soft_0/INN 4.307666e-16
C2403 PHII eeg_fd_ota_chopped_full2_0/eeg_fd_ota_core_soft_0/INP 4.077701e-16
C2404 PHII eeg_tg_lowq_3/B 5.418324e-15
C2405 PHII eeg_tg_lowq_7/B 7.203664e-16
C2406 VDD18 VSS 5.270369e-15
C2415 eeg_fd_ota_chopped_full2_0/eeg_fd_ota_core_soft_0/INN VSS 1.709720e-15
C2416 eeg_fd_ota_chopped_full2_0/eeg_fd_ota_core_soft_0/INN eeg_fd_ota_chopped_full2_0/eeg_fd_ota_core_soft_0/INP 4.747254e-15
C2417 eeg_fd_ota_chopped_full2_0/eeg_fd_ota_core_soft_0/INN eeg_tg_lowq_3/B 4.971801e-16
C2418 eeg_fd_ota_chopped_full2_0/eeg_fd_ota_core_soft_0/INN eeg_tg_lowq_7/B 5.135942e-15
C2419 eeg_fd_ota_chopped_full2_0/eeg_fd_ota_core_soft_0/INP VSS 4.881870e-15
C2420 eeg_fd_ota_chopped_full2_0/eeg_fd_ota_core_soft_0/INP eeg_tg_lowq_3/B 5.233646e-16
C2421 eeg_fd_ota_chopped_full2_0/eeg_fd_ota_core_soft_0/INP eeg_tg_lowq_7/B 5.252581e-16
C2422 eeg_tg_lowq_3/B VSS 2.830580e-15
C2423 eeg_tg_lowq_3/B eeg_tg_lowq_7/B 4.996116e-15
C2424 eeg_tg_lowq_7/B VSS 2.659180e-15
C2425 NPHIBI PHIBI 1.215812e-15
C2426 NPHIBI VDD18 5.262242e-16
C2427 NPHIBI VSS 2.537269e-15
C2428 NPHIBI eeg_fd_ota_chopped_full2_0/eeg_fd_ota_core_soft_0/INP 1.076105e-16
C2429 NPHIBI eeg_tg_lowq_3/B 4.755154e-17
C2430 PHIBI VDD18 6.588032e-16
C2431 PHIBI VSS 1.789951e-15
C2432 PHIBI eeg_fd_ota_chopped_full2_0/eeg_fd_ota_core_soft_0/INP 2.857784e-16
C2433 PHIBI eeg_tg_lowq_3/B 1.181323e-16
C2434 VDD18 VSS 3.714735e-15
C2435 VDD18 eeg_fd_ota_chopped_full2_0/eeg_fd_ota_core_soft_0/INP 3.128723e-16
C2436 VDD18 eeg_tg_lowq_3/B 1.484229e-16
C2437 VSS eeg_fd_ota_chopped_full2_0/eeg_fd_ota_core_soft_0/INP 1.097210e-16
C2438 VSS eeg_tg_lowq_3/B 7.819878e-17
C2439 eeg_fd_ota_chopped_full2_0/eeg_fd_ota_core_soft_0/INP VSS 1.462840e-15
C2440 eeg_fd_ota_chopped_full2_0/eeg_fd_ota_core_soft_0/INP eeg_tg_lowq_3/B 1.492117e-15
C2441 eeg_tg_lowq_3/B VSS 2.430800e-15
C2442 PHIBI VDD18 1.564350e-16
C2443 PHIBI VSS 4.901000e-17
C2444 PHIBI eeg_fd_ota_chopped_full2_0/eeg_fd_ota_core_soft_0/INP 2.862080e-17
C2445 VDD18 VSS 1.561810e-15
C2446 VDD18 eeg_fd_ota_chopped_full2_0/eeg_fd_ota_core_soft_0/INP 1.697704e-16
C2447 eeg_fd_ota_chopped_full2_0/eeg_fd_ota_core_soft_0/INP VSS 8.867300e-17
C2448 NPHIBI VSS 2.062020e-16
C2449 NPHIBI eeg_tg_lowq_3/B 2.084120e-17
C2450 eeg_tg_lowq_3/B VSS 1.088312e-16
C2451 NPHIBI VSS 2.062020e-16
C2452 NPHIBI eeg_fd_ota_chopped_full2_0/eeg_fd_ota_core_soft_0/INP 2.084120e-17
C2453 eeg_fd_ota_chopped_full2_0/eeg_fd_ota_core_soft_0/INP VSS 1.088312e-16
C2454 NPHIBI VDD18 1.594600e-16
C2455 NPHIBI VSS 4.382640e-17
C2456 NPHIBI eeg_fd_ota_chopped_full2_0/eeg_fd_ota_core_soft_0/INP 2.402360e-17
C2457 NPHIBI eeg_tg_lowq_3/B 2.402360e-17
C2458 VDD18 VSS 2.327590e-15
C2459 VDD18 eeg_fd_ota_chopped_full2_0/eeg_fd_ota_core_soft_0/INP 1.554040e-16
C2460 VDD18 eeg_tg_lowq_3/B 1.554040e-16
C2461 eeg_fd_ota_chopped_full2_0/eeg_fd_ota_core_soft_0/INP VSS 7.837880e-17
C2462 eeg_fd_ota_chopped_full2_0/eeg_fd_ota_core_soft_0/INP eeg_tg_lowq_3/B 1.170160e-16
C2463 eeg_tg_lowq_3/B VSS 7.837880e-17
C2464 PHIBI VDD18 1.564350e-16
C2465 PHIBI VSS 4.901000e-17
C2466 PHIBI eeg_tg_lowq_3/B 2.862080e-17
C2467 VDD18 VSS 1.561810e-15
C2468 VDD18 eeg_tg_lowq_3/B 1.697704e-16
C2469 eeg_tg_lowq_3/B VSS 8.867300e-17
C2470 PHIBI VSS 2.027230e-16
C2473 eeg_fd_ota_chopped_full2_0/eeg_fd_ota_core_soft_0/INP VSS 1.267930e-16
C2474 eeg_fd_ota_chopped_full2_0/eeg_fd_ota_core_soft_0/INP eeg_tg_lowq_3/B 5.623600e-17
C2475 eeg_tg_lowq_3/B VSS 1.267930e-16
C2476 NPHIBI PHIBI 1.215812e-15
C2477 NPHIBI VDD18 5.262242e-16
C2478 NPHIBI VSS 2.537269e-15
C2479 NPHIBI eeg_fd_ota_chopped_full2_0/eeg_fd_ota_core_soft_0/INN 1.076105e-16
C2480 NPHIBI eeg_tg_lowq_7/B 4.755154e-17
C2481 PHIBI VDD18 6.588032e-16
C2482 PHIBI VSS 1.789951e-15
C2483 PHIBI eeg_fd_ota_chopped_full2_0/eeg_fd_ota_core_soft_0/INN 2.857784e-16
C2484 PHIBI eeg_tg_lowq_7/B 1.181323e-16
C2485 VDD18 VSS 3.714735e-15
C2486 VDD18 eeg_fd_ota_chopped_full2_0/eeg_fd_ota_core_soft_0/INN 3.128723e-16
C2487 VDD18 eeg_tg_lowq_7/B 1.484229e-16
C2488 VSS eeg_fd_ota_chopped_full2_0/eeg_fd_ota_core_soft_0/INN 1.097210e-16
C2489 VSS eeg_tg_lowq_7/B 7.819878e-17
C2490 eeg_fd_ota_chopped_full2_0/eeg_fd_ota_core_soft_0/INN VSS 1.462840e-15
C2491 eeg_fd_ota_chopped_full2_0/eeg_fd_ota_core_soft_0/INN eeg_tg_lowq_7/B 1.492117e-15
C2492 eeg_tg_lowq_7/B VSS 2.430800e-15
C2493 PHIBI VDD18 1.564350e-16
C2494 PHIBI VSS 4.901000e-17
C2495 PHIBI eeg_fd_ota_chopped_full2_0/eeg_fd_ota_core_soft_0/INN 2.862080e-17
C2496 VDD18 VSS 1.561810e-15
C2497 VDD18 eeg_fd_ota_chopped_full2_0/eeg_fd_ota_core_soft_0/INN 1.697704e-16
C2498 eeg_fd_ota_chopped_full2_0/eeg_fd_ota_core_soft_0/INN VSS 8.867300e-17
C2499 NPHIBI VSS 2.062020e-16
C2500 NPHIBI eeg_tg_lowq_7/B 2.084120e-17
C2501 eeg_tg_lowq_7/B VSS 1.088312e-16
C2502 NPHIBI VSS 2.062020e-16
C2503 NPHIBI eeg_fd_ota_chopped_full2_0/eeg_fd_ota_core_soft_0/INN 2.084120e-17
C2504 eeg_fd_ota_chopped_full2_0/eeg_fd_ota_core_soft_0/INN VSS 1.088312e-16
C2505 NPHIBI VDD18 1.594600e-16
C2506 NPHIBI VSS 4.382640e-17
C2507 NPHIBI eeg_fd_ota_chopped_full2_0/eeg_fd_ota_core_soft_0/INN 2.402360e-17
C2508 NPHIBI eeg_tg_lowq_7/B 2.402360e-17
C2509 VDD18 VSS 2.327590e-15
C2510 VDD18 eeg_fd_ota_chopped_full2_0/eeg_fd_ota_core_soft_0/INN 1.554040e-16
C2511 VDD18 eeg_tg_lowq_7/B 1.554040e-16
C2512 eeg_fd_ota_chopped_full2_0/eeg_fd_ota_core_soft_0/INN VSS 7.837880e-17
C2513 eeg_fd_ota_chopped_full2_0/eeg_fd_ota_core_soft_0/INN eeg_tg_lowq_7/B 1.170160e-16
C2514 eeg_tg_lowq_7/B VSS 7.837880e-17
C2515 PHIBI VDD18 1.564350e-16
C2516 PHIBI VSS 4.901000e-17
C2517 PHIBI eeg_tg_lowq_7/B 2.862080e-17
C2518 VDD18 VSS 1.561810e-15
C2519 VDD18 eeg_tg_lowq_7/B 1.697704e-16
C2520 eeg_tg_lowq_7/B VSS 8.867300e-17
C2521 PHIBI VSS 2.027230e-16
C2524 eeg_fd_ota_chopped_full2_0/eeg_fd_ota_core_soft_0/INN VSS 1.267930e-16
C2525 eeg_fd_ota_chopped_full2_0/eeg_fd_ota_core_soft_0/INN eeg_tg_lowq_7/B 5.623600e-17
C2526 eeg_tg_lowq_7/B VSS 1.267930e-16
C2527 NPHII PHII 1.215812e-15
C2528 NPHII VDD18 5.262242e-16
C2529 NPHII VSS 2.537269e-15
C2530 NPHII eeg_fd_ota_chopped_full2_0/eeg_fd_ota_core_soft_0/INN 1.076105e-16
C2531 NPHII eeg_tg_lowq_3/B 4.755154e-17
C2532 PHII VDD18 6.588032e-16
C2533 PHII VSS 1.789951e-15
C2534 PHII eeg_fd_ota_chopped_full2_0/eeg_fd_ota_core_soft_0/INN 2.857784e-16
C2535 PHII eeg_tg_lowq_3/B 1.181323e-16
C2536 VDD18 VSS 3.714735e-15
C2537 VDD18 eeg_fd_ota_chopped_full2_0/eeg_fd_ota_core_soft_0/INN 3.128723e-16
C2538 VDD18 eeg_tg_lowq_3/B 1.484229e-16
C2539 VSS eeg_fd_ota_chopped_full2_0/eeg_fd_ota_core_soft_0/INN 1.097210e-16
C2540 VSS eeg_tg_lowq_3/B 7.819878e-17
C2541 eeg_fd_ota_chopped_full2_0/eeg_fd_ota_core_soft_0/INN VSS 1.462840e-15
C2542 eeg_fd_ota_chopped_full2_0/eeg_fd_ota_core_soft_0/INN eeg_tg_lowq_3/B 1.492117e-15
C2543 eeg_tg_lowq_3/B VSS 2.430800e-15
C2544 PHII VDD18 1.564350e-16
C2545 PHII VSS 4.901000e-17
C2546 PHII eeg_fd_ota_chopped_full2_0/eeg_fd_ota_core_soft_0/INN 2.862080e-17
C2547 VDD18 VSS 1.561810e-15
C2548 VDD18 eeg_fd_ota_chopped_full2_0/eeg_fd_ota_core_soft_0/INN 1.697704e-16
C2549 eeg_fd_ota_chopped_full2_0/eeg_fd_ota_core_soft_0/INN VSS 8.867300e-17
C2550 NPHII VSS 2.062020e-16
C2551 NPHII eeg_tg_lowq_3/B 2.084120e-17
C2552 eeg_tg_lowq_3/B VSS 1.088312e-16
C2553 NPHII VSS 2.062020e-16
C2554 NPHII eeg_fd_ota_chopped_full2_0/eeg_fd_ota_core_soft_0/INN 2.084120e-17
C2555 eeg_fd_ota_chopped_full2_0/eeg_fd_ota_core_soft_0/INN VSS 1.088312e-16
C2556 NPHII VDD18 1.594600e-16
C2557 NPHII VSS 4.382640e-17
C2558 NPHII eeg_fd_ota_chopped_full2_0/eeg_fd_ota_core_soft_0/INN 2.402360e-17
C2559 NPHII eeg_tg_lowq_3/B 2.402360e-17
C2560 VDD18 VSS 2.327590e-15
C2561 VDD18 eeg_fd_ota_chopped_full2_0/eeg_fd_ota_core_soft_0/INN 1.554040e-16
C2562 VDD18 eeg_tg_lowq_3/B 1.554040e-16
C2563 eeg_fd_ota_chopped_full2_0/eeg_fd_ota_core_soft_0/INN VSS 7.837880e-17
C2564 eeg_fd_ota_chopped_full2_0/eeg_fd_ota_core_soft_0/INN eeg_tg_lowq_3/B 1.170160e-16
C2565 eeg_tg_lowq_3/B VSS 7.837880e-17
C2566 PHII VDD18 1.564350e-16
C2567 PHII VSS 4.901000e-17
C2568 PHII eeg_tg_lowq_3/B 2.862080e-17
C2569 VDD18 VSS 1.561810e-15
C2570 VDD18 eeg_tg_lowq_3/B 1.697704e-16
C2571 eeg_tg_lowq_3/B VSS 8.867300e-17
C2572 PHII VSS 2.027230e-16
C2575 eeg_fd_ota_chopped_full2_0/eeg_fd_ota_core_soft_0/INN VSS 1.267930e-16
C2576 eeg_fd_ota_chopped_full2_0/eeg_fd_ota_core_soft_0/INN eeg_tg_lowq_3/B 5.623600e-17
C2577 eeg_tg_lowq_3/B VSS 1.267930e-16
C2578 NPHII PHII 1.215812e-15
C2579 NPHII VDD18 5.262242e-16
C2580 NPHII VSS 2.537269e-15
C2581 NPHII eeg_fd_ota_chopped_full2_0/eeg_fd_ota_core_soft_0/INP 1.076105e-16
C2582 NPHII eeg_tg_lowq_7/B 4.755154e-17
C2583 PHII VDD18 6.588032e-16
C2584 PHII VSS 1.789951e-15
C2585 PHII eeg_fd_ota_chopped_full2_0/eeg_fd_ota_core_soft_0/INP 2.857784e-16
C2586 PHII eeg_tg_lowq_7/B 1.181323e-16
C2587 VDD18 VSS 3.714735e-15
C2588 VDD18 eeg_fd_ota_chopped_full2_0/eeg_fd_ota_core_soft_0/INP 3.128723e-16
C2589 VDD18 eeg_tg_lowq_7/B 1.484229e-16
C2590 VSS eeg_fd_ota_chopped_full2_0/eeg_fd_ota_core_soft_0/INP 1.097210e-16
C2591 VSS eeg_tg_lowq_7/B 7.819878e-17
C2592 eeg_fd_ota_chopped_full2_0/eeg_fd_ota_core_soft_0/INP VSS 1.462840e-15
C2593 eeg_fd_ota_chopped_full2_0/eeg_fd_ota_core_soft_0/INP eeg_tg_lowq_7/B 1.492117e-15
C2594 eeg_tg_lowq_7/B VSS 2.430800e-15
C2595 PHII VDD18 1.564350e-16
C2596 PHII VSS 4.901000e-17
C2597 PHII eeg_fd_ota_chopped_full2_0/eeg_fd_ota_core_soft_0/INP 2.862080e-17
C2598 VDD18 VSS 1.561810e-15
C2599 VDD18 eeg_fd_ota_chopped_full2_0/eeg_fd_ota_core_soft_0/INP 1.697704e-16
C2600 eeg_fd_ota_chopped_full2_0/eeg_fd_ota_core_soft_0/INP VSS 8.867300e-17
C2601 NPHII VSS 2.062020e-16
C2602 NPHII eeg_tg_lowq_7/B 2.084120e-17
C2603 eeg_tg_lowq_7/B VSS 1.088312e-16
C2604 NPHII VSS 2.062020e-16
C2605 NPHII eeg_fd_ota_chopped_full2_0/eeg_fd_ota_core_soft_0/INP 2.084120e-17
C2606 eeg_fd_ota_chopped_full2_0/eeg_fd_ota_core_soft_0/INP VSS 1.088312e-16
C2607 NPHII VDD18 1.594600e-16
C2608 NPHII VSS 4.382640e-17
C2609 NPHII eeg_fd_ota_chopped_full2_0/eeg_fd_ota_core_soft_0/INP 2.402360e-17
C2610 NPHII eeg_tg_lowq_7/B 2.402360e-17
C2611 VDD18 VSS 2.327590e-15
C2612 VDD18 eeg_fd_ota_chopped_full2_0/eeg_fd_ota_core_soft_0/INP 1.554040e-16
C2613 VDD18 eeg_tg_lowq_7/B 1.554040e-16
C2614 eeg_fd_ota_chopped_full2_0/eeg_fd_ota_core_soft_0/INP VSS 7.837880e-17
C2615 eeg_fd_ota_chopped_full2_0/eeg_fd_ota_core_soft_0/INP eeg_tg_lowq_7/B 1.170160e-16
C2616 eeg_tg_lowq_7/B VSS 7.837880e-17
C2617 PHII VDD18 1.564350e-16
C2618 PHII VSS 4.901000e-17
C2619 PHII eeg_tg_lowq_7/B 2.862080e-17
C2620 VDD18 VSS 1.561810e-15
C2621 VDD18 eeg_tg_lowq_7/B 1.697704e-16
C2622 eeg_tg_lowq_7/B VSS 8.867300e-17
C2623 PHII VSS 2.027230e-16
C2626 eeg_fd_ota_chopped_full2_0/eeg_fd_ota_core_soft_0/INP VSS 1.267930e-16
C2627 eeg_fd_ota_chopped_full2_0/eeg_fd_ota_core_soft_0/INP eeg_tg_lowq_7/B 5.623600e-17
C2628 eeg_tg_lowq_7/B VSS 1.267930e-16
C2629 VCM_REF VDD18 2.703258e-17
C2630 VCM_REF VSS 3.540900e-14
C2632 VCM_REF eeg_fd_ota_chopped_full2_0/eeg_cmfb_amp_dl2_0/VCM_SENSE 1.587590e-14
C2635 VCM_REF eeg_fd_ota_chopped_full2_0/eeg_fd_ota_core_soft_0/m1_51141_3443# 7.672760e-17
C2637 VCM_REF eeg_fd_ota_chopped_full2_0/eeg_fd_ota_core_soft_0/m1_n51659_3443# 7.672760e-17
C2639 VDD18 VSS 1.621650e-14
C2640 VDD18 eeg_fd_ota_chopped_full2_0/eeg_cmfb_amp_dl2_0/VBP 3.427693e-15
C2641 VDD18 eeg_fd_ota_chopped_full2_0/eeg_cmfb_amp_dl2_0/VCM_SENSE 4.825121e-15
C2642 VDD18 eeg_fd_ota_chopped_full2_0/eeg_fd_ota_core_soft_0/INN 2.563693e-17
C2643 VDD18 eeg_fd_ota_chopped_full2_0/eeg_fd_ota_core_soft_0/INP 2.022347e-16
C2644 VDD18 eeg_fd_ota_chopped_full2_0/eeg_fd_ota_core_soft_0/OUTN 2.666394e-16
C2645 VDD18 eeg_fd_ota_chopped_full2_0/eeg_fd_ota_core_soft_0/OUTP 2.827840e-16
C2646 VSS eeg_fd_ota_chopped_full2_0/eeg_bias_gen_0/VBNF 3.521512e-15
C2647 VSS eeg_fd_ota_chopped_full2_0/eeg_fd_ota_core_soft_0/INN 1.319906e-14
C2648 VSS eeg_fd_ota_chopped_full2_0/eeg_fd_ota_core_soft_0/INP 2.891675e-15
C2649 VSS eeg_fd_ota_chopped_full2_0/eeg_fd_ota_core_soft_0/OUTN 1.737419e-15
C2650 VSS eeg_fd_ota_chopped_full2_0/eeg_fd_ota_core_soft_0/OUTP 8.481620e-16
C2651 VSS eeg_fd_ota_chopped_full2_0/eeg_fd_ota_core_soft_0/m1_n22658_111# 2.612991e-14
C2652 eeg_fd_ota_chopped_full2_0/eeg_bias_gen_0/VBNF VSS 6.189670e-15
C2653 eeg_fd_ota_chopped_full2_0/eeg_bias_gen_0/VBNF eeg_fd_ota_chopped_full2_0/eeg_fd_ota_core_soft_0/INN 6.911931e-17
C2654 eeg_fd_ota_chopped_full2_0/eeg_bias_gen_0/VBNF eeg_fd_ota_chopped_full2_0/eeg_fd_ota_core_soft_0/INP 6.042561e-17
C2655 eeg_fd_ota_chopped_full2_0/eeg_bias_gen_0/VBNF eeg_fd_ota_chopped_full2_0/eeg_fd_ota_core_soft_0/m1_n22658_111# 6.839995e-16
C2656 eeg_fd_ota_chopped_full2_0/eeg_cmfb_amp_dl2_0/VBP VSS 1.400120e-14
C2658 eeg_fd_ota_chopped_full2_0/eeg_cmfb_amp_dl2_0/VBP eeg_fd_ota_chopped_full2_0/eeg_fd_ota_core_soft_0/INN 6.164535e-17
C2659 eeg_fd_ota_chopped_full2_0/eeg_cmfb_amp_dl2_0/VBP eeg_fd_ota_chopped_full2_0/eeg_fd_ota_core_soft_0/INP 6.844558e-16
C2660 eeg_fd_ota_chopped_full2_0/eeg_cmfb_amp_dl2_0/VBP eeg_fd_ota_chopped_full2_0/eeg_fd_ota_core_soft_0/OUTN 7.668368e-16
C2661 eeg_fd_ota_chopped_full2_0/eeg_cmfb_amp_dl2_0/VBP eeg_fd_ota_chopped_full2_0/eeg_fd_ota_core_soft_0/OUTP 7.875883e-16
C2662 eeg_fd_ota_chopped_full2_0/eeg_cmfb_amp_dl2_0/VCM_SENSE VSS 2.834530e-14
C2665 eeg_fd_ota_chopped_full2_0/eeg_cmfb_amp_dl2_0/VCM_SENSE eeg_fd_ota_chopped_full2_0/eeg_fd_ota_core_soft_0/m1_28741_3443# 7.672760e-17
C2667 eeg_fd_ota_chopped_full2_0/eeg_cmfb_amp_dl2_0/VCM_SENSE eeg_fd_ota_chopped_full2_0/eeg_fd_ota_core_soft_0/m1_n29259_3443# 7.672760e-17
C2669 eeg_fd_ota_chopped_full2_0/eeg_fd_ota_core_soft_0/INN VSS 1.448180e-14
C2670 eeg_fd_ota_chopped_full2_0/eeg_fd_ota_core_soft_0/INN eeg_fd_ota_chopped_full2_0/eeg_fd_ota_core_soft_0/INP 2.623505e-14
C2671 eeg_fd_ota_chopped_full2_0/eeg_fd_ota_core_soft_0/INN eeg_fd_ota_chopped_full2_0/eeg_fd_ota_core_soft_0/OUTN 7.379468e-15
C2672 eeg_fd_ota_chopped_full2_0/eeg_fd_ota_core_soft_0/INN eeg_fd_ota_chopped_full2_0/eeg_fd_ota_core_soft_0/OUTP 1.018187e-14
C2673 eeg_fd_ota_chopped_full2_0/eeg_fd_ota_core_soft_0/INN eeg_fd_ota_chopped_full2_0/eeg_fd_ota_core_soft_0/m1_n22658_111# 4.063561e-15
C2674 eeg_fd_ota_chopped_full2_0/eeg_fd_ota_core_soft_0/INP VSS 3.261730e-14
C2675 eeg_fd_ota_chopped_full2_0/eeg_fd_ota_core_soft_0/INP eeg_fd_ota_chopped_full2_0/eeg_fd_ota_core_soft_0/OUTN 6.641364e-15
C2676 eeg_fd_ota_chopped_full2_0/eeg_fd_ota_core_soft_0/INP eeg_fd_ota_chopped_full2_0/eeg_fd_ota_core_soft_0/OUTP 3.395166e-15
C2677 eeg_fd_ota_chopped_full2_0/eeg_fd_ota_core_soft_0/INP eeg_fd_ota_chopped_full2_0/eeg_fd_ota_core_soft_0/m1_n22658_111# 4.388117e-15
C2678 eeg_fd_ota_chopped_full2_0/eeg_fd_ota_core_soft_0/OUTN VSS 3.542310e-14
C2679 eeg_fd_ota_chopped_full2_0/eeg_fd_ota_core_soft_0/OUTN eeg_fd_ota_chopped_full2_0/eeg_fd_ota_core_soft_0/OUTP 9.928293e-15
C2703 eeg_fd_ota_chopped_full2_0/eeg_fd_ota_core_soft_0/OUTN eeg_fd_ota_chopped_full2_0/eeg_fd_ota_core_soft_0/m1_47141_3443# 9.923910e-17
C2712 eeg_fd_ota_chopped_full2_0/eeg_fd_ota_core_soft_0/OUTN eeg_fd_ota_chopped_full2_0/eeg_fd_ota_core_soft_0/m1_57541_3443# 9.923911e-17
C2713 eeg_fd_ota_chopped_full2_0/eeg_fd_ota_core_soft_0/OUTN eeg_fd_ota_chopped_full2_0/eeg_fd_ota_core_soft_0/m1_n22658_111# 3.475590e-16
C2714 eeg_fd_ota_chopped_full2_0/eeg_fd_ota_core_soft_0/OUTP VSS 2.763250e-14
C2715 eeg_fd_ota_chopped_full2_0/eeg_fd_ota_core_soft_0/OUTP eeg_fd_ota_chopped_full2_0/eeg_fd_ota_core_soft_0/m1_n22658_111# 5.910065e-17
C2739 eeg_fd_ota_chopped_full2_0/eeg_fd_ota_core_soft_0/OUTP eeg_fd_ota_chopped_full2_0/eeg_fd_ota_core_soft_0/m1_n47659_3443# 1.052830e-16
C2748 eeg_fd_ota_chopped_full2_0/eeg_fd_ota_core_soft_0/OUTP eeg_fd_ota_chopped_full2_0/eeg_fd_ota_core_soft_0/m1_n58059_3443# 1.052831e-16
C2749 eeg_fd_ota_chopped_full2_0/eeg_fd_ota_core_soft_0/m1_28341_n3864# VSS 4.702790e-16
C2750 eeg_fd_ota_chopped_full2_0/eeg_fd_ota_core_soft_0/m1_28341_n3864# eeg_fd_ota_chopped_full2_0/eeg_fd_ota_core_soft_0/m1_29141_n3864# 6.789050e-17
C2751 eeg_fd_ota_chopped_full2_0/eeg_fd_ota_core_soft_0/m1_28741_3443# VSS 4.622480e-16
C2752 eeg_fd_ota_chopped_full2_0/eeg_fd_ota_core_soft_0/m1_28741_3443# eeg_fd_ota_chopped_full2_0/eeg_fd_ota_core_soft_0/m1_29541_3443# 6.789050e-17
C2753 eeg_fd_ota_chopped_full2_0/eeg_fd_ota_core_soft_0/m1_29141_n3864# VSS 4.190540e-16
C2754 eeg_fd_ota_chopped_full2_0/eeg_fd_ota_core_soft_0/m1_29141_n3864# eeg_fd_ota_chopped_full2_0/eeg_fd_ota_core_soft_0/m1_29941_n3864# 6.789040e-17
C2755 eeg_fd_ota_chopped_full2_0/eeg_fd_ota_core_soft_0/m1_29541_3443# VSS 4.190540e-16
C2756 eeg_fd_ota_chopped_full2_0/eeg_fd_ota_core_soft_0/m1_29541_3443# eeg_fd_ota_chopped_full2_0/eeg_fd_ota_core_soft_0/m1_30341_3443# 6.789050e-17
C2757 eeg_fd_ota_chopped_full2_0/eeg_fd_ota_core_soft_0/m1_29941_n3864# VSS 4.190540e-16
C2758 eeg_fd_ota_chopped_full2_0/eeg_fd_ota_core_soft_0/m1_29941_n3864# eeg_fd_ota_chopped_full2_0/eeg_fd_ota_core_soft_0/m1_30741_n3864# 6.789050e-17
C2759 eeg_fd_ota_chopped_full2_0/eeg_fd_ota_core_soft_0/m1_30341_3443# VSS 4.190540e-16
C2760 eeg_fd_ota_chopped_full2_0/eeg_fd_ota_core_soft_0/m1_30341_3443# eeg_fd_ota_chopped_full2_0/eeg_fd_ota_core_soft_0/m1_31141_3443# 6.789050e-17
C2761 eeg_fd_ota_chopped_full2_0/eeg_fd_ota_core_soft_0/m1_30741_n3864# VSS 4.190540e-16
C2762 eeg_fd_ota_chopped_full2_0/eeg_fd_ota_core_soft_0/m1_30741_n3864# eeg_fd_ota_chopped_full2_0/eeg_fd_ota_core_soft_0/m1_31541_n3864# 6.789040e-17
C2763 eeg_fd_ota_chopped_full2_0/eeg_fd_ota_core_soft_0/m1_31141_3443# VSS 4.190540e-16
C2764 eeg_fd_ota_chopped_full2_0/eeg_fd_ota_core_soft_0/m1_31141_3443# eeg_fd_ota_chopped_full2_0/eeg_fd_ota_core_soft_0/m1_31941_3443# 6.789050e-17
C2765 eeg_fd_ota_chopped_full2_0/eeg_fd_ota_core_soft_0/m1_31541_n3864# VSS 4.190540e-16
C2766 eeg_fd_ota_chopped_full2_0/eeg_fd_ota_core_soft_0/m1_31541_n3864# eeg_fd_ota_chopped_full2_0/eeg_fd_ota_core_soft_0/m1_32341_n3864# 6.789050e-17
C2767 eeg_fd_ota_chopped_full2_0/eeg_fd_ota_core_soft_0/m1_31941_3443# VSS 4.190540e-16
C2768 eeg_fd_ota_chopped_full2_0/eeg_fd_ota_core_soft_0/m1_31941_3443# eeg_fd_ota_chopped_full2_0/eeg_fd_ota_core_soft_0/m1_32741_3443# 6.789040e-17
C2769 eeg_fd_ota_chopped_full2_0/eeg_fd_ota_core_soft_0/m1_32341_n3864# VSS 4.190540e-16
C2770 eeg_fd_ota_chopped_full2_0/eeg_fd_ota_core_soft_0/m1_32341_n3864# eeg_fd_ota_chopped_full2_0/eeg_fd_ota_core_soft_0/m1_33141_n3864# 6.789050e-17
C2771 eeg_fd_ota_chopped_full2_0/eeg_fd_ota_core_soft_0/m1_32741_3443# VSS 4.190540e-16
C2772 eeg_fd_ota_chopped_full2_0/eeg_fd_ota_core_soft_0/m1_32741_3443# eeg_fd_ota_chopped_full2_0/eeg_fd_ota_core_soft_0/m1_33541_3443# 6.789050e-17
C2773 eeg_fd_ota_chopped_full2_0/eeg_fd_ota_core_soft_0/m1_33141_n3864# VSS 4.190540e-16
C2774 eeg_fd_ota_chopped_full2_0/eeg_fd_ota_core_soft_0/m1_33141_n3864# eeg_fd_ota_chopped_full2_0/eeg_fd_ota_core_soft_0/m1_33941_n3864# 6.789050e-17
C2775 eeg_fd_ota_chopped_full2_0/eeg_fd_ota_core_soft_0/m1_33541_3443# VSS 4.190540e-16
C2776 eeg_fd_ota_chopped_full2_0/eeg_fd_ota_core_soft_0/m1_33541_3443# eeg_fd_ota_chopped_full2_0/eeg_fd_ota_core_soft_0/m1_34341_3443# 6.789040e-17
C2777 eeg_fd_ota_chopped_full2_0/eeg_fd_ota_core_soft_0/m1_33941_n3864# VSS 4.190540e-16
C2778 eeg_fd_ota_chopped_full2_0/eeg_fd_ota_core_soft_0/m1_33941_n3864# eeg_fd_ota_chopped_full2_0/eeg_fd_ota_core_soft_0/m1_34741_n3864# 6.789050e-17
C2779 eeg_fd_ota_chopped_full2_0/eeg_fd_ota_core_soft_0/m1_34341_3443# VSS 4.190540e-16
C2780 eeg_fd_ota_chopped_full2_0/eeg_fd_ota_core_soft_0/m1_34341_3443# eeg_fd_ota_chopped_full2_0/eeg_fd_ota_core_soft_0/m1_35141_3443# 6.789050e-17
C2781 eeg_fd_ota_chopped_full2_0/eeg_fd_ota_core_soft_0/m1_34741_n3864# VSS 4.190540e-16
C2782 eeg_fd_ota_chopped_full2_0/eeg_fd_ota_core_soft_0/m1_34741_n3864# eeg_fd_ota_chopped_full2_0/eeg_fd_ota_core_soft_0/m1_35541_n3864# 6.789040e-17
C2783 eeg_fd_ota_chopped_full2_0/eeg_fd_ota_core_soft_0/m1_35141_3443# VSS 4.190540e-16
C2784 eeg_fd_ota_chopped_full2_0/eeg_fd_ota_core_soft_0/m1_35141_3443# eeg_fd_ota_chopped_full2_0/eeg_fd_ota_core_soft_0/m1_35941_3443# 6.789050e-17
C2785 eeg_fd_ota_chopped_full2_0/eeg_fd_ota_core_soft_0/m1_35541_n3864# VSS 4.190540e-16
C2786 eeg_fd_ota_chopped_full2_0/eeg_fd_ota_core_soft_0/m1_35541_n3864# eeg_fd_ota_chopped_full2_0/eeg_fd_ota_core_soft_0/m1_36341_n3864# 6.789050e-17
C2787 eeg_fd_ota_chopped_full2_0/eeg_fd_ota_core_soft_0/m1_35941_3443# VSS 4.190540e-16
C2788 eeg_fd_ota_chopped_full2_0/eeg_fd_ota_core_soft_0/m1_35941_3443# eeg_fd_ota_chopped_full2_0/eeg_fd_ota_core_soft_0/m1_36741_3443# 6.789050e-17
C2789 eeg_fd_ota_chopped_full2_0/eeg_fd_ota_core_soft_0/m1_36341_n3864# VSS 4.190540e-16
C2790 eeg_fd_ota_chopped_full2_0/eeg_fd_ota_core_soft_0/m1_36341_n3864# eeg_fd_ota_chopped_full2_0/eeg_fd_ota_core_soft_0/m1_37141_n3864# 6.789040e-17
C2791 eeg_fd_ota_chopped_full2_0/eeg_fd_ota_core_soft_0/m1_36741_3443# VSS 4.190540e-16
C2792 eeg_fd_ota_chopped_full2_0/eeg_fd_ota_core_soft_0/m1_36741_3443# eeg_fd_ota_chopped_full2_0/eeg_fd_ota_core_soft_0/m1_37541_3443# 6.789050e-17
C2793 eeg_fd_ota_chopped_full2_0/eeg_fd_ota_core_soft_0/m1_37141_n3864# VSS 4.190540e-16
C2794 eeg_fd_ota_chopped_full2_0/eeg_fd_ota_core_soft_0/m1_37141_n3864# eeg_fd_ota_chopped_full2_0/eeg_fd_ota_core_soft_0/m1_37941_n3864# 6.789050e-17
C2795 eeg_fd_ota_chopped_full2_0/eeg_fd_ota_core_soft_0/m1_37541_3443# VSS 4.190540e-16
C2796 eeg_fd_ota_chopped_full2_0/eeg_fd_ota_core_soft_0/m1_37541_3443# eeg_fd_ota_chopped_full2_0/eeg_fd_ota_core_soft_0/m1_38341_3443# 6.789040e-17
C2797 eeg_fd_ota_chopped_full2_0/eeg_fd_ota_core_soft_0/m1_37941_n3864# VSS 4.190540e-16
C2798 eeg_fd_ota_chopped_full2_0/eeg_fd_ota_core_soft_0/m1_37941_n3864# eeg_fd_ota_chopped_full2_0/eeg_fd_ota_core_soft_0/m1_38741_n3864# 6.789050e-17
C2799 eeg_fd_ota_chopped_full2_0/eeg_fd_ota_core_soft_0/m1_38341_3443# VSS 4.190540e-16
C2800 eeg_fd_ota_chopped_full2_0/eeg_fd_ota_core_soft_0/m1_38341_3443# eeg_fd_ota_chopped_full2_0/eeg_fd_ota_core_soft_0/m1_39141_3443# 6.789050e-17
C2801 eeg_fd_ota_chopped_full2_0/eeg_fd_ota_core_soft_0/m1_38741_n3864# VSS 4.190540e-16
C2802 eeg_fd_ota_chopped_full2_0/eeg_fd_ota_core_soft_0/m1_38741_n3864# eeg_fd_ota_chopped_full2_0/eeg_fd_ota_core_soft_0/m1_39541_n3864# 6.789050e-17
C2803 eeg_fd_ota_chopped_full2_0/eeg_fd_ota_core_soft_0/m1_39141_3443# VSS 4.190540e-16
C2804 eeg_fd_ota_chopped_full2_0/eeg_fd_ota_core_soft_0/m1_39141_3443# eeg_fd_ota_chopped_full2_0/eeg_fd_ota_core_soft_0/m1_39941_3443# 6.789040e-17
C2805 eeg_fd_ota_chopped_full2_0/eeg_fd_ota_core_soft_0/m1_39541_n3864# VSS 4.190540e-16
C2806 eeg_fd_ota_chopped_full2_0/eeg_fd_ota_core_soft_0/m1_39541_n3864# eeg_fd_ota_chopped_full2_0/eeg_fd_ota_core_soft_0/m1_40341_n3864# 6.789050e-17
C2807 eeg_fd_ota_chopped_full2_0/eeg_fd_ota_core_soft_0/m1_39941_3443# VSS 4.190540e-16
C2808 eeg_fd_ota_chopped_full2_0/eeg_fd_ota_core_soft_0/m1_39941_3443# eeg_fd_ota_chopped_full2_0/eeg_fd_ota_core_soft_0/m1_40741_3443# 6.789050e-17
C2809 eeg_fd_ota_chopped_full2_0/eeg_fd_ota_core_soft_0/m1_40341_n3864# VSS 4.190540e-16
C2810 eeg_fd_ota_chopped_full2_0/eeg_fd_ota_core_soft_0/m1_40341_n3864# eeg_fd_ota_chopped_full2_0/eeg_fd_ota_core_soft_0/m1_41141_n3864# 6.789040e-17
C2811 eeg_fd_ota_chopped_full2_0/eeg_fd_ota_core_soft_0/m1_40741_3443# VSS 4.190540e-16
C2812 eeg_fd_ota_chopped_full2_0/eeg_fd_ota_core_soft_0/m1_40741_3443# eeg_fd_ota_chopped_full2_0/eeg_fd_ota_core_soft_0/m1_41541_3443# 6.789050e-17
C2813 eeg_fd_ota_chopped_full2_0/eeg_fd_ota_core_soft_0/m1_41141_n3864# VSS 4.190540e-16
C2814 eeg_fd_ota_chopped_full2_0/eeg_fd_ota_core_soft_0/m1_41141_n3864# eeg_fd_ota_chopped_full2_0/eeg_fd_ota_core_soft_0/m1_41941_n3864# 6.789050e-17
C2815 eeg_fd_ota_chopped_full2_0/eeg_fd_ota_core_soft_0/m1_41541_3443# VSS 4.190540e-16
C2816 eeg_fd_ota_chopped_full2_0/eeg_fd_ota_core_soft_0/m1_41541_3443# eeg_fd_ota_chopped_full2_0/eeg_fd_ota_core_soft_0/m1_42341_3443# 6.789050e-17
C2817 eeg_fd_ota_chopped_full2_0/eeg_fd_ota_core_soft_0/m1_41941_n3864# VSS 4.190540e-16
C2818 eeg_fd_ota_chopped_full2_0/eeg_fd_ota_core_soft_0/m1_41941_n3864# eeg_fd_ota_chopped_full2_0/eeg_fd_ota_core_soft_0/m1_42741_n3864# 6.789040e-17
C2819 eeg_fd_ota_chopped_full2_0/eeg_fd_ota_core_soft_0/m1_42341_3443# VSS 4.190540e-16
C2820 eeg_fd_ota_chopped_full2_0/eeg_fd_ota_core_soft_0/m1_42341_3443# eeg_fd_ota_chopped_full2_0/eeg_fd_ota_core_soft_0/m1_43141_3443# 6.789050e-17
C2821 eeg_fd_ota_chopped_full2_0/eeg_fd_ota_core_soft_0/m1_42741_n3864# VSS 4.190540e-16
C2822 eeg_fd_ota_chopped_full2_0/eeg_fd_ota_core_soft_0/m1_42741_n3864# eeg_fd_ota_chopped_full2_0/eeg_fd_ota_core_soft_0/m1_43541_n3864# 6.789050e-17
C2823 eeg_fd_ota_chopped_full2_0/eeg_fd_ota_core_soft_0/m1_43141_3443# VSS 4.190540e-16
C2824 eeg_fd_ota_chopped_full2_0/eeg_fd_ota_core_soft_0/m1_43141_3443# eeg_fd_ota_chopped_full2_0/eeg_fd_ota_core_soft_0/m1_43941_3443# 6.789040e-17
C2825 eeg_fd_ota_chopped_full2_0/eeg_fd_ota_core_soft_0/m1_43541_n3864# VSS 4.190540e-16
C2826 eeg_fd_ota_chopped_full2_0/eeg_fd_ota_core_soft_0/m1_43541_n3864# eeg_fd_ota_chopped_full2_0/eeg_fd_ota_core_soft_0/m1_44341_n3864# 6.789050e-17
C2827 eeg_fd_ota_chopped_full2_0/eeg_fd_ota_core_soft_0/m1_43941_3443# VSS 4.190540e-16
C2828 eeg_fd_ota_chopped_full2_0/eeg_fd_ota_core_soft_0/m1_43941_3443# eeg_fd_ota_chopped_full2_0/eeg_fd_ota_core_soft_0/m1_44741_3443# 6.789050e-17
C2829 eeg_fd_ota_chopped_full2_0/eeg_fd_ota_core_soft_0/m1_44341_n3864# VSS 4.190540e-16
C2830 eeg_fd_ota_chopped_full2_0/eeg_fd_ota_core_soft_0/m1_44341_n3864# eeg_fd_ota_chopped_full2_0/eeg_fd_ota_core_soft_0/m1_45141_n3864# 6.789050e-17
C2831 eeg_fd_ota_chopped_full2_0/eeg_fd_ota_core_soft_0/m1_44741_3443# VSS 4.190540e-16
C2832 eeg_fd_ota_chopped_full2_0/eeg_fd_ota_core_soft_0/m1_44741_3443# eeg_fd_ota_chopped_full2_0/eeg_fd_ota_core_soft_0/m1_45541_3443# 6.789040e-17
C2833 eeg_fd_ota_chopped_full2_0/eeg_fd_ota_core_soft_0/m1_45141_n3864# VSS 4.190540e-16
C2834 eeg_fd_ota_chopped_full2_0/eeg_fd_ota_core_soft_0/m1_45141_n3864# eeg_fd_ota_chopped_full2_0/eeg_fd_ota_core_soft_0/m1_45941_n3864# 6.789050e-17
C2835 eeg_fd_ota_chopped_full2_0/eeg_fd_ota_core_soft_0/m1_45541_3443# VSS 4.190540e-16
C2836 eeg_fd_ota_chopped_full2_0/eeg_fd_ota_core_soft_0/m1_45541_3443# eeg_fd_ota_chopped_full2_0/eeg_fd_ota_core_soft_0/m1_46341_3443# 6.789050e-17
C2837 eeg_fd_ota_chopped_full2_0/eeg_fd_ota_core_soft_0/m1_45941_n3864# VSS 4.190540e-16
C2838 eeg_fd_ota_chopped_full2_0/eeg_fd_ota_core_soft_0/m1_45941_n3864# eeg_fd_ota_chopped_full2_0/eeg_fd_ota_core_soft_0/m1_46741_n3864# 6.789040e-17
C2839 eeg_fd_ota_chopped_full2_0/eeg_fd_ota_core_soft_0/m1_46341_3443# VSS 4.190540e-16
C2840 eeg_fd_ota_chopped_full2_0/eeg_fd_ota_core_soft_0/m1_46341_3443# eeg_fd_ota_chopped_full2_0/eeg_fd_ota_core_soft_0/m1_47141_3443# 6.789050e-17
C2841 eeg_fd_ota_chopped_full2_0/eeg_fd_ota_core_soft_0/m1_46741_n3864# VSS 4.190540e-16
C2842 eeg_fd_ota_chopped_full2_0/eeg_fd_ota_core_soft_0/m1_46741_n3864# eeg_fd_ota_chopped_full2_0/eeg_fd_ota_core_soft_0/m1_47541_n3864# 6.789050e-17
C2843 eeg_fd_ota_chopped_full2_0/eeg_fd_ota_core_soft_0/m1_47141_3443# VSS 4.607340e-16
C2844 eeg_fd_ota_chopped_full2_0/eeg_fd_ota_core_soft_0/m1_47541_n3864# VSS 4.702790e-16
C2845 eeg_fd_ota_chopped_full2_0/eeg_fd_ota_core_soft_0/m1_50741_n3864# VSS 4.702790e-16
C2846 eeg_fd_ota_chopped_full2_0/eeg_fd_ota_core_soft_0/m1_50741_n3864# eeg_fd_ota_chopped_full2_0/eeg_fd_ota_core_soft_0/m1_51541_n3864# 6.789050e-17
C2847 eeg_fd_ota_chopped_full2_0/eeg_fd_ota_core_soft_0/m1_51141_3443# VSS 4.622480e-16
C2848 eeg_fd_ota_chopped_full2_0/eeg_fd_ota_core_soft_0/m1_51141_3443# eeg_fd_ota_chopped_full2_0/eeg_fd_ota_core_soft_0/m1_51941_3443# 6.789050e-17
C2849 eeg_fd_ota_chopped_full2_0/eeg_fd_ota_core_soft_0/m1_51541_n3864# VSS 4.190540e-16
C2850 eeg_fd_ota_chopped_full2_0/eeg_fd_ota_core_soft_0/m1_51541_n3864# eeg_fd_ota_chopped_full2_0/eeg_fd_ota_core_soft_0/m1_52341_n3864# 6.789040e-17
C2851 eeg_fd_ota_chopped_full2_0/eeg_fd_ota_core_soft_0/m1_51941_3443# VSS 4.190540e-16
C2852 eeg_fd_ota_chopped_full2_0/eeg_fd_ota_core_soft_0/m1_51941_3443# eeg_fd_ota_chopped_full2_0/eeg_fd_ota_core_soft_0/m1_52741_3443# 6.789050e-17
C2853 eeg_fd_ota_chopped_full2_0/eeg_fd_ota_core_soft_0/m1_52341_n3864# VSS 4.190540e-16
C2854 eeg_fd_ota_chopped_full2_0/eeg_fd_ota_core_soft_0/m1_52341_n3864# eeg_fd_ota_chopped_full2_0/eeg_fd_ota_core_soft_0/m1_53141_n3864# 6.789050e-17
C2855 eeg_fd_ota_chopped_full2_0/eeg_fd_ota_core_soft_0/m1_52741_3443# VSS 4.190540e-16
C2856 eeg_fd_ota_chopped_full2_0/eeg_fd_ota_core_soft_0/m1_52741_3443# eeg_fd_ota_chopped_full2_0/eeg_fd_ota_core_soft_0/m1_53541_3443# 6.789050e-17
C2857 eeg_fd_ota_chopped_full2_0/eeg_fd_ota_core_soft_0/m1_53141_n3864# VSS 4.190540e-16
C2858 eeg_fd_ota_chopped_full2_0/eeg_fd_ota_core_soft_0/m1_53141_n3864# eeg_fd_ota_chopped_full2_0/eeg_fd_ota_core_soft_0/m1_53941_n3864# 6.789040e-17
C2859 eeg_fd_ota_chopped_full2_0/eeg_fd_ota_core_soft_0/m1_53541_3443# VSS 4.190540e-16
C2860 eeg_fd_ota_chopped_full2_0/eeg_fd_ota_core_soft_0/m1_53541_3443# eeg_fd_ota_chopped_full2_0/eeg_fd_ota_core_soft_0/m1_54341_3443# 6.789050e-17
C2861 eeg_fd_ota_chopped_full2_0/eeg_fd_ota_core_soft_0/m1_53941_n3864# VSS 4.190540e-16
C2862 eeg_fd_ota_chopped_full2_0/eeg_fd_ota_core_soft_0/m1_53941_n3864# eeg_fd_ota_chopped_full2_0/eeg_fd_ota_core_soft_0/m1_54741_n3864# 6.789050e-17
C2863 eeg_fd_ota_chopped_full2_0/eeg_fd_ota_core_soft_0/m1_54341_3443# VSS 4.190540e-16
C2864 eeg_fd_ota_chopped_full2_0/eeg_fd_ota_core_soft_0/m1_54341_3443# eeg_fd_ota_chopped_full2_0/eeg_fd_ota_core_soft_0/m1_55141_3443# 6.789040e-17
C2865 eeg_fd_ota_chopped_full2_0/eeg_fd_ota_core_soft_0/m1_54741_n3864# VSS 4.190540e-16
C2866 eeg_fd_ota_chopped_full2_0/eeg_fd_ota_core_soft_0/m1_54741_n3864# eeg_fd_ota_chopped_full2_0/eeg_fd_ota_core_soft_0/m1_55541_n3864# 6.789050e-17
C2867 eeg_fd_ota_chopped_full2_0/eeg_fd_ota_core_soft_0/m1_55141_3443# VSS 4.190540e-16
C2868 eeg_fd_ota_chopped_full2_0/eeg_fd_ota_core_soft_0/m1_55141_3443# eeg_fd_ota_chopped_full2_0/eeg_fd_ota_core_soft_0/m1_55941_3443# 6.789050e-17
C2869 eeg_fd_ota_chopped_full2_0/eeg_fd_ota_core_soft_0/m1_55541_n3864# VSS 4.190540e-16
C2870 eeg_fd_ota_chopped_full2_0/eeg_fd_ota_core_soft_0/m1_55541_n3864# eeg_fd_ota_chopped_full2_0/eeg_fd_ota_core_soft_0/m1_56341_n3864# 6.789050e-17
C2871 eeg_fd_ota_chopped_full2_0/eeg_fd_ota_core_soft_0/m1_55941_3443# VSS 4.190540e-16
C2872 eeg_fd_ota_chopped_full2_0/eeg_fd_ota_core_soft_0/m1_55941_3443# eeg_fd_ota_chopped_full2_0/eeg_fd_ota_core_soft_0/m1_56741_3443# 6.789040e-17
C2873 eeg_fd_ota_chopped_full2_0/eeg_fd_ota_core_soft_0/m1_56341_n3864# VSS 4.190540e-16
C2874 eeg_fd_ota_chopped_full2_0/eeg_fd_ota_core_soft_0/m1_56341_n3864# eeg_fd_ota_chopped_full2_0/eeg_fd_ota_core_soft_0/m1_57141_n3864# 6.789050e-17
C2875 eeg_fd_ota_chopped_full2_0/eeg_fd_ota_core_soft_0/m1_56741_3443# VSS 4.190540e-16
C2876 eeg_fd_ota_chopped_full2_0/eeg_fd_ota_core_soft_0/m1_56741_3443# eeg_fd_ota_chopped_full2_0/eeg_fd_ota_core_soft_0/m1_57541_3443# 6.789050e-17
C2877 eeg_fd_ota_chopped_full2_0/eeg_fd_ota_core_soft_0/m1_57141_n3864# VSS 4.190540e-16
C2878 eeg_fd_ota_chopped_full2_0/eeg_fd_ota_core_soft_0/m1_57141_n3864# eeg_fd_ota_chopped_full2_0/eeg_fd_ota_core_soft_0/m1_57941_n3864# 6.789040e-17
C2879 eeg_fd_ota_chopped_full2_0/eeg_fd_ota_core_soft_0/m1_57541_3443# VSS 4.607340e-16
C2880 eeg_fd_ota_chopped_full2_0/eeg_fd_ota_core_soft_0/m1_57941_n3864# VSS 4.702790e-16
C2881 eeg_fd_ota_chopped_full2_0/eeg_fd_ota_core_soft_0/m1_n22658_111# VSS 1.794040e-14
C2882 eeg_fd_ota_chopped_full2_0/eeg_fd_ota_core_soft_0/m1_n28859_n3864# VSS 4.702790e-16
C2883 eeg_fd_ota_chopped_full2_0/eeg_fd_ota_core_soft_0/m1_n28859_n3864# eeg_fd_ota_chopped_full2_0/eeg_fd_ota_core_soft_0/m1_n29659_n3864# 6.789040e-17
C2884 eeg_fd_ota_chopped_full2_0/eeg_fd_ota_core_soft_0/m1_n29259_3443# VSS 4.622480e-16
C2885 eeg_fd_ota_chopped_full2_0/eeg_fd_ota_core_soft_0/m1_n29259_3443# eeg_fd_ota_chopped_full2_0/eeg_fd_ota_core_soft_0/m1_n30059_3443# 6.789050e-17
C2886 eeg_fd_ota_chopped_full2_0/eeg_fd_ota_core_soft_0/m1_n29659_n3864# VSS 4.190540e-16
C2887 eeg_fd_ota_chopped_full2_0/eeg_fd_ota_core_soft_0/m1_n29659_n3864# eeg_fd_ota_chopped_full2_0/eeg_fd_ota_core_soft_0/m1_n30459_n3864# 6.789050e-17
C2888 eeg_fd_ota_chopped_full2_0/eeg_fd_ota_core_soft_0/m1_n30059_3443# VSS 4.190540e-16
C2889 eeg_fd_ota_chopped_full2_0/eeg_fd_ota_core_soft_0/m1_n30059_3443# eeg_fd_ota_chopped_full2_0/eeg_fd_ota_core_soft_0/m1_n30859_3443# 6.789040e-17
C2890 eeg_fd_ota_chopped_full2_0/eeg_fd_ota_core_soft_0/m1_n30459_n3864# VSS 4.190540e-16
C2891 eeg_fd_ota_chopped_full2_0/eeg_fd_ota_core_soft_0/m1_n30459_n3864# eeg_fd_ota_chopped_full2_0/eeg_fd_ota_core_soft_0/m1_n31259_n3864# 6.789050e-17
C2892 eeg_fd_ota_chopped_full2_0/eeg_fd_ota_core_soft_0/m1_n30859_3443# VSS 4.190540e-16
C2893 eeg_fd_ota_chopped_full2_0/eeg_fd_ota_core_soft_0/m1_n30859_3443# eeg_fd_ota_chopped_full2_0/eeg_fd_ota_core_soft_0/m1_n31659_3443# 6.789050e-17
C2894 eeg_fd_ota_chopped_full2_0/eeg_fd_ota_core_soft_0/m1_n31259_n3864# VSS 4.190540e-16
C2895 eeg_fd_ota_chopped_full2_0/eeg_fd_ota_core_soft_0/m1_n31259_n3864# eeg_fd_ota_chopped_full2_0/eeg_fd_ota_core_soft_0/m1_n32059_n3864# 6.789050e-17
C2896 eeg_fd_ota_chopped_full2_0/eeg_fd_ota_core_soft_0/m1_n31659_3443# VSS 4.190540e-16
C2897 eeg_fd_ota_chopped_full2_0/eeg_fd_ota_core_soft_0/m1_n31659_3443# eeg_fd_ota_chopped_full2_0/eeg_fd_ota_core_soft_0/m1_n32459_3443# 6.789040e-17
C2898 eeg_fd_ota_chopped_full2_0/eeg_fd_ota_core_soft_0/m1_n32059_n3864# VSS 4.190540e-16
C2899 eeg_fd_ota_chopped_full2_0/eeg_fd_ota_core_soft_0/m1_n32059_n3864# eeg_fd_ota_chopped_full2_0/eeg_fd_ota_core_soft_0/m1_n32859_n3864# 6.789050e-17
C2900 eeg_fd_ota_chopped_full2_0/eeg_fd_ota_core_soft_0/m1_n32459_3443# VSS 4.190540e-16
C2901 eeg_fd_ota_chopped_full2_0/eeg_fd_ota_core_soft_0/m1_n32459_3443# eeg_fd_ota_chopped_full2_0/eeg_fd_ota_core_soft_0/m1_n33259_3443# 6.789050e-17
C2902 eeg_fd_ota_chopped_full2_0/eeg_fd_ota_core_soft_0/m1_n32859_n3864# VSS 4.190540e-16
C2903 eeg_fd_ota_chopped_full2_0/eeg_fd_ota_core_soft_0/m1_n32859_n3864# eeg_fd_ota_chopped_full2_0/eeg_fd_ota_core_soft_0/m1_n33659_n3864# 6.789040e-17
C2904 eeg_fd_ota_chopped_full2_0/eeg_fd_ota_core_soft_0/m1_n33259_3443# VSS 4.190540e-16
C2905 eeg_fd_ota_chopped_full2_0/eeg_fd_ota_core_soft_0/m1_n33259_3443# eeg_fd_ota_chopped_full2_0/eeg_fd_ota_core_soft_0/m1_n34059_3443# 6.789050e-17
C2906 eeg_fd_ota_chopped_full2_0/eeg_fd_ota_core_soft_0/m1_n33659_n3864# VSS 4.190540e-16
C2907 eeg_fd_ota_chopped_full2_0/eeg_fd_ota_core_soft_0/m1_n33659_n3864# eeg_fd_ota_chopped_full2_0/eeg_fd_ota_core_soft_0/m1_n34459_n3864# 6.789050e-17
C2908 eeg_fd_ota_chopped_full2_0/eeg_fd_ota_core_soft_0/m1_n34059_3443# VSS 4.190540e-16
C2909 eeg_fd_ota_chopped_full2_0/eeg_fd_ota_core_soft_0/m1_n34059_3443# eeg_fd_ota_chopped_full2_0/eeg_fd_ota_core_soft_0/m1_n34859_3443# 6.789050e-17
C2910 eeg_fd_ota_chopped_full2_0/eeg_fd_ota_core_soft_0/m1_n34459_n3864# VSS 4.190540e-16
C2911 eeg_fd_ota_chopped_full2_0/eeg_fd_ota_core_soft_0/m1_n34459_n3864# eeg_fd_ota_chopped_full2_0/eeg_fd_ota_core_soft_0/m1_n35259_n3864# 6.789040e-17
C2912 eeg_fd_ota_chopped_full2_0/eeg_fd_ota_core_soft_0/m1_n34859_3443# VSS 4.190540e-16
C2913 eeg_fd_ota_chopped_full2_0/eeg_fd_ota_core_soft_0/m1_n34859_3443# eeg_fd_ota_chopped_full2_0/eeg_fd_ota_core_soft_0/m1_n35659_3443# 6.789050e-17
C2914 eeg_fd_ota_chopped_full2_0/eeg_fd_ota_core_soft_0/m1_n35259_n3864# VSS 4.190540e-16
C2915 eeg_fd_ota_chopped_full2_0/eeg_fd_ota_core_soft_0/m1_n35259_n3864# eeg_fd_ota_chopped_full2_0/eeg_fd_ota_core_soft_0/m1_n36059_n3864# 6.789050e-17
C2916 eeg_fd_ota_chopped_full2_0/eeg_fd_ota_core_soft_0/m1_n35659_3443# VSS 4.190540e-16
C2917 eeg_fd_ota_chopped_full2_0/eeg_fd_ota_core_soft_0/m1_n35659_3443# eeg_fd_ota_chopped_full2_0/eeg_fd_ota_core_soft_0/m1_n36459_3443# 6.789040e-17
C2918 eeg_fd_ota_chopped_full2_0/eeg_fd_ota_core_soft_0/m1_n36059_n3864# VSS 4.190540e-16
C2919 eeg_fd_ota_chopped_full2_0/eeg_fd_ota_core_soft_0/m1_n36059_n3864# eeg_fd_ota_chopped_full2_0/eeg_fd_ota_core_soft_0/m1_n36859_n3864# 6.789050e-17
C2920 eeg_fd_ota_chopped_full2_0/eeg_fd_ota_core_soft_0/m1_n36459_3443# VSS 4.190540e-16
C2921 eeg_fd_ota_chopped_full2_0/eeg_fd_ota_core_soft_0/m1_n36459_3443# eeg_fd_ota_chopped_full2_0/eeg_fd_ota_core_soft_0/m1_n37259_3443# 6.789050e-17
C2922 eeg_fd_ota_chopped_full2_0/eeg_fd_ota_core_soft_0/m1_n36859_n3864# VSS 4.190540e-16
C2923 eeg_fd_ota_chopped_full2_0/eeg_fd_ota_core_soft_0/m1_n36859_n3864# eeg_fd_ota_chopped_full2_0/eeg_fd_ota_core_soft_0/m1_n37659_n3864# 6.789050e-17
C2924 eeg_fd_ota_chopped_full2_0/eeg_fd_ota_core_soft_0/m1_n37259_3443# VSS 4.190540e-16
C2925 eeg_fd_ota_chopped_full2_0/eeg_fd_ota_core_soft_0/m1_n37259_3443# eeg_fd_ota_chopped_full2_0/eeg_fd_ota_core_soft_0/m1_n38059_3443# 6.789040e-17
C2926 eeg_fd_ota_chopped_full2_0/eeg_fd_ota_core_soft_0/m1_n37659_n3864# VSS 4.190540e-16
C2927 eeg_fd_ota_chopped_full2_0/eeg_fd_ota_core_soft_0/m1_n37659_n3864# eeg_fd_ota_chopped_full2_0/eeg_fd_ota_core_soft_0/m1_n38459_n3864# 6.789050e-17
C2928 eeg_fd_ota_chopped_full2_0/eeg_fd_ota_core_soft_0/m1_n38059_3443# VSS 4.190540e-16
C2929 eeg_fd_ota_chopped_full2_0/eeg_fd_ota_core_soft_0/m1_n38059_3443# eeg_fd_ota_chopped_full2_0/eeg_fd_ota_core_soft_0/m1_n38859_3443# 6.789050e-17
C2930 eeg_fd_ota_chopped_full2_0/eeg_fd_ota_core_soft_0/m1_n38459_n3864# VSS 4.190540e-16
C2931 eeg_fd_ota_chopped_full2_0/eeg_fd_ota_core_soft_0/m1_n38459_n3864# eeg_fd_ota_chopped_full2_0/eeg_fd_ota_core_soft_0/m1_n39259_n3864# 6.789040e-17
C2932 eeg_fd_ota_chopped_full2_0/eeg_fd_ota_core_soft_0/m1_n38859_3443# VSS 4.190540e-16
C2933 eeg_fd_ota_chopped_full2_0/eeg_fd_ota_core_soft_0/m1_n38859_3443# eeg_fd_ota_chopped_full2_0/eeg_fd_ota_core_soft_0/m1_n39659_3443# 6.789050e-17
C2934 eeg_fd_ota_chopped_full2_0/eeg_fd_ota_core_soft_0/m1_n39259_n3864# VSS 4.190540e-16
C2935 eeg_fd_ota_chopped_full2_0/eeg_fd_ota_core_soft_0/m1_n39259_n3864# eeg_fd_ota_chopped_full2_0/eeg_fd_ota_core_soft_0/m1_n40059_n3864# 6.789050e-17
C2936 eeg_fd_ota_chopped_full2_0/eeg_fd_ota_core_soft_0/m1_n39659_3443# VSS 4.190540e-16
C2937 eeg_fd_ota_chopped_full2_0/eeg_fd_ota_core_soft_0/m1_n39659_3443# eeg_fd_ota_chopped_full2_0/eeg_fd_ota_core_soft_0/m1_n40459_3443# 6.789050e-17
C2938 eeg_fd_ota_chopped_full2_0/eeg_fd_ota_core_soft_0/m1_n40059_n3864# VSS 4.190540e-16
C2939 eeg_fd_ota_chopped_full2_0/eeg_fd_ota_core_soft_0/m1_n40059_n3864# eeg_fd_ota_chopped_full2_0/eeg_fd_ota_core_soft_0/m1_n40859_n3864# 6.789040e-17
C2940 eeg_fd_ota_chopped_full2_0/eeg_fd_ota_core_soft_0/m1_n40459_3443# VSS 4.190540e-16
C2941 eeg_fd_ota_chopped_full2_0/eeg_fd_ota_core_soft_0/m1_n40459_3443# eeg_fd_ota_chopped_full2_0/eeg_fd_ota_core_soft_0/m1_n41259_3443# 6.789050e-17
C2942 eeg_fd_ota_chopped_full2_0/eeg_fd_ota_core_soft_0/m1_n40859_n3864# VSS 4.190540e-16
C2943 eeg_fd_ota_chopped_full2_0/eeg_fd_ota_core_soft_0/m1_n40859_n3864# eeg_fd_ota_chopped_full2_0/eeg_fd_ota_core_soft_0/m1_n41659_n3864# 6.789050e-17
C2944 eeg_fd_ota_chopped_full2_0/eeg_fd_ota_core_soft_0/m1_n41259_3443# VSS 4.190540e-16
C2945 eeg_fd_ota_chopped_full2_0/eeg_fd_ota_core_soft_0/m1_n41259_3443# eeg_fd_ota_chopped_full2_0/eeg_fd_ota_core_soft_0/m1_n42059_3443# 6.789040e-17
C2946 eeg_fd_ota_chopped_full2_0/eeg_fd_ota_core_soft_0/m1_n41659_n3864# VSS 4.190540e-16
C2947 eeg_fd_ota_chopped_full2_0/eeg_fd_ota_core_soft_0/m1_n41659_n3864# eeg_fd_ota_chopped_full2_0/eeg_fd_ota_core_soft_0/m1_n42459_n3864# 6.789050e-17
C2948 eeg_fd_ota_chopped_full2_0/eeg_fd_ota_core_soft_0/m1_n42059_3443# VSS 4.190540e-16
C2949 eeg_fd_ota_chopped_full2_0/eeg_fd_ota_core_soft_0/m1_n42059_3443# eeg_fd_ota_chopped_full2_0/eeg_fd_ota_core_soft_0/m1_n42859_3443# 6.789050e-17
C2950 eeg_fd_ota_chopped_full2_0/eeg_fd_ota_core_soft_0/m1_n42459_n3864# VSS 4.190540e-16
C2951 eeg_fd_ota_chopped_full2_0/eeg_fd_ota_core_soft_0/m1_n42459_n3864# eeg_fd_ota_chopped_full2_0/eeg_fd_ota_core_soft_0/m1_n43259_n3864# 6.789050e-17
C2952 eeg_fd_ota_chopped_full2_0/eeg_fd_ota_core_soft_0/m1_n42859_3443# VSS 4.190540e-16
C2953 eeg_fd_ota_chopped_full2_0/eeg_fd_ota_core_soft_0/m1_n42859_3443# eeg_fd_ota_chopped_full2_0/eeg_fd_ota_core_soft_0/m1_n43659_3443# 6.789040e-17
C2954 eeg_fd_ota_chopped_full2_0/eeg_fd_ota_core_soft_0/m1_n43259_n3864# VSS 4.190540e-16
C2955 eeg_fd_ota_chopped_full2_0/eeg_fd_ota_core_soft_0/m1_n43259_n3864# eeg_fd_ota_chopped_full2_0/eeg_fd_ota_core_soft_0/m1_n44059_n3864# 6.789050e-17
C2956 eeg_fd_ota_chopped_full2_0/eeg_fd_ota_core_soft_0/m1_n43659_3443# VSS 4.190540e-16
C2957 eeg_fd_ota_chopped_full2_0/eeg_fd_ota_core_soft_0/m1_n43659_3443# eeg_fd_ota_chopped_full2_0/eeg_fd_ota_core_soft_0/m1_n44459_3443# 6.789050e-17
C2958 eeg_fd_ota_chopped_full2_0/eeg_fd_ota_core_soft_0/m1_n44059_n3864# VSS 4.190540e-16
C2959 eeg_fd_ota_chopped_full2_0/eeg_fd_ota_core_soft_0/m1_n44059_n3864# eeg_fd_ota_chopped_full2_0/eeg_fd_ota_core_soft_0/m1_n44859_n3864# 6.789040e-17
C2960 eeg_fd_ota_chopped_full2_0/eeg_fd_ota_core_soft_0/m1_n44459_3443# VSS 4.190540e-16
C2961 eeg_fd_ota_chopped_full2_0/eeg_fd_ota_core_soft_0/m1_n44459_3443# eeg_fd_ota_chopped_full2_0/eeg_fd_ota_core_soft_0/m1_n45259_3443# 6.789050e-17
C2962 eeg_fd_ota_chopped_full2_0/eeg_fd_ota_core_soft_0/m1_n44859_n3864# VSS 4.190540e-16
C2963 eeg_fd_ota_chopped_full2_0/eeg_fd_ota_core_soft_0/m1_n44859_n3864# eeg_fd_ota_chopped_full2_0/eeg_fd_ota_core_soft_0/m1_n45659_n3864# 6.789050e-17
C2964 eeg_fd_ota_chopped_full2_0/eeg_fd_ota_core_soft_0/m1_n45259_3443# VSS 4.190540e-16
C2965 eeg_fd_ota_chopped_full2_0/eeg_fd_ota_core_soft_0/m1_n45259_3443# eeg_fd_ota_chopped_full2_0/eeg_fd_ota_core_soft_0/m1_n46059_3443# 6.789050e-17
C2966 eeg_fd_ota_chopped_full2_0/eeg_fd_ota_core_soft_0/m1_n45659_n3864# VSS 4.190540e-16
C2967 eeg_fd_ota_chopped_full2_0/eeg_fd_ota_core_soft_0/m1_n45659_n3864# eeg_fd_ota_chopped_full2_0/eeg_fd_ota_core_soft_0/m1_n46459_n3864# 6.789040e-17
C2968 eeg_fd_ota_chopped_full2_0/eeg_fd_ota_core_soft_0/m1_n46059_3443# VSS 4.190540e-16
C2969 eeg_fd_ota_chopped_full2_0/eeg_fd_ota_core_soft_0/m1_n46059_3443# eeg_fd_ota_chopped_full2_0/eeg_fd_ota_core_soft_0/m1_n46859_3443# 6.789050e-17
C2970 eeg_fd_ota_chopped_full2_0/eeg_fd_ota_core_soft_0/m1_n46459_n3864# VSS 4.190540e-16
C2971 eeg_fd_ota_chopped_full2_0/eeg_fd_ota_core_soft_0/m1_n46459_n3864# eeg_fd_ota_chopped_full2_0/eeg_fd_ota_core_soft_0/m1_n47259_n3864# 6.789050e-17
C2972 eeg_fd_ota_chopped_full2_0/eeg_fd_ota_core_soft_0/m1_n46859_3443# VSS 4.190540e-16
C2973 eeg_fd_ota_chopped_full2_0/eeg_fd_ota_core_soft_0/m1_n46859_3443# eeg_fd_ota_chopped_full2_0/eeg_fd_ota_core_soft_0/m1_n47659_3443# 6.789040e-17
C2974 eeg_fd_ota_chopped_full2_0/eeg_fd_ota_core_soft_0/m1_n47259_n3864# VSS 4.190540e-16
C2975 eeg_fd_ota_chopped_full2_0/eeg_fd_ota_core_soft_0/m1_n47259_n3864# eeg_fd_ota_chopped_full2_0/eeg_fd_ota_core_soft_0/m1_n48059_n3864# 6.789050e-17
C2976 eeg_fd_ota_chopped_full2_0/eeg_fd_ota_core_soft_0/m1_n47659_3443# VSS 4.607340e-16
C2977 eeg_fd_ota_chopped_full2_0/eeg_fd_ota_core_soft_0/m1_n48059_n3864# VSS 4.702790e-16
C2978 eeg_fd_ota_chopped_full2_0/eeg_fd_ota_core_soft_0/m1_n51259_n3864# VSS 4.702790e-16
C2979 eeg_fd_ota_chopped_full2_0/eeg_fd_ota_core_soft_0/m1_n51259_n3864# eeg_fd_ota_chopped_full2_0/eeg_fd_ota_core_soft_0/m1_n52059_n3864# 6.789040e-17
C2980 eeg_fd_ota_chopped_full2_0/eeg_fd_ota_core_soft_0/m1_n51659_3443# VSS 4.622480e-16
C2981 eeg_fd_ota_chopped_full2_0/eeg_fd_ota_core_soft_0/m1_n51659_3443# eeg_fd_ota_chopped_full2_0/eeg_fd_ota_core_soft_0/m1_n52459_3443# 6.789050e-17
C2982 eeg_fd_ota_chopped_full2_0/eeg_fd_ota_core_soft_0/m1_n52059_n3864# VSS 4.190540e-16
C2983 eeg_fd_ota_chopped_full2_0/eeg_fd_ota_core_soft_0/m1_n52059_n3864# eeg_fd_ota_chopped_full2_0/eeg_fd_ota_core_soft_0/m1_n52859_n3864# 6.789050e-17
C2984 eeg_fd_ota_chopped_full2_0/eeg_fd_ota_core_soft_0/m1_n52459_3443# VSS 4.190540e-16
C2985 eeg_fd_ota_chopped_full2_0/eeg_fd_ota_core_soft_0/m1_n52459_3443# eeg_fd_ota_chopped_full2_0/eeg_fd_ota_core_soft_0/m1_n53259_3443# 6.789040e-17
C2986 eeg_fd_ota_chopped_full2_0/eeg_fd_ota_core_soft_0/m1_n52859_n3864# VSS 4.190540e-16
C2987 eeg_fd_ota_chopped_full2_0/eeg_fd_ota_core_soft_0/m1_n52859_n3864# eeg_fd_ota_chopped_full2_0/eeg_fd_ota_core_soft_0/m1_n53659_n3864# 6.789050e-17
C2988 eeg_fd_ota_chopped_full2_0/eeg_fd_ota_core_soft_0/m1_n53259_3443# VSS 4.190540e-16
C2989 eeg_fd_ota_chopped_full2_0/eeg_fd_ota_core_soft_0/m1_n53259_3443# eeg_fd_ota_chopped_full2_0/eeg_fd_ota_core_soft_0/m1_n54059_3443# 6.789050e-17
C2990 eeg_fd_ota_chopped_full2_0/eeg_fd_ota_core_soft_0/m1_n53659_n3864# VSS 4.190540e-16
C2991 eeg_fd_ota_chopped_full2_0/eeg_fd_ota_core_soft_0/m1_n53659_n3864# eeg_fd_ota_chopped_full2_0/eeg_fd_ota_core_soft_0/m1_n54459_n3864# 6.789050e-17
C2992 eeg_fd_ota_chopped_full2_0/eeg_fd_ota_core_soft_0/m1_n54059_3443# VSS 4.190540e-16
C2993 eeg_fd_ota_chopped_full2_0/eeg_fd_ota_core_soft_0/m1_n54059_3443# eeg_fd_ota_chopped_full2_0/eeg_fd_ota_core_soft_0/m1_n54859_3443# 6.789040e-17
C2994 eeg_fd_ota_chopped_full2_0/eeg_fd_ota_core_soft_0/m1_n54459_n3864# VSS 4.190540e-16
C2995 eeg_fd_ota_chopped_full2_0/eeg_fd_ota_core_soft_0/m1_n54459_n3864# eeg_fd_ota_chopped_full2_0/eeg_fd_ota_core_soft_0/m1_n55259_n3864# 6.789050e-17
C2996 eeg_fd_ota_chopped_full2_0/eeg_fd_ota_core_soft_0/m1_n54859_3443# VSS 4.190540e-16
C2997 eeg_fd_ota_chopped_full2_0/eeg_fd_ota_core_soft_0/m1_n54859_3443# eeg_fd_ota_chopped_full2_0/eeg_fd_ota_core_soft_0/m1_n55659_3443# 6.789050e-17
C2998 eeg_fd_ota_chopped_full2_0/eeg_fd_ota_core_soft_0/m1_n55259_n3864# VSS 4.190540e-16
C2999 eeg_fd_ota_chopped_full2_0/eeg_fd_ota_core_soft_0/m1_n55259_n3864# eeg_fd_ota_chopped_full2_0/eeg_fd_ota_core_soft_0/m1_n56059_n3864# 6.789040e-17
C3000 eeg_fd_ota_chopped_full2_0/eeg_fd_ota_core_soft_0/m1_n55659_3443# VSS 4.190540e-16
C3001 eeg_fd_ota_chopped_full2_0/eeg_fd_ota_core_soft_0/m1_n55659_3443# eeg_fd_ota_chopped_full2_0/eeg_fd_ota_core_soft_0/m1_n56459_3443# 6.789050e-17
C3002 eeg_fd_ota_chopped_full2_0/eeg_fd_ota_core_soft_0/m1_n56059_n3864# VSS 4.190540e-16
C3003 eeg_fd_ota_chopped_full2_0/eeg_fd_ota_core_soft_0/m1_n56059_n3864# eeg_fd_ota_chopped_full2_0/eeg_fd_ota_core_soft_0/m1_n56859_n3864# 6.789050e-17
C3004 eeg_fd_ota_chopped_full2_0/eeg_fd_ota_core_soft_0/m1_n56459_3443# VSS 4.190540e-16
C3005 eeg_fd_ota_chopped_full2_0/eeg_fd_ota_core_soft_0/m1_n56459_3443# eeg_fd_ota_chopped_full2_0/eeg_fd_ota_core_soft_0/m1_n57259_3443# 6.789050e-17
C3006 eeg_fd_ota_chopped_full2_0/eeg_fd_ota_core_soft_0/m1_n56859_n3864# VSS 4.190540e-16
C3007 eeg_fd_ota_chopped_full2_0/eeg_fd_ota_core_soft_0/m1_n56859_n3864# eeg_fd_ota_chopped_full2_0/eeg_fd_ota_core_soft_0/m1_n57659_n3864# 6.789040e-17
C3008 eeg_fd_ota_chopped_full2_0/eeg_fd_ota_core_soft_0/m1_n57259_3443# VSS 4.190540e-16
C3009 eeg_fd_ota_chopped_full2_0/eeg_fd_ota_core_soft_0/m1_n57259_3443# eeg_fd_ota_chopped_full2_0/eeg_fd_ota_core_soft_0/m1_n58059_3443# 6.789050e-17
C3010 eeg_fd_ota_chopped_full2_0/eeg_fd_ota_core_soft_0/m1_n57659_n3864# VSS 4.190540e-16
C3011 eeg_fd_ota_chopped_full2_0/eeg_fd_ota_core_soft_0/m1_n57659_n3864# eeg_fd_ota_chopped_full2_0/eeg_fd_ota_core_soft_0/m1_n58459_n3864# 6.789050e-17
C3012 eeg_fd_ota_chopped_full2_0/eeg_fd_ota_core_soft_0/m1_n58059_3443# VSS 4.607340e-16
C3013 eeg_fd_ota_chopped_full2_0/eeg_fd_ota_core_soft_0/m1_n58459_n3864# VSS 4.702790e-16
C3014 eeg_fd_ota_chopped_full2_0/eeg_fd_ota_core_soft_0/m1_n51259_n3864# VSS 6.746650e-16
C3015 eeg_fd_ota_chopped_full2_0/eeg_fd_ota_core_soft_0/m1_n51659_3443# VSS 6.746650e-16
C3016 eeg_fd_ota_chopped_full2_0/eeg_fd_ota_core_soft_0/m1_n51659_3443# VSS 6.746650e-16
C3017 eeg_fd_ota_chopped_full2_0/eeg_fd_ota_core_soft_0/m1_n52059_n3864# VSS 6.746650e-16
C3018 eeg_fd_ota_chopped_full2_0/eeg_fd_ota_core_soft_0/m1_n52059_n3864# VSS 6.746650e-16
C3019 eeg_fd_ota_chopped_full2_0/eeg_fd_ota_core_soft_0/m1_n52459_3443# VSS 6.746650e-16
C3020 eeg_fd_ota_chopped_full2_0/eeg_fd_ota_core_soft_0/m1_n52459_3443# VSS 6.746650e-16
C3021 eeg_fd_ota_chopped_full2_0/eeg_fd_ota_core_soft_0/m1_n52859_n3864# VSS 6.746650e-16
C3022 eeg_fd_ota_chopped_full2_0/eeg_fd_ota_core_soft_0/m1_n52859_n3864# VSS 6.746650e-16
C3023 eeg_fd_ota_chopped_full2_0/eeg_fd_ota_core_soft_0/m1_n53259_3443# VSS 6.746650e-16
C3024 VSS eeg_fd_ota_chopped_full2_0/eeg_bias_gen_0/VBNF 6.766352e-15
C3025 VSS eeg_fd_ota_chopped_full2_0/eeg_fd_ota_core_soft_0/m1_n22658_111# 7.972532e-16
C3026 eeg_fd_ota_chopped_full2_0/eeg_bias_gen_0/VBNF VSS 2.104804e-14
C3027 eeg_fd_ota_chopped_full2_0/eeg_bias_gen_0/VBNF eeg_fd_ota_chopped_full2_0/eeg_fd_ota_core_soft_0/m1_n22658_111# 6.671600e-15
C3028 eeg_fd_ota_chopped_full2_0/eeg_fd_ota_core_soft_0/m1_n22658_111# VSS 2.222918e-16
C3029 eeg_fd_ota_chopped_full2_0/eeg_fd_ota_core_soft_0/m1_n53259_3443# VSS 6.746650e-16
C3030 eeg_fd_ota_chopped_full2_0/eeg_fd_ota_core_soft_0/m1_n53659_n3864# VSS 6.746650e-16
C3031 eeg_fd_ota_chopped_full2_0/eeg_fd_ota_core_soft_0/m1_31541_n3864# VSS 6.746650e-16
C3032 eeg_fd_ota_chopped_full2_0/eeg_fd_ota_core_soft_0/m1_31941_3443# VSS 6.746650e-16
C3033 eeg_fd_ota_chopped_full2_0/eeg_fd_ota_core_soft_0/m1_n53659_n3864# VSS 6.746650e-16
C3034 eeg_fd_ota_chopped_full2_0/eeg_fd_ota_core_soft_0/m1_n54059_3443# VSS 6.746650e-16
C3035 eeg_fd_ota_chopped_full2_0/eeg_fd_ota_core_soft_0/m1_31141_3443# VSS 6.746650e-16
C3036 eeg_fd_ota_chopped_full2_0/eeg_fd_ota_core_soft_0/m1_31541_n3864# VSS 6.746650e-16
C3037 eeg_fd_ota_chopped_full2_0/eeg_fd_ota_core_soft_0/m1_35541_n3864# VSS 6.746650e-16
C3038 eeg_fd_ota_chopped_full2_0/eeg_fd_ota_core_soft_0/m1_35941_3443# VSS 6.746650e-16
C3039 eeg_fd_ota_chopped_full2_0/eeg_fd_ota_core_soft_0/m1_n54059_3443# VSS 6.746650e-16
C3040 eeg_fd_ota_chopped_full2_0/eeg_fd_ota_core_soft_0/m1_n54459_n3864# VSS 6.746650e-16
C3041 eeg_fd_ota_chopped_full2_0/eeg_fd_ota_core_soft_0/m1_39541_n3864# VSS 6.746650e-16
C3042 eeg_fd_ota_chopped_full2_0/eeg_fd_ota_core_soft_0/m1_39941_3443# VSS 6.746650e-16
C3043 eeg_fd_ota_chopped_full2_0/eeg_fd_ota_core_soft_0/m1_30741_n3864# VSS 6.746650e-16
C3044 eeg_fd_ota_chopped_full2_0/eeg_fd_ota_core_soft_0/m1_31141_3443# VSS 6.746650e-16
C3045 eeg_fd_ota_chopped_full2_0/eeg_fd_ota_core_soft_0/m1_35141_3443# VSS 6.746650e-16
C3046 eeg_fd_ota_chopped_full2_0/eeg_fd_ota_core_soft_0/m1_35541_n3864# VSS 6.746650e-16
C3047 eeg_fd_ota_chopped_full2_0/eeg_fd_ota_core_soft_0/m1_n54459_n3864# VSS 6.746650e-16
C3048 eeg_fd_ota_chopped_full2_0/eeg_fd_ota_core_soft_0/m1_n54859_3443# VSS 6.746650e-16
C3049 eeg_fd_ota_chopped_full2_0/eeg_fd_ota_core_soft_0/m1_43541_n3864# VSS 6.746650e-16
C3050 eeg_fd_ota_chopped_full2_0/eeg_fd_ota_core_soft_0/m1_43941_3443# VSS 6.746650e-16
C3051 eeg_fd_ota_chopped_full2_0/eeg_fd_ota_core_soft_0/m1_39141_3443# VSS 6.746650e-16
C3052 eeg_fd_ota_chopped_full2_0/eeg_fd_ota_core_soft_0/m1_39541_n3864# VSS 6.746650e-16
C3053 eeg_fd_ota_chopped_full2_0/eeg_fd_ota_core_soft_0/m1_30341_3443# VSS 6.746650e-16
C3054 eeg_fd_ota_chopped_full2_0/eeg_fd_ota_core_soft_0/m1_30741_n3864# VSS 6.746650e-16
C3055 eeg_fd_ota_chopped_full2_0/eeg_fd_ota_core_soft_0/m1_34741_n3864# VSS 6.746650e-16
C3056 eeg_fd_ota_chopped_full2_0/eeg_fd_ota_core_soft_0/m1_35141_3443# VSS 6.746650e-16
C3057 eeg_fd_ota_chopped_full2_0/eeg_fd_ota_core_soft_0/m1_n54859_3443# VSS 6.746650e-16
C3058 eeg_fd_ota_chopped_full2_0/eeg_fd_ota_core_soft_0/m1_n55259_n3864# VSS 6.746650e-16
C3059 eeg_fd_ota_chopped_full2_0/eeg_fd_ota_core_soft_0/m1_43141_3443# VSS 6.746650e-16
C3060 eeg_fd_ota_chopped_full2_0/eeg_fd_ota_core_soft_0/m1_43541_n3864# VSS 6.746650e-16
C3061 eeg_fd_ota_chopped_full2_0/eeg_fd_ota_core_soft_0/m1_38741_n3864# VSS 6.746650e-16
C3062 eeg_fd_ota_chopped_full2_0/eeg_fd_ota_core_soft_0/m1_39141_3443# VSS 6.746650e-16
C3063 eeg_fd_ota_chopped_full2_0/eeg_fd_ota_core_soft_0/m1_29941_n3864# VSS 6.746650e-16
C3064 eeg_fd_ota_chopped_full2_0/eeg_fd_ota_core_soft_0/m1_30341_3443# VSS 6.746650e-16
C3065 eeg_fd_ota_chopped_full2_0/eeg_fd_ota_core_soft_0/m1_34341_3443# VSS 6.746650e-16
C3066 eeg_fd_ota_chopped_full2_0/eeg_fd_ota_core_soft_0/m1_34741_n3864# VSS 6.746650e-16
C3067 eeg_fd_ota_chopped_full2_0/eeg_fd_ota_core_soft_0/m1_42741_n3864# VSS 6.746650e-16
C3068 eeg_fd_ota_chopped_full2_0/eeg_fd_ota_core_soft_0/m1_43141_3443# VSS 6.746650e-16
C3069 eeg_fd_ota_chopped_full2_0/eeg_fd_ota_core_soft_0/m1_38341_3443# VSS 6.746650e-16
C3070 eeg_fd_ota_chopped_full2_0/eeg_fd_ota_core_soft_0/m1_38741_n3864# VSS 6.746650e-16
C3071 eeg_fd_ota_chopped_full2_0/eeg_fd_ota_core_soft_0/m1_29541_3443# VSS 6.746650e-16
C3072 eeg_fd_ota_chopped_full2_0/eeg_fd_ota_core_soft_0/m1_29941_n3864# VSS 6.746650e-16
C3073 eeg_fd_ota_chopped_full2_0/eeg_fd_ota_core_soft_0/m1_33941_n3864# VSS 6.746650e-16
C3074 eeg_fd_ota_chopped_full2_0/eeg_fd_ota_core_soft_0/m1_34341_3443# VSS 6.746650e-16
C3077 VSS eeg_fd_ota_chopped_full2_0/eeg_fd_ota_core_soft_0/OUTP 1.412244e-15
C3078 VSS eeg_fd_ota_chopped_full2_0/eeg_fd_ota_core_soft_0/m1_n22658_111# 1.572616e-15
C3079 eeg_fd_ota_chopped_full2_0/eeg_fd_ota_core_soft_0/INN VSS 3.113808e-14
C3080 eeg_fd_ota_chopped_full2_0/eeg_fd_ota_core_soft_0/INN eeg_fd_ota_chopped_full2_0/eeg_fd_ota_core_soft_0/INP 2.420658e-16
C3081 eeg_fd_ota_chopped_full2_0/eeg_fd_ota_core_soft_0/INN eeg_fd_ota_chopped_full2_0/eeg_fd_ota_core_soft_0/OUTN 1.694693e-14
C3082 eeg_fd_ota_chopped_full2_0/eeg_fd_ota_core_soft_0/INN eeg_fd_ota_chopped_full2_0/eeg_fd_ota_core_soft_0/m1_n22658_111# 1.694693e-14
C3083 eeg_fd_ota_chopped_full2_0/eeg_fd_ota_core_soft_0/INP VSS 3.114656e-14
C3084 eeg_fd_ota_chopped_full2_0/eeg_fd_ota_core_soft_0/INP eeg_fd_ota_chopped_full2_0/eeg_fd_ota_core_soft_0/OUTP 1.694693e-14
C3085 eeg_fd_ota_chopped_full2_0/eeg_fd_ota_core_soft_0/INP eeg_fd_ota_chopped_full2_0/eeg_fd_ota_core_soft_0/m1_n22658_111# 1.694693e-14
C3086 eeg_fd_ota_chopped_full2_0/eeg_fd_ota_core_soft_0/OUTN VSS 1.622652e-16
C3087 eeg_fd_ota_chopped_full2_0/eeg_fd_ota_core_soft_0/OUTN eeg_fd_ota_chopped_full2_0/eeg_fd_ota_core_soft_0/m1_n22658_111# 2.029956e-15
C3088 eeg_fd_ota_chopped_full2_0/eeg_fd_ota_core_soft_0/OUTP VSS 1.754879e-16
C3089 eeg_fd_ota_chopped_full2_0/eeg_fd_ota_core_soft_0/OUTP eeg_fd_ota_chopped_full2_0/eeg_fd_ota_core_soft_0/m1_n22658_111# 2.196456e-15
C3090 eeg_fd_ota_chopped_full2_0/eeg_fd_ota_core_soft_0/m1_n22658_111# VSS 2.094330e-15
C3091 eeg_fd_ota_chopped_full2_0/eeg_fd_ota_core_soft_0/m1_42341_3443# VSS 6.746650e-16
C3092 eeg_fd_ota_chopped_full2_0/eeg_fd_ota_core_soft_0/m1_42741_n3864# VSS 6.746650e-16
C3093 eeg_fd_ota_chopped_full2_0/eeg_fd_ota_core_soft_0/m1_37941_n3864# VSS 6.746650e-16
C3094 eeg_fd_ota_chopped_full2_0/eeg_fd_ota_core_soft_0/m1_38341_3443# VSS 6.746650e-16
C3095 eeg_fd_ota_chopped_full2_0/eeg_fd_ota_core_soft_0/m1_29141_n3864# VSS 6.746650e-16
C3096 eeg_fd_ota_chopped_full2_0/eeg_fd_ota_core_soft_0/m1_29541_3443# VSS 6.746650e-16
C3097 eeg_fd_ota_chopped_full2_0/eeg_fd_ota_core_soft_0/m1_33541_3443# VSS 6.746650e-16
C3098 eeg_fd_ota_chopped_full2_0/eeg_fd_ota_core_soft_0/m1_33941_n3864# VSS 6.746650e-16
C3099 eeg_fd_ota_chopped_full2_0/eeg_fd_ota_core_soft_0/m1_41941_n3864# VSS 6.746650e-16
C3100 eeg_fd_ota_chopped_full2_0/eeg_fd_ota_core_soft_0/m1_42341_3443# VSS 6.746650e-16
C3101 eeg_fd_ota_chopped_full2_0/eeg_fd_ota_core_soft_0/m1_37541_3443# VSS 6.746650e-16
C3102 eeg_fd_ota_chopped_full2_0/eeg_fd_ota_core_soft_0/m1_37941_n3864# VSS 6.746650e-16
C3103 eeg_fd_ota_chopped_full2_0/eeg_fd_ota_core_soft_0/m1_28741_3443# VSS 6.746650e-16
C3104 eeg_fd_ota_chopped_full2_0/eeg_fd_ota_core_soft_0/m1_29141_n3864# VSS 6.746650e-16
C3105 eeg_fd_ota_chopped_full2_0/eeg_fd_ota_core_soft_0/m1_33141_n3864# VSS 6.746650e-16
C3106 eeg_fd_ota_chopped_full2_0/eeg_fd_ota_core_soft_0/m1_33541_3443# VSS 6.746650e-16
C3107 eeg_fd_ota_chopped_full2_0/eeg_fd_ota_core_soft_0/m1_41541_3443# VSS 6.746650e-16
C3108 eeg_fd_ota_chopped_full2_0/eeg_fd_ota_core_soft_0/m1_41941_n3864# VSS 6.746650e-16
C3109 eeg_fd_ota_chopped_full2_0/eeg_fd_ota_core_soft_0/m1_37141_n3864# VSS 6.746650e-16
C3110 eeg_fd_ota_chopped_full2_0/eeg_fd_ota_core_soft_0/m1_37541_3443# VSS 6.746650e-16
C3111 eeg_fd_ota_chopped_full2_0/eeg_fd_ota_core_soft_0/m1_28341_n3864# VSS 6.746650e-16
C3112 eeg_fd_ota_chopped_full2_0/eeg_fd_ota_core_soft_0/m1_28741_3443# VSS 6.746650e-16
C3113 eeg_fd_ota_chopped_full2_0/eeg_fd_ota_core_soft_0/m1_32741_3443# VSS 6.746650e-16
C3114 eeg_fd_ota_chopped_full2_0/eeg_fd_ota_core_soft_0/m1_33141_n3864# VSS 6.746650e-16
C3115 eeg_fd_ota_chopped_full2_0/eeg_fd_ota_core_soft_0/OUTN VSS 6.746650e-16
C3116 eeg_fd_ota_chopped_full2_0/eeg_fd_ota_core_soft_0/m1_47541_n3864# VSS 6.746650e-16
C3117 eeg_fd_ota_chopped_full2_0/eeg_fd_ota_core_soft_0/m1_41141_n3864# VSS 6.746650e-16
C3118 eeg_fd_ota_chopped_full2_0/eeg_fd_ota_core_soft_0/m1_41541_3443# VSS 6.746650e-16
C3119 eeg_fd_ota_chopped_full2_0/eeg_cmfb_amp_dl2_0/VCM_SENSE VSS 6.746650e-16
C3120 eeg_fd_ota_chopped_full2_0/eeg_fd_ota_core_soft_0/m1_28341_n3864# VSS 6.746650e-16
C3121 eeg_fd_ota_chopped_full2_0/eeg_fd_ota_core_soft_0/m1_32341_n3864# VSS 6.746650e-16
C3122 eeg_fd_ota_chopped_full2_0/eeg_fd_ota_core_soft_0/m1_32741_3443# VSS 6.746650e-16
C3123 eeg_fd_ota_chopped_full2_0/eeg_fd_ota_core_soft_0/m1_36741_3443# VSS 6.746650e-16
C3124 eeg_fd_ota_chopped_full2_0/eeg_fd_ota_core_soft_0/m1_37141_n3864# VSS 6.746650e-16
C3125 eeg_fd_ota_chopped_full2_0/eeg_fd_ota_core_soft_0/m1_53941_n3864# VSS 6.746650e-16
C3126 eeg_fd_ota_chopped_full2_0/eeg_fd_ota_core_soft_0/m1_54341_3443# VSS 6.746650e-16
C3127 eeg_fd_ota_chopped_full2_0/eeg_fd_ota_core_soft_0/m1_47141_3443# VSS 6.746650e-16
C3128 eeg_fd_ota_chopped_full2_0/eeg_fd_ota_core_soft_0/m1_47541_n3864# VSS 6.746650e-16
C3129 eeg_fd_ota_chopped_full2_0/eeg_fd_ota_core_soft_0/m1_40741_3443# VSS 6.746650e-16
C3130 eeg_fd_ota_chopped_full2_0/eeg_fd_ota_core_soft_0/m1_41141_n3864# VSS 6.746650e-16
C3131 eeg_fd_ota_chopped_full2_0/eeg_fd_ota_core_soft_0/m1_36341_n3864# VSS 6.746650e-16
C3132 eeg_fd_ota_chopped_full2_0/eeg_fd_ota_core_soft_0/m1_36741_3443# VSS 6.746650e-16
C3133 eeg_fd_ota_chopped_full2_0/eeg_fd_ota_core_soft_0/m1_31941_3443# VSS 6.746650e-16
C3134 eeg_fd_ota_chopped_full2_0/eeg_fd_ota_core_soft_0/m1_32341_n3864# VSS 6.746650e-16
C3135 eeg_fd_ota_chopped_full2_0/eeg_fd_ota_core_soft_0/OUTN VSS 6.746650e-16
C3136 eeg_fd_ota_chopped_full2_0/eeg_fd_ota_core_soft_0/m1_57941_n3864# VSS 6.746650e-16
C3137 eeg_fd_ota_chopped_full2_0/eeg_fd_ota_core_soft_0/m1_53541_3443# VSS 6.746650e-16
C3138 eeg_fd_ota_chopped_full2_0/eeg_fd_ota_core_soft_0/m1_53941_n3864# VSS 6.746650e-16
C3139 eeg_fd_ota_chopped_full2_0/eeg_fd_ota_core_soft_0/m1_46741_n3864# VSS 6.746650e-16
C3140 eeg_fd_ota_chopped_full2_0/eeg_fd_ota_core_soft_0/m1_47141_3443# VSS 6.746650e-16
C3141 eeg_fd_ota_chopped_full2_0/eeg_fd_ota_core_soft_0/m1_40341_n3864# VSS 6.746650e-16
C3142 eeg_fd_ota_chopped_full2_0/eeg_fd_ota_core_soft_0/m1_40741_3443# VSS 6.746650e-16
C3143 eeg_fd_ota_chopped_full2_0/eeg_fd_ota_core_soft_0/m1_35941_3443# VSS 6.746650e-16
C3144 eeg_fd_ota_chopped_full2_0/eeg_fd_ota_core_soft_0/m1_36341_n3864# VSS 6.746650e-16
C3145 eeg_fd_ota_chopped_full2_0/eeg_fd_ota_core_soft_0/m1_57541_3443# VSS 6.746650e-16
C3146 eeg_fd_ota_chopped_full2_0/eeg_fd_ota_core_soft_0/m1_57941_n3864# VSS 6.746650e-16
C3147 eeg_fd_ota_chopped_full2_0/eeg_fd_ota_core_soft_0/m1_53141_n3864# VSS 6.746650e-16
C3148 eeg_fd_ota_chopped_full2_0/eeg_fd_ota_core_soft_0/m1_53541_3443# VSS 6.746650e-16
C3149 eeg_fd_ota_chopped_full2_0/eeg_fd_ota_core_soft_0/m1_46341_3443# VSS 6.746650e-16
C3150 eeg_fd_ota_chopped_full2_0/eeg_fd_ota_core_soft_0/m1_46741_n3864# VSS 6.746650e-16
C3151 eeg_fd_ota_chopped_full2_0/eeg_fd_ota_core_soft_0/m1_n44859_n3864# VSS 6.746650e-16
C3152 eeg_fd_ota_chopped_full2_0/eeg_fd_ota_core_soft_0/m1_n45259_3443# VSS 6.746650e-16
C3153 eeg_fd_ota_chopped_full2_0/eeg_fd_ota_core_soft_0/m1_39941_3443# VSS 6.746650e-16
C3154 eeg_fd_ota_chopped_full2_0/eeg_fd_ota_core_soft_0/m1_40341_n3864# VSS 6.746650e-16
C3155 eeg_fd_ota_chopped_full2_0/eeg_fd_ota_core_soft_0/m1_57141_n3864# VSS 6.746650e-16
C3156 eeg_fd_ota_chopped_full2_0/eeg_fd_ota_core_soft_0/m1_57541_3443# VSS 6.746650e-16
C3157 eeg_fd_ota_chopped_full2_0/eeg_fd_ota_core_soft_0/m1_52741_3443# VSS 6.746650e-16
C3158 eeg_fd_ota_chopped_full2_0/eeg_fd_ota_core_soft_0/m1_53141_n3864# VSS 6.746650e-16
C3159 eeg_fd_ota_chopped_full2_0/eeg_fd_ota_core_soft_0/m1_45941_n3864# VSS 6.746650e-16
C3160 eeg_fd_ota_chopped_full2_0/eeg_fd_ota_core_soft_0/m1_46341_3443# VSS 6.746650e-16
C3161 eeg_fd_ota_chopped_full2_0/eeg_fd_ota_core_soft_0/m1_n45259_3443# VSS 6.746650e-16
C3162 eeg_fd_ota_chopped_full2_0/eeg_fd_ota_core_soft_0/m1_n45659_n3864# VSS 6.746650e-16
C3163 eeg_fd_ota_chopped_full2_0/eeg_fd_ota_core_soft_0/m1_n40859_n3864# VSS 6.746650e-16
C3164 eeg_fd_ota_chopped_full2_0/eeg_fd_ota_core_soft_0/m1_n41259_3443# VSS 6.746650e-16
C3165 eeg_fd_ota_chopped_full2_0/eeg_fd_ota_core_soft_0/m1_56741_3443# VSS 6.746650e-16
C3166 eeg_fd_ota_chopped_full2_0/eeg_fd_ota_core_soft_0/m1_57141_n3864# VSS 6.746650e-16
C3167 eeg_fd_ota_chopped_full2_0/eeg_fd_ota_core_soft_0/m1_52341_n3864# VSS 6.746650e-16
C3168 eeg_fd_ota_chopped_full2_0/eeg_fd_ota_core_soft_0/m1_52741_3443# VSS 6.746650e-16
C3169 eeg_fd_ota_chopped_full2_0/eeg_fd_ota_core_soft_0/m1_45541_3443# VSS 6.746650e-16
C3170 eeg_fd_ota_chopped_full2_0/eeg_fd_ota_core_soft_0/m1_45941_n3864# VSS 6.746650e-16
C3171 eeg_fd_ota_chopped_full2_0/eeg_fd_ota_core_soft_0/m1_n45659_n3864# VSS 6.746650e-16
C3172 eeg_fd_ota_chopped_full2_0/eeg_fd_ota_core_soft_0/m1_n46059_3443# VSS 6.746650e-16
C3173 eeg_fd_ota_chopped_full2_0/eeg_fd_ota_core_soft_0/m1_n41259_3443# VSS 6.746650e-16
C3174 eeg_fd_ota_chopped_full2_0/eeg_fd_ota_core_soft_0/m1_n41659_n3864# VSS 6.746650e-16
C3175 eeg_fd_ota_chopped_full2_0/eeg_fd_ota_core_soft_0/m1_n36859_n3864# VSS 6.746650e-16
C3176 eeg_fd_ota_chopped_full2_0/eeg_fd_ota_core_soft_0/m1_n37259_3443# VSS 6.746650e-16
C3177 eeg_fd_ota_chopped_full2_0/eeg_fd_ota_core_soft_0/m1_56341_n3864# VSS 6.746650e-16
C3178 eeg_fd_ota_chopped_full2_0/eeg_fd_ota_core_soft_0/m1_56741_3443# VSS 6.746650e-16
C3179 eeg_fd_ota_chopped_full2_0/eeg_fd_ota_core_soft_0/m1_51941_3443# VSS 6.746650e-16
C3180 eeg_fd_ota_chopped_full2_0/eeg_fd_ota_core_soft_0/m1_52341_n3864# VSS 6.746650e-16
C3181 eeg_fd_ota_chopped_full2_0/eeg_fd_ota_core_soft_0/m1_45141_n3864# VSS 6.746650e-16
C3182 eeg_fd_ota_chopped_full2_0/eeg_fd_ota_core_soft_0/m1_45541_3443# VSS 6.746650e-16
C3183 eeg_fd_ota_chopped_full2_0/eeg_fd_ota_core_soft_0/m1_n46059_3443# VSS 6.746650e-16
C3184 eeg_fd_ota_chopped_full2_0/eeg_fd_ota_core_soft_0/m1_n46459_n3864# VSS 6.746650e-16
C3185 eeg_fd_ota_chopped_full2_0/eeg_fd_ota_core_soft_0/m1_n41659_n3864# VSS 6.746650e-16
C3186 eeg_fd_ota_chopped_full2_0/eeg_fd_ota_core_soft_0/m1_n42059_3443# VSS 6.746650e-16
C3187 eeg_fd_ota_chopped_full2_0/eeg_fd_ota_core_soft_0/m1_n37259_3443# VSS 6.746650e-16
C3188 eeg_fd_ota_chopped_full2_0/eeg_fd_ota_core_soft_0/m1_n37659_n3864# VSS 6.746650e-16
C3189 eeg_fd_ota_chopped_full2_0/eeg_fd_ota_core_soft_0/m1_n32859_n3864# VSS 6.746650e-16
C3190 eeg_fd_ota_chopped_full2_0/eeg_fd_ota_core_soft_0/m1_n33259_3443# VSS 6.746650e-16
C3191 eeg_fd_ota_chopped_full2_0/eeg_fd_ota_core_soft_0/m1_55941_3443# VSS 6.746650e-16
C3192 eeg_fd_ota_chopped_full2_0/eeg_fd_ota_core_soft_0/m1_56341_n3864# VSS 6.746650e-16
C3193 eeg_fd_ota_chopped_full2_0/eeg_fd_ota_core_soft_0/m1_51541_n3864# VSS 6.746650e-16
C3194 eeg_fd_ota_chopped_full2_0/eeg_fd_ota_core_soft_0/m1_51941_3443# VSS 6.746650e-16
C3195 eeg_fd_ota_chopped_full2_0/eeg_fd_ota_core_soft_0/m1_44741_3443# VSS 6.746650e-16
C3196 eeg_fd_ota_chopped_full2_0/eeg_fd_ota_core_soft_0/m1_45141_n3864# VSS 6.746650e-16
C3197 eeg_fd_ota_chopped_full2_0/eeg_fd_ota_core_soft_0/m1_n46459_n3864# VSS 6.746650e-16
C3198 eeg_fd_ota_chopped_full2_0/eeg_fd_ota_core_soft_0/m1_n46859_3443# VSS 6.746650e-16
C3199 eeg_fd_ota_chopped_full2_0/eeg_fd_ota_core_soft_0/m1_n42059_3443# VSS 6.746650e-16
C3200 eeg_fd_ota_chopped_full2_0/eeg_fd_ota_core_soft_0/m1_n42459_n3864# VSS 6.746650e-16
C3201 eeg_fd_ota_chopped_full2_0/eeg_fd_ota_core_soft_0/m1_n37659_n3864# VSS 6.746650e-16
C3202 eeg_fd_ota_chopped_full2_0/eeg_fd_ota_core_soft_0/m1_n38059_3443# VSS 6.746650e-16
C3203 eeg_fd_ota_chopped_full2_0/eeg_fd_ota_core_soft_0/m1_n33259_3443# VSS 6.746650e-16
C3204 eeg_fd_ota_chopped_full2_0/eeg_fd_ota_core_soft_0/m1_n33659_n3864# VSS 6.746650e-16
C3205 eeg_fd_ota_chopped_full2_0/eeg_fd_ota_core_soft_0/m1_n28859_n3864# VSS 6.746650e-16
C3206 eeg_fd_ota_chopped_full2_0/eeg_fd_ota_core_soft_0/m1_n29259_3443# VSS 6.746650e-16
C3207 VDD18 VSS 4.124974e-14
C3208 VDD18 eeg_fd_ota_chopped_full2_0/eeg_cmfb_amp_dl2_0/VBP 1.216293e-14
C3209 VDD18 eeg_fd_ota_chopped_full2_0/eeg_fd_ota_core_soft_0/OUTP 1.242512e-15
C3210 eeg_fd_ota_chopped_full2_0/eeg_cmfb_amp_dl2_0/VBP VSS 2.342324e-15
C3211 eeg_fd_ota_chopped_full2_0/eeg_cmfb_amp_dl2_0/VBP eeg_fd_ota_chopped_full2_0/eeg_fd_ota_core_soft_0/OUTP 3.335800e-15
C3212 eeg_fd_ota_chopped_full2_0/eeg_fd_ota_core_soft_0/m1_55541_n3864# VSS 6.746650e-16
C3213 eeg_fd_ota_chopped_full2_0/eeg_fd_ota_core_soft_0/m1_55941_3443# VSS 6.746650e-16
C3214 eeg_fd_ota_chopped_full2_0/eeg_fd_ota_core_soft_0/m1_51141_3443# VSS 6.746650e-16
C3215 eeg_fd_ota_chopped_full2_0/eeg_fd_ota_core_soft_0/m1_51541_n3864# VSS 6.746650e-16
C3216 eeg_fd_ota_chopped_full2_0/eeg_fd_ota_core_soft_0/m1_44341_n3864# VSS 6.746650e-16
C3217 eeg_fd_ota_chopped_full2_0/eeg_fd_ota_core_soft_0/m1_44741_3443# VSS 6.746650e-16
C3218 eeg_fd_ota_chopped_full2_0/eeg_fd_ota_core_soft_0/m1_n55259_n3864# VSS 6.746650e-16
C3219 eeg_fd_ota_chopped_full2_0/eeg_fd_ota_core_soft_0/m1_n55659_3443# VSS 6.746650e-16
C3220 eeg_fd_ota_chopped_full2_0/eeg_fd_ota_core_soft_0/m1_n46859_3443# VSS 6.746650e-16
C3221 eeg_fd_ota_chopped_full2_0/eeg_fd_ota_core_soft_0/m1_n47259_n3864# VSS 6.746650e-16
C3222 eeg_fd_ota_chopped_full2_0/eeg_fd_ota_core_soft_0/m1_n42459_n3864# VSS 6.746650e-16
C3223 eeg_fd_ota_chopped_full2_0/eeg_fd_ota_core_soft_0/m1_n42859_3443# VSS 6.746650e-16
C3224 eeg_fd_ota_chopped_full2_0/eeg_fd_ota_core_soft_0/m1_n38059_3443# VSS 6.746650e-16
C3225 eeg_fd_ota_chopped_full2_0/eeg_fd_ota_core_soft_0/m1_n38459_n3864# VSS 6.746650e-16
C3226 eeg_fd_ota_chopped_full2_0/eeg_fd_ota_core_soft_0/m1_n33659_n3864# VSS 6.746650e-16
C3227 eeg_fd_ota_chopped_full2_0/eeg_fd_ota_core_soft_0/m1_n34059_3443# VSS 6.746650e-16
C3228 eeg_fd_ota_chopped_full2_0/eeg_fd_ota_core_soft_0/m1_n29259_3443# VSS 6.746650e-16
C3229 eeg_fd_ota_chopped_full2_0/eeg_fd_ota_core_soft_0/m1_n29659_n3864# VSS 6.746650e-16
C3230 eeg_fd_ota_chopped_full2_0/eeg_fd_ota_core_soft_0/m1_55141_3443# VSS 6.746650e-16
C3231 eeg_fd_ota_chopped_full2_0/eeg_fd_ota_core_soft_0/m1_55541_n3864# VSS 6.746650e-16
C3232 eeg_fd_ota_chopped_full2_0/eeg_fd_ota_core_soft_0/m1_50741_n3864# VSS 6.746650e-16
C3233 eeg_fd_ota_chopped_full2_0/eeg_fd_ota_core_soft_0/m1_51141_3443# VSS 6.746650e-16
C3234 eeg_fd_ota_chopped_full2_0/eeg_fd_ota_core_soft_0/m1_43941_3443# VSS 6.746650e-16
C3235 eeg_fd_ota_chopped_full2_0/eeg_fd_ota_core_soft_0/m1_44341_n3864# VSS 6.746650e-16
C3236 eeg_fd_ota_chopped_full2_0/eeg_fd_ota_core_soft_0/m1_n55659_3443# VSS 6.746650e-16
C3237 eeg_fd_ota_chopped_full2_0/eeg_fd_ota_core_soft_0/m1_n56059_n3864# VSS 6.746650e-16
C3238 eeg_fd_ota_chopped_full2_0/eeg_fd_ota_core_soft_0/m1_n47259_n3864# VSS 6.746650e-16
C3239 eeg_fd_ota_chopped_full2_0/eeg_fd_ota_core_soft_0/m1_n47659_3443# VSS 6.746650e-16
C3240 eeg_fd_ota_chopped_full2_0/eeg_fd_ota_core_soft_0/m1_n42859_3443# VSS 6.746650e-16
C3241 eeg_fd_ota_chopped_full2_0/eeg_fd_ota_core_soft_0/m1_n43259_n3864# VSS 6.746650e-16
C3242 eeg_fd_ota_chopped_full2_0/eeg_fd_ota_core_soft_0/m1_n38459_n3864# VSS 6.746650e-16
C3243 eeg_fd_ota_chopped_full2_0/eeg_fd_ota_core_soft_0/m1_n38859_3443# VSS 6.746650e-16
C3244 eeg_fd_ota_chopped_full2_0/eeg_fd_ota_core_soft_0/m1_n34059_3443# VSS 6.746650e-16
C3245 eeg_fd_ota_chopped_full2_0/eeg_fd_ota_core_soft_0/m1_n34459_n3864# VSS 6.746650e-16
C3246 eeg_fd_ota_chopped_full2_0/eeg_fd_ota_core_soft_0/m1_n29659_n3864# VSS 6.746650e-16
C3247 eeg_fd_ota_chopped_full2_0/eeg_fd_ota_core_soft_0/m1_n30059_3443# VSS 6.746650e-16
C3248 eeg_fd_ota_chopped_full2_0/eeg_fd_ota_core_soft_0/m1_54741_n3864# VSS 6.746650e-16
C3249 eeg_fd_ota_chopped_full2_0/eeg_fd_ota_core_soft_0/m1_55141_3443# VSS 6.746650e-16
C3250 VCM_REF VSS 6.746650e-16
C3251 eeg_fd_ota_chopped_full2_0/eeg_fd_ota_core_soft_0/m1_50741_n3864# VSS 6.746650e-16
C3252 eeg_fd_ota_chopped_full2_0/eeg_fd_ota_core_soft_0/m1_n56059_n3864# VSS 6.746650e-16
C3253 eeg_fd_ota_chopped_full2_0/eeg_fd_ota_core_soft_0/m1_n56459_3443# VSS 6.746650e-16
C3254 eeg_fd_ota_chopped_full2_0/eeg_fd_ota_core_soft_0/m1_n47659_3443# VSS 6.746650e-16
C3255 eeg_fd_ota_chopped_full2_0/eeg_fd_ota_core_soft_0/m1_n48059_n3864# VSS 6.746650e-16
C3256 eeg_fd_ota_chopped_full2_0/eeg_fd_ota_core_soft_0/m1_n43259_n3864# VSS 6.746650e-16
C3257 eeg_fd_ota_chopped_full2_0/eeg_fd_ota_core_soft_0/m1_n43659_3443# VSS 6.746650e-16
C3258 eeg_fd_ota_chopped_full2_0/eeg_fd_ota_core_soft_0/m1_n38859_3443# VSS 6.746650e-16
C3259 eeg_fd_ota_chopped_full2_0/eeg_fd_ota_core_soft_0/m1_n39259_n3864# VSS 6.746650e-16
C3260 eeg_fd_ota_chopped_full2_0/eeg_fd_ota_core_soft_0/m1_n34459_n3864# VSS 6.746650e-16
C3261 eeg_fd_ota_chopped_full2_0/eeg_fd_ota_core_soft_0/m1_n34859_3443# VSS 6.746650e-16
C3262 eeg_fd_ota_chopped_full2_0/eeg_fd_ota_core_soft_0/m1_n30059_3443# VSS 6.746650e-16
C3263 eeg_fd_ota_chopped_full2_0/eeg_fd_ota_core_soft_0/m1_n30459_n3864# VSS 6.746650e-16
C3264 eeg_fd_ota_chopped_full2_0/eeg_fd_ota_core_soft_0/m1_54341_3443# VSS 6.746650e-16
C3265 eeg_fd_ota_chopped_full2_0/eeg_fd_ota_core_soft_0/m1_54741_n3864# VSS 6.746650e-16
C3266 eeg_fd_ota_chopped_full2_0/eeg_fd_ota_core_soft_0/m1_n56459_3443# VSS 6.746650e-16
C3267 eeg_fd_ota_chopped_full2_0/eeg_fd_ota_core_soft_0/m1_n56859_n3864# VSS 6.746650e-16
C3268 eeg_fd_ota_chopped_full2_0/eeg_fd_ota_core_soft_0/OUTP VSS 6.746650e-16
C3269 eeg_fd_ota_chopped_full2_0/eeg_fd_ota_core_soft_0/m1_n48059_n3864# VSS 6.746650e-16
C3270 eeg_fd_ota_chopped_full2_0/eeg_fd_ota_core_soft_0/m1_n43659_3443# VSS 6.746650e-16
C3271 eeg_fd_ota_chopped_full2_0/eeg_fd_ota_core_soft_0/m1_n44059_n3864# VSS 6.746650e-16
C3272 eeg_fd_ota_chopped_full2_0/eeg_fd_ota_core_soft_0/m1_n39259_n3864# VSS 6.746650e-16
C3273 eeg_fd_ota_chopped_full2_0/eeg_fd_ota_core_soft_0/m1_n39659_3443# VSS 6.746650e-16
C3274 eeg_fd_ota_chopped_full2_0/eeg_fd_ota_core_soft_0/m1_n34859_3443# VSS 6.746650e-16
C3275 eeg_fd_ota_chopped_full2_0/eeg_fd_ota_core_soft_0/m1_n35259_n3864# VSS 6.746650e-16
C3276 eeg_fd_ota_chopped_full2_0/eeg_fd_ota_core_soft_0/m1_n30459_n3864# VSS 6.746650e-16
C3277 eeg_fd_ota_chopped_full2_0/eeg_fd_ota_core_soft_0/m1_n30859_3443# VSS 6.746650e-16
C3278 eeg_fd_ota_chopped_full2_0/eeg_fd_ota_core_soft_0/m1_n56859_n3864# VSS 6.746650e-16
C3279 eeg_fd_ota_chopped_full2_0/eeg_fd_ota_core_soft_0/m1_n57259_3443# VSS 6.746650e-16
C3280 VCM_REF VSS 6.746650e-16
C3281 eeg_fd_ota_chopped_full2_0/eeg_fd_ota_core_soft_0/m1_n51259_n3864# VSS 6.746650e-16
C3282 eeg_fd_ota_chopped_full2_0/eeg_fd_ota_core_soft_0/m1_n44059_n3864# VSS 6.746650e-16
C3283 eeg_fd_ota_chopped_full2_0/eeg_fd_ota_core_soft_0/m1_n44459_3443# VSS 6.746650e-16
C3284 eeg_fd_ota_chopped_full2_0/eeg_fd_ota_core_soft_0/m1_n39659_3443# VSS 6.746650e-16
C3285 eeg_fd_ota_chopped_full2_0/eeg_fd_ota_core_soft_0/m1_n40059_n3864# VSS 6.746650e-16
C3286 eeg_fd_ota_chopped_full2_0/eeg_fd_ota_core_soft_0/m1_n35259_n3864# VSS 6.746650e-16
C3287 eeg_fd_ota_chopped_full2_0/eeg_fd_ota_core_soft_0/m1_n35659_3443# VSS 6.746650e-16
C3288 eeg_fd_ota_chopped_full2_0/eeg_fd_ota_core_soft_0/m1_n30859_3443# VSS 6.746650e-16
C3289 eeg_fd_ota_chopped_full2_0/eeg_fd_ota_core_soft_0/m1_n31259_n3864# VSS 6.746650e-16
C3290 eeg_fd_ota_chopped_full2_0/eeg_fd_ota_core_soft_0/m1_n57259_3443# VSS 6.746650e-16
C3291 eeg_fd_ota_chopped_full2_0/eeg_fd_ota_core_soft_0/m1_n57659_n3864# VSS 6.746650e-16
C3292 eeg_fd_ota_chopped_full2_0/eeg_fd_ota_core_soft_0/m1_n44459_3443# VSS 6.746650e-16
C3293 eeg_fd_ota_chopped_full2_0/eeg_fd_ota_core_soft_0/m1_n44859_n3864# VSS 6.746650e-16
C3294 eeg_fd_ota_chopped_full2_0/eeg_fd_ota_core_soft_0/m1_n40059_n3864# VSS 6.746650e-16
C3295 eeg_fd_ota_chopped_full2_0/eeg_fd_ota_core_soft_0/m1_n40459_3443# VSS 6.746650e-16
C3296 eeg_fd_ota_chopped_full2_0/eeg_fd_ota_core_soft_0/m1_n35659_3443# VSS 6.746650e-16
C3297 eeg_fd_ota_chopped_full2_0/eeg_fd_ota_core_soft_0/m1_n36059_n3864# VSS 6.746650e-16
C3298 eeg_fd_ota_chopped_full2_0/eeg_fd_ota_core_soft_0/m1_n31259_n3864# VSS 6.746650e-16
C3299 eeg_fd_ota_chopped_full2_0/eeg_fd_ota_core_soft_0/m1_n31659_3443# VSS 6.746650e-16
C3300 VDD18 VSS 4.124974e-14
C3301 VDD18 eeg_fd_ota_chopped_full2_0/eeg_cmfb_amp_dl2_0/VBP 1.216293e-14
C3302 VDD18 eeg_fd_ota_chopped_full2_0/eeg_fd_ota_core_soft_0/OUTN 1.242512e-15
C3303 eeg_fd_ota_chopped_full2_0/eeg_cmfb_amp_dl2_0/VBP VSS 2.342324e-15
C3304 eeg_fd_ota_chopped_full2_0/eeg_cmfb_amp_dl2_0/VBP eeg_fd_ota_chopped_full2_0/eeg_fd_ota_core_soft_0/OUTN 3.335800e-15
C3305 eeg_fd_ota_chopped_full2_0/eeg_fd_ota_core_soft_0/m1_n57659_n3864# VSS 6.746650e-16
C3306 eeg_fd_ota_chopped_full2_0/eeg_fd_ota_core_soft_0/m1_n58059_3443# VSS 6.746650e-16
C3307 eeg_fd_ota_chopped_full2_0/eeg_fd_ota_core_soft_0/m1_n40459_3443# VSS 6.746650e-16
C3308 eeg_fd_ota_chopped_full2_0/eeg_fd_ota_core_soft_0/m1_n40859_n3864# VSS 6.746650e-16
C3309 eeg_fd_ota_chopped_full2_0/eeg_fd_ota_core_soft_0/m1_n36059_n3864# VSS 6.746650e-16
C3310 eeg_fd_ota_chopped_full2_0/eeg_fd_ota_core_soft_0/m1_n36459_3443# VSS 6.746650e-16
C3311 eeg_fd_ota_chopped_full2_0/eeg_fd_ota_core_soft_0/m1_n31659_3443# VSS 6.746650e-16
C3312 eeg_fd_ota_chopped_full2_0/eeg_fd_ota_core_soft_0/m1_n32059_n3864# VSS 6.746650e-16
C3313 eeg_fd_ota_chopped_full2_0/eeg_fd_ota_core_soft_0/m1_n58059_3443# VSS 6.746650e-16
C3314 eeg_fd_ota_chopped_full2_0/eeg_fd_ota_core_soft_0/m1_n58459_n3864# VSS 6.746650e-16
C3315 eeg_fd_ota_chopped_full2_0/eeg_fd_ota_core_soft_0/m1_n36459_3443# VSS 6.746650e-16
C3316 eeg_fd_ota_chopped_full2_0/eeg_fd_ota_core_soft_0/m1_n36859_n3864# VSS 6.746650e-16
C3317 eeg_fd_ota_chopped_full2_0/eeg_fd_ota_core_soft_0/m1_n32059_n3864# VSS 6.746650e-16
C3318 eeg_fd_ota_chopped_full2_0/eeg_fd_ota_core_soft_0/m1_n32459_3443# VSS 6.746650e-16
C3319 eeg_fd_ota_chopped_full2_0/eeg_fd_ota_core_soft_0/OUTP VSS 6.746650e-16
C3320 eeg_fd_ota_chopped_full2_0/eeg_fd_ota_core_soft_0/m1_n58459_n3864# VSS 6.746650e-16
C3321 eeg_fd_ota_chopped_full2_0/eeg_fd_ota_core_soft_0/m1_n32459_3443# VSS 6.746650e-16
C3322 eeg_fd_ota_chopped_full2_0/eeg_fd_ota_core_soft_0/m1_n32859_n3864# VSS 6.746650e-16
C3323 eeg_fd_ota_chopped_full2_0/eeg_cmfb_amp_dl2_0/VCM_SENSE VSS 6.746650e-16
C3324 eeg_fd_ota_chopped_full2_0/eeg_fd_ota_core_soft_0/m1_n28859_n3864# VSS 6.746650e-16
C3325 VCM_REF VSS 1.699680e-15
C3326 VCM_REF eeg_pseudo_res_0/m1_68_66# 5.017998e-16
C3327 VCM_REF eeg_tg_lowq_3/B 8.460309e-16
C3328 eeg_pseudo_res_0/m1_68_66# VSS 3.582030e-15
C3329 eeg_pseudo_res_0/m1_68_66# eeg_tg_lowq_3/B 1.314672e-15
C3330 eeg_tg_lowq_3/B VSS 8.414800e-16
C3331 VCM_REF VSS 3.678650e-15
C3332 VCM_REF eeg_pseudo_res_0/m1_68_66# 1.322042e-15
C3333 eeg_pseudo_res_0/m1_68_66# VSS 4.103261e-16
C3334 eeg_pseudo_res_0/m1_68_66# VSS 4.103261e-16
C3335 eeg_pseudo_res_0/m1_68_66# eeg_tg_lowq_3/B 1.322042e-15
C3336 eeg_tg_lowq_3/B VSS 3.678650e-15
C3337 VCM_REF VSS 1.699680e-15
C3338 VCM_REF eeg_pseudo_res_1/m1_68_66# 5.017998e-16
C3339 VCM_REF eeg_tg_lowq_7/B 8.460309e-16
C3340 eeg_pseudo_res_1/m1_68_66# VSS 3.582030e-15
C3341 eeg_pseudo_res_1/m1_68_66# eeg_tg_lowq_7/B 1.314672e-15
C3342 eeg_tg_lowq_7/B VSS 8.414800e-16
C3343 VCM_REF VSS 3.678650e-15
C3344 VCM_REF eeg_pseudo_res_1/m1_68_66# 1.322042e-15
C3345 eeg_pseudo_res_1/m1_68_66# VSS 4.103261e-16
C3346 eeg_pseudo_res_1/m1_68_66# VSS 4.103261e-16
C3347 eeg_pseudo_res_1/m1_68_66# eeg_tg_lowq_7/B 1.322042e-15
C3348 eeg_tg_lowq_7/B VSS 3.678650e-15
C3349 S16 VDD18 6.588032e-16
C3350 S16 VSS 1.789951e-15
C3351 S16 eeg_inv_2/Y 1.215812e-15
C3352 S16 eeg_tg_lowq_0/A 1.181323e-16
C3353 S16 eeg_tg_lowq_3/B 2.857784e-16
C3354 VDD18 VSS 3.714735e-15
C3355 VDD18 eeg_inv_2/Y 5.262242e-16
C3356 VDD18 eeg_tg_lowq_0/A 1.484229e-16
C3357 VDD18 eeg_tg_lowq_3/B 3.128723e-16
C3358 VSS eeg_inv_2/Y 1.446619e-15
C3359 VSS eeg_tg_lowq_0/A 7.819878e-17
C3360 VSS eeg_tg_lowq_3/B 1.097210e-16
C3361 eeg_inv_2/Y VSS 1.090650e-15
C3362 eeg_inv_2/Y eeg_tg_lowq_0/A 4.755154e-17
C3363 eeg_inv_2/Y eeg_tg_lowq_3/B 1.076105e-16
C3364 eeg_tg_lowq_0/A VSS 2.430800e-15
C3365 eeg_tg_lowq_0/A eeg_tg_lowq_3/B 1.492117e-15
C3366 eeg_tg_lowq_3/B VSS 1.462840e-15
C3367 S16 VDD18 1.564350e-16
C3368 S16 VSS 4.901000e-17
C3369 S16 eeg_tg_lowq_3/B 2.862080e-17
C3370 VDD18 VSS 1.561810e-15
C3371 VDD18 eeg_tg_lowq_3/B 1.697704e-16
C3372 eeg_tg_lowq_3/B VSS 8.867300e-17
C3373 eeg_inv_2/Y VSS 2.062020e-16
C3374 eeg_inv_2/Y eeg_tg_lowq_0/A 2.084120e-17
C3375 eeg_tg_lowq_0/A VSS 1.088312e-16
C3376 eeg_inv_2/Y VSS 2.062020e-16
C3377 eeg_inv_2/Y eeg_tg_lowq_3/B 2.084120e-17
C3378 eeg_tg_lowq_3/B VSS 1.088312e-16
C3379 VDD18 VSS 2.327590e-15
C3380 VDD18 eeg_inv_2/Y 1.594600e-16
C3381 VDD18 eeg_tg_lowq_0/A 1.554040e-16
C3382 VDD18 eeg_tg_lowq_3/B 1.554040e-16
C3383 eeg_inv_2/Y VSS 4.382640e-17
C3384 eeg_inv_2/Y eeg_tg_lowq_0/A 2.402360e-17
C3385 eeg_inv_2/Y eeg_tg_lowq_3/B 2.402360e-17
C3386 eeg_tg_lowq_0/A VSS 7.837880e-17
C3387 eeg_tg_lowq_0/A eeg_tg_lowq_3/B 1.170160e-16
C3388 eeg_tg_lowq_3/B VSS 7.837880e-17
C3389 S16 VDD18 1.564350e-16
C3390 S16 VSS 4.901000e-17
C3391 S16 eeg_tg_lowq_0/A 2.862080e-17
C3392 VDD18 VSS 1.561810e-15
C3393 VDD18 eeg_tg_lowq_0/A 1.697704e-16
C3394 eeg_tg_lowq_0/A VSS 8.867300e-17
C3395 S16 VSS 2.027230e-16
C3398 eeg_tg_lowq_0/A VSS 1.267930e-16
C3399 eeg_tg_lowq_0/A eeg_tg_lowq_3/B 5.623600e-17
C3400 eeg_tg_lowq_3/B VSS 1.267930e-16
C3401 S8 VDD18 6.588032e-16
C3402 S8 VSS 1.789951e-15
C3403 S8 eeg_inv_3/Y 1.215812e-15
C3404 S8 eeg_tg_lowq_1/A 1.181323e-16
C3405 S8 eeg_tg_lowq_3/B 2.857784e-16
C3406 VDD18 VSS 3.714735e-15
C3407 VDD18 eeg_inv_3/Y 5.262242e-16
C3408 VDD18 eeg_tg_lowq_1/A 1.484229e-16
C3409 VDD18 eeg_tg_lowq_3/B 3.128723e-16
C3410 VSS eeg_inv_3/Y 1.446619e-15
C3411 VSS eeg_tg_lowq_1/A 7.819878e-17
C3412 VSS eeg_tg_lowq_3/B 1.097210e-16
C3413 eeg_inv_3/Y VSS 1.090650e-15
C3414 eeg_inv_3/Y eeg_tg_lowq_1/A 4.755154e-17
C3415 eeg_inv_3/Y eeg_tg_lowq_3/B 1.076105e-16
C3416 eeg_tg_lowq_1/A VSS 2.430800e-15
C3417 eeg_tg_lowq_1/A eeg_tg_lowq_3/B 1.492117e-15
C3418 eeg_tg_lowq_3/B VSS 1.462840e-15
C3419 S8 VDD18 1.564350e-16
C3420 S8 VSS 4.901000e-17
C3421 S8 eeg_tg_lowq_3/B 2.862080e-17
C3422 VDD18 VSS 1.561810e-15
C3423 VDD18 eeg_tg_lowq_3/B 1.697704e-16
C3424 eeg_tg_lowq_3/B VSS 8.867300e-17
C3425 eeg_inv_3/Y VSS 2.062020e-16
C3426 eeg_inv_3/Y eeg_tg_lowq_1/A 2.084120e-17
C3427 eeg_tg_lowq_1/A VSS 1.088312e-16
C3428 eeg_inv_3/Y VSS 2.062020e-16
C3429 eeg_inv_3/Y eeg_tg_lowq_3/B 2.084120e-17
C3430 eeg_tg_lowq_3/B VSS 1.088312e-16
C3431 VDD18 VSS 2.327590e-15
C3432 VDD18 eeg_inv_3/Y 1.594600e-16
C3433 VDD18 eeg_tg_lowq_1/A 1.554040e-16
C3434 VDD18 eeg_tg_lowq_3/B 1.554040e-16
C3435 eeg_inv_3/Y VSS 4.382640e-17
C3436 eeg_inv_3/Y eeg_tg_lowq_1/A 2.402360e-17
C3437 eeg_inv_3/Y eeg_tg_lowq_3/B 2.402360e-17
C3438 eeg_tg_lowq_1/A VSS 7.837880e-17
C3439 eeg_tg_lowq_1/A eeg_tg_lowq_3/B 1.170160e-16
C3440 eeg_tg_lowq_3/B VSS 7.837880e-17
C3441 S8 VDD18 1.564350e-16
C3442 S8 VSS 4.901000e-17
C3443 S8 eeg_tg_lowq_1/A 2.862080e-17
C3444 VDD18 VSS 1.561810e-15
C3445 VDD18 eeg_tg_lowq_1/A 1.697704e-16
C3446 eeg_tg_lowq_1/A VSS 8.867300e-17
C3447 S8 VSS 2.027230e-16
C3450 eeg_tg_lowq_1/A VSS 1.267930e-16
C3451 eeg_tg_lowq_1/A eeg_tg_lowq_3/B 5.623600e-17
C3452 eeg_tg_lowq_3/B VSS 1.267930e-16
C3453 RST VCM_REF 2.857784e-16
C3454 RST VDD18 6.588032e-16
C3455 RST VSS 1.789951e-15
C3456 RST eeg_inv_0/Y 1.215812e-15
C3457 RST eeg_tg_lowq_3/B 1.181323e-16
C3458 VCM_REF VDD18 3.128723e-16
C3459 VCM_REF VSS 1.572561e-15
C3460 VCM_REF eeg_inv_0/Y 1.076105e-16
C3461 VCM_REF eeg_tg_lowq_3/B 1.492117e-15
C3462 VDD18 VSS 3.714735e-15
C3463 VDD18 eeg_inv_0/Y 5.262242e-16
C3464 VDD18 eeg_tg_lowq_3/B 1.484229e-16
C3465 VSS eeg_inv_0/Y 1.446619e-15
C3466 VSS eeg_tg_lowq_3/B 7.819878e-17
C3467 eeg_inv_0/Y VSS 1.090650e-15
C3468 eeg_inv_0/Y eeg_tg_lowq_3/B 4.755154e-17
C3469 eeg_tg_lowq_3/B VSS 2.430800e-15
C3470 RST VCM_REF 2.862080e-17
C3471 RST VDD18 1.564350e-16
C3472 RST VSS 4.901000e-17
C3473 VCM_REF VDD18 1.697704e-16
C3474 VCM_REF VSS 8.867300e-17
C3475 VDD18 VSS 1.561810e-15
C3476 eeg_inv_0/Y VSS 2.062020e-16
C3477 eeg_inv_0/Y eeg_tg_lowq_3/B 2.084120e-17
C3478 eeg_tg_lowq_3/B VSS 1.088312e-16
C3479 VCM_REF VSS 1.088312e-16
C3480 VCM_REF eeg_inv_0/Y 2.084120e-17
C3481 eeg_inv_0/Y VSS 2.062020e-16
C3482 VCM_REF VDD18 1.554040e-16
C3483 VCM_REF VSS 7.837880e-17
C3484 VCM_REF eeg_inv_0/Y 2.402360e-17
C3485 VCM_REF eeg_tg_lowq_3/B 1.170160e-16
C3486 VDD18 VSS 2.327590e-15
C3487 VDD18 eeg_inv_0/Y 1.594600e-16
C3488 VDD18 eeg_tg_lowq_3/B 1.554040e-16
C3489 eeg_inv_0/Y VSS 4.382640e-17
C3490 eeg_inv_0/Y eeg_tg_lowq_3/B 2.402360e-17
C3491 eeg_tg_lowq_3/B VSS 7.837880e-17
C3492 RST VDD18 1.564350e-16
C3493 RST VSS 4.901000e-17
C3494 RST eeg_tg_lowq_3/B 2.862080e-17
C3495 VDD18 VSS 1.561810e-15
C3496 VDD18 eeg_tg_lowq_3/B 1.697704e-16
C3497 eeg_tg_lowq_3/B VSS 8.867300e-17
C3499 RST VSS 2.027230e-16
C3501 VCM_REF VSS 1.267930e-16
C3502 VCM_REF eeg_tg_lowq_3/B 5.623600e-17
C3503 eeg_tg_lowq_3/B VSS 1.267930e-16
C3504 S32 VDD18 6.588032e-16
C3505 S32 VSS 1.789951e-15
C3506 S32 eeg_inv_1/Y 1.215812e-15
C3507 S32 eeg_tg_lowq_3/A 1.181323e-16
C3508 S32 eeg_tg_lowq_3/B 2.857784e-16
C3509 VDD18 VSS 3.714735e-15
C3510 VDD18 eeg_inv_1/Y 5.262242e-16
C3511 VDD18 eeg_tg_lowq_3/A 1.484229e-16
C3512 VDD18 eeg_tg_lowq_3/B 3.128723e-16
C3513 VSS eeg_inv_1/Y 1.446619e-15
C3514 VSS eeg_tg_lowq_3/A 7.819878e-17
C3515 VSS eeg_tg_lowq_3/B 1.097210e-16
C3516 eeg_inv_1/Y VSS 1.090650e-15
C3517 eeg_inv_1/Y eeg_tg_lowq_3/A 4.755154e-17
C3518 eeg_inv_1/Y eeg_tg_lowq_3/B 1.076105e-16
C3519 eeg_tg_lowq_3/A VSS 2.430800e-15
C3520 eeg_tg_lowq_3/A eeg_tg_lowq_3/B 1.492117e-15
C3521 eeg_tg_lowq_3/B VSS 1.462840e-15
C3522 S32 VDD18 1.564350e-16
C3523 S32 VSS 4.901000e-17
C3524 S32 eeg_tg_lowq_3/B 2.862080e-17
C3525 VDD18 VSS 1.561810e-15
C3526 VDD18 eeg_tg_lowq_3/B 1.697704e-16
C3527 eeg_tg_lowq_3/B VSS 8.867300e-17
C3528 eeg_inv_1/Y VSS 2.062020e-16
C3529 eeg_inv_1/Y eeg_tg_lowq_3/A 2.084120e-17
C3530 eeg_tg_lowq_3/A VSS 1.088312e-16
C3531 eeg_inv_1/Y VSS 2.062020e-16
C3532 eeg_inv_1/Y eeg_tg_lowq_3/B 2.084120e-17
C3533 eeg_tg_lowq_3/B VSS 1.088312e-16
C3534 VDD18 VSS 2.327590e-15
C3535 VDD18 eeg_inv_1/Y 1.594600e-16
C3536 VDD18 eeg_tg_lowq_3/A 1.554040e-16
C3537 VDD18 eeg_tg_lowq_3/B 1.554040e-16
C3538 eeg_inv_1/Y VSS 4.382640e-17
C3539 eeg_inv_1/Y eeg_tg_lowq_3/A 2.402360e-17
C3540 eeg_inv_1/Y eeg_tg_lowq_3/B 2.402360e-17
C3541 eeg_tg_lowq_3/A VSS 7.837880e-17
C3542 eeg_tg_lowq_3/A eeg_tg_lowq_3/B 1.170160e-16
C3543 eeg_tg_lowq_3/B VSS 7.837880e-17
C3544 S32 VDD18 1.564350e-16
C3545 S32 VSS 4.901000e-17
C3546 S32 eeg_tg_lowq_3/A 2.862080e-17
C3547 VDD18 VSS 1.561810e-15
C3548 VDD18 eeg_tg_lowq_3/A 1.697704e-16
C3549 eeg_tg_lowq_3/A VSS 8.867300e-17
C3550 S32 VSS 2.027230e-16
C3553 eeg_tg_lowq_3/A VSS 1.267930e-16
C3554 eeg_tg_lowq_3/A eeg_tg_lowq_3/B 5.623600e-17
C3555 eeg_tg_lowq_3/B VSS 1.267930e-16
C3556 RST VCM_REF 2.857784e-16
C3557 RST VDD18 6.588032e-16
C3558 RST VSS 1.789951e-15
C3559 RST eeg_inv_0/Y 1.215812e-15
C3560 RST eeg_tg_lowq_7/B 1.181323e-16
C3561 VCM_REF VDD18 3.128723e-16
C3562 VCM_REF VSS 1.572561e-15
C3563 VCM_REF eeg_inv_0/Y 1.076105e-16
C3564 VCM_REF eeg_tg_lowq_7/B 1.492117e-15
C3565 VDD18 VSS 3.714735e-15
C3566 VDD18 eeg_inv_0/Y 5.262242e-16
C3567 VDD18 eeg_tg_lowq_7/B 1.484229e-16
C3568 VSS eeg_inv_0/Y 1.446619e-15
C3569 VSS eeg_tg_lowq_7/B 7.819878e-17
C3570 eeg_inv_0/Y VSS 1.090650e-15
C3571 eeg_inv_0/Y eeg_tg_lowq_7/B 4.755154e-17
C3572 eeg_tg_lowq_7/B VSS 2.430800e-15
C3573 RST VCM_REF 2.862080e-17
C3574 RST VDD18 1.564350e-16
C3575 RST VSS 4.901000e-17
C3576 VCM_REF VDD18 1.697704e-16
C3577 VCM_REF VSS 8.867300e-17
C3578 VDD18 VSS 1.561810e-15
C3579 eeg_inv_0/Y VSS 2.062020e-16
C3580 eeg_inv_0/Y eeg_tg_lowq_7/B 2.084120e-17
C3581 eeg_tg_lowq_7/B VSS 1.088312e-16
C3582 VCM_REF VSS 1.088312e-16
C3583 VCM_REF eeg_inv_0/Y 2.084120e-17
C3584 eeg_inv_0/Y VSS 2.062020e-16
C3585 VCM_REF VDD18 1.554040e-16
C3586 VCM_REF VSS 7.837880e-17
C3587 VCM_REF eeg_inv_0/Y 2.402360e-17
C3588 VCM_REF eeg_tg_lowq_7/B 1.170160e-16
C3589 VDD18 VSS 2.327590e-15
C3590 VDD18 eeg_inv_0/Y 1.594600e-16
C3591 VDD18 eeg_tg_lowq_7/B 1.554040e-16
C3592 eeg_inv_0/Y VSS 4.382640e-17
C3593 eeg_inv_0/Y eeg_tg_lowq_7/B 2.402360e-17
C3594 eeg_tg_lowq_7/B VSS 7.837880e-17
C3595 RST VDD18 1.564350e-16
C3596 RST VSS 4.901000e-17
C3597 RST eeg_tg_lowq_7/B 2.862080e-17
C3598 VDD18 VSS 1.561810e-15
C3599 VDD18 eeg_tg_lowq_7/B 1.697704e-16
C3600 eeg_tg_lowq_7/B VSS 8.867300e-17
C3602 RST VSS 2.027230e-16
C3604 VCM_REF VSS 1.267930e-16
C3605 VCM_REF eeg_tg_lowq_7/B 5.623600e-17
C3606 eeg_tg_lowq_7/B VSS 1.267930e-16
C3607 S8 VDD18 6.588032e-16
C3608 S8 VSS 1.789951e-15
C3609 S8 eeg_inv_3/Y 1.215812e-15
C3610 S8 eeg_tg_lowq_5/A 1.181323e-16
C3611 S8 eeg_tg_lowq_7/B 2.857784e-16
C3612 VDD18 VSS 3.714735e-15
C3613 VDD18 eeg_inv_3/Y 5.262242e-16
C3614 VDD18 eeg_tg_lowq_5/A 1.484229e-16
C3615 VDD18 eeg_tg_lowq_7/B 3.128723e-16
C3616 VSS eeg_inv_3/Y 1.446619e-15
C3617 VSS eeg_tg_lowq_5/A 7.819878e-17
C3618 VSS eeg_tg_lowq_7/B 1.097210e-16
C3619 eeg_inv_3/Y VSS 1.090650e-15
C3620 eeg_inv_3/Y eeg_tg_lowq_5/A 4.755154e-17
C3621 eeg_inv_3/Y eeg_tg_lowq_7/B 1.076105e-16
C3622 eeg_tg_lowq_5/A VSS 2.430800e-15
C3623 eeg_tg_lowq_5/A eeg_tg_lowq_7/B 1.492117e-15
C3624 eeg_tg_lowq_7/B VSS 1.462840e-15
C3625 S8 VDD18 1.564350e-16
C3626 S8 VSS 4.901000e-17
C3627 S8 eeg_tg_lowq_7/B 2.862080e-17
C3628 VDD18 VSS 1.561810e-15
C3629 VDD18 eeg_tg_lowq_7/B 1.697704e-16
C3630 eeg_tg_lowq_7/B VSS 8.867300e-17
C3631 eeg_inv_3/Y VSS 2.062020e-16
C3632 eeg_inv_3/Y eeg_tg_lowq_5/A 2.084120e-17
C3633 eeg_tg_lowq_5/A VSS 1.088312e-16
C3634 eeg_inv_3/Y VSS 2.062020e-16
C3635 eeg_inv_3/Y eeg_tg_lowq_7/B 2.084120e-17
C3636 eeg_tg_lowq_7/B VSS 1.088312e-16
C3637 VDD18 VSS 2.327590e-15
C3638 VDD18 eeg_inv_3/Y 1.594600e-16
C3639 VDD18 eeg_tg_lowq_5/A 1.554040e-16
C3640 VDD18 eeg_tg_lowq_7/B 1.554040e-16
C3641 eeg_inv_3/Y VSS 4.382640e-17
C3642 eeg_inv_3/Y eeg_tg_lowq_5/A 2.402360e-17
C3643 eeg_inv_3/Y eeg_tg_lowq_7/B 2.402360e-17
C3644 eeg_tg_lowq_5/A VSS 7.837880e-17
C3645 eeg_tg_lowq_5/A eeg_tg_lowq_7/B 1.170160e-16
C3646 eeg_tg_lowq_7/B VSS 7.837880e-17
C3647 S8 VDD18 1.564350e-16
C3648 S8 VSS 4.901000e-17
C3649 S8 eeg_tg_lowq_5/A 2.862080e-17
C3650 VDD18 VSS 1.561810e-15
C3651 VDD18 eeg_tg_lowq_5/A 1.697704e-16
C3652 eeg_tg_lowq_5/A VSS 8.867300e-17
C3653 S8 VSS 2.027230e-16
C3656 eeg_tg_lowq_5/A VSS 1.267930e-16
C3657 eeg_tg_lowq_5/A eeg_tg_lowq_7/B 5.623600e-17
C3658 eeg_tg_lowq_7/B VSS 1.267930e-16
C3659 S16 VDD18 6.588032e-16
C3660 S16 VSS 1.789951e-15
C3661 S16 eeg_inv_2/Y 1.215812e-15
C3662 S16 eeg_tg_lowq_6/A 1.181323e-16
C3663 S16 eeg_tg_lowq_7/B 2.857784e-16
C3664 VDD18 VSS 3.714735e-15
C3665 VDD18 eeg_inv_2/Y 5.262242e-16
C3666 VDD18 eeg_tg_lowq_6/A 1.484229e-16
C3667 VDD18 eeg_tg_lowq_7/B 3.128723e-16
C3668 VSS eeg_inv_2/Y 1.446619e-15
C3669 VSS eeg_tg_lowq_6/A 7.819878e-17
C3670 VSS eeg_tg_lowq_7/B 1.097210e-16
C3671 eeg_inv_2/Y VSS 1.090650e-15
C3672 eeg_inv_2/Y eeg_tg_lowq_6/A 4.755154e-17
C3673 eeg_inv_2/Y eeg_tg_lowq_7/B 1.076105e-16
C3674 eeg_tg_lowq_6/A VSS 2.430800e-15
C3675 eeg_tg_lowq_6/A eeg_tg_lowq_7/B 1.492117e-15
C3676 eeg_tg_lowq_7/B VSS 1.462840e-15
C3677 S16 VDD18 1.564350e-16
C3678 S16 VSS 4.901000e-17
C3679 S16 eeg_tg_lowq_7/B 2.862080e-17
C3680 VDD18 VSS 1.561810e-15
C3681 VDD18 eeg_tg_lowq_7/B 1.697704e-16
C3682 eeg_tg_lowq_7/B VSS 8.867300e-17
C3683 eeg_inv_2/Y VSS 2.062020e-16
C3684 eeg_inv_2/Y eeg_tg_lowq_6/A 2.084120e-17
C3685 eeg_tg_lowq_6/A VSS 1.088312e-16
C3686 eeg_inv_2/Y VSS 2.062020e-16
C3687 eeg_inv_2/Y eeg_tg_lowq_7/B 2.084120e-17
C3688 eeg_tg_lowq_7/B VSS 1.088312e-16
C3689 VDD18 VSS 2.327590e-15
C3690 VDD18 eeg_inv_2/Y 1.594600e-16
C3691 VDD18 eeg_tg_lowq_6/A 1.554040e-16
C3692 VDD18 eeg_tg_lowq_7/B 1.554040e-16
C3693 eeg_inv_2/Y VSS 4.382640e-17
C3694 eeg_inv_2/Y eeg_tg_lowq_6/A 2.402360e-17
C3695 eeg_inv_2/Y eeg_tg_lowq_7/B 2.402360e-17
C3696 eeg_tg_lowq_6/A VSS 7.837880e-17
C3697 eeg_tg_lowq_6/A eeg_tg_lowq_7/B 1.170160e-16
C3698 eeg_tg_lowq_7/B VSS 7.837880e-17
C3699 S16 VDD18 1.564350e-16
C3700 S16 VSS 4.901000e-17
C3701 S16 eeg_tg_lowq_6/A 2.862080e-17
C3702 VDD18 VSS 1.561810e-15
C3703 VDD18 eeg_tg_lowq_6/A 1.697704e-16
C3704 eeg_tg_lowq_6/A VSS 8.867300e-17
C3705 S16 VSS 2.027230e-16
C3708 eeg_tg_lowq_6/A VSS 1.267930e-16
C3709 eeg_tg_lowq_6/A eeg_tg_lowq_7/B 5.623600e-17
C3710 eeg_tg_lowq_7/B VSS 1.267930e-16
C3711 S32 VDD18 6.588032e-16
C3712 S32 VSS 1.789951e-15
C3713 S32 eeg_inv_1/Y 1.215812e-15
C3714 S32 eeg_tg_lowq_7/A 1.181323e-16
C3715 S32 eeg_tg_lowq_7/B 2.857784e-16
C3716 VDD18 VSS 3.714735e-15
C3717 VDD18 eeg_inv_1/Y 5.262242e-16
C3718 VDD18 eeg_tg_lowq_7/A 1.484229e-16
C3719 VDD18 eeg_tg_lowq_7/B 3.128723e-16
C3720 VSS eeg_inv_1/Y 1.446619e-15
C3721 VSS eeg_tg_lowq_7/A 7.819878e-17
C3722 VSS eeg_tg_lowq_7/B 1.097210e-16
C3723 eeg_inv_1/Y VSS 1.090650e-15
C3724 eeg_inv_1/Y eeg_tg_lowq_7/A 4.755154e-17
C3725 eeg_inv_1/Y eeg_tg_lowq_7/B 1.076105e-16
C3726 eeg_tg_lowq_7/A VSS 2.430800e-15
C3727 eeg_tg_lowq_7/A eeg_tg_lowq_7/B 1.492117e-15
C3728 eeg_tg_lowq_7/B VSS 1.462840e-15
C3729 S32 VDD18 1.564350e-16
C3730 S32 VSS 4.901000e-17
C3731 S32 eeg_tg_lowq_7/B 2.862080e-17
C3732 VDD18 VSS 1.561810e-15
C3733 VDD18 eeg_tg_lowq_7/B 1.697704e-16
C3734 eeg_tg_lowq_7/B VSS 8.867300e-17
C3735 eeg_inv_1/Y VSS 2.062020e-16
C3736 eeg_inv_1/Y eeg_tg_lowq_7/A 2.084120e-17
C3737 eeg_tg_lowq_7/A VSS 1.088312e-16
C3738 eeg_inv_1/Y VSS 2.062020e-16
C3739 eeg_inv_1/Y eeg_tg_lowq_7/B 2.084120e-17
C3740 eeg_tg_lowq_7/B VSS 1.088312e-16
C3741 VDD18 VSS 2.327590e-15
C3742 VDD18 eeg_inv_1/Y 1.594600e-16
C3743 VDD18 eeg_tg_lowq_7/A 1.554040e-16
C3744 VDD18 eeg_tg_lowq_7/B 1.554040e-16
C3745 eeg_inv_1/Y VSS 4.382640e-17
C3746 eeg_inv_1/Y eeg_tg_lowq_7/A 2.402360e-17
C3747 eeg_inv_1/Y eeg_tg_lowq_7/B 2.402360e-17
C3748 eeg_tg_lowq_7/A VSS 7.837880e-17
C3749 eeg_tg_lowq_7/A eeg_tg_lowq_7/B 1.170160e-16
C3750 eeg_tg_lowq_7/B VSS 7.837880e-17
C3751 S32 VDD18 1.564350e-16
C3752 S32 VSS 4.901000e-17
C3753 S32 eeg_tg_lowq_7/A 2.862080e-17
C3754 VDD18 VSS 1.561810e-15
C3755 VDD18 eeg_tg_lowq_7/A 1.697704e-16
C3756 eeg_tg_lowq_7/A VSS 8.867300e-17
C3757 S32 VSS 2.027230e-16
C3760 eeg_tg_lowq_7/A VSS 1.267930e-16
C3761 eeg_tg_lowq_7/A eeg_tg_lowq_7/B 5.623600e-17
C3762 eeg_tg_lowq_7/B VSS 1.267930e-16
C3763 RST VDD18 1.658314e-16
C3764 RST VSS 1.620786e-15
C3765 RST eeg_inv_0/Y 1.823050e-16
C3766 VDD18 VSS 1.332013e-15
C3767 VDD18 eeg_inv_0/Y 7.937490e-16
C3768 VSS eeg_inv_0/Y 7.176584e-17
C3769 eeg_inv_0/Y VSS 9.197480e-16
C3770 RST VDD18 1.883250e-16
C3771 RST VSS 4.355510e-17
C3772 RST eeg_inv_0/Y 2.887600e-17
C3773 VDD18 VSS 2.592707e-15
C3774 VDD18 eeg_inv_0/Y 3.212380e-16
C3775 eeg_inv_0/Y VSS 8.691660e-17
C3776 RST VSS 2.152613e-16
C3778 VSS eeg_inv_0/Y 5.623600e-17
C3779 eeg_inv_0/Y VSS 1.770690e-16
C3780 S32 VDD18 1.658314e-16
C3781 S32 VSS 1.620786e-15
C3782 S32 eeg_inv_1/Y 1.823050e-16
C3783 VDD18 VSS 1.332013e-15
C3784 VDD18 eeg_inv_1/Y 7.937490e-16
C3785 VSS eeg_inv_1/Y 7.176584e-17
C3786 eeg_inv_1/Y VSS 9.197480e-16
C3787 S32 VDD18 1.883250e-16
C3788 S32 VSS 4.355510e-17
C3789 S32 eeg_inv_1/Y 2.887600e-17
C3790 VDD18 VSS 2.592707e-15
C3791 VDD18 eeg_inv_1/Y 3.212380e-16
C3792 eeg_inv_1/Y VSS 8.691660e-17
C3793 S32 VSS 2.152613e-16
C3795 VSS eeg_inv_1/Y 5.623600e-17
C3796 eeg_inv_1/Y VSS 1.770690e-16
C3797 S16 VDD18 1.658314e-16
C3798 S16 VSS 1.620786e-15
C3799 S16 eeg_inv_2/Y 1.823050e-16
C3800 VDD18 VSS 1.332013e-15
C3801 VDD18 eeg_inv_2/Y 7.937490e-16
C3802 VSS eeg_inv_2/Y 7.176584e-17
C3803 eeg_inv_2/Y VSS 9.197480e-16
C3804 S16 VDD18 1.883250e-16
C3805 S16 VSS 4.355510e-17
C3806 S16 eeg_inv_2/Y 2.887600e-17
C3807 VDD18 VSS 2.592707e-15
C3808 VDD18 eeg_inv_2/Y 3.212380e-16
C3809 eeg_inv_2/Y VSS 8.691660e-17
C3810 S16 VSS 2.152613e-16
C3812 VSS eeg_inv_2/Y 5.623600e-17
C3813 eeg_inv_2/Y VSS 1.770690e-16
C3814 S8 VDD18 1.658314e-16
C3815 S8 VSS 1.620786e-15
C3816 S8 eeg_inv_3/Y 1.823050e-16
C3817 VDD18 VSS 1.332013e-15
C3818 VDD18 eeg_inv_3/Y 7.937490e-16
C3819 VSS eeg_inv_3/Y 7.176584e-17
C3820 eeg_inv_3/Y VSS 9.197480e-16
C3821 S8 VDD18 1.883250e-16
C3822 S8 VSS 4.355510e-17
C3823 S8 eeg_inv_3/Y 2.887600e-17
C3824 VDD18 VSS 2.592707e-15
C3825 VDD18 eeg_inv_3/Y 3.212380e-16
C3826 eeg_inv_3/Y VSS 8.691660e-17
C3827 S8 VSS 2.152613e-16
C3829 VSS eeg_inv_3/Y 5.623600e-17
C3830 eeg_inv_3/Y VSS 1.770690e-16
.ends
