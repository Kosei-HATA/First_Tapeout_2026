* NGSPICE flat PEX netlist for eeg_afe_top (sky130A)
* Devices: magic `ext2spice lvs` netlist, hierarchy inlined by ext2pex.py
* (parallel fingers/unit devices merged: exact BSIM equivalence);
* Parasitic capacitors: magic .ext database (node->substrate, cap->coupling)
* sky130A extraction excludes FET gate/diffusion caps (kept in BSIM
* ad/as/pd/ps terms), so no double counting. Caps in farads.
* PGA_OUTP/PGA_OUTN are aliased internal nets (PGA outputs) exposed
* as extra pins for the PEX testbenches.
* totals: 1054 devices (652 parallel merged), 6020 caps (8367.426 fF substrate + 20946.972 fF coupling)

.subckt eeg_afe_top ELP ELN VCM_REF VP VN PHII NPHII PHIBI NPHIBI PHIM NPHIM PHIBM NPHIBM CLK16 NCLK16 BIT NBIT S8 S16 S32 S64 VDD18 VSS PGA_OUTP PGA_OUTN
X0 VDD18 eeg_afe_pga_0/eeg_fd_ota_chopped_full2_0/eeg_bias_gen_0/VBP eeg_afe_pga_0/eeg_fd_ota_chopped_full2_0/eeg_bias_gen_0/VBN VDD18 sky130_fd_pr__pfet_01v8 ad=5.1 pd=12.04 as=1.25 ps=5.5 w=5 l=4 nf=1
X1 eeg_afe_pga_0/eeg_fd_ota_chopped_full2_0/eeg_bias_gen_0/VBN eeg_afe_pga_0/eeg_fd_ota_chopped_full2_0/eeg_bias_gen_0/VBP VDD18 VDD18 sky130_fd_pr__pfet_01v8 ad=1.25 pd=5.5 as=5.1 ps=12.04 w=5 l=4 nf=1
R2 eeg_afe_pga_0/eeg_fd_ota_chopped_full2_0/eeg_bias_gen_0/m1_6341_n27552# eeg_afe_pga_0/eeg_fd_ota_chopped_full2_0/eeg_bias_gen_0/m1_6741_n20245# 100000
X3 eeg_afe_pga_0/eeg_fd_ota_chopped_full2_0/eeg_bias_gen_0/VBN eeg_afe_pga_0/eeg_fd_ota_chopped_full2_0/eeg_bias_gen_0/eeg_pseudo_res_0/m1_68_66# eeg_afe_pga_0/eeg_fd_ota_chopped_full2_0/eeg_bias_gen_0/eeg_pseudo_res_0/m1_68_66# eeg_afe_pga_0/eeg_fd_ota_chopped_full2_0/eeg_bias_gen_0/VBN sky130_fd_pr__pfet_01v8 ad=1.02 pd=4.04 as=1.02 ps=4.04 w=1 l=4 nf=1
X4 VDD18 eeg_afe_pga_0/eeg_fd_ota_chopped_full2_0/eeg_bias_gen_0/eeg_pseudo_res_0/m1_68_66# eeg_afe_pga_0/eeg_fd_ota_chopped_full2_0/eeg_bias_gen_0/eeg_pseudo_res_0/m1_68_66# VDD18 sky130_fd_pr__pfet_01v8 ad=1.02 pd=4.04 as=1.02 ps=4.04 w=1 l=4 nf=1
R5 eeg_afe_pga_0/eeg_fd_ota_chopped_full2_0/eeg_bias_gen_0/m1_10859_n29089# eeg_afe_pga_0/eeg_fd_ota_chopped_full2_0/eeg_bias_gen_0/m1_10459_n36396# 100000
X6 eeg_afe_pga_0/eeg_fd_ota_chopped_full2_0/eeg_bias_gen_0/VBN eeg_afe_pga_0/eeg_fd_ota_chopped_full2_0/eeg_bias_gen_0/VBN VSS VSS sky130_fd_pr__nfet_01v8 ad=1.25 pd=5.5 as=5.1 ps=12.04 w=5 l=4 nf=1
X7 VSS eeg_afe_pga_0/eeg_fd_ota_chopped_full2_0/eeg_bias_gen_0/VBN eeg_afe_pga_0/eeg_fd_ota_chopped_full2_0/eeg_bias_gen_0/VBN VSS sky130_fd_pr__nfet_01v8 ad=5.1 pd=12.04 as=1.25 ps=5.5 w=5 l=4 nf=1
R8 eeg_afe_pga_0/eeg_fd_ota_chopped_full2_0/eeg_bias_gen_0/m1_5941_n20245# eeg_afe_pga_0/eeg_fd_ota_chopped_full2_0/eeg_bias_gen_0/m1_6341_n27552# 100000
R9 eeg_afe_pga_0/eeg_fd_ota_chopped_full2_0/eeg_bias_gen_0/m1_10341_n27552# eeg_afe_pga_0/eeg_fd_ota_chopped_full2_0/eeg_bias_gen_0/m1_10741_n20245# 100000
R10 eeg_afe_pga_0/eeg_fd_ota_chopped_full2_0/eeg_bias_gen_0/m1_2524_466# VSS 24985.5
R11 eeg_afe_pga_0/eeg_fd_ota_chopped_full2_0/eeg_bias_gen_0/m1_11259_n36396# eeg_afe_pga_0/eeg_fd_ota_chopped_full2_0/eeg_bias_gen_0/m1_10859_n29089# 100000
R12 eeg_afe_pga_0/eeg_fd_ota_chopped_full2_0/eeg_bias_gen_0/m1_11141_n9864# eeg_afe_pga_0/eeg_fd_ota_chopped_full2_0/eeg_bias_gen_0/VBNF 100000
R13 eeg_afe_pga_0/eeg_fd_ota_chopped_full2_0/eeg_bias_gen_0/m1_11541_n37933# eeg_afe_pga_0/eeg_fd_ota_chopped_full2_0/eeg_bias_gen_0/m1_11259_n36396# 100000
R14 eeg_afe_pga_0/eeg_fd_ota_chopped_full2_0/eeg_bias_gen_0/m1_5541_n27552# eeg_afe_pga_0/eeg_fd_ota_chopped_full2_0/eeg_bias_gen_0/m1_5941_n20245# 100000
R15 eeg_afe_pga_0/eeg_fd_ota_chopped_full2_0/eeg_bias_gen_0/m1_9941_n20245# eeg_afe_pga_0/eeg_fd_ota_chopped_full2_0/eeg_bias_gen_0/m1_10341_n27552# 100000
R16 eeg_afe_pga_0/eeg_fd_ota_chopped_full2_0/eeg_bias_gen_0/m1_10741_n2557# eeg_afe_pga_0/eeg_fd_ota_chopped_full2_0/eeg_bias_gen_0/m1_11141_n9864# 100000
R17 eeg_afe_pga_0/eeg_fd_ota_chopped_full2_0/eeg_bias_gen_0/m1_5141_n20245# eeg_afe_pga_0/eeg_fd_ota_chopped_full2_0/eeg_bias_gen_0/m1_5541_n27552# 100000
R18 eeg_afe_pga_0/eeg_fd_ota_chopped_full2_0/eeg_bias_gen_0/m1_9541_n27552# eeg_afe_pga_0/eeg_fd_ota_chopped_full2_0/eeg_bias_gen_0/m1_9941_n20245# 100000
R19 eeg_afe_pga_0/eeg_fd_ota_chopped_full2_0/eeg_bias_gen_0/m1_5259_n11401# eeg_afe_pga_0/eeg_fd_ota_chopped_full2_0/eeg_bias_gen_0/m1_4859_n18708# 100000
R20 eeg_afe_pga_0/eeg_fd_ota_chopped_full2_0/eeg_bias_gen_0/m1_11141_n45240# eeg_afe_pga_0/eeg_fd_ota_chopped_full2_0/eeg_bias_gen_0/m1_11541_n37933# 100000
R21 eeg_afe_pga_0/eeg_fd_ota_chopped_full2_0/eeg_bias_gen_0/m1_10341_n9864# eeg_afe_pga_0/eeg_fd_ota_chopped_full2_0/eeg_bias_gen_0/m1_10741_n2557# 100000
R22 eeg_afe_pga_0/eeg_fd_ota_chopped_full2_0/eeg_bias_gen_0/m1_4741_n27552# eeg_afe_pga_0/eeg_fd_ota_chopped_full2_0/eeg_bias_gen_0/m1_5141_n20245# 100000
R23 eeg_afe_pga_0/eeg_fd_ota_chopped_full2_0/eeg_bias_gen_0/m1_9141_n20245# eeg_afe_pga_0/eeg_fd_ota_chopped_full2_0/eeg_bias_gen_0/m1_9541_n27552# 100000
R24 eeg_afe_pga_0/eeg_fd_ota_chopped_full2_0/eeg_bias_gen_0/m1_5659_n18708# eeg_afe_pga_0/eeg_fd_ota_chopped_full2_0/eeg_bias_gen_0/m1_5259_n11401# 100000
R25 eeg_afe_pga_0/eeg_fd_ota_chopped_full2_0/eeg_bias_gen_0/m1_5941_n2557# eeg_afe_pga_0/eeg_fd_ota_chopped_full2_0/eeg_bias_gen_0/m1_6341_n9864# 100000
R26 eeg_afe_pga_0/eeg_fd_ota_chopped_full2_0/eeg_bias_gen_0/m1_10741_n37933# eeg_afe_pga_0/eeg_fd_ota_chopped_full2_0/eeg_bias_gen_0/m1_11141_n45240# 100000
R27 eeg_afe_pga_0/eeg_fd_ota_chopped_full2_0/eeg_bias_gen_0/m1_4341_n20245# eeg_afe_pga_0/eeg_fd_ota_chopped_full2_0/eeg_bias_gen_0/m1_4741_n27552# 100000
R28 eeg_afe_pga_0/eeg_fd_ota_chopped_full2_0/eeg_bias_gen_0/m1_8741_n27552# eeg_afe_pga_0/eeg_fd_ota_chopped_full2_0/eeg_bias_gen_0/m1_9141_n20245# 100000
R29 eeg_afe_pga_0/eeg_fd_ota_chopped_full2_0/eeg_bias_gen_0/m1_6059_n11401# eeg_afe_pga_0/eeg_fd_ota_chopped_full2_0/eeg_bias_gen_0/m1_5659_n18708# 100000
R30 eeg_afe_pga_0/eeg_fd_ota_chopped_full2_0/eeg_bias_gen_0/m1_10059_n11401# eeg_afe_pga_0/eeg_fd_ota_chopped_full2_0/eeg_bias_gen_0/m1_9659_n18708# 100000
R31 eeg_afe_pga_0/eeg_fd_ota_chopped_full2_0/eeg_bias_gen_0/m1_10859_n11401# eeg_afe_pga_0/eeg_fd_ota_chopped_full2_0/eeg_bias_gen_0/m1_10459_n18708# 100000
R32 eeg_afe_pga_0/eeg_fd_ota_chopped_full2_0/eeg_bias_gen_0/m1_5541_n9864# eeg_afe_pga_0/eeg_fd_ota_chopped_full2_0/eeg_bias_gen_0/m1_5941_n2557# 100000
R33 eeg_afe_pga_0/eeg_fd_ota_chopped_full2_0/eeg_bias_gen_0/m1_10341_n45240# eeg_afe_pga_0/eeg_fd_ota_chopped_full2_0/eeg_bias_gen_0/m1_10741_n37933# 100000
X34 VDD18 eeg_afe_pga_0/eeg_fd_ota_chopped_full2_0/eeg_bias_gen_0/VBP eeg_afe_pga_0/eeg_fd_ota_chopped_full2_0/eeg_bias_gen_0/VBP VDD18 sky130_fd_pr__pfet_01v8 ad=5.1 pd=12.04 as=1.25 ps=5.5 w=5 l=4 nf=1
X35 eeg_afe_pga_0/eeg_fd_ota_chopped_full2_0/eeg_bias_gen_0/VBP eeg_afe_pga_0/eeg_fd_ota_chopped_full2_0/eeg_bias_gen_0/VBP VDD18 VDD18 sky130_fd_pr__pfet_01v8 ad=1.25 pd=5.5 as=5.1 ps=12.04 w=5 l=4 nf=1
R36 eeg_afe_pga_0/eeg_fd_ota_chopped_full2_0/eeg_bias_gen_0/m1_5941_n37933# eeg_afe_pga_0/eeg_fd_ota_chopped_full2_0/eeg_bias_gen_0/m1_6341_n45240# 100000
R37 eeg_afe_pga_0/eeg_fd_ota_chopped_full2_0/eeg_bias_gen_0/m1_3941_n27552# eeg_afe_pga_0/eeg_fd_ota_chopped_full2_0/eeg_bias_gen_0/m1_4341_n20245# 100000
R38 eeg_afe_pga_0/eeg_fd_ota_chopped_full2_0/eeg_bias_gen_0/m1_8341_n20245# eeg_afe_pga_0/eeg_fd_ota_chopped_full2_0/eeg_bias_gen_0/m1_8741_n27552# 100000
R39 eeg_afe_pga_0/eeg_fd_ota_chopped_full2_0/eeg_bias_gen_0/m1_6459_n18708# eeg_afe_pga_0/eeg_fd_ota_chopped_full2_0/eeg_bias_gen_0/m1_6059_n11401# 100000
R40 eeg_afe_pga_0/eeg_fd_ota_chopped_full2_0/eeg_bias_gen_0/m1_11259_n18708# eeg_afe_pga_0/eeg_fd_ota_chopped_full2_0/eeg_bias_gen_0/m1_10859_n11401# 100000
R41 eeg_afe_pga_0/eeg_fd_ota_chopped_full2_0/eeg_bias_gen_0/m1_5141_n2557# eeg_afe_pga_0/eeg_fd_ota_chopped_full2_0/eeg_bias_gen_0/m1_5541_n9864# 100000
R42 eeg_afe_pga_0/eeg_fd_ota_chopped_full2_0/eeg_bias_gen_0/m1_9541_n9864# eeg_afe_pga_0/eeg_fd_ota_chopped_full2_0/eeg_bias_gen_0/m1_9941_n2557# 100000
R43 eeg_afe_pga_0/eeg_fd_ota_chopped_full2_0/eeg_bias_gen_0/m1_5259_n29089# eeg_afe_pga_0/eeg_fd_ota_chopped_full2_0/eeg_bias_gen_0/m1_4859_n36396# 100000
R44 eeg_afe_pga_0/eeg_fd_ota_chopped_full2_0/eeg_bias_gen_0/VBN eeg_afe_pga_0/eeg_fd_ota_chopped_full2_0/eeg_bias_gen_0/m1_3941_n45240# 100000
R45 eeg_afe_pga_0/eeg_fd_ota_chopped_full2_0/eeg_bias_gen_0/m1_5541_n45240# eeg_afe_pga_0/eeg_fd_ota_chopped_full2_0/eeg_bias_gen_0/m1_5941_n37933# 100000
R46 eeg_afe_pga_0/eeg_fd_ota_chopped_full2_0/eeg_bias_gen_0/m1_3701_n29089# eeg_afe_pga_0/eeg_fd_ota_chopped_full2_0/eeg_bias_gen_0/m1_3941_n27552# 100000
R47 eeg_afe_pga_0/eeg_fd_ota_chopped_full2_0/eeg_bias_gen_0/m1_7941_n27552# eeg_afe_pga_0/eeg_fd_ota_chopped_full2_0/eeg_bias_gen_0/m1_8341_n20245# 100000
R48 eeg_afe_pga_0/eeg_fd_ota_chopped_full2_0/eeg_bias_gen_0/m1_6859_n11401# eeg_afe_pga_0/eeg_fd_ota_chopped_full2_0/eeg_bias_gen_0/m1_6459_n18708# 100000
R49 eeg_afe_pga_0/eeg_fd_ota_chopped_full2_0/eeg_bias_gen_0/m1_11541_n20245# eeg_afe_pga_0/eeg_fd_ota_chopped_full2_0/eeg_bias_gen_0/m1_11259_n18708# 100000
R50 eeg_afe_pga_0/eeg_fd_ota_chopped_full2_0/eeg_bias_gen_0/m1_4741_n9864# eeg_afe_pga_0/eeg_fd_ota_chopped_full2_0/eeg_bias_gen_0/m1_5141_n2557# 100000
R51 eeg_afe_pga_0/eeg_fd_ota_chopped_full2_0/eeg_bias_gen_0/m1_9141_n2557# eeg_afe_pga_0/eeg_fd_ota_chopped_full2_0/eeg_bias_gen_0/m1_9541_n9864# 100000
R52 eeg_afe_pga_0/eeg_fd_ota_chopped_full2_0/eeg_bias_gen_0/m1_5659_n36396# eeg_afe_pga_0/eeg_fd_ota_chopped_full2_0/eeg_bias_gen_0/m1_5259_n29089# 100000
R53 eeg_afe_pga_0/eeg_fd_ota_chopped_full2_0/eeg_bias_gen_0/m1_9941_n2557# eeg_afe_pga_0/eeg_fd_ota_chopped_full2_0/eeg_bias_gen_0/m1_10341_n9864# 100000
R54 eeg_afe_pga_0/eeg_fd_ota_chopped_full2_0/eeg_bias_gen_0/m1_5141_n37933# eeg_afe_pga_0/eeg_fd_ota_chopped_full2_0/eeg_bias_gen_0/m1_5541_n45240# 100000
R55 eeg_afe_pga_0/eeg_fd_ota_chopped_full2_0/eeg_bias_gen_0/m1_9541_n45240# eeg_afe_pga_0/eeg_fd_ota_chopped_full2_0/eeg_bias_gen_0/m1_9941_n37933# 100000
R56 eeg_afe_pga_0/eeg_fd_ota_chopped_full2_0/eeg_bias_gen_0/m1_6859_n29089# eeg_afe_pga_0/eeg_fd_ota_chopped_full2_0/eeg_bias_gen_0/m1_6459_n36396# 100000
R57 eeg_afe_pga_0/eeg_fd_ota_chopped_full2_0/eeg_bias_gen_0/m1_10459_n36396# eeg_afe_pga_0/eeg_fd_ota_chopped_full2_0/eeg_bias_gen_0/m1_10059_n29089# 100000
R58 eeg_afe_pga_0/eeg_fd_ota_chopped_full2_0/eeg_bias_gen_0/m1_7541_n20245# eeg_afe_pga_0/eeg_fd_ota_chopped_full2_0/eeg_bias_gen_0/m1_7941_n27552# 100000
R59 eeg_afe_pga_0/eeg_fd_ota_chopped_full2_0/eeg_bias_gen_0/m1_7259_n18708# eeg_afe_pga_0/eeg_fd_ota_chopped_full2_0/eeg_bias_gen_0/m1_6859_n11401# 100000
R60 eeg_afe_pga_0/eeg_fd_ota_chopped_full2_0/eeg_bias_gen_0/m1_4341_n2557# eeg_afe_pga_0/eeg_fd_ota_chopped_full2_0/eeg_bias_gen_0/m1_4741_n9864# 100000
R61 eeg_afe_pga_0/eeg_fd_ota_chopped_full2_0/eeg_bias_gen_0/m1_8741_n9864# eeg_afe_pga_0/eeg_fd_ota_chopped_full2_0/eeg_bias_gen_0/m1_9141_n2557# 100000
R62 eeg_afe_pga_0/eeg_fd_ota_chopped_full2_0/eeg_bias_gen_0/m1_6059_n29089# eeg_afe_pga_0/eeg_fd_ota_chopped_full2_0/eeg_bias_gen_0/m1_5659_n36396# 100000
R63 eeg_afe_pga_0/eeg_fd_ota_chopped_full2_0/eeg_bias_gen_0/m1_4741_n45240# eeg_afe_pga_0/eeg_fd_ota_chopped_full2_0/eeg_bias_gen_0/m1_5141_n37933# 100000
R64 eeg_afe_pga_0/eeg_fd_ota_chopped_full2_0/eeg_bias_gen_0/m1_9141_n37933# eeg_afe_pga_0/eeg_fd_ota_chopped_full2_0/eeg_bias_gen_0/m1_9541_n45240# 100000
R65 eeg_afe_pga_0/eeg_fd_ota_chopped_full2_0/eeg_bias_gen_0/m1_9941_n37933# eeg_afe_pga_0/eeg_fd_ota_chopped_full2_0/eeg_bias_gen_0/m1_10341_n45240# 100000
R66 eeg_afe_pga_0/eeg_fd_ota_chopped_full2_0/eeg_bias_gen_0/m1_7259_n36396# eeg_afe_pga_0/eeg_fd_ota_chopped_full2_0/eeg_bias_gen_0/m1_6859_n29089# 100000
R67 eeg_afe_pga_0/eeg_fd_ota_chopped_full2_0/eeg_bias_gen_0/m1_7141_n27552# eeg_afe_pga_0/eeg_fd_ota_chopped_full2_0/eeg_bias_gen_0/m1_7541_n20245# 100000
R68 eeg_afe_pga_0/eeg_fd_ota_chopped_full2_0/eeg_bias_gen_0/m1_7659_n11401# eeg_afe_pga_0/eeg_fd_ota_chopped_full2_0/eeg_bias_gen_0/m1_7259_n18708# 100000
R69 eeg_afe_pga_0/eeg_fd_ota_chopped_full2_0/eeg_bias_gen_0/m1_10459_n18708# eeg_afe_pga_0/eeg_fd_ota_chopped_full2_0/eeg_bias_gen_0/m1_10059_n11401# 100000
R70 eeg_afe_pga_0/eeg_fd_ota_chopped_full2_0/eeg_bias_gen_0/m1_3941_n9864# eeg_afe_pga_0/eeg_fd_ota_chopped_full2_0/eeg_bias_gen_0/m1_4341_n2557# 100000
R71 eeg_afe_pga_0/eeg_fd_ota_chopped_full2_0/eeg_bias_gen_0/m1_8341_n2557# eeg_afe_pga_0/eeg_fd_ota_chopped_full2_0/eeg_bias_gen_0/m1_8741_n9864# 100000
R72 eeg_afe_pga_0/eeg_fd_ota_chopped_full2_0/eeg_bias_gen_0/m1_6459_n36396# eeg_afe_pga_0/eeg_fd_ota_chopped_full2_0/eeg_bias_gen_0/m1_6059_n29089# 100000
R73 eeg_afe_pga_0/eeg_fd_ota_chopped_full2_0/eeg_bias_gen_0/m1_4341_n37933# eeg_afe_pga_0/eeg_fd_ota_chopped_full2_0/eeg_bias_gen_0/m1_4741_n45240# 100000
R74 eeg_afe_pga_0/eeg_fd_ota_chopped_full2_0/eeg_bias_gen_0/m1_8741_n45240# eeg_afe_pga_0/eeg_fd_ota_chopped_full2_0/eeg_bias_gen_0/m1_9141_n37933# 100000
R75 eeg_afe_pga_0/eeg_fd_ota_chopped_full2_0/eeg_bias_gen_0/m1_7659_n29089# eeg_afe_pga_0/eeg_fd_ota_chopped_full2_0/eeg_bias_gen_0/m1_7259_n36396# 100000
R76 eeg_afe_pga_0/eeg_fd_ota_chopped_full2_0/eeg_bias_gen_0/m1_6741_n20245# eeg_afe_pga_0/eeg_fd_ota_chopped_full2_0/eeg_bias_gen_0/m1_7141_n27552# 100000
R77 eeg_afe_pga_0/eeg_fd_ota_chopped_full2_0/eeg_bias_gen_0/m1_11141_n27552# eeg_afe_pga_0/eeg_fd_ota_chopped_full2_0/eeg_bias_gen_0/m1_11541_n20245# 100000
R78 eeg_afe_pga_0/eeg_fd_ota_chopped_full2_0/eeg_bias_gen_0/m1_8059_n18708# eeg_afe_pga_0/eeg_fd_ota_chopped_full2_0/eeg_bias_gen_0/m1_7659_n11401# 100000
R79 eeg_afe_pga_0/eeg_fd_ota_chopped_full2_0/eeg_bias_gen_0/m1_3701_n11401# eeg_afe_pga_0/eeg_fd_ota_chopped_full2_0/eeg_bias_gen_0/m1_3941_n9864# 100000
R80 eeg_afe_pga_0/eeg_fd_ota_chopped_full2_0/eeg_bias_gen_0/m1_7941_n9864# eeg_afe_pga_0/eeg_fd_ota_chopped_full2_0/eeg_bias_gen_0/m1_8341_n2557# 100000
R81 eeg_afe_pga_0/eeg_fd_ota_chopped_full2_0/eeg_bias_gen_0/m1_8341_n37933# eeg_afe_pga_0/eeg_fd_ota_chopped_full2_0/eeg_bias_gen_0/m1_8741_n45240# 100000
R82 eeg_afe_pga_0/eeg_fd_ota_chopped_full2_0/eeg_bias_gen_0/m1_4059_n36396# eeg_afe_pga_0/eeg_fd_ota_chopped_full2_0/eeg_bias_gen_0/m1_3701_n29089# 100000
R83 eeg_afe_pga_0/eeg_fd_ota_chopped_full2_0/eeg_bias_gen_0/m1_8059_n36396# eeg_afe_pga_0/eeg_fd_ota_chopped_full2_0/eeg_bias_gen_0/m1_7659_n29089# 100000
R84 eeg_afe_pga_0/eeg_fd_ota_chopped_full2_0/eeg_bias_gen_0/m1_10741_n20245# eeg_afe_pga_0/eeg_fd_ota_chopped_full2_0/eeg_bias_gen_0/m1_11141_n27552# 100000
R85 eeg_afe_pga_0/eeg_fd_ota_chopped_full2_0/eeg_bias_gen_0/m1_4059_n18708# eeg_afe_pga_0/eeg_fd_ota_chopped_full2_0/eeg_bias_gen_0/m1_3701_n11401# 100000
R86 eeg_afe_pga_0/eeg_fd_ota_chopped_full2_0/eeg_bias_gen_0/m1_8459_n11401# eeg_afe_pga_0/eeg_fd_ota_chopped_full2_0/eeg_bias_gen_0/m1_8059_n18708# 100000
R87 eeg_afe_pga_0/eeg_fd_ota_chopped_full2_0/eeg_bias_gen_0/m1_7541_n2557# eeg_afe_pga_0/eeg_fd_ota_chopped_full2_0/eeg_bias_gen_0/m1_7941_n9864# 100000
R88 eeg_afe_pga_0/eeg_fd_ota_chopped_full2_0/eeg_bias_gen_0/m1_7941_n45240# eeg_afe_pga_0/eeg_fd_ota_chopped_full2_0/eeg_bias_gen_0/m1_8341_n37933# 100000
R89 eeg_afe_pga_0/eeg_fd_ota_chopped_full2_0/eeg_bias_gen_0/m1_4459_n29089# eeg_afe_pga_0/eeg_fd_ota_chopped_full2_0/eeg_bias_gen_0/m1_4059_n36396# 100000
R90 eeg_afe_pga_0/eeg_fd_ota_chopped_full2_0/eeg_bias_gen_0/m1_8459_n29089# eeg_afe_pga_0/eeg_fd_ota_chopped_full2_0/eeg_bias_gen_0/m1_8059_n36396# 100000
R91 eeg_afe_pga_0/eeg_fd_ota_chopped_full2_0/eeg_bias_gen_0/m1_4459_n11401# eeg_afe_pga_0/eeg_fd_ota_chopped_full2_0/eeg_bias_gen_0/m1_4059_n18708# 100000
R92 eeg_afe_pga_0/eeg_fd_ota_chopped_full2_0/eeg_bias_gen_0/m1_8859_n18708# eeg_afe_pga_0/eeg_fd_ota_chopped_full2_0/eeg_bias_gen_0/m1_8459_n11401# 100000
R93 eeg_afe_pga_0/eeg_fd_ota_chopped_full2_0/eeg_bias_gen_0/m1_7141_n9864# eeg_afe_pga_0/eeg_fd_ota_chopped_full2_0/eeg_bias_gen_0/m1_7541_n2557# 100000
R94 eeg_afe_pga_0/eeg_fd_ota_chopped_full2_0/eeg_bias_gen_0/m1_7541_n37933# eeg_afe_pga_0/eeg_fd_ota_chopped_full2_0/eeg_bias_gen_0/m1_7941_n45240# 100000
R95 eeg_afe_pga_0/eeg_fd_ota_chopped_full2_0/eeg_bias_gen_0/m1_4859_n36396# eeg_afe_pga_0/eeg_fd_ota_chopped_full2_0/eeg_bias_gen_0/m1_4459_n29089# 100000
R96 eeg_afe_pga_0/eeg_fd_ota_chopped_full2_0/eeg_bias_gen_0/m1_8859_n36396# eeg_afe_pga_0/eeg_fd_ota_chopped_full2_0/eeg_bias_gen_0/m1_8459_n29089# 100000
R97 eeg_afe_pga_0/eeg_fd_ota_chopped_full2_0/eeg_bias_gen_0/m1_4859_n18708# eeg_afe_pga_0/eeg_fd_ota_chopped_full2_0/eeg_bias_gen_0/m1_4459_n11401# 100000
R98 eeg_afe_pga_0/eeg_fd_ota_chopped_full2_0/eeg_bias_gen_0/m1_6741_n2557# eeg_afe_pga_0/eeg_fd_ota_chopped_full2_0/eeg_bias_gen_0/m1_7141_n9864# 100000
R99 eeg_afe_pga_0/eeg_fd_ota_chopped_full2_0/eeg_bias_gen_0/m1_7141_n45240# eeg_afe_pga_0/eeg_fd_ota_chopped_full2_0/eeg_bias_gen_0/m1_7541_n37933# 100000
R100 eeg_afe_pga_0/eeg_fd_ota_chopped_full2_0/eeg_bias_gen_0/m1_9259_n29089# eeg_afe_pga_0/eeg_fd_ota_chopped_full2_0/eeg_bias_gen_0/m1_8859_n36396# 100000
R101 eeg_afe_pga_0/eeg_fd_ota_chopped_full2_0/eeg_bias_gen_0/m1_9259_n11401# eeg_afe_pga_0/eeg_fd_ota_chopped_full2_0/eeg_bias_gen_0/m1_8859_n18708# 100000
R102 eeg_afe_pga_0/eeg_fd_ota_chopped_full2_0/eeg_bias_gen_0/m1_6341_n9864# eeg_afe_pga_0/eeg_fd_ota_chopped_full2_0/eeg_bias_gen_0/m1_6741_n2557# 100000
R103 eeg_afe_pga_0/eeg_fd_ota_chopped_full2_0/eeg_bias_gen_0/m1_6741_n37933# eeg_afe_pga_0/eeg_fd_ota_chopped_full2_0/eeg_bias_gen_0/m1_7141_n45240# 100000
R104 eeg_afe_pga_0/eeg_fd_ota_chopped_full2_0/eeg_bias_gen_0/m1_9659_n36396# eeg_afe_pga_0/eeg_fd_ota_chopped_full2_0/eeg_bias_gen_0/m1_9259_n29089# 100000
R105 eeg_afe_pga_0/eeg_fd_ota_chopped_full2_0/eeg_bias_gen_0/m1_9659_n18708# eeg_afe_pga_0/eeg_fd_ota_chopped_full2_0/eeg_bias_gen_0/m1_9259_n11401# 100000
R106 eeg_afe_pga_0/eeg_fd_ota_chopped_full2_0/eeg_bias_gen_0/m1_6341_n45240# eeg_afe_pga_0/eeg_fd_ota_chopped_full2_0/eeg_bias_gen_0/m1_6741_n37933# 100000
R107 eeg_afe_pga_0/eeg_fd_ota_chopped_full2_0/eeg_bias_gen_0/m1_10059_n29089# eeg_afe_pga_0/eeg_fd_ota_chopped_full2_0/eeg_bias_gen_0/m1_9659_n36396# 100000
R108 eeg_afe_pga_0/eeg_fd_ota_chopped_full2_0/eeg_bias_gen_0/m1_3941_n45240# eeg_afe_pga_0/eeg_fd_ota_chopped_full2_0/eeg_bias_gen_0/m1_4341_n37933# 100000
X109 eeg_afe_pga_0/eeg_fd_ota_chopped_full2_0/eeg_bias_gen_0/VBP eeg_afe_pga_0/eeg_fd_ota_chopped_full2_0/eeg_bias_gen_0/VBN eeg_afe_pga_0/eeg_fd_ota_chopped_full2_0/eeg_bias_gen_0/m1_2524_466# VSS sky130_fd_pr__nfet_01v8 ad=5 pd=22 as=8.85 ps=28.54 w=20 l=4 nf=4
X112 eeg_afe_pga_0/eeg_fd_ota_chopped_full2_0/eeg_bias_gen_0/m1_2524_466# eeg_afe_pga_0/eeg_fd_ota_chopped_full2_0/eeg_bias_gen_0/VBN eeg_afe_pga_0/eeg_fd_ota_chopped_full2_0/eeg_bias_gen_0/VBP VSS sky130_fd_pr__nfet_01v8 ad=8.85 pd=28.54 as=5 ps=22 w=20 l=4 nf=4
CMIM117 eeg_afe_pga_0/eeg_fd_ota_chopped_full2_0/eeg_bias_gen_0/VBNF VSS 1.000000e-10
X242 eeg_afe_pga_0/eeg_fd_ota_chopped_full2_0/eeg_cmfb_amp_dl2_s2_0/m1_370_1493# eeg_afe_pga_0/eeg_fd_ota_chopped_full2_0/eeg_cmfb_amp_dl2_s2_0/m1_370_1493# VDD18 VDD18 sky130_fd_pr__pfet_01v8 ad=2.04 pd=6.04 as=2.04 ps=6.04 w=2 l=2 nf=1
X243 eeg_afe_pga_0/eeg_fd_ota_chopped_full2_0/eeg_cmfb_amp_dl2_s2_0/m1_370_1493# eeg_afe_pga_0/eeg_fd_ota_chopped_full2_0/stage2_0/VCM2 eeg_afe_pga_0/eeg_fd_ota_chopped_full2_0/eeg_cmfb_amp_dl2_s2_0/m1_68_166# VSS sky130_fd_pr__nfet_01v8 ad=2.04 pd=6.04 as=2.04 ps=6.04 w=2 l=2 nf=1
X244 eeg_afe_pga_0/eeg_fd_ota_chopped_full2_0/eeg_cmfb_amp_dl2_s2_0/m1_68_166# eeg_afe_pga_0/eeg_fd_ota_chopped_full2_0/eeg_bias_gen_0/VBNF VSS VSS sky130_fd_pr__nfet_01v8 ad=1.5 pd=6.5 as=6.12 ps=14.04 w=6 l=4 nf=1
X245 VSS eeg_afe_pga_0/eeg_fd_ota_chopped_full2_0/eeg_bias_gen_0/VBNF eeg_afe_pga_0/eeg_fd_ota_chopped_full2_0/eeg_cmfb_amp_dl2_s2_0/m1_68_166# VSS sky130_fd_pr__nfet_01v8 ad=6.12 pd=14.04 as=1.5 ps=6.5 w=6 l=4 nf=1
X246 eeg_afe_pga_0/eeg_fd_ota_chopped_full2_0/stage2_0/VBP2 eeg_afe_pga_0/eeg_fd_ota_chopped_full2_0/stage2_0/VBP2 VDD18 VDD18 sky130_fd_pr__pfet_01v8 ad=0.15 pd=1.6 as=0.15 ps=1.6 w=0.5 l=4 nf=1
X247 eeg_afe_pga_0/eeg_fd_ota_chopped_full2_0/stage2_0/VBP2 VCM_REF eeg_afe_pga_0/eeg_fd_ota_chopped_full2_0/eeg_cmfb_amp_dl2_s2_0/m1_68_166# VSS sky130_fd_pr__nfet_01v8 ad=2.04 pd=6.04 as=2.04 ps=6.04 w=2 l=2 nf=1
X248 eeg_afe_pga_0/eeg_fd_ota_chopped_full2_0/eeg_cmfb_amp_dl2_0/VBP eeg_afe_pga_0/eeg_fd_ota_chopped_full2_0/eeg_cmfb_amp_dl2_0/VBP VDD18 VDD18 sky130_fd_pr__pfet_01v8 ad=4.08 pd=10.04 as=4.08 ps=10.04 w=4 l=4 nf=1
X249 eeg_afe_pga_0/eeg_fd_ota_chopped_full2_0/eeg_cmfb_amp_dl2_0/VBP VCM_REF eeg_afe_pga_0/eeg_fd_ota_chopped_full2_0/eeg_cmfb_amp_dl2_0/m1_68_166# VSS sky130_fd_pr__nfet_01v8 ad=2.04 pd=6.04 as=2.04 ps=6.04 w=2 l=2 nf=1
X250 eeg_afe_pga_0/eeg_fd_ota_chopped_full2_0/eeg_cmfb_amp_dl2_0/m1_68_166# eeg_afe_pga_0/eeg_fd_ota_chopped_full2_0/eeg_bias_gen_0/VBNF VSS VSS sky130_fd_pr__nfet_01v8 ad=1.5 pd=6.5 as=6.12 ps=14.04 w=6 l=4 nf=1
X251 VSS eeg_afe_pga_0/eeg_fd_ota_chopped_full2_0/eeg_bias_gen_0/VBNF eeg_afe_pga_0/eeg_fd_ota_chopped_full2_0/eeg_cmfb_amp_dl2_0/m1_68_166# VSS sky130_fd_pr__nfet_01v8 ad=6.12 pd=14.04 as=1.5 ps=6.5 w=6 l=4 nf=1
X252 eeg_afe_pga_0/eeg_fd_ota_chopped_full2_0/eeg_cmfb_amp_dl2_0/m1_370_1493# eeg_afe_pga_0/eeg_fd_ota_chopped_full2_0/eeg_cmfb_amp_dl2_0/m1_370_1493# VDD18 VDD18 sky130_fd_pr__pfet_01v8 ad=2.04 pd=6.04 as=2.04 ps=6.04 w=2 l=2 nf=1
X253 eeg_afe_pga_0/eeg_fd_ota_chopped_full2_0/eeg_cmfb_amp_dl2_0/m1_370_1493# eeg_afe_pga_0/eeg_fd_ota_chopped_full2_0/eeg_cmfb_amp_dl2_0/VCM_SENSE eeg_afe_pga_0/eeg_fd_ota_chopped_full2_0/eeg_cmfb_amp_dl2_0/m1_68_166# VSS sky130_fd_pr__nfet_01v8 ad=2.04 pd=6.04 as=2.04 ps=6.04 w=2 l=2 nf=1
R254 eeg_afe_pga_0/eeg_fd_ota_chopped_full2_0/stage2_0/m1_58341_n8557# eeg_afe_pga_0/eeg_fd_ota_chopped_full2_0/stage2_0/m1_58741_n15864# 100000
R255 eeg_afe_pga_0/eeg_fd_ota_chopped_full2_0/stage2_0/m1_24741_n15864# eeg_afe_pga_0/eeg_fd_ota_chopped_full2_0/stage2_0/m1_25141_n8557# 100000
R256 eeg_afe_pga_0/eeg_fd_ota_chopped_full2_0/stage2_0/m1_20341_n8557# eeg_afe_pga_0/eeg_fd_ota_chopped_full2_0/stage2_0/m1_20741_n15864# 100000
R257 eeg_afe_pga_0/eeg_fd_ota_chopped_full2_0/stage2_0/m1_35941_n15864# eeg_afe_pga_0/eeg_fd_ota_chopped_full2_0/stage2_0/m1_36341_n8557# 100000
R258 eeg_afe_pga_0/eeg_fd_ota_chopped_full2_0/stage2_0/m1_79941_n8557# eeg_afe_pga_0/eeg_fd_ota_chopped_full2_0/stage2_0/m1_80341_n15864# 100000
R259 eeg_afe_pga_0/eeg_fd_ota_chopped_full2_0/stage2_0/m1_75541_n15864# eeg_afe_pga_0/eeg_fd_ota_chopped_full2_0/stage2_0/m1_75941_n8557# 100000
R260 eeg_afe_pga_0/eeg_fd_ota_chopped_full2_0/stage2_0/m1_69141_n8557# eeg_afe_pga_0/eeg_fd_ota_chopped_full2_0/stage2_0/m1_69541_n15864# 100000
R261 eeg_afe_pga_0/eeg_fd_ota_chopped_full2_0/stage2_0/m1_64741_n15864# eeg_afe_pga_0/eeg_fd_ota_chopped_full2_0/stage2_0/m1_65141_n8557# 100000
R262 eeg_afe_pga_0/eeg_fd_ota_chopped_full2_0/stage2_0/m1_57941_n15864# eeg_afe_pga_0/eeg_fd_ota_chopped_full2_0/stage2_0/m1_58341_n8557# 100000
R263 eeg_afe_pga_0/eeg_fd_ota_chopped_full2_0/stage2_0/m1_28741_n15864# eeg_afe_pga_0/eeg_fd_ota_chopped_full2_0/stage2_0/m1_29141_n8557# 100000
R264 eeg_afe_pga_0/eeg_fd_ota_chopped_full2_0/stage2_0/m1_24341_n8557# eeg_afe_pga_0/eeg_fd_ota_chopped_full2_0/stage2_0/m1_24741_n15864# 100000
R265 eeg_afe_pga_0/eeg_fd_ota_chopped_full2_0/stage2_0/m1_19941_n15864# eeg_afe_pga_0/eeg_fd_ota_chopped_full2_0/stage2_0/m1_20341_n8557# 100000
R266 eeg_afe_pga_0/eeg_fd_ota_chopped_full2_0/stage2_0/m1_35541_n8557# eeg_afe_pga_0/eeg_fd_ota_chopped_full2_0/stage2_0/m1_35941_n15864# 100000
R267 eeg_afe_pga_0/eeg_fd_ota_chopped_full2_0/stage2_0/m1_79541_n15864# eeg_afe_pga_0/eeg_fd_ota_chopped_full2_0/stage2_0/m1_79941_n8557# 100000
R268 eeg_afe_pga_0/eeg_fd_ota_chopped_full2_0/stage2_0/m1_75141_n8557# eeg_afe_pga_0/eeg_fd_ota_chopped_full2_0/stage2_0/m1_75541_n15864# 100000
R269 eeg_afe_pga_0/eeg_fd_ota_chopped_full2_0/stage2_0/m1_68741_n15864# eeg_afe_pga_0/eeg_fd_ota_chopped_full2_0/stage2_0/m1_69141_n8557# 100000
R270 eeg_afe_pga_0/eeg_fd_ota_chopped_full2_0/stage2_0/m1_64341_n8557# eeg_afe_pga_0/eeg_fd_ota_chopped_full2_0/stage2_0/m1_64741_n15864# 100000
R271 eeg_afe_pga_0/eeg_fd_ota_chopped_full2_0/stage2_0/m1_57541_n8557# eeg_afe_pga_0/eeg_fd_ota_chopped_full2_0/stage2_0/m1_57941_n15864# 100000
R272 eeg_afe_pga_0/eeg_fd_ota_chopped_full2_0/stage2_0/m1_28341_n8557# eeg_afe_pga_0/eeg_fd_ota_chopped_full2_0/stage2_0/m1_28741_n15864# 100000
R273 eeg_afe_pga_0/eeg_fd_ota_chopped_full2_0/stage2_0/m1_23941_n15864# eeg_afe_pga_0/eeg_fd_ota_chopped_full2_0/stage2_0/m1_24341_n8557# 100000
R274 PGA_OUTP eeg_afe_pga_0/eeg_fd_ota_chopped_full2_0/stage2_0/m1_19941_n15864# 100000
R275 eeg_afe_pga_0/eeg_fd_ota_chopped_full2_0/stage2_0/m1_35141_n15864# eeg_afe_pga_0/eeg_fd_ota_chopped_full2_0/stage2_0/m1_35541_n8557# 100000
R276 eeg_afe_pga_0/eeg_fd_ota_chopped_full2_0/stage2_0/m1_79141_n8557# eeg_afe_pga_0/eeg_fd_ota_chopped_full2_0/stage2_0/m1_79541_n15864# 100000
R277 eeg_afe_pga_0/eeg_fd_ota_chopped_full2_0/stage2_0/m1_74741_n15864# eeg_afe_pga_0/eeg_fd_ota_chopped_full2_0/stage2_0/m1_75141_n8557# 100000
R278 eeg_afe_pga_0/eeg_fd_ota_chopped_full2_0/stage2_0/m1_68341_n8557# eeg_afe_pga_0/eeg_fd_ota_chopped_full2_0/stage2_0/m1_68741_n15864# 100000
R279 eeg_afe_pga_0/eeg_fd_ota_chopped_full2_0/stage2_0/m1_63941_n15864# eeg_afe_pga_0/eeg_fd_ota_chopped_full2_0/stage2_0/m1_64341_n8557# 100000
R280 eeg_afe_pga_0/eeg_fd_ota_chopped_full2_0/stage2_0/m1_27941_n15864# eeg_afe_pga_0/eeg_fd_ota_chopped_full2_0/stage2_0/m1_28341_n8557# 100000
R281 eeg_afe_pga_0/eeg_fd_ota_chopped_full2_0/stage2_0/m1_23541_n8557# eeg_afe_pga_0/eeg_fd_ota_chopped_full2_0/stage2_0/m1_23941_n15864# 100000
R282 eeg_afe_pga_0/eeg_fd_ota_chopped_full2_0/stage2_0/m1_39141_n15864# eeg_afe_pga_0/eeg_fd_ota_chopped_full2_0/stage2_0/VCM2 100000
R283 eeg_afe_pga_0/eeg_fd_ota_chopped_full2_0/stage2_0/m1_34741_n8557# eeg_afe_pga_0/eeg_fd_ota_chopped_full2_0/stage2_0/m1_35141_n15864# 100000
R284 eeg_afe_pga_0/eeg_fd_ota_chopped_full2_0/stage2_0/m1_78741_n15864# eeg_afe_pga_0/eeg_fd_ota_chopped_full2_0/stage2_0/m1_79141_n8557# 100000
R285 eeg_afe_pga_0/eeg_fd_ota_chopped_full2_0/stage2_0/m1_74341_n8557# eeg_afe_pga_0/eeg_fd_ota_chopped_full2_0/stage2_0/m1_74741_n15864# 100000
R286 eeg_afe_pga_0/eeg_fd_ota_chopped_full2_0/stage2_0/m1_67941_n15864# eeg_afe_pga_0/eeg_fd_ota_chopped_full2_0/stage2_0/m1_68341_n8557# 100000
R287 PGA_OUTP eeg_afe_pga_0/eeg_fd_ota_chopped_full2_0/stage2_0/m1_63941_n15864# 100000
R288 eeg_afe_pga_0/eeg_fd_ota_chopped_full2_0/stage2_0/m1_27541_n8557# eeg_afe_pga_0/eeg_fd_ota_chopped_full2_0/stage2_0/m1_27941_n15864# 100000
R289 eeg_afe_pga_0/eeg_fd_ota_chopped_full2_0/stage2_0/m1_23141_n15864# eeg_afe_pga_0/eeg_fd_ota_chopped_full2_0/stage2_0/m1_23541_n8557# 100000
R290 eeg_afe_pga_0/eeg_fd_ota_chopped_full2_0/stage2_0/m1_38741_n8557# eeg_afe_pga_0/eeg_fd_ota_chopped_full2_0/stage2_0/m1_39141_n15864# 100000
R291 eeg_afe_pga_0/eeg_fd_ota_chopped_full2_0/stage2_0/m1_34341_n15864# eeg_afe_pga_0/eeg_fd_ota_chopped_full2_0/stage2_0/m1_34741_n8557# 100000
R292 eeg_afe_pga_0/eeg_fd_ota_chopped_full2_0/stage2_0/m1_78341_n8557# eeg_afe_pga_0/eeg_fd_ota_chopped_full2_0/stage2_0/m1_78741_n15864# 100000
R293 eeg_afe_pga_0/eeg_fd_ota_chopped_full2_0/stage2_0/m1_73941_n15864# eeg_afe_pga_0/eeg_fd_ota_chopped_full2_0/stage2_0/m1_74341_n8557# 100000
R294 eeg_afe_pga_0/eeg_fd_ota_chopped_full2_0/stage2_0/m1_67541_n8557# eeg_afe_pga_0/eeg_fd_ota_chopped_full2_0/stage2_0/m1_67941_n15864# 100000
R295 eeg_afe_pga_0/eeg_fd_ota_chopped_full2_0/stage2_0/m1_27141_n15864# eeg_afe_pga_0/eeg_fd_ota_chopped_full2_0/stage2_0/m1_27541_n8557# 100000
R296 eeg_afe_pga_0/eeg_fd_ota_chopped_full2_0/stage2_0/m1_22741_n8557# eeg_afe_pga_0/eeg_fd_ota_chopped_full2_0/stage2_0/m1_23141_n15864# 100000
R297 eeg_afe_pga_0/eeg_fd_ota_chopped_full2_0/stage2_0/m1_38341_n15864# eeg_afe_pga_0/eeg_fd_ota_chopped_full2_0/stage2_0/m1_38741_n8557# 100000
R298 eeg_afe_pga_0/eeg_fd_ota_chopped_full2_0/stage2_0/m1_33941_n8557# eeg_afe_pga_0/eeg_fd_ota_chopped_full2_0/stage2_0/m1_34341_n15864# 100000
R299 eeg_afe_pga_0/eeg_fd_ota_chopped_full2_0/stage2_0/m1_77941_n15864# eeg_afe_pga_0/eeg_fd_ota_chopped_full2_0/stage2_0/m1_78341_n8557# 100000
R300 PGA_OUTN eeg_afe_pga_0/eeg_fd_ota_chopped_full2_0/stage2_0/m1_73941_n15864# 100000
R301 eeg_afe_pga_0/eeg_fd_ota_chopped_full2_0/stage2_0/m1_26741_n8557# eeg_afe_pga_0/eeg_fd_ota_chopped_full2_0/stage2_0/m1_27141_n15864# 100000
R302 eeg_afe_pga_0/eeg_fd_ota_chopped_full2_0/stage2_0/m1_22341_n15864# eeg_afe_pga_0/eeg_fd_ota_chopped_full2_0/stage2_0/m1_22741_n8557# 100000
R303 eeg_afe_pga_0/eeg_fd_ota_chopped_full2_0/stage2_0/m1_37941_n8557# eeg_afe_pga_0/eeg_fd_ota_chopped_full2_0/stage2_0/m1_38341_n15864# 100000
R304 eeg_afe_pga_0/eeg_fd_ota_chopped_full2_0/stage2_0/m1_33541_n15864# eeg_afe_pga_0/eeg_fd_ota_chopped_full2_0/stage2_0/m1_33941_n8557# 100000
R305 eeg_afe_pga_0/eeg_fd_ota_chopped_full2_0/stage2_0/m1_77541_n8557# eeg_afe_pga_0/eeg_fd_ota_chopped_full2_0/stage2_0/m1_77941_n15864# 100000
R306 eeg_afe_pga_0/eeg_fd_ota_chopped_full2_0/stage2_0/m1_26341_n15864# eeg_afe_pga_0/eeg_fd_ota_chopped_full2_0/stage2_0/m1_26741_n8557# 100000
R307 eeg_afe_pga_0/eeg_fd_ota_chopped_full2_0/stage2_0/m1_21941_n8557# eeg_afe_pga_0/eeg_fd_ota_chopped_full2_0/stage2_0/m1_22341_n15864# 100000
R308 eeg_afe_pga_0/eeg_fd_ota_chopped_full2_0/stage2_0/m1_37541_n15864# eeg_afe_pga_0/eeg_fd_ota_chopped_full2_0/stage2_0/m1_37941_n8557# 100000
R309 eeg_afe_pga_0/eeg_fd_ota_chopped_full2_0/stage2_0/m1_33141_n8557# eeg_afe_pga_0/eeg_fd_ota_chopped_full2_0/stage2_0/m1_33541_n15864# 100000
R310 eeg_afe_pga_0/eeg_fd_ota_chopped_full2_0/stage2_0/m1_25941_n8557# eeg_afe_pga_0/eeg_fd_ota_chopped_full2_0/stage2_0/m1_26341_n15864# 100000
R311 eeg_afe_pga_0/eeg_fd_ota_chopped_full2_0/stage2_0/m1_21541_n15864# eeg_afe_pga_0/eeg_fd_ota_chopped_full2_0/stage2_0/m1_21941_n8557# 100000
R312 eeg_afe_pga_0/eeg_fd_ota_chopped_full2_0/stage2_0/m1_37141_n8557# eeg_afe_pga_0/eeg_fd_ota_chopped_full2_0/stage2_0/m1_37541_n15864# 100000
R313 eeg_afe_pga_0/eeg_fd_ota_chopped_full2_0/stage2_0/m1_25541_n15864# eeg_afe_pga_0/eeg_fd_ota_chopped_full2_0/stage2_0/m1_25941_n8557# 100000
R314 eeg_afe_pga_0/eeg_fd_ota_chopped_full2_0/stage2_0/m1_21141_n8557# eeg_afe_pga_0/eeg_fd_ota_chopped_full2_0/stage2_0/m1_21541_n15864# 100000
R315 eeg_afe_pga_0/eeg_fd_ota_chopped_full2_0/stage2_0/m1_25141_n8557# eeg_afe_pga_0/eeg_fd_ota_chopped_full2_0/stage2_0/m1_25541_n15864# 100000
X316 PGA_OUTN eeg_afe_pga_0/eeg_fd_ota_chopped_full2_0/stage2_0/VBP2 VDD18 VDD18 sky130_fd_pr__pfet_01v8 ad=6 pd=26 as=10.62 ps=33.54 w=24 l=12 nf=4
X317 VDD18 eeg_afe_pga_0/eeg_fd_ota_chopped_full2_0/stage2_0/VBP2 PGA_OUTN VDD18 sky130_fd_pr__pfet_01v8 ad=10.62 pd=33.54 as=6 ps=26 w=24 l=12 nf=4
R324 eeg_afe_pga_0/eeg_fd_ota_chopped_full2_0/stage2_0/m1_32741_n15864# eeg_afe_pga_0/eeg_fd_ota_chopped_full2_0/stage2_0/m1_33141_n8557# 100000
X325 PGA_OUTN eeg_afe_pga_0/eeg_fd_ota_chopped_full2_0/stage2_0/N2N VSS VSS sky130_fd_pr__nfet_01v8 ad=1.5 pd=6.5 as=6.12 ps=14.04 w=6 l=12 nf=1
X326 VSS eeg_afe_pga_0/eeg_fd_ota_chopped_full2_0/stage2_0/N2N PGA_OUTN VSS sky130_fd_pr__nfet_01v8 ad=6.12 pd=14.04 as=1.5 ps=6.5 w=6 l=12 nf=1
R327 eeg_afe_pga_0/eeg_fd_ota_chopped_full2_0/stage2_0/m1_32341_n8557# eeg_afe_pga_0/eeg_fd_ota_chopped_full2_0/stage2_0/m1_32741_n15864# 100000
R328 eeg_afe_pga_0/eeg_fd_ota_chopped_full2_0/stage2_0/m1_31941_n15864# eeg_afe_pga_0/eeg_fd_ota_chopped_full2_0/stage2_0/m1_32341_n8557# 100000
R329 eeg_afe_pga_0/eeg_fd_ota_chopped_full2_0/stage2_0/m1_31541_n8557# eeg_afe_pga_0/eeg_fd_ota_chopped_full2_0/stage2_0/m1_31941_n15864# 100000
R330 eeg_afe_pga_0/eeg_fd_ota_chopped_full2_0/stage2_0/m1_31141_n15864# eeg_afe_pga_0/eeg_fd_ota_chopped_full2_0/stage2_0/m1_31541_n8557# 100000
R331 eeg_afe_pga_0/eeg_fd_ota_chopped_full2_0/stage2_0/m1_30741_n8557# eeg_afe_pga_0/eeg_fd_ota_chopped_full2_0/stage2_0/m1_31141_n15864# 100000
R332 eeg_afe_pga_0/eeg_fd_ota_chopped_full2_0/stage2_0/m1_30341_n15864# eeg_afe_pga_0/eeg_fd_ota_chopped_full2_0/stage2_0/m1_30741_n8557# 100000
R333 eeg_afe_pga_0/eeg_fd_ota_chopped_full2_0/stage2_0/N2N eeg_afe_pga_0/eeg_fd_ota_chopped_full2_0/stage2_0/m1_12966_n5928# 20000
R334 eeg_afe_pga_0/eeg_fd_ota_chopped_full2_0/stage2_0/m1_29941_n8557# eeg_afe_pga_0/eeg_fd_ota_chopped_full2_0/stage2_0/m1_30341_n15864# 100000
R335 eeg_afe_pga_0/eeg_fd_ota_chopped_full2_0/stage2_0/m1_45141_n15864# eeg_afe_pga_0/eeg_fd_ota_chopped_full2_0/stage2_0/m1_45541_n8557# 100000
R336 eeg_afe_pga_0/eeg_fd_ota_chopped_full2_0/stage2_0/N2P eeg_afe_pga_0/eeg_fd_ota_chopped_full2_0/stage2_0/m1_3966_n5928# 20000
R337 eeg_afe_pga_0/eeg_fd_ota_chopped_full2_0/stage2_0/m1_29541_n15864# eeg_afe_pga_0/eeg_fd_ota_chopped_full2_0/stage2_0/m1_29941_n8557# 100000
R338 eeg_afe_pga_0/eeg_fd_ota_chopped_full2_0/stage2_0/m1_44741_n8557# eeg_afe_pga_0/eeg_fd_ota_chopped_full2_0/stage2_0/m1_45141_n15864# 100000
R339 eeg_afe_pga_0/eeg_fd_ota_chopped_full2_0/stage2_0/m1_49141_n15864# eeg_afe_pga_0/eeg_fd_ota_chopped_full2_0/stage2_0/m1_49541_n8557# 100000
R340 eeg_afe_pga_0/eeg_fd_ota_chopped_full2_0/stage2_0/m1_29141_n8557# eeg_afe_pga_0/eeg_fd_ota_chopped_full2_0/stage2_0/m1_29541_n15864# 100000
R341 eeg_afe_pga_0/eeg_fd_ota_chopped_full2_0/stage2_0/m1_44341_n15864# eeg_afe_pga_0/eeg_fd_ota_chopped_full2_0/stage2_0/m1_44741_n8557# 100000
R342 eeg_afe_pga_0/eeg_fd_ota_chopped_full2_0/stage2_0/m1_48741_n8557# eeg_afe_pga_0/eeg_fd_ota_chopped_full2_0/stage2_0/m1_49141_n15864# 100000
R343 eeg_afe_pga_0/eeg_fd_ota_chopped_full2_0/stage2_0/m1_53141_n15864# eeg_afe_pga_0/eeg_fd_ota_chopped_full2_0/stage2_0/m1_53541_n8557# 100000
R344 eeg_afe_pga_0/eeg_fd_ota_chopped_full2_0/stage2_0/m1_43941_n8557# eeg_afe_pga_0/eeg_fd_ota_chopped_full2_0/stage2_0/m1_44341_n15864# 100000
R345 eeg_afe_pga_0/eeg_fd_ota_chopped_full2_0/stage2_0/m1_48341_n15864# eeg_afe_pga_0/eeg_fd_ota_chopped_full2_0/stage2_0/m1_48741_n8557# 100000
R346 eeg_afe_pga_0/eeg_fd_ota_chopped_full2_0/stage2_0/m1_52741_n8557# eeg_afe_pga_0/eeg_fd_ota_chopped_full2_0/stage2_0/m1_53141_n15864# 100000
R347 eeg_afe_pga_0/eeg_fd_ota_chopped_full2_0/stage2_0/m1_57141_n15864# eeg_afe_pga_0/eeg_fd_ota_chopped_full2_0/stage2_0/m1_57541_n8557# 100000
R348 eeg_afe_pga_0/eeg_fd_ota_chopped_full2_0/stage2_0/m1_43541_n15864# eeg_afe_pga_0/eeg_fd_ota_chopped_full2_0/stage2_0/m1_43941_n8557# 100000
R349 eeg_afe_pga_0/eeg_fd_ota_chopped_full2_0/stage2_0/m1_47941_n8557# eeg_afe_pga_0/eeg_fd_ota_chopped_full2_0/stage2_0/m1_48341_n15864# 100000
R350 eeg_afe_pga_0/eeg_fd_ota_chopped_full2_0/stage2_0/m1_52341_n15864# eeg_afe_pga_0/eeg_fd_ota_chopped_full2_0/stage2_0/m1_52741_n8557# 100000
R351 eeg_afe_pga_0/eeg_fd_ota_chopped_full2_0/stage2_0/m1_56741_n8557# eeg_afe_pga_0/eeg_fd_ota_chopped_full2_0/stage2_0/m1_57141_n15864# 100000
R352 eeg_afe_pga_0/eeg_fd_ota_chopped_full2_0/stage2_0/m1_43141_n8557# eeg_afe_pga_0/eeg_fd_ota_chopped_full2_0/stage2_0/m1_43541_n15864# 100000
R353 eeg_afe_pga_0/eeg_fd_ota_chopped_full2_0/stage2_0/m1_47541_n15864# eeg_afe_pga_0/eeg_fd_ota_chopped_full2_0/stage2_0/m1_47941_n8557# 100000
R354 eeg_afe_pga_0/eeg_fd_ota_chopped_full2_0/stage2_0/m1_51941_n8557# eeg_afe_pga_0/eeg_fd_ota_chopped_full2_0/stage2_0/m1_52341_n15864# 100000
R355 eeg_afe_pga_0/eeg_fd_ota_chopped_full2_0/stage2_0/m1_56341_n15864# eeg_afe_pga_0/eeg_fd_ota_chopped_full2_0/stage2_0/m1_56741_n8557# 100000
R356 eeg_afe_pga_0/eeg_fd_ota_chopped_full2_0/stage2_0/m1_42741_n15864# eeg_afe_pga_0/eeg_fd_ota_chopped_full2_0/stage2_0/m1_43141_n8557# 100000
R357 eeg_afe_pga_0/eeg_fd_ota_chopped_full2_0/stage2_0/m1_47141_n8557# eeg_afe_pga_0/eeg_fd_ota_chopped_full2_0/stage2_0/m1_47541_n15864# 100000
R358 eeg_afe_pga_0/eeg_fd_ota_chopped_full2_0/stage2_0/m1_51541_n15864# eeg_afe_pga_0/eeg_fd_ota_chopped_full2_0/stage2_0/m1_51941_n8557# 100000
R359 eeg_afe_pga_0/eeg_fd_ota_chopped_full2_0/stage2_0/m1_55941_n8557# eeg_afe_pga_0/eeg_fd_ota_chopped_full2_0/stage2_0/m1_56341_n15864# 100000
R360 eeg_afe_pga_0/eeg_fd_ota_chopped_full2_0/stage2_0/m1_61141_n15864# eeg_afe_pga_0/eeg_fd_ota_chopped_full2_0/stage2_0/VCM2 100000
R361 eeg_afe_pga_0/eeg_fd_ota_chopped_full2_0/stage2_0/m1_42341_n8557# eeg_afe_pga_0/eeg_fd_ota_chopped_full2_0/stage2_0/m1_42741_n15864# 100000
R362 eeg_afe_pga_0/eeg_fd_ota_chopped_full2_0/stage2_0/m1_46741_n15864# eeg_afe_pga_0/eeg_fd_ota_chopped_full2_0/stage2_0/m1_47141_n8557# 100000
R363 eeg_afe_pga_0/eeg_fd_ota_chopped_full2_0/stage2_0/m1_51141_n8557# eeg_afe_pga_0/eeg_fd_ota_chopped_full2_0/stage2_0/m1_51541_n15864# 100000
R364 eeg_afe_pga_0/eeg_fd_ota_chopped_full2_0/stage2_0/m1_55541_n15864# eeg_afe_pga_0/eeg_fd_ota_chopped_full2_0/stage2_0/m1_55941_n8557# 100000
R365 eeg_afe_pga_0/eeg_fd_ota_chopped_full2_0/stage2_0/m1_60741_n8557# eeg_afe_pga_0/eeg_fd_ota_chopped_full2_0/stage2_0/m1_61141_n15864# 100000
R366 eeg_afe_pga_0/eeg_fd_ota_chopped_full2_0/stage2_0/m1_67141_n15864# eeg_afe_pga_0/eeg_fd_ota_chopped_full2_0/stage2_0/m1_67541_n8557# 100000
R367 eeg_afe_pga_0/eeg_fd_ota_chopped_full2_0/stage2_0/m1_41941_n15864# eeg_afe_pga_0/eeg_fd_ota_chopped_full2_0/stage2_0/m1_42341_n8557# 100000
R368 eeg_afe_pga_0/eeg_fd_ota_chopped_full2_0/stage2_0/m1_46341_n8557# eeg_afe_pga_0/eeg_fd_ota_chopped_full2_0/stage2_0/m1_46741_n15864# 100000
R369 eeg_afe_pga_0/eeg_fd_ota_chopped_full2_0/stage2_0/m1_50741_n15864# eeg_afe_pga_0/eeg_fd_ota_chopped_full2_0/stage2_0/m1_51141_n8557# 100000
R370 eeg_afe_pga_0/eeg_fd_ota_chopped_full2_0/stage2_0/m1_55141_n8557# eeg_afe_pga_0/eeg_fd_ota_chopped_full2_0/stage2_0/m1_55541_n15864# 100000
R371 eeg_afe_pga_0/eeg_fd_ota_chopped_full2_0/stage2_0/m1_60341_n15864# eeg_afe_pga_0/eeg_fd_ota_chopped_full2_0/stage2_0/m1_60741_n8557# 100000
R372 eeg_afe_pga_0/eeg_fd_ota_chopped_full2_0/stage2_0/m1_71141_n15864# VCM_REF 100000
R373 eeg_afe_pga_0/eeg_fd_ota_chopped_full2_0/stage2_0/m1_66741_n8557# eeg_afe_pga_0/eeg_fd_ota_chopped_full2_0/stage2_0/m1_67141_n15864# 100000
R374 PGA_OUTN eeg_afe_pga_0/eeg_fd_ota_chopped_full2_0/stage2_0/m1_41941_n15864# 100000
R375 eeg_afe_pga_0/eeg_fd_ota_chopped_full2_0/stage2_0/m1_45941_n15864# eeg_afe_pga_0/eeg_fd_ota_chopped_full2_0/stage2_0/m1_46341_n8557# 100000
R376 eeg_afe_pga_0/eeg_fd_ota_chopped_full2_0/stage2_0/m1_50341_n8557# eeg_afe_pga_0/eeg_fd_ota_chopped_full2_0/stage2_0/m1_50741_n15864# 100000
R377 eeg_afe_pga_0/eeg_fd_ota_chopped_full2_0/stage2_0/m1_54741_n15864# eeg_afe_pga_0/eeg_fd_ota_chopped_full2_0/stage2_0/m1_55141_n8557# 100000
R378 eeg_afe_pga_0/eeg_fd_ota_chopped_full2_0/stage2_0/m1_59941_n8557# eeg_afe_pga_0/eeg_fd_ota_chopped_full2_0/stage2_0/m1_60341_n15864# 100000
R379 eeg_afe_pga_0/eeg_fd_ota_chopped_full2_0/stage2_0/m1_77141_n15864# eeg_afe_pga_0/eeg_fd_ota_chopped_full2_0/stage2_0/m1_77541_n8557# 100000
R380 eeg_afe_pga_0/eeg_fd_ota_chopped_full2_0/stage2_0/m1_70741_n8557# eeg_afe_pga_0/eeg_fd_ota_chopped_full2_0/stage2_0/m1_71141_n15864# 100000
R381 eeg_afe_pga_0/eeg_fd_ota_chopped_full2_0/stage2_0/m1_66341_n15864# eeg_afe_pga_0/eeg_fd_ota_chopped_full2_0/stage2_0/m1_66741_n8557# 100000
X382 PGA_OUTP eeg_afe_pga_0/eeg_fd_ota_chopped_full2_0/stage2_0/VBP2 VDD18 VDD18 sky130_fd_pr__pfet_01v8 ad=6 pd=26 as=10.62 ps=33.54 w=24 l=12 nf=4
X383 VDD18 eeg_afe_pga_0/eeg_fd_ota_chopped_full2_0/stage2_0/VBP2 PGA_OUTP VDD18 sky130_fd_pr__pfet_01v8 ad=10.62 pd=33.54 as=6 ps=26 w=24 l=12 nf=4
R390 eeg_afe_pga_0/eeg_fd_ota_chopped_full2_0/stage2_0/m1_45541_n8557# eeg_afe_pga_0/eeg_fd_ota_chopped_full2_0/stage2_0/m1_45941_n15864# 100000
R391 eeg_afe_pga_0/eeg_fd_ota_chopped_full2_0/stage2_0/m1_49941_n15864# eeg_afe_pga_0/eeg_fd_ota_chopped_full2_0/stage2_0/m1_50341_n8557# 100000
R392 eeg_afe_pga_0/eeg_fd_ota_chopped_full2_0/stage2_0/m1_54341_n8557# eeg_afe_pga_0/eeg_fd_ota_chopped_full2_0/stage2_0/m1_54741_n15864# 100000
R393 eeg_afe_pga_0/eeg_fd_ota_chopped_full2_0/stage2_0/m1_59541_n15864# eeg_afe_pga_0/eeg_fd_ota_chopped_full2_0/stage2_0/m1_59941_n8557# 100000
R394 eeg_afe_pga_0/eeg_fd_ota_chopped_full2_0/stage2_0/m1_81141_n15864# VCM_REF 100000
R395 eeg_afe_pga_0/eeg_fd_ota_chopped_full2_0/stage2_0/m1_76741_n8557# eeg_afe_pga_0/eeg_fd_ota_chopped_full2_0/stage2_0/m1_77141_n15864# 100000
R396 eeg_afe_pga_0/eeg_fd_ota_chopped_full2_0/stage2_0/m1_70341_n15864# eeg_afe_pga_0/eeg_fd_ota_chopped_full2_0/stage2_0/m1_70741_n8557# 100000
R397 eeg_afe_pga_0/eeg_fd_ota_chopped_full2_0/stage2_0/m1_65941_n8557# eeg_afe_pga_0/eeg_fd_ota_chopped_full2_0/stage2_0/m1_66341_n15864# 100000
R398 eeg_afe_pga_0/eeg_fd_ota_chopped_full2_0/stage2_0/m1_49541_n8557# eeg_afe_pga_0/eeg_fd_ota_chopped_full2_0/stage2_0/m1_49941_n15864# 100000
R399 eeg_afe_pga_0/eeg_fd_ota_chopped_full2_0/stage2_0/m1_53941_n15864# eeg_afe_pga_0/eeg_fd_ota_chopped_full2_0/stage2_0/m1_54341_n8557# 100000
R400 eeg_afe_pga_0/eeg_fd_ota_chopped_full2_0/stage2_0/m1_59141_n8557# eeg_afe_pga_0/eeg_fd_ota_chopped_full2_0/stage2_0/m1_59541_n15864# 100000
R401 eeg_afe_pga_0/eeg_fd_ota_chopped_full2_0/stage2_0/m1_36741_n15864# eeg_afe_pga_0/eeg_fd_ota_chopped_full2_0/stage2_0/m1_37141_n8557# 100000
R402 eeg_afe_pga_0/eeg_fd_ota_chopped_full2_0/stage2_0/m1_80741_n8557# eeg_afe_pga_0/eeg_fd_ota_chopped_full2_0/stage2_0/m1_81141_n15864# 100000
R403 eeg_afe_pga_0/eeg_fd_ota_chopped_full2_0/stage2_0/m1_76341_n15864# eeg_afe_pga_0/eeg_fd_ota_chopped_full2_0/stage2_0/m1_76741_n8557# 100000
R404 eeg_afe_pga_0/eeg_fd_ota_chopped_full2_0/stage2_0/m1_69941_n8557# eeg_afe_pga_0/eeg_fd_ota_chopped_full2_0/stage2_0/m1_70341_n15864# 100000
R405 eeg_afe_pga_0/eeg_fd_ota_chopped_full2_0/stage2_0/m1_65541_n15864# eeg_afe_pga_0/eeg_fd_ota_chopped_full2_0/stage2_0/m1_65941_n8557# 100000
R406 eeg_afe_pga_0/eeg_fd_ota_chopped_full2_0/stage2_0/m1_53541_n8557# eeg_afe_pga_0/eeg_fd_ota_chopped_full2_0/stage2_0/m1_53941_n15864# 100000
R407 eeg_afe_pga_0/eeg_fd_ota_chopped_full2_0/stage2_0/m1_58741_n15864# eeg_afe_pga_0/eeg_fd_ota_chopped_full2_0/stage2_0/m1_59141_n8557# 100000
R408 eeg_afe_pga_0/eeg_fd_ota_chopped_full2_0/stage2_0/m1_20741_n15864# eeg_afe_pga_0/eeg_fd_ota_chopped_full2_0/stage2_0/m1_21141_n8557# 100000
R409 eeg_afe_pga_0/eeg_fd_ota_chopped_full2_0/stage2_0/m1_36341_n8557# eeg_afe_pga_0/eeg_fd_ota_chopped_full2_0/stage2_0/m1_36741_n15864# 100000
R410 eeg_afe_pga_0/eeg_fd_ota_chopped_full2_0/stage2_0/m1_80341_n15864# eeg_afe_pga_0/eeg_fd_ota_chopped_full2_0/stage2_0/m1_80741_n8557# 100000
R411 eeg_afe_pga_0/eeg_fd_ota_chopped_full2_0/stage2_0/m1_75941_n8557# eeg_afe_pga_0/eeg_fd_ota_chopped_full2_0/stage2_0/m1_76341_n15864# 100000
R412 eeg_afe_pga_0/eeg_fd_ota_chopped_full2_0/stage2_0/m1_69541_n15864# eeg_afe_pga_0/eeg_fd_ota_chopped_full2_0/stage2_0/m1_69941_n8557# 100000
R413 eeg_afe_pga_0/eeg_fd_ota_chopped_full2_0/stage2_0/m1_65141_n8557# eeg_afe_pga_0/eeg_fd_ota_chopped_full2_0/stage2_0/m1_65541_n15864# 100000
X414 PGA_OUTP eeg_afe_pga_0/eeg_fd_ota_chopped_full2_0/stage2_0/N2P VSS VSS sky130_fd_pr__nfet_01v8 ad=1.5 pd=6.5 as=6.12 ps=14.04 w=6 l=12 nf=1
X415 VSS eeg_afe_pga_0/eeg_fd_ota_chopped_full2_0/stage2_0/N2P PGA_OUTP VSS sky130_fd_pr__nfet_01v8 ad=6.12 pd=14.04 as=1.5 ps=6.5 w=6 l=12 nf=1
CMIM416 eeg_afe_pga_0/eeg_fd_ota_chopped_full2_0/stage2_0/m1_3966_n5928# PGA_OUTP 1.000000e-11
CMIM417 eeg_afe_pga_0/eeg_fd_ota_chopped_full2_0/stage2_0/m1_12966_n5928# PGA_OUTN 1.000000e-11
X456 eeg_afe_pga_0/eeg_fd_ota_chopped_full2_0/stage2_0/N2P PHIBM eeg_afe_pga_0/eeg_fd_ota_chopped_full2_0/stage2_0/N2P VDD18 sky130_fd_pr__pfet_01v8 ad=0.5544 pd=3 as=0.5544 ps=3 w=0.84 l=0.15 nf=1
X457 eeg_afe_pga_0/eeg_fd_ota_chopped_full2_0/eeg_fd_ota_core_soft_0/OUTN NPHIBM eeg_afe_pga_0/eeg_fd_ota_chopped_full2_0/eeg_fd_ota_core_soft_0/OUTN VSS sky130_fd_pr__nfet_01v8 ad=0.126 pd=1.44 as=0.126 ps=1.44 w=0.42 l=0.15 nf=1
X458 eeg_afe_pga_0/eeg_fd_ota_chopped_full2_0/stage2_0/N2P NPHIBM eeg_afe_pga_0/eeg_fd_ota_chopped_full2_0/stage2_0/N2P VSS sky130_fd_pr__nfet_01v8 ad=0.126 pd=1.44 as=0.126 ps=1.44 w=0.42 l=0.15 nf=1
X459 eeg_afe_pga_0/eeg_fd_ota_chopped_full2_0/stage2_0/N2P NPHIBM eeg_afe_pga_0/eeg_fd_ota_chopped_full2_0/eeg_fd_ota_core_soft_0/OUTN VDD18 sky130_fd_pr__pfet_01v8 ad=1.7136 pd=5.4 as=1.7136 ps=5.4 w=1.68 l=0.15 nf=1
X460 eeg_afe_pga_0/eeg_fd_ota_chopped_full2_0/eeg_fd_ota_core_soft_0/OUTN PHIBM eeg_afe_pga_0/eeg_fd_ota_chopped_full2_0/eeg_fd_ota_core_soft_0/OUTN VDD18 sky130_fd_pr__pfet_01v8 ad=0.5544 pd=3 as=0.5544 ps=3 w=0.84 l=0.15 nf=1
X461 eeg_afe_pga_0/eeg_fd_ota_chopped_full2_0/stage2_0/N2P PHIBM eeg_afe_pga_0/eeg_fd_ota_chopped_full2_0/eeg_fd_ota_core_soft_0/OUTN VSS sky130_fd_pr__nfet_01v8 ad=0.5544 pd=3 as=0.5544 ps=3 w=0.84 l=0.15 nf=1
X462 eeg_afe_pga_0/eeg_fd_ota_chopped_full2_0/stage2_0/N2N PHIBM eeg_afe_pga_0/eeg_fd_ota_chopped_full2_0/stage2_0/N2N VDD18 sky130_fd_pr__pfet_01v8 ad=0.5544 pd=3 as=0.5544 ps=3 w=0.84 l=0.15 nf=1
X463 eeg_afe_pga_0/eeg_fd_ota_chopped_full2_0/eeg_fd_ota_core_soft_0/OUTP NPHIBM eeg_afe_pga_0/eeg_fd_ota_chopped_full2_0/eeg_fd_ota_core_soft_0/OUTP VSS sky130_fd_pr__nfet_01v8 ad=0.126 pd=1.44 as=0.126 ps=1.44 w=0.42 l=0.15 nf=1
X464 eeg_afe_pga_0/eeg_fd_ota_chopped_full2_0/stage2_0/N2N NPHIBM eeg_afe_pga_0/eeg_fd_ota_chopped_full2_0/stage2_0/N2N VSS sky130_fd_pr__nfet_01v8 ad=0.126 pd=1.44 as=0.126 ps=1.44 w=0.42 l=0.15 nf=1
X465 eeg_afe_pga_0/eeg_fd_ota_chopped_full2_0/stage2_0/N2N NPHIBM eeg_afe_pga_0/eeg_fd_ota_chopped_full2_0/eeg_fd_ota_core_soft_0/OUTP VDD18 sky130_fd_pr__pfet_01v8 ad=1.7136 pd=5.4 as=1.7136 ps=5.4 w=1.68 l=0.15 nf=1
X466 eeg_afe_pga_0/eeg_fd_ota_chopped_full2_0/eeg_fd_ota_core_soft_0/OUTP PHIBM eeg_afe_pga_0/eeg_fd_ota_chopped_full2_0/eeg_fd_ota_core_soft_0/OUTP VDD18 sky130_fd_pr__pfet_01v8 ad=0.5544 pd=3 as=0.5544 ps=3 w=0.84 l=0.15 nf=1
X467 eeg_afe_pga_0/eeg_fd_ota_chopped_full2_0/stage2_0/N2N PHIBM eeg_afe_pga_0/eeg_fd_ota_chopped_full2_0/eeg_fd_ota_core_soft_0/OUTP VSS sky130_fd_pr__nfet_01v8 ad=0.5544 pd=3 as=0.5544 ps=3 w=0.84 l=0.15 nf=1
X468 eeg_afe_pga_0/eeg_fd_ota_chopped_full2_0/stage2_0/N2N PHIM eeg_afe_pga_0/eeg_fd_ota_chopped_full2_0/stage2_0/N2N VDD18 sky130_fd_pr__pfet_01v8 ad=0.5544 pd=3 as=0.5544 ps=3 w=0.84 l=0.15 nf=1
X469 eeg_afe_pga_0/eeg_fd_ota_chopped_full2_0/eeg_fd_ota_core_soft_0/OUTN NPHIM eeg_afe_pga_0/eeg_fd_ota_chopped_full2_0/eeg_fd_ota_core_soft_0/OUTN VSS sky130_fd_pr__nfet_01v8 ad=0.126 pd=1.44 as=0.126 ps=1.44 w=0.42 l=0.15 nf=1
X470 eeg_afe_pga_0/eeg_fd_ota_chopped_full2_0/stage2_0/N2N NPHIM eeg_afe_pga_0/eeg_fd_ota_chopped_full2_0/stage2_0/N2N VSS sky130_fd_pr__nfet_01v8 ad=0.126 pd=1.44 as=0.126 ps=1.44 w=0.42 l=0.15 nf=1
X471 eeg_afe_pga_0/eeg_fd_ota_chopped_full2_0/stage2_0/N2N NPHIM eeg_afe_pga_0/eeg_fd_ota_chopped_full2_0/eeg_fd_ota_core_soft_0/OUTN VDD18 sky130_fd_pr__pfet_01v8 ad=1.7136 pd=5.4 as=1.7136 ps=5.4 w=1.68 l=0.15 nf=1
X472 eeg_afe_pga_0/eeg_fd_ota_chopped_full2_0/eeg_fd_ota_core_soft_0/OUTN PHIM eeg_afe_pga_0/eeg_fd_ota_chopped_full2_0/eeg_fd_ota_core_soft_0/OUTN VDD18 sky130_fd_pr__pfet_01v8 ad=0.5544 pd=3 as=0.5544 ps=3 w=0.84 l=0.15 nf=1
X473 eeg_afe_pga_0/eeg_fd_ota_chopped_full2_0/stage2_0/N2N PHIM eeg_afe_pga_0/eeg_fd_ota_chopped_full2_0/eeg_fd_ota_core_soft_0/OUTN VSS sky130_fd_pr__nfet_01v8 ad=0.5544 pd=3 as=0.5544 ps=3 w=0.84 l=0.15 nf=1
X474 eeg_afe_pga_0/eeg_fd_ota_chopped_full2_0/stage2_0/N2P PHIM eeg_afe_pga_0/eeg_fd_ota_chopped_full2_0/stage2_0/N2P VDD18 sky130_fd_pr__pfet_01v8 ad=0.5544 pd=3 as=0.5544 ps=3 w=0.84 l=0.15 nf=1
X475 eeg_afe_pga_0/eeg_fd_ota_chopped_full2_0/eeg_fd_ota_core_soft_0/OUTP NPHIM eeg_afe_pga_0/eeg_fd_ota_chopped_full2_0/eeg_fd_ota_core_soft_0/OUTP VSS sky130_fd_pr__nfet_01v8 ad=0.126 pd=1.44 as=0.126 ps=1.44 w=0.42 l=0.15 nf=1
X476 eeg_afe_pga_0/eeg_fd_ota_chopped_full2_0/stage2_0/N2P NPHIM eeg_afe_pga_0/eeg_fd_ota_chopped_full2_0/stage2_0/N2P VSS sky130_fd_pr__nfet_01v8 ad=0.126 pd=1.44 as=0.126 ps=1.44 w=0.42 l=0.15 nf=1
X477 eeg_afe_pga_0/eeg_fd_ota_chopped_full2_0/stage2_0/N2P NPHIM eeg_afe_pga_0/eeg_fd_ota_chopped_full2_0/eeg_fd_ota_core_soft_0/OUTP VDD18 sky130_fd_pr__pfet_01v8 ad=1.7136 pd=5.4 as=1.7136 ps=5.4 w=1.68 l=0.15 nf=1
X478 eeg_afe_pga_0/eeg_fd_ota_chopped_full2_0/eeg_fd_ota_core_soft_0/OUTP PHIM eeg_afe_pga_0/eeg_fd_ota_chopped_full2_0/eeg_fd_ota_core_soft_0/OUTP VDD18 sky130_fd_pr__pfet_01v8 ad=0.5544 pd=3 as=0.5544 ps=3 w=0.84 l=0.15 nf=1
X479 eeg_afe_pga_0/eeg_fd_ota_chopped_full2_0/stage2_0/N2P PHIM eeg_afe_pga_0/eeg_fd_ota_chopped_full2_0/eeg_fd_ota_core_soft_0/OUTP VSS sky130_fd_pr__nfet_01v8 ad=0.5544 pd=3 as=0.5544 ps=3 w=0.84 l=0.15 nf=1
X480 eeg_afe_pga_0/eeg_fd_ota_chopped_full2_0/eeg_fd_ota_core_soft_0/INP PHIBI eeg_afe_pga_0/eeg_fd_ota_chopped_full2_0/eeg_fd_ota_core_soft_0/INP VDD18 sky130_fd_pr__pfet_01v8 ad=0.5544 pd=3 as=0.5544 ps=3 w=0.84 l=0.15 nf=1
X481 eeg_afe_pga_0/eeg_tg_lowq_3/B NPHIBI eeg_afe_pga_0/eeg_tg_lowq_3/B VSS sky130_fd_pr__nfet_01v8 ad=0.126 pd=1.44 as=0.126 ps=1.44 w=0.42 l=0.15 nf=1
X482 eeg_afe_pga_0/eeg_fd_ota_chopped_full2_0/eeg_fd_ota_core_soft_0/INP NPHIBI eeg_afe_pga_0/eeg_fd_ota_chopped_full2_0/eeg_fd_ota_core_soft_0/INP VSS sky130_fd_pr__nfet_01v8 ad=0.126 pd=1.44 as=0.126 ps=1.44 w=0.42 l=0.15 nf=1
X483 eeg_afe_pga_0/eeg_fd_ota_chopped_full2_0/eeg_fd_ota_core_soft_0/INP NPHIBI eeg_afe_pga_0/eeg_tg_lowq_3/B VDD18 sky130_fd_pr__pfet_01v8 ad=1.7136 pd=5.4 as=1.7136 ps=5.4 w=1.68 l=0.15 nf=1
X484 eeg_afe_pga_0/eeg_tg_lowq_3/B PHIBI eeg_afe_pga_0/eeg_tg_lowq_3/B VDD18 sky130_fd_pr__pfet_01v8 ad=0.5544 pd=3 as=0.5544 ps=3 w=0.84 l=0.15 nf=1
X485 eeg_afe_pga_0/eeg_fd_ota_chopped_full2_0/eeg_fd_ota_core_soft_0/INP PHIBI eeg_afe_pga_0/eeg_tg_lowq_3/B VSS sky130_fd_pr__nfet_01v8 ad=0.5544 pd=3 as=0.5544 ps=3 w=0.84 l=0.15 nf=1
X486 eeg_afe_pga_0/eeg_fd_ota_chopped_full2_0/eeg_fd_ota_core_soft_0/INN PHIBI eeg_afe_pga_0/eeg_fd_ota_chopped_full2_0/eeg_fd_ota_core_soft_0/INN VDD18 sky130_fd_pr__pfet_01v8 ad=0.5544 pd=3 as=0.5544 ps=3 w=0.84 l=0.15 nf=1
X487 eeg_afe_pga_0/eeg_tg_lowq_7/B NPHIBI eeg_afe_pga_0/eeg_tg_lowq_7/B VSS sky130_fd_pr__nfet_01v8 ad=0.126 pd=1.44 as=0.126 ps=1.44 w=0.42 l=0.15 nf=1
X488 eeg_afe_pga_0/eeg_fd_ota_chopped_full2_0/eeg_fd_ota_core_soft_0/INN NPHIBI eeg_afe_pga_0/eeg_fd_ota_chopped_full2_0/eeg_fd_ota_core_soft_0/INN VSS sky130_fd_pr__nfet_01v8 ad=0.126 pd=1.44 as=0.126 ps=1.44 w=0.42 l=0.15 nf=1
X489 eeg_afe_pga_0/eeg_fd_ota_chopped_full2_0/eeg_fd_ota_core_soft_0/INN NPHIBI eeg_afe_pga_0/eeg_tg_lowq_7/B VDD18 sky130_fd_pr__pfet_01v8 ad=1.7136 pd=5.4 as=1.7136 ps=5.4 w=1.68 l=0.15 nf=1
X490 eeg_afe_pga_0/eeg_tg_lowq_7/B PHIBI eeg_afe_pga_0/eeg_tg_lowq_7/B VDD18 sky130_fd_pr__pfet_01v8 ad=0.5544 pd=3 as=0.5544 ps=3 w=0.84 l=0.15 nf=1
X491 eeg_afe_pga_0/eeg_fd_ota_chopped_full2_0/eeg_fd_ota_core_soft_0/INN PHIBI eeg_afe_pga_0/eeg_tg_lowq_7/B VSS sky130_fd_pr__nfet_01v8 ad=0.5544 pd=3 as=0.5544 ps=3 w=0.84 l=0.15 nf=1
X492 eeg_afe_pga_0/eeg_fd_ota_chopped_full2_0/eeg_fd_ota_core_soft_0/INN PHII eeg_afe_pga_0/eeg_fd_ota_chopped_full2_0/eeg_fd_ota_core_soft_0/INN VDD18 sky130_fd_pr__pfet_01v8 ad=0.5544 pd=3 as=0.5544 ps=3 w=0.84 l=0.15 nf=1
X493 eeg_afe_pga_0/eeg_tg_lowq_3/B NPHII eeg_afe_pga_0/eeg_tg_lowq_3/B VSS sky130_fd_pr__nfet_01v8 ad=0.126 pd=1.44 as=0.126 ps=1.44 w=0.42 l=0.15 nf=1
X494 eeg_afe_pga_0/eeg_fd_ota_chopped_full2_0/eeg_fd_ota_core_soft_0/INN NPHII eeg_afe_pga_0/eeg_fd_ota_chopped_full2_0/eeg_fd_ota_core_soft_0/INN VSS sky130_fd_pr__nfet_01v8 ad=0.126 pd=1.44 as=0.126 ps=1.44 w=0.42 l=0.15 nf=1
X495 eeg_afe_pga_0/eeg_fd_ota_chopped_full2_0/eeg_fd_ota_core_soft_0/INN NPHII eeg_afe_pga_0/eeg_tg_lowq_3/B VDD18 sky130_fd_pr__pfet_01v8 ad=1.7136 pd=5.4 as=1.7136 ps=5.4 w=1.68 l=0.15 nf=1
X496 eeg_afe_pga_0/eeg_tg_lowq_3/B PHII eeg_afe_pga_0/eeg_tg_lowq_3/B VDD18 sky130_fd_pr__pfet_01v8 ad=0.5544 pd=3 as=0.5544 ps=3 w=0.84 l=0.15 nf=1
X497 eeg_afe_pga_0/eeg_fd_ota_chopped_full2_0/eeg_fd_ota_core_soft_0/INN PHII eeg_afe_pga_0/eeg_tg_lowq_3/B VSS sky130_fd_pr__nfet_01v8 ad=0.5544 pd=3 as=0.5544 ps=3 w=0.84 l=0.15 nf=1
X498 eeg_afe_pga_0/eeg_fd_ota_chopped_full2_0/eeg_fd_ota_core_soft_0/INP PHII eeg_afe_pga_0/eeg_fd_ota_chopped_full2_0/eeg_fd_ota_core_soft_0/INP VDD18 sky130_fd_pr__pfet_01v8 ad=0.5544 pd=3 as=0.5544 ps=3 w=0.84 l=0.15 nf=1
X499 eeg_afe_pga_0/eeg_tg_lowq_7/B NPHII eeg_afe_pga_0/eeg_tg_lowq_7/B VSS sky130_fd_pr__nfet_01v8 ad=0.126 pd=1.44 as=0.126 ps=1.44 w=0.42 l=0.15 nf=1
X500 eeg_afe_pga_0/eeg_fd_ota_chopped_full2_0/eeg_fd_ota_core_soft_0/INP NPHII eeg_afe_pga_0/eeg_fd_ota_chopped_full2_0/eeg_fd_ota_core_soft_0/INP VSS sky130_fd_pr__nfet_01v8 ad=0.126 pd=1.44 as=0.126 ps=1.44 w=0.42 l=0.15 nf=1
X501 eeg_afe_pga_0/eeg_fd_ota_chopped_full2_0/eeg_fd_ota_core_soft_0/INP NPHII eeg_afe_pga_0/eeg_tg_lowq_7/B VDD18 sky130_fd_pr__pfet_01v8 ad=1.7136 pd=5.4 as=1.7136 ps=5.4 w=1.68 l=0.15 nf=1
X502 eeg_afe_pga_0/eeg_tg_lowq_7/B PHII eeg_afe_pga_0/eeg_tg_lowq_7/B VDD18 sky130_fd_pr__pfet_01v8 ad=0.5544 pd=3 as=0.5544 ps=3 w=0.84 l=0.15 nf=1
X503 eeg_afe_pga_0/eeg_fd_ota_chopped_full2_0/eeg_fd_ota_core_soft_0/INP PHII eeg_afe_pga_0/eeg_tg_lowq_7/B VSS sky130_fd_pr__nfet_01v8 ad=0.5544 pd=3 as=0.5544 ps=3 w=0.84 l=0.15 nf=1
R504 eeg_afe_pga_0/eeg_fd_ota_chopped_full2_0/eeg_fd_ota_core_soft_0/m1_n51659_3443# eeg_afe_pga_0/eeg_fd_ota_chopped_full2_0/eeg_fd_ota_core_soft_0/m1_n51259_n3864# 100000
R505 eeg_afe_pga_0/eeg_fd_ota_chopped_full2_0/eeg_fd_ota_core_soft_0/m1_n52059_n3864# eeg_afe_pga_0/eeg_fd_ota_chopped_full2_0/eeg_fd_ota_core_soft_0/m1_n51659_3443# 100000
R506 eeg_afe_pga_0/eeg_fd_ota_chopped_full2_0/eeg_fd_ota_core_soft_0/m1_n52459_3443# eeg_afe_pga_0/eeg_fd_ota_chopped_full2_0/eeg_fd_ota_core_soft_0/m1_n52059_n3864# 100000
R507 eeg_afe_pga_0/eeg_fd_ota_chopped_full2_0/eeg_fd_ota_core_soft_0/m1_n52859_n3864# eeg_afe_pga_0/eeg_fd_ota_chopped_full2_0/eeg_fd_ota_core_soft_0/m1_n52459_3443# 100000
R508 eeg_afe_pga_0/eeg_fd_ota_chopped_full2_0/eeg_fd_ota_core_soft_0/m1_n53259_3443# eeg_afe_pga_0/eeg_fd_ota_chopped_full2_0/eeg_fd_ota_core_soft_0/m1_n52859_n3864# 100000
X509 VSS eeg_afe_pga_0/eeg_fd_ota_chopped_full2_0/eeg_bias_gen_0/VBNF eeg_afe_pga_0/eeg_fd_ota_chopped_full2_0/eeg_fd_ota_core_soft_0/m1_n22658_111# VSS sky130_fd_pr__nfet_01v8 ad=16.62 pd=59.54 as=12 ps=52 w=48 l=4 nf=8
X510 eeg_afe_pga_0/eeg_fd_ota_chopped_full2_0/eeg_fd_ota_core_soft_0/m1_n22658_111# eeg_afe_pga_0/eeg_fd_ota_chopped_full2_0/eeg_bias_gen_0/VBNF VSS VSS sky130_fd_pr__nfet_01v8 ad=12 pd=52 as=16.62 ps=59.54 w=48 l=4 nf=8
R525 eeg_afe_pga_0/eeg_fd_ota_chopped_full2_0/eeg_fd_ota_core_soft_0/m1_n53659_n3864# eeg_afe_pga_0/eeg_fd_ota_chopped_full2_0/eeg_fd_ota_core_soft_0/m1_n53259_3443# 100000
R526 eeg_afe_pga_0/eeg_fd_ota_chopped_full2_0/eeg_fd_ota_core_soft_0/m1_31541_n3864# eeg_afe_pga_0/eeg_fd_ota_chopped_full2_0/eeg_fd_ota_core_soft_0/m1_31941_3443# 100000
R527 eeg_afe_pga_0/eeg_fd_ota_chopped_full2_0/eeg_fd_ota_core_soft_0/m1_n54059_3443# eeg_afe_pga_0/eeg_fd_ota_chopped_full2_0/eeg_fd_ota_core_soft_0/m1_n53659_n3864# 100000
R528 eeg_afe_pga_0/eeg_fd_ota_chopped_full2_0/eeg_fd_ota_core_soft_0/m1_31141_3443# eeg_afe_pga_0/eeg_fd_ota_chopped_full2_0/eeg_fd_ota_core_soft_0/m1_31541_n3864# 100000
R529 eeg_afe_pga_0/eeg_fd_ota_chopped_full2_0/eeg_fd_ota_core_soft_0/m1_35541_n3864# eeg_afe_pga_0/eeg_fd_ota_chopped_full2_0/eeg_fd_ota_core_soft_0/m1_35941_3443# 100000
R530 eeg_afe_pga_0/eeg_fd_ota_chopped_full2_0/eeg_fd_ota_core_soft_0/m1_n54459_n3864# eeg_afe_pga_0/eeg_fd_ota_chopped_full2_0/eeg_fd_ota_core_soft_0/m1_n54059_3443# 100000
R531 eeg_afe_pga_0/eeg_fd_ota_chopped_full2_0/eeg_fd_ota_core_soft_0/m1_39541_n3864# eeg_afe_pga_0/eeg_fd_ota_chopped_full2_0/eeg_fd_ota_core_soft_0/m1_39941_3443# 100000
R532 eeg_afe_pga_0/eeg_fd_ota_chopped_full2_0/eeg_fd_ota_core_soft_0/m1_30741_n3864# eeg_afe_pga_0/eeg_fd_ota_chopped_full2_0/eeg_fd_ota_core_soft_0/m1_31141_3443# 100000
R533 eeg_afe_pga_0/eeg_fd_ota_chopped_full2_0/eeg_fd_ota_core_soft_0/m1_35141_3443# eeg_afe_pga_0/eeg_fd_ota_chopped_full2_0/eeg_fd_ota_core_soft_0/m1_35541_n3864# 100000
R534 eeg_afe_pga_0/eeg_fd_ota_chopped_full2_0/eeg_fd_ota_core_soft_0/m1_n54859_3443# eeg_afe_pga_0/eeg_fd_ota_chopped_full2_0/eeg_fd_ota_core_soft_0/m1_n54459_n3864# 100000
R535 eeg_afe_pga_0/eeg_fd_ota_chopped_full2_0/eeg_fd_ota_core_soft_0/m1_43541_n3864# eeg_afe_pga_0/eeg_fd_ota_chopped_full2_0/eeg_fd_ota_core_soft_0/m1_43941_3443# 100000
R536 eeg_afe_pga_0/eeg_fd_ota_chopped_full2_0/eeg_fd_ota_core_soft_0/m1_39141_3443# eeg_afe_pga_0/eeg_fd_ota_chopped_full2_0/eeg_fd_ota_core_soft_0/m1_39541_n3864# 100000
R537 eeg_afe_pga_0/eeg_fd_ota_chopped_full2_0/eeg_fd_ota_core_soft_0/m1_30341_3443# eeg_afe_pga_0/eeg_fd_ota_chopped_full2_0/eeg_fd_ota_core_soft_0/m1_30741_n3864# 100000
R538 eeg_afe_pga_0/eeg_fd_ota_chopped_full2_0/eeg_fd_ota_core_soft_0/m1_34741_n3864# eeg_afe_pga_0/eeg_fd_ota_chopped_full2_0/eeg_fd_ota_core_soft_0/m1_35141_3443# 100000
R539 eeg_afe_pga_0/eeg_fd_ota_chopped_full2_0/eeg_fd_ota_core_soft_0/m1_n55259_n3864# eeg_afe_pga_0/eeg_fd_ota_chopped_full2_0/eeg_fd_ota_core_soft_0/m1_n54859_3443# 100000
R540 eeg_afe_pga_0/eeg_fd_ota_chopped_full2_0/eeg_fd_ota_core_soft_0/m1_43141_3443# eeg_afe_pga_0/eeg_fd_ota_chopped_full2_0/eeg_fd_ota_core_soft_0/m1_43541_n3864# 100000
R541 eeg_afe_pga_0/eeg_fd_ota_chopped_full2_0/eeg_fd_ota_core_soft_0/m1_38741_n3864# eeg_afe_pga_0/eeg_fd_ota_chopped_full2_0/eeg_fd_ota_core_soft_0/m1_39141_3443# 100000
R542 eeg_afe_pga_0/eeg_fd_ota_chopped_full2_0/eeg_fd_ota_core_soft_0/m1_29941_n3864# eeg_afe_pga_0/eeg_fd_ota_chopped_full2_0/eeg_fd_ota_core_soft_0/m1_30341_3443# 100000
R543 eeg_afe_pga_0/eeg_fd_ota_chopped_full2_0/eeg_fd_ota_core_soft_0/m1_34341_3443# eeg_afe_pga_0/eeg_fd_ota_chopped_full2_0/eeg_fd_ota_core_soft_0/m1_34741_n3864# 100000
R544 eeg_afe_pga_0/eeg_fd_ota_chopped_full2_0/eeg_fd_ota_core_soft_0/m1_42741_n3864# eeg_afe_pga_0/eeg_fd_ota_chopped_full2_0/eeg_fd_ota_core_soft_0/m1_43141_3443# 100000
R545 eeg_afe_pga_0/eeg_fd_ota_chopped_full2_0/eeg_fd_ota_core_soft_0/m1_38341_3443# eeg_afe_pga_0/eeg_fd_ota_chopped_full2_0/eeg_fd_ota_core_soft_0/m1_38741_n3864# 100000
R546 eeg_afe_pga_0/eeg_fd_ota_chopped_full2_0/eeg_fd_ota_core_soft_0/m1_29541_3443# eeg_afe_pga_0/eeg_fd_ota_chopped_full2_0/eeg_fd_ota_core_soft_0/m1_29941_n3864# 100000
R547 eeg_afe_pga_0/eeg_fd_ota_chopped_full2_0/eeg_fd_ota_core_soft_0/m1_33941_n3864# eeg_afe_pga_0/eeg_fd_ota_chopped_full2_0/eeg_fd_ota_core_soft_0/m1_34341_3443# 100000
X548 eeg_afe_pga_0/eeg_fd_ota_chopped_full2_0/eeg_fd_ota_core_soft_0/OUTP eeg_afe_pga_0/eeg_fd_ota_chopped_full2_0/eeg_fd_ota_core_soft_0/INP eeg_afe_pga_0/eeg_fd_ota_chopped_full2_0/eeg_fd_ota_core_soft_0/m1_n22658_111# VSS sky130_fd_pr__nfet_01v8 ad=30 pd=126 as=30 ps=126 w=120 l=4 nf=12
X549 eeg_afe_pga_0/eeg_fd_ota_chopped_full2_0/eeg_fd_ota_core_soft_0/m1_n22658_111# eeg_afe_pga_0/eeg_fd_ota_chopped_full2_0/eeg_fd_ota_core_soft_0/INN eeg_afe_pga_0/eeg_fd_ota_chopped_full2_0/eeg_fd_ota_core_soft_0/OUTN VSS sky130_fd_pr__nfet_01v8 ad=30 pd=126 as=30 ps=126 w=120 l=4 nf=12
X550 eeg_afe_pga_0/eeg_fd_ota_chopped_full2_0/eeg_fd_ota_core_soft_0/m1_n22658_111# eeg_afe_pga_0/eeg_fd_ota_chopped_full2_0/eeg_fd_ota_core_soft_0/INP eeg_afe_pga_0/eeg_fd_ota_chopped_full2_0/eeg_fd_ota_core_soft_0/OUTP VSS sky130_fd_pr__nfet_01v8 ad=30 pd=126 as=30 ps=126 w=120 l=4 nf=12
X551 eeg_afe_pga_0/eeg_fd_ota_chopped_full2_0/eeg_fd_ota_core_soft_0/OUTN eeg_afe_pga_0/eeg_fd_ota_chopped_full2_0/eeg_fd_ota_core_soft_0/INN eeg_afe_pga_0/eeg_fd_ota_chopped_full2_0/eeg_fd_ota_core_soft_0/m1_n22658_111# VSS sky130_fd_pr__nfet_01v8 ad=30 pd=126 as=30 ps=126 w=120 l=4 nf=12
X560 eeg_afe_pga_0/eeg_fd_ota_chopped_full2_0/eeg_fd_ota_core_soft_0/m1_n22658_111# VSS eeg_afe_pga_0/eeg_fd_ota_chopped_full2_0/eeg_fd_ota_core_soft_0/OUTP VSS sky130_fd_pr__nfet_01v8 ad=17.4 pd=23.48 as=2.5 ps=10.5 w=10 l=4 nf=1
X592 eeg_afe_pga_0/eeg_fd_ota_chopped_full2_0/eeg_fd_ota_core_soft_0/OUTP VSS eeg_afe_pga_0/eeg_fd_ota_chopped_full2_0/eeg_fd_ota_core_soft_0/m1_n22658_111# VSS sky130_fd_pr__nfet_01v8 ad=2.5 pd=10.5 as=17.4 ps=23.48 w=10 l=4 nf=1
R598 eeg_afe_pga_0/eeg_fd_ota_chopped_full2_0/eeg_fd_ota_core_soft_0/m1_42341_3443# eeg_afe_pga_0/eeg_fd_ota_chopped_full2_0/eeg_fd_ota_core_soft_0/m1_42741_n3864# 100000
R599 eeg_afe_pga_0/eeg_fd_ota_chopped_full2_0/eeg_fd_ota_core_soft_0/m1_37941_n3864# eeg_afe_pga_0/eeg_fd_ota_chopped_full2_0/eeg_fd_ota_core_soft_0/m1_38341_3443# 100000
R600 eeg_afe_pga_0/eeg_fd_ota_chopped_full2_0/eeg_fd_ota_core_soft_0/m1_29141_n3864# eeg_afe_pga_0/eeg_fd_ota_chopped_full2_0/eeg_fd_ota_core_soft_0/m1_29541_3443# 100000
R601 eeg_afe_pga_0/eeg_fd_ota_chopped_full2_0/eeg_fd_ota_core_soft_0/m1_33541_3443# eeg_afe_pga_0/eeg_fd_ota_chopped_full2_0/eeg_fd_ota_core_soft_0/m1_33941_n3864# 100000
R602 eeg_afe_pga_0/eeg_fd_ota_chopped_full2_0/eeg_fd_ota_core_soft_0/m1_41941_n3864# eeg_afe_pga_0/eeg_fd_ota_chopped_full2_0/eeg_fd_ota_core_soft_0/m1_42341_3443# 100000
R603 eeg_afe_pga_0/eeg_fd_ota_chopped_full2_0/eeg_fd_ota_core_soft_0/m1_37541_3443# eeg_afe_pga_0/eeg_fd_ota_chopped_full2_0/eeg_fd_ota_core_soft_0/m1_37941_n3864# 100000
R604 eeg_afe_pga_0/eeg_fd_ota_chopped_full2_0/eeg_fd_ota_core_soft_0/m1_28741_3443# eeg_afe_pga_0/eeg_fd_ota_chopped_full2_0/eeg_fd_ota_core_soft_0/m1_29141_n3864# 100000
R605 eeg_afe_pga_0/eeg_fd_ota_chopped_full2_0/eeg_fd_ota_core_soft_0/m1_33141_n3864# eeg_afe_pga_0/eeg_fd_ota_chopped_full2_0/eeg_fd_ota_core_soft_0/m1_33541_3443# 100000
R606 eeg_afe_pga_0/eeg_fd_ota_chopped_full2_0/eeg_fd_ota_core_soft_0/m1_41541_3443# eeg_afe_pga_0/eeg_fd_ota_chopped_full2_0/eeg_fd_ota_core_soft_0/m1_41941_n3864# 100000
R607 eeg_afe_pga_0/eeg_fd_ota_chopped_full2_0/eeg_fd_ota_core_soft_0/m1_37141_n3864# eeg_afe_pga_0/eeg_fd_ota_chopped_full2_0/eeg_fd_ota_core_soft_0/m1_37541_3443# 100000
R608 eeg_afe_pga_0/eeg_fd_ota_chopped_full2_0/eeg_fd_ota_core_soft_0/m1_28341_n3864# eeg_afe_pga_0/eeg_fd_ota_chopped_full2_0/eeg_fd_ota_core_soft_0/m1_28741_3443# 100000
R609 eeg_afe_pga_0/eeg_fd_ota_chopped_full2_0/eeg_fd_ota_core_soft_0/m1_32741_3443# eeg_afe_pga_0/eeg_fd_ota_chopped_full2_0/eeg_fd_ota_core_soft_0/m1_33141_n3864# 100000
R610 eeg_afe_pga_0/eeg_fd_ota_chopped_full2_0/eeg_fd_ota_core_soft_0/m1_47541_n3864# eeg_afe_pga_0/eeg_fd_ota_chopped_full2_0/eeg_fd_ota_core_soft_0/OUTN 100000
R611 eeg_afe_pga_0/eeg_fd_ota_chopped_full2_0/eeg_fd_ota_core_soft_0/m1_41141_n3864# eeg_afe_pga_0/eeg_fd_ota_chopped_full2_0/eeg_fd_ota_core_soft_0/m1_41541_3443# 100000
R612 eeg_afe_pga_0/eeg_fd_ota_chopped_full2_0/eeg_cmfb_amp_dl2_0/VCM_SENSE eeg_afe_pga_0/eeg_fd_ota_chopped_full2_0/eeg_fd_ota_core_soft_0/m1_28341_n3864# 100000
R613 eeg_afe_pga_0/eeg_fd_ota_chopped_full2_0/eeg_fd_ota_core_soft_0/m1_32341_n3864# eeg_afe_pga_0/eeg_fd_ota_chopped_full2_0/eeg_fd_ota_core_soft_0/m1_32741_3443# 100000
R614 eeg_afe_pga_0/eeg_fd_ota_chopped_full2_0/eeg_fd_ota_core_soft_0/m1_36741_3443# eeg_afe_pga_0/eeg_fd_ota_chopped_full2_0/eeg_fd_ota_core_soft_0/m1_37141_n3864# 100000
R615 eeg_afe_pga_0/eeg_fd_ota_chopped_full2_0/eeg_fd_ota_core_soft_0/m1_53941_n3864# eeg_afe_pga_0/eeg_fd_ota_chopped_full2_0/eeg_fd_ota_core_soft_0/m1_54341_3443# 100000
R616 eeg_afe_pga_0/eeg_fd_ota_chopped_full2_0/eeg_fd_ota_core_soft_0/m1_47141_3443# eeg_afe_pga_0/eeg_fd_ota_chopped_full2_0/eeg_fd_ota_core_soft_0/m1_47541_n3864# 100000
R617 eeg_afe_pga_0/eeg_fd_ota_chopped_full2_0/eeg_fd_ota_core_soft_0/m1_40741_3443# eeg_afe_pga_0/eeg_fd_ota_chopped_full2_0/eeg_fd_ota_core_soft_0/m1_41141_n3864# 100000
R618 eeg_afe_pga_0/eeg_fd_ota_chopped_full2_0/eeg_fd_ota_core_soft_0/m1_36341_n3864# eeg_afe_pga_0/eeg_fd_ota_chopped_full2_0/eeg_fd_ota_core_soft_0/m1_36741_3443# 100000
R619 eeg_afe_pga_0/eeg_fd_ota_chopped_full2_0/eeg_fd_ota_core_soft_0/m1_31941_3443# eeg_afe_pga_0/eeg_fd_ota_chopped_full2_0/eeg_fd_ota_core_soft_0/m1_32341_n3864# 100000
R620 eeg_afe_pga_0/eeg_fd_ota_chopped_full2_0/eeg_fd_ota_core_soft_0/m1_57941_n3864# eeg_afe_pga_0/eeg_fd_ota_chopped_full2_0/eeg_fd_ota_core_soft_0/OUTN 100000
R621 eeg_afe_pga_0/eeg_fd_ota_chopped_full2_0/eeg_fd_ota_core_soft_0/m1_53541_3443# eeg_afe_pga_0/eeg_fd_ota_chopped_full2_0/eeg_fd_ota_core_soft_0/m1_53941_n3864# 100000
R622 eeg_afe_pga_0/eeg_fd_ota_chopped_full2_0/eeg_fd_ota_core_soft_0/m1_46741_n3864# eeg_afe_pga_0/eeg_fd_ota_chopped_full2_0/eeg_fd_ota_core_soft_0/m1_47141_3443# 100000
R623 eeg_afe_pga_0/eeg_fd_ota_chopped_full2_0/eeg_fd_ota_core_soft_0/m1_40341_n3864# eeg_afe_pga_0/eeg_fd_ota_chopped_full2_0/eeg_fd_ota_core_soft_0/m1_40741_3443# 100000
R624 eeg_afe_pga_0/eeg_fd_ota_chopped_full2_0/eeg_fd_ota_core_soft_0/m1_35941_3443# eeg_afe_pga_0/eeg_fd_ota_chopped_full2_0/eeg_fd_ota_core_soft_0/m1_36341_n3864# 100000
R625 eeg_afe_pga_0/eeg_fd_ota_chopped_full2_0/eeg_fd_ota_core_soft_0/m1_57541_3443# eeg_afe_pga_0/eeg_fd_ota_chopped_full2_0/eeg_fd_ota_core_soft_0/m1_57941_n3864# 100000
R626 eeg_afe_pga_0/eeg_fd_ota_chopped_full2_0/eeg_fd_ota_core_soft_0/m1_53141_n3864# eeg_afe_pga_0/eeg_fd_ota_chopped_full2_0/eeg_fd_ota_core_soft_0/m1_53541_3443# 100000
R627 eeg_afe_pga_0/eeg_fd_ota_chopped_full2_0/eeg_fd_ota_core_soft_0/m1_46341_3443# eeg_afe_pga_0/eeg_fd_ota_chopped_full2_0/eeg_fd_ota_core_soft_0/m1_46741_n3864# 100000
R628 eeg_afe_pga_0/eeg_fd_ota_chopped_full2_0/eeg_fd_ota_core_soft_0/m1_n45259_3443# eeg_afe_pga_0/eeg_fd_ota_chopped_full2_0/eeg_fd_ota_core_soft_0/m1_n44859_n3864# 100000
R629 eeg_afe_pga_0/eeg_fd_ota_chopped_full2_0/eeg_fd_ota_core_soft_0/m1_39941_3443# eeg_afe_pga_0/eeg_fd_ota_chopped_full2_0/eeg_fd_ota_core_soft_0/m1_40341_n3864# 100000
R630 eeg_afe_pga_0/eeg_fd_ota_chopped_full2_0/eeg_fd_ota_core_soft_0/m1_57141_n3864# eeg_afe_pga_0/eeg_fd_ota_chopped_full2_0/eeg_fd_ota_core_soft_0/m1_57541_3443# 100000
R631 eeg_afe_pga_0/eeg_fd_ota_chopped_full2_0/eeg_fd_ota_core_soft_0/m1_52741_3443# eeg_afe_pga_0/eeg_fd_ota_chopped_full2_0/eeg_fd_ota_core_soft_0/m1_53141_n3864# 100000
R632 eeg_afe_pga_0/eeg_fd_ota_chopped_full2_0/eeg_fd_ota_core_soft_0/m1_45941_n3864# eeg_afe_pga_0/eeg_fd_ota_chopped_full2_0/eeg_fd_ota_core_soft_0/m1_46341_3443# 100000
R633 eeg_afe_pga_0/eeg_fd_ota_chopped_full2_0/eeg_fd_ota_core_soft_0/m1_n45659_n3864# eeg_afe_pga_0/eeg_fd_ota_chopped_full2_0/eeg_fd_ota_core_soft_0/m1_n45259_3443# 100000
R634 eeg_afe_pga_0/eeg_fd_ota_chopped_full2_0/eeg_fd_ota_core_soft_0/m1_n41259_3443# eeg_afe_pga_0/eeg_fd_ota_chopped_full2_0/eeg_fd_ota_core_soft_0/m1_n40859_n3864# 100000
R635 eeg_afe_pga_0/eeg_fd_ota_chopped_full2_0/eeg_fd_ota_core_soft_0/m1_56741_3443# eeg_afe_pga_0/eeg_fd_ota_chopped_full2_0/eeg_fd_ota_core_soft_0/m1_57141_n3864# 100000
R636 eeg_afe_pga_0/eeg_fd_ota_chopped_full2_0/eeg_fd_ota_core_soft_0/m1_52341_n3864# eeg_afe_pga_0/eeg_fd_ota_chopped_full2_0/eeg_fd_ota_core_soft_0/m1_52741_3443# 100000
R637 eeg_afe_pga_0/eeg_fd_ota_chopped_full2_0/eeg_fd_ota_core_soft_0/m1_45541_3443# eeg_afe_pga_0/eeg_fd_ota_chopped_full2_0/eeg_fd_ota_core_soft_0/m1_45941_n3864# 100000
R638 eeg_afe_pga_0/eeg_fd_ota_chopped_full2_0/eeg_fd_ota_core_soft_0/m1_n46059_3443# eeg_afe_pga_0/eeg_fd_ota_chopped_full2_0/eeg_fd_ota_core_soft_0/m1_n45659_n3864# 100000
R639 eeg_afe_pga_0/eeg_fd_ota_chopped_full2_0/eeg_fd_ota_core_soft_0/m1_n41659_n3864# eeg_afe_pga_0/eeg_fd_ota_chopped_full2_0/eeg_fd_ota_core_soft_0/m1_n41259_3443# 100000
R640 eeg_afe_pga_0/eeg_fd_ota_chopped_full2_0/eeg_fd_ota_core_soft_0/m1_n37259_3443# eeg_afe_pga_0/eeg_fd_ota_chopped_full2_0/eeg_fd_ota_core_soft_0/m1_n36859_n3864# 100000
R641 eeg_afe_pga_0/eeg_fd_ota_chopped_full2_0/eeg_fd_ota_core_soft_0/m1_56341_n3864# eeg_afe_pga_0/eeg_fd_ota_chopped_full2_0/eeg_fd_ota_core_soft_0/m1_56741_3443# 100000
R642 eeg_afe_pga_0/eeg_fd_ota_chopped_full2_0/eeg_fd_ota_core_soft_0/m1_51941_3443# eeg_afe_pga_0/eeg_fd_ota_chopped_full2_0/eeg_fd_ota_core_soft_0/m1_52341_n3864# 100000
R643 eeg_afe_pga_0/eeg_fd_ota_chopped_full2_0/eeg_fd_ota_core_soft_0/m1_45141_n3864# eeg_afe_pga_0/eeg_fd_ota_chopped_full2_0/eeg_fd_ota_core_soft_0/m1_45541_3443# 100000
R644 eeg_afe_pga_0/eeg_fd_ota_chopped_full2_0/eeg_fd_ota_core_soft_0/m1_n46459_n3864# eeg_afe_pga_0/eeg_fd_ota_chopped_full2_0/eeg_fd_ota_core_soft_0/m1_n46059_3443# 100000
R645 eeg_afe_pga_0/eeg_fd_ota_chopped_full2_0/eeg_fd_ota_core_soft_0/m1_n42059_3443# eeg_afe_pga_0/eeg_fd_ota_chopped_full2_0/eeg_fd_ota_core_soft_0/m1_n41659_n3864# 100000
R646 eeg_afe_pga_0/eeg_fd_ota_chopped_full2_0/eeg_fd_ota_core_soft_0/m1_n37659_n3864# eeg_afe_pga_0/eeg_fd_ota_chopped_full2_0/eeg_fd_ota_core_soft_0/m1_n37259_3443# 100000
R647 eeg_afe_pga_0/eeg_fd_ota_chopped_full2_0/eeg_fd_ota_core_soft_0/m1_n33259_3443# eeg_afe_pga_0/eeg_fd_ota_chopped_full2_0/eeg_fd_ota_core_soft_0/m1_n32859_n3864# 100000
R648 eeg_afe_pga_0/eeg_fd_ota_chopped_full2_0/eeg_fd_ota_core_soft_0/m1_55941_3443# eeg_afe_pga_0/eeg_fd_ota_chopped_full2_0/eeg_fd_ota_core_soft_0/m1_56341_n3864# 100000
R649 eeg_afe_pga_0/eeg_fd_ota_chopped_full2_0/eeg_fd_ota_core_soft_0/m1_51541_n3864# eeg_afe_pga_0/eeg_fd_ota_chopped_full2_0/eeg_fd_ota_core_soft_0/m1_51941_3443# 100000
R650 eeg_afe_pga_0/eeg_fd_ota_chopped_full2_0/eeg_fd_ota_core_soft_0/m1_44741_3443# eeg_afe_pga_0/eeg_fd_ota_chopped_full2_0/eeg_fd_ota_core_soft_0/m1_45141_n3864# 100000
R651 eeg_afe_pga_0/eeg_fd_ota_chopped_full2_0/eeg_fd_ota_core_soft_0/m1_n46859_3443# eeg_afe_pga_0/eeg_fd_ota_chopped_full2_0/eeg_fd_ota_core_soft_0/m1_n46459_n3864# 100000
R652 eeg_afe_pga_0/eeg_fd_ota_chopped_full2_0/eeg_fd_ota_core_soft_0/m1_n42459_n3864# eeg_afe_pga_0/eeg_fd_ota_chopped_full2_0/eeg_fd_ota_core_soft_0/m1_n42059_3443# 100000
R653 eeg_afe_pga_0/eeg_fd_ota_chopped_full2_0/eeg_fd_ota_core_soft_0/m1_n38059_3443# eeg_afe_pga_0/eeg_fd_ota_chopped_full2_0/eeg_fd_ota_core_soft_0/m1_n37659_n3864# 100000
R654 eeg_afe_pga_0/eeg_fd_ota_chopped_full2_0/eeg_fd_ota_core_soft_0/m1_n33659_n3864# eeg_afe_pga_0/eeg_fd_ota_chopped_full2_0/eeg_fd_ota_core_soft_0/m1_n33259_3443# 100000
R655 eeg_afe_pga_0/eeg_fd_ota_chopped_full2_0/eeg_fd_ota_core_soft_0/m1_n29259_3443# eeg_afe_pga_0/eeg_fd_ota_chopped_full2_0/eeg_fd_ota_core_soft_0/m1_n28859_n3864# 100000
X656 eeg_afe_pga_0/eeg_fd_ota_chopped_full2_0/eeg_fd_ota_core_soft_0/OUTP eeg_afe_pga_0/eeg_fd_ota_chopped_full2_0/eeg_cmfb_amp_dl2_0/VBP VDD18 VDD18 sky130_fd_pr__pfet_01v8 ad=6 pd=26 as=10.62 ps=33.54 w=24 l=4 nf=4
X657 VDD18 eeg_afe_pga_0/eeg_fd_ota_chopped_full2_0/eeg_cmfb_amp_dl2_0/VBP eeg_afe_pga_0/eeg_fd_ota_chopped_full2_0/eeg_fd_ota_core_soft_0/OUTP VDD18 sky130_fd_pr__pfet_01v8 ad=10.62 pd=33.54 as=6 ps=26 w=24 l=4 nf=4
R664 eeg_afe_pga_0/eeg_fd_ota_chopped_full2_0/eeg_fd_ota_core_soft_0/m1_55541_n3864# eeg_afe_pga_0/eeg_fd_ota_chopped_full2_0/eeg_fd_ota_core_soft_0/m1_55941_3443# 100000
R665 eeg_afe_pga_0/eeg_fd_ota_chopped_full2_0/eeg_fd_ota_core_soft_0/m1_51141_3443# eeg_afe_pga_0/eeg_fd_ota_chopped_full2_0/eeg_fd_ota_core_soft_0/m1_51541_n3864# 100000
R666 eeg_afe_pga_0/eeg_fd_ota_chopped_full2_0/eeg_fd_ota_core_soft_0/m1_44341_n3864# eeg_afe_pga_0/eeg_fd_ota_chopped_full2_0/eeg_fd_ota_core_soft_0/m1_44741_3443# 100000
R667 eeg_afe_pga_0/eeg_fd_ota_chopped_full2_0/eeg_fd_ota_core_soft_0/m1_n55659_3443# eeg_afe_pga_0/eeg_fd_ota_chopped_full2_0/eeg_fd_ota_core_soft_0/m1_n55259_n3864# 100000
R668 eeg_afe_pga_0/eeg_fd_ota_chopped_full2_0/eeg_fd_ota_core_soft_0/m1_n47259_n3864# eeg_afe_pga_0/eeg_fd_ota_chopped_full2_0/eeg_fd_ota_core_soft_0/m1_n46859_3443# 100000
R669 eeg_afe_pga_0/eeg_fd_ota_chopped_full2_0/eeg_fd_ota_core_soft_0/m1_n42859_3443# eeg_afe_pga_0/eeg_fd_ota_chopped_full2_0/eeg_fd_ota_core_soft_0/m1_n42459_n3864# 100000
R670 eeg_afe_pga_0/eeg_fd_ota_chopped_full2_0/eeg_fd_ota_core_soft_0/m1_n38459_n3864# eeg_afe_pga_0/eeg_fd_ota_chopped_full2_0/eeg_fd_ota_core_soft_0/m1_n38059_3443# 100000
R671 eeg_afe_pga_0/eeg_fd_ota_chopped_full2_0/eeg_fd_ota_core_soft_0/m1_n34059_3443# eeg_afe_pga_0/eeg_fd_ota_chopped_full2_0/eeg_fd_ota_core_soft_0/m1_n33659_n3864# 100000
R672 eeg_afe_pga_0/eeg_fd_ota_chopped_full2_0/eeg_fd_ota_core_soft_0/m1_n29659_n3864# eeg_afe_pga_0/eeg_fd_ota_chopped_full2_0/eeg_fd_ota_core_soft_0/m1_n29259_3443# 100000
R673 eeg_afe_pga_0/eeg_fd_ota_chopped_full2_0/eeg_fd_ota_core_soft_0/m1_55141_3443# eeg_afe_pga_0/eeg_fd_ota_chopped_full2_0/eeg_fd_ota_core_soft_0/m1_55541_n3864# 100000
R674 eeg_afe_pga_0/eeg_fd_ota_chopped_full2_0/eeg_fd_ota_core_soft_0/m1_50741_n3864# eeg_afe_pga_0/eeg_fd_ota_chopped_full2_0/eeg_fd_ota_core_soft_0/m1_51141_3443# 100000
R675 eeg_afe_pga_0/eeg_fd_ota_chopped_full2_0/eeg_fd_ota_core_soft_0/m1_43941_3443# eeg_afe_pga_0/eeg_fd_ota_chopped_full2_0/eeg_fd_ota_core_soft_0/m1_44341_n3864# 100000
R676 eeg_afe_pga_0/eeg_fd_ota_chopped_full2_0/eeg_fd_ota_core_soft_0/m1_n56059_n3864# eeg_afe_pga_0/eeg_fd_ota_chopped_full2_0/eeg_fd_ota_core_soft_0/m1_n55659_3443# 100000
R677 eeg_afe_pga_0/eeg_fd_ota_chopped_full2_0/eeg_fd_ota_core_soft_0/m1_n47659_3443# eeg_afe_pga_0/eeg_fd_ota_chopped_full2_0/eeg_fd_ota_core_soft_0/m1_n47259_n3864# 100000
R678 eeg_afe_pga_0/eeg_fd_ota_chopped_full2_0/eeg_fd_ota_core_soft_0/m1_n43259_n3864# eeg_afe_pga_0/eeg_fd_ota_chopped_full2_0/eeg_fd_ota_core_soft_0/m1_n42859_3443# 100000
R679 eeg_afe_pga_0/eeg_fd_ota_chopped_full2_0/eeg_fd_ota_core_soft_0/m1_n38859_3443# eeg_afe_pga_0/eeg_fd_ota_chopped_full2_0/eeg_fd_ota_core_soft_0/m1_n38459_n3864# 100000
R680 eeg_afe_pga_0/eeg_fd_ota_chopped_full2_0/eeg_fd_ota_core_soft_0/m1_n34459_n3864# eeg_afe_pga_0/eeg_fd_ota_chopped_full2_0/eeg_fd_ota_core_soft_0/m1_n34059_3443# 100000
R681 eeg_afe_pga_0/eeg_fd_ota_chopped_full2_0/eeg_fd_ota_core_soft_0/m1_n30059_3443# eeg_afe_pga_0/eeg_fd_ota_chopped_full2_0/eeg_fd_ota_core_soft_0/m1_n29659_n3864# 100000
R682 eeg_afe_pga_0/eeg_fd_ota_chopped_full2_0/eeg_fd_ota_core_soft_0/m1_54741_n3864# eeg_afe_pga_0/eeg_fd_ota_chopped_full2_0/eeg_fd_ota_core_soft_0/m1_55141_3443# 100000
R683 VCM_REF eeg_afe_pga_0/eeg_fd_ota_chopped_full2_0/eeg_fd_ota_core_soft_0/m1_50741_n3864# 100000
R684 eeg_afe_pga_0/eeg_fd_ota_chopped_full2_0/eeg_fd_ota_core_soft_0/m1_n56459_3443# eeg_afe_pga_0/eeg_fd_ota_chopped_full2_0/eeg_fd_ota_core_soft_0/m1_n56059_n3864# 100000
R685 eeg_afe_pga_0/eeg_fd_ota_chopped_full2_0/eeg_fd_ota_core_soft_0/m1_n48059_n3864# eeg_afe_pga_0/eeg_fd_ota_chopped_full2_0/eeg_fd_ota_core_soft_0/m1_n47659_3443# 100000
R686 eeg_afe_pga_0/eeg_fd_ota_chopped_full2_0/eeg_fd_ota_core_soft_0/m1_n43659_3443# eeg_afe_pga_0/eeg_fd_ota_chopped_full2_0/eeg_fd_ota_core_soft_0/m1_n43259_n3864# 100000
R687 eeg_afe_pga_0/eeg_fd_ota_chopped_full2_0/eeg_fd_ota_core_soft_0/m1_n39259_n3864# eeg_afe_pga_0/eeg_fd_ota_chopped_full2_0/eeg_fd_ota_core_soft_0/m1_n38859_3443# 100000
R688 eeg_afe_pga_0/eeg_fd_ota_chopped_full2_0/eeg_fd_ota_core_soft_0/m1_n34859_3443# eeg_afe_pga_0/eeg_fd_ota_chopped_full2_0/eeg_fd_ota_core_soft_0/m1_n34459_n3864# 100000
R689 eeg_afe_pga_0/eeg_fd_ota_chopped_full2_0/eeg_fd_ota_core_soft_0/m1_n30459_n3864# eeg_afe_pga_0/eeg_fd_ota_chopped_full2_0/eeg_fd_ota_core_soft_0/m1_n30059_3443# 100000
R690 eeg_afe_pga_0/eeg_fd_ota_chopped_full2_0/eeg_fd_ota_core_soft_0/m1_54341_3443# eeg_afe_pga_0/eeg_fd_ota_chopped_full2_0/eeg_fd_ota_core_soft_0/m1_54741_n3864# 100000
R691 eeg_afe_pga_0/eeg_fd_ota_chopped_full2_0/eeg_fd_ota_core_soft_0/m1_n56859_n3864# eeg_afe_pga_0/eeg_fd_ota_chopped_full2_0/eeg_fd_ota_core_soft_0/m1_n56459_3443# 100000
R692 eeg_afe_pga_0/eeg_fd_ota_chopped_full2_0/eeg_fd_ota_core_soft_0/OUTP eeg_afe_pga_0/eeg_fd_ota_chopped_full2_0/eeg_fd_ota_core_soft_0/m1_n48059_n3864# 100000
R693 eeg_afe_pga_0/eeg_fd_ota_chopped_full2_0/eeg_fd_ota_core_soft_0/m1_n44059_n3864# eeg_afe_pga_0/eeg_fd_ota_chopped_full2_0/eeg_fd_ota_core_soft_0/m1_n43659_3443# 100000
R694 eeg_afe_pga_0/eeg_fd_ota_chopped_full2_0/eeg_fd_ota_core_soft_0/m1_n39659_3443# eeg_afe_pga_0/eeg_fd_ota_chopped_full2_0/eeg_fd_ota_core_soft_0/m1_n39259_n3864# 100000
R695 eeg_afe_pga_0/eeg_fd_ota_chopped_full2_0/eeg_fd_ota_core_soft_0/m1_n35259_n3864# eeg_afe_pga_0/eeg_fd_ota_chopped_full2_0/eeg_fd_ota_core_soft_0/m1_n34859_3443# 100000
R696 eeg_afe_pga_0/eeg_fd_ota_chopped_full2_0/eeg_fd_ota_core_soft_0/m1_n30859_3443# eeg_afe_pga_0/eeg_fd_ota_chopped_full2_0/eeg_fd_ota_core_soft_0/m1_n30459_n3864# 100000
R697 eeg_afe_pga_0/eeg_fd_ota_chopped_full2_0/eeg_fd_ota_core_soft_0/m1_n57259_3443# eeg_afe_pga_0/eeg_fd_ota_chopped_full2_0/eeg_fd_ota_core_soft_0/m1_n56859_n3864# 100000
R698 eeg_afe_pga_0/eeg_fd_ota_chopped_full2_0/eeg_fd_ota_core_soft_0/m1_n51259_n3864# VCM_REF 100000
R699 eeg_afe_pga_0/eeg_fd_ota_chopped_full2_0/eeg_fd_ota_core_soft_0/m1_n44459_3443# eeg_afe_pga_0/eeg_fd_ota_chopped_full2_0/eeg_fd_ota_core_soft_0/m1_n44059_n3864# 100000
R700 eeg_afe_pga_0/eeg_fd_ota_chopped_full2_0/eeg_fd_ota_core_soft_0/m1_n40059_n3864# eeg_afe_pga_0/eeg_fd_ota_chopped_full2_0/eeg_fd_ota_core_soft_0/m1_n39659_3443# 100000
R701 eeg_afe_pga_0/eeg_fd_ota_chopped_full2_0/eeg_fd_ota_core_soft_0/m1_n35659_3443# eeg_afe_pga_0/eeg_fd_ota_chopped_full2_0/eeg_fd_ota_core_soft_0/m1_n35259_n3864# 100000
R702 eeg_afe_pga_0/eeg_fd_ota_chopped_full2_0/eeg_fd_ota_core_soft_0/m1_n31259_n3864# eeg_afe_pga_0/eeg_fd_ota_chopped_full2_0/eeg_fd_ota_core_soft_0/m1_n30859_3443# 100000
R703 eeg_afe_pga_0/eeg_fd_ota_chopped_full2_0/eeg_fd_ota_core_soft_0/m1_n57659_n3864# eeg_afe_pga_0/eeg_fd_ota_chopped_full2_0/eeg_fd_ota_core_soft_0/m1_n57259_3443# 100000
R704 eeg_afe_pga_0/eeg_fd_ota_chopped_full2_0/eeg_fd_ota_core_soft_0/m1_n44859_n3864# eeg_afe_pga_0/eeg_fd_ota_chopped_full2_0/eeg_fd_ota_core_soft_0/m1_n44459_3443# 100000
R705 eeg_afe_pga_0/eeg_fd_ota_chopped_full2_0/eeg_fd_ota_core_soft_0/m1_n40459_3443# eeg_afe_pga_0/eeg_fd_ota_chopped_full2_0/eeg_fd_ota_core_soft_0/m1_n40059_n3864# 100000
R706 eeg_afe_pga_0/eeg_fd_ota_chopped_full2_0/eeg_fd_ota_core_soft_0/m1_n36059_n3864# eeg_afe_pga_0/eeg_fd_ota_chopped_full2_0/eeg_fd_ota_core_soft_0/m1_n35659_3443# 100000
R707 eeg_afe_pga_0/eeg_fd_ota_chopped_full2_0/eeg_fd_ota_core_soft_0/m1_n31659_3443# eeg_afe_pga_0/eeg_fd_ota_chopped_full2_0/eeg_fd_ota_core_soft_0/m1_n31259_n3864# 100000
X708 eeg_afe_pga_0/eeg_fd_ota_chopped_full2_0/eeg_fd_ota_core_soft_0/OUTN eeg_afe_pga_0/eeg_fd_ota_chopped_full2_0/eeg_cmfb_amp_dl2_0/VBP VDD18 VDD18 sky130_fd_pr__pfet_01v8 ad=6 pd=26 as=10.62 ps=33.54 w=24 l=4 nf=4
X709 VDD18 eeg_afe_pga_0/eeg_fd_ota_chopped_full2_0/eeg_cmfb_amp_dl2_0/VBP eeg_afe_pga_0/eeg_fd_ota_chopped_full2_0/eeg_fd_ota_core_soft_0/OUTN VDD18 sky130_fd_pr__pfet_01v8 ad=10.62 pd=33.54 as=6 ps=26 w=24 l=4 nf=4
R716 eeg_afe_pga_0/eeg_fd_ota_chopped_full2_0/eeg_fd_ota_core_soft_0/m1_n58059_3443# eeg_afe_pga_0/eeg_fd_ota_chopped_full2_0/eeg_fd_ota_core_soft_0/m1_n57659_n3864# 100000
R717 eeg_afe_pga_0/eeg_fd_ota_chopped_full2_0/eeg_fd_ota_core_soft_0/m1_n40859_n3864# eeg_afe_pga_0/eeg_fd_ota_chopped_full2_0/eeg_fd_ota_core_soft_0/m1_n40459_3443# 100000
R718 eeg_afe_pga_0/eeg_fd_ota_chopped_full2_0/eeg_fd_ota_core_soft_0/m1_n36459_3443# eeg_afe_pga_0/eeg_fd_ota_chopped_full2_0/eeg_fd_ota_core_soft_0/m1_n36059_n3864# 100000
R719 eeg_afe_pga_0/eeg_fd_ota_chopped_full2_0/eeg_fd_ota_core_soft_0/m1_n32059_n3864# eeg_afe_pga_0/eeg_fd_ota_chopped_full2_0/eeg_fd_ota_core_soft_0/m1_n31659_3443# 100000
R720 eeg_afe_pga_0/eeg_fd_ota_chopped_full2_0/eeg_fd_ota_core_soft_0/m1_n58459_n3864# eeg_afe_pga_0/eeg_fd_ota_chopped_full2_0/eeg_fd_ota_core_soft_0/m1_n58059_3443# 100000
R721 eeg_afe_pga_0/eeg_fd_ota_chopped_full2_0/eeg_fd_ota_core_soft_0/m1_n36859_n3864# eeg_afe_pga_0/eeg_fd_ota_chopped_full2_0/eeg_fd_ota_core_soft_0/m1_n36459_3443# 100000
R722 eeg_afe_pga_0/eeg_fd_ota_chopped_full2_0/eeg_fd_ota_core_soft_0/m1_n32459_3443# eeg_afe_pga_0/eeg_fd_ota_chopped_full2_0/eeg_fd_ota_core_soft_0/m1_n32059_n3864# 100000
R723 eeg_afe_pga_0/eeg_fd_ota_chopped_full2_0/eeg_fd_ota_core_soft_0/OUTP eeg_afe_pga_0/eeg_fd_ota_chopped_full2_0/eeg_fd_ota_core_soft_0/m1_n58459_n3864# 100000
R724 eeg_afe_pga_0/eeg_fd_ota_chopped_full2_0/eeg_fd_ota_core_soft_0/m1_n32859_n3864# eeg_afe_pga_0/eeg_fd_ota_chopped_full2_0/eeg_fd_ota_core_soft_0/m1_n32459_3443# 100000
R725 eeg_afe_pga_0/eeg_fd_ota_chopped_full2_0/eeg_fd_ota_core_soft_0/m1_n28859_n3864# eeg_afe_pga_0/eeg_fd_ota_chopped_full2_0/eeg_cmfb_amp_dl2_0/VCM_SENSE 100000
X726 VCM_REF eeg_afe_pga_0/eeg_pseudo_res_0/m1_68_66# eeg_afe_pga_0/eeg_pseudo_res_0/m1_68_66# VCM_REF sky130_fd_pr__pfet_01v8 ad=1.02 pd=4.04 as=1.02 ps=4.04 w=1 l=4 nf=1
X727 eeg_afe_pga_0/eeg_tg_lowq_3/B eeg_afe_pga_0/eeg_pseudo_res_0/m1_68_66# eeg_afe_pga_0/eeg_pseudo_res_0/m1_68_66# eeg_afe_pga_0/eeg_tg_lowq_3/B sky130_fd_pr__pfet_01v8 ad=1.02 pd=4.04 as=1.02 ps=4.04 w=1 l=4 nf=1
X728 VCM_REF eeg_afe_pga_0/eeg_pseudo_res_1/m1_68_66# eeg_afe_pga_0/eeg_pseudo_res_1/m1_68_66# VCM_REF sky130_fd_pr__pfet_01v8 ad=1.02 pd=4.04 as=1.02 ps=4.04 w=1 l=4 nf=1
X729 eeg_afe_pga_0/eeg_tg_lowq_7/B eeg_afe_pga_0/eeg_pseudo_res_1/m1_68_66# eeg_afe_pga_0/eeg_pseudo_res_1/m1_68_66# eeg_afe_pga_0/eeg_tg_lowq_7/B sky130_fd_pr__pfet_01v8 ad=1.02 pd=4.04 as=1.02 ps=4.04 w=1 l=4 nf=1
X730 eeg_afe_pga_0/eeg_tg_lowq_3/B S16 eeg_afe_pga_0/eeg_tg_lowq_3/B VDD18 sky130_fd_pr__pfet_01v8 ad=0.5544 pd=3 as=0.5544 ps=3 w=0.84 l=0.15 nf=1
X731 eeg_afe_pga_0/eeg_tg_lowq_0/A eeg_afe_pga_0/eeg_inv_2/Y eeg_afe_pga_0/eeg_tg_lowq_0/A VSS sky130_fd_pr__nfet_01v8 ad=0.126 pd=1.44 as=0.126 ps=1.44 w=0.42 l=0.15 nf=1
X732 eeg_afe_pga_0/eeg_tg_lowq_3/B eeg_afe_pga_0/eeg_inv_2/Y eeg_afe_pga_0/eeg_tg_lowq_3/B VSS sky130_fd_pr__nfet_01v8 ad=0.126 pd=1.44 as=0.126 ps=1.44 w=0.42 l=0.15 nf=1
X733 eeg_afe_pga_0/eeg_tg_lowq_3/B eeg_afe_pga_0/eeg_inv_2/Y eeg_afe_pga_0/eeg_tg_lowq_0/A VDD18 sky130_fd_pr__pfet_01v8 ad=1.7136 pd=5.4 as=1.7136 ps=5.4 w=1.68 l=0.15 nf=1
X734 eeg_afe_pga_0/eeg_tg_lowq_0/A S16 eeg_afe_pga_0/eeg_tg_lowq_0/A VDD18 sky130_fd_pr__pfet_01v8 ad=0.5544 pd=3 as=0.5544 ps=3 w=0.84 l=0.15 nf=1
X735 eeg_afe_pga_0/eeg_tg_lowq_3/B S16 eeg_afe_pga_0/eeg_tg_lowq_0/A VSS sky130_fd_pr__nfet_01v8 ad=0.5544 pd=3 as=0.5544 ps=3 w=0.84 l=0.15 nf=1
X736 eeg_afe_pga_0/eeg_tg_lowq_3/B S8 eeg_afe_pga_0/eeg_tg_lowq_3/B VDD18 sky130_fd_pr__pfet_01v8 ad=0.5544 pd=3 as=0.5544 ps=3 w=0.84 l=0.15 nf=1
X737 eeg_afe_pga_0/eeg_tg_lowq_1/A eeg_afe_pga_0/eeg_inv_3/Y eeg_afe_pga_0/eeg_tg_lowq_1/A VSS sky130_fd_pr__nfet_01v8 ad=0.126 pd=1.44 as=0.126 ps=1.44 w=0.42 l=0.15 nf=1
X738 eeg_afe_pga_0/eeg_tg_lowq_3/B eeg_afe_pga_0/eeg_inv_3/Y eeg_afe_pga_0/eeg_tg_lowq_3/B VSS sky130_fd_pr__nfet_01v8 ad=0.126 pd=1.44 as=0.126 ps=1.44 w=0.42 l=0.15 nf=1
X739 eeg_afe_pga_0/eeg_tg_lowq_3/B eeg_afe_pga_0/eeg_inv_3/Y eeg_afe_pga_0/eeg_tg_lowq_1/A VDD18 sky130_fd_pr__pfet_01v8 ad=1.7136 pd=5.4 as=1.7136 ps=5.4 w=1.68 l=0.15 nf=1
X740 eeg_afe_pga_0/eeg_tg_lowq_1/A S8 eeg_afe_pga_0/eeg_tg_lowq_1/A VDD18 sky130_fd_pr__pfet_01v8 ad=0.5544 pd=3 as=0.5544 ps=3 w=0.84 l=0.15 nf=1
X741 eeg_afe_pga_0/eeg_tg_lowq_3/B S8 eeg_afe_pga_0/eeg_tg_lowq_1/A VSS sky130_fd_pr__nfet_01v8 ad=0.5544 pd=3 as=0.5544 ps=3 w=0.84 l=0.15 nf=1
X742 VCM_REF VSS VCM_REF VDD18 sky130_fd_pr__pfet_01v8 ad=1.1088 pd=6 as=1.1088 ps=6 w=1.68 l=0.15 nf=2
X743 eeg_afe_pga_0/eeg_tg_lowq_3/B eeg_afe_pga_0/eeg_inv_0/Y eeg_afe_pga_0/eeg_tg_lowq_3/B VSS sky130_fd_pr__nfet_01v8 ad=0.126 pd=1.44 as=0.126 ps=1.44 w=0.42 l=0.15 nf=1
X744 VCM_REF eeg_afe_pga_0/eeg_inv_0/Y VCM_REF VSS sky130_fd_pr__nfet_01v8 ad=0.252 pd=2.88 as=0.252 ps=2.88 w=0.84 l=0.15 nf=2
X745 VCM_REF eeg_afe_pga_0/eeg_inv_0/Y eeg_afe_pga_0/eeg_tg_lowq_3/B VDD18 sky130_fd_pr__pfet_01v8 ad=1.7136 pd=5.4 as=1.7136 ps=5.4 w=1.68 l=0.15 nf=1
X746 eeg_afe_pga_0/eeg_tg_lowq_3/B VSS eeg_afe_pga_0/eeg_tg_lowq_3/B VDD18 sky130_fd_pr__pfet_01v8 ad=0.5544 pd=3 as=0.5544 ps=3 w=0.84 l=0.15 nf=1
X747 VCM_REF VSS eeg_afe_pga_0/eeg_tg_lowq_3/B VSS sky130_fd_pr__nfet_01v8 ad=0.5544 pd=3 as=0.5544 ps=3 w=0.84 l=0.15 nf=1
X748 eeg_afe_pga_0/eeg_tg_lowq_3/B S32 eeg_afe_pga_0/eeg_tg_lowq_3/B VDD18 sky130_fd_pr__pfet_01v8 ad=0.5544 pd=3 as=0.5544 ps=3 w=0.84 l=0.15 nf=1
X749 eeg_afe_pga_0/eeg_tg_lowq_3/A eeg_afe_pga_0/eeg_inv_1/Y eeg_afe_pga_0/eeg_tg_lowq_3/A VSS sky130_fd_pr__nfet_01v8 ad=0.126 pd=1.44 as=0.126 ps=1.44 w=0.42 l=0.15 nf=1
X750 eeg_afe_pga_0/eeg_tg_lowq_3/B eeg_afe_pga_0/eeg_inv_1/Y eeg_afe_pga_0/eeg_tg_lowq_3/B VSS sky130_fd_pr__nfet_01v8 ad=0.126 pd=1.44 as=0.126 ps=1.44 w=0.42 l=0.15 nf=1
X751 eeg_afe_pga_0/eeg_tg_lowq_3/B eeg_afe_pga_0/eeg_inv_1/Y eeg_afe_pga_0/eeg_tg_lowq_3/A VDD18 sky130_fd_pr__pfet_01v8 ad=1.7136 pd=5.4 as=1.7136 ps=5.4 w=1.68 l=0.15 nf=1
X752 eeg_afe_pga_0/eeg_tg_lowq_3/A S32 eeg_afe_pga_0/eeg_tg_lowq_3/A VDD18 sky130_fd_pr__pfet_01v8 ad=0.5544 pd=3 as=0.5544 ps=3 w=0.84 l=0.15 nf=1
X753 eeg_afe_pga_0/eeg_tg_lowq_3/B S32 eeg_afe_pga_0/eeg_tg_lowq_3/A VSS sky130_fd_pr__nfet_01v8 ad=0.5544 pd=3 as=0.5544 ps=3 w=0.84 l=0.15 nf=1
X755 eeg_afe_pga_0/eeg_tg_lowq_7/B eeg_afe_pga_0/eeg_inv_0/Y eeg_afe_pga_0/eeg_tg_lowq_7/B VSS sky130_fd_pr__nfet_01v8 ad=0.126 pd=1.44 as=0.126 ps=1.44 w=0.42 l=0.15 nf=1
X757 VCM_REF eeg_afe_pga_0/eeg_inv_0/Y eeg_afe_pga_0/eeg_tg_lowq_7/B VDD18 sky130_fd_pr__pfet_01v8 ad=1.7136 pd=5.4 as=1.7136 ps=5.4 w=1.68 l=0.15 nf=1
X758 eeg_afe_pga_0/eeg_tg_lowq_7/B VSS eeg_afe_pga_0/eeg_tg_lowq_7/B VDD18 sky130_fd_pr__pfet_01v8 ad=0.5544 pd=3 as=0.5544 ps=3 w=0.84 l=0.15 nf=1
X759 VCM_REF VSS eeg_afe_pga_0/eeg_tg_lowq_7/B VSS sky130_fd_pr__nfet_01v8 ad=0.5544 pd=3 as=0.5544 ps=3 w=0.84 l=0.15 nf=1
X760 eeg_afe_pga_0/eeg_tg_lowq_7/B S8 eeg_afe_pga_0/eeg_tg_lowq_7/B VDD18 sky130_fd_pr__pfet_01v8 ad=0.5544 pd=3 as=0.5544 ps=3 w=0.84 l=0.15 nf=1
X761 eeg_afe_pga_0/eeg_tg_lowq_5/A eeg_afe_pga_0/eeg_inv_3/Y eeg_afe_pga_0/eeg_tg_lowq_5/A VSS sky130_fd_pr__nfet_01v8 ad=0.126 pd=1.44 as=0.126 ps=1.44 w=0.42 l=0.15 nf=1
X762 eeg_afe_pga_0/eeg_tg_lowq_7/B eeg_afe_pga_0/eeg_inv_3/Y eeg_afe_pga_0/eeg_tg_lowq_7/B VSS sky130_fd_pr__nfet_01v8 ad=0.126 pd=1.44 as=0.126 ps=1.44 w=0.42 l=0.15 nf=1
X763 eeg_afe_pga_0/eeg_tg_lowq_7/B eeg_afe_pga_0/eeg_inv_3/Y eeg_afe_pga_0/eeg_tg_lowq_5/A VDD18 sky130_fd_pr__pfet_01v8 ad=1.7136 pd=5.4 as=1.7136 ps=5.4 w=1.68 l=0.15 nf=1
X764 eeg_afe_pga_0/eeg_tg_lowq_5/A S8 eeg_afe_pga_0/eeg_tg_lowq_5/A VDD18 sky130_fd_pr__pfet_01v8 ad=0.5544 pd=3 as=0.5544 ps=3 w=0.84 l=0.15 nf=1
X765 eeg_afe_pga_0/eeg_tg_lowq_7/B S8 eeg_afe_pga_0/eeg_tg_lowq_5/A VSS sky130_fd_pr__nfet_01v8 ad=0.5544 pd=3 as=0.5544 ps=3 w=0.84 l=0.15 nf=1
X766 eeg_afe_pga_0/eeg_tg_lowq_7/B S16 eeg_afe_pga_0/eeg_tg_lowq_7/B VDD18 sky130_fd_pr__pfet_01v8 ad=0.5544 pd=3 as=0.5544 ps=3 w=0.84 l=0.15 nf=1
X767 eeg_afe_pga_0/eeg_tg_lowq_6/A eeg_afe_pga_0/eeg_inv_2/Y eeg_afe_pga_0/eeg_tg_lowq_6/A VSS sky130_fd_pr__nfet_01v8 ad=0.126 pd=1.44 as=0.126 ps=1.44 w=0.42 l=0.15 nf=1
X768 eeg_afe_pga_0/eeg_tg_lowq_7/B eeg_afe_pga_0/eeg_inv_2/Y eeg_afe_pga_0/eeg_tg_lowq_7/B VSS sky130_fd_pr__nfet_01v8 ad=0.126 pd=1.44 as=0.126 ps=1.44 w=0.42 l=0.15 nf=1
X769 eeg_afe_pga_0/eeg_tg_lowq_7/B eeg_afe_pga_0/eeg_inv_2/Y eeg_afe_pga_0/eeg_tg_lowq_6/A VDD18 sky130_fd_pr__pfet_01v8 ad=1.7136 pd=5.4 as=1.7136 ps=5.4 w=1.68 l=0.15 nf=1
X770 eeg_afe_pga_0/eeg_tg_lowq_6/A S16 eeg_afe_pga_0/eeg_tg_lowq_6/A VDD18 sky130_fd_pr__pfet_01v8 ad=0.5544 pd=3 as=0.5544 ps=3 w=0.84 l=0.15 nf=1
X771 eeg_afe_pga_0/eeg_tg_lowq_7/B S16 eeg_afe_pga_0/eeg_tg_lowq_6/A VSS sky130_fd_pr__nfet_01v8 ad=0.5544 pd=3 as=0.5544 ps=3 w=0.84 l=0.15 nf=1
X772 eeg_afe_pga_0/eeg_tg_lowq_7/B S32 eeg_afe_pga_0/eeg_tg_lowq_7/B VDD18 sky130_fd_pr__pfet_01v8 ad=0.5544 pd=3 as=0.5544 ps=3 w=0.84 l=0.15 nf=1
X773 eeg_afe_pga_0/eeg_tg_lowq_7/A eeg_afe_pga_0/eeg_inv_1/Y eeg_afe_pga_0/eeg_tg_lowq_7/A VSS sky130_fd_pr__nfet_01v8 ad=0.126 pd=1.44 as=0.126 ps=1.44 w=0.42 l=0.15 nf=1
X774 eeg_afe_pga_0/eeg_tg_lowq_7/B eeg_afe_pga_0/eeg_inv_1/Y eeg_afe_pga_0/eeg_tg_lowq_7/B VSS sky130_fd_pr__nfet_01v8 ad=0.126 pd=1.44 as=0.126 ps=1.44 w=0.42 l=0.15 nf=1
X775 eeg_afe_pga_0/eeg_tg_lowq_7/B eeg_afe_pga_0/eeg_inv_1/Y eeg_afe_pga_0/eeg_tg_lowq_7/A VDD18 sky130_fd_pr__pfet_01v8 ad=1.7136 pd=5.4 as=1.7136 ps=5.4 w=1.68 l=0.15 nf=1
X776 eeg_afe_pga_0/eeg_tg_lowq_7/A S32 eeg_afe_pga_0/eeg_tg_lowq_7/A VDD18 sky130_fd_pr__pfet_01v8 ad=0.5544 pd=3 as=0.5544 ps=3 w=0.84 l=0.15 nf=1
X777 eeg_afe_pga_0/eeg_tg_lowq_7/B S32 eeg_afe_pga_0/eeg_tg_lowq_7/A VSS sky130_fd_pr__nfet_01v8 ad=0.5544 pd=3 as=0.5544 ps=3 w=0.84 l=0.15 nf=1
X778 VDD18 VSS eeg_afe_pga_0/eeg_inv_0/Y VDD18 sky130_fd_pr__pfet_01v8 ad=2.04 pd=6.04 as=2.04 ps=6.04 w=2 l=0.15 nf=1
X779 VSS VSS eeg_afe_pga_0/eeg_inv_0/Y VSS sky130_fd_pr__nfet_01v8 ad=1.02 pd=4.04 as=1.02 ps=4.04 w=1 l=0.15 nf=1
X780 VDD18 S32 eeg_afe_pga_0/eeg_inv_1/Y VDD18 sky130_fd_pr__pfet_01v8 ad=2.04 pd=6.04 as=2.04 ps=6.04 w=2 l=0.15 nf=1
X781 VSS S32 eeg_afe_pga_0/eeg_inv_1/Y VSS sky130_fd_pr__nfet_01v8 ad=1.02 pd=4.04 as=1.02 ps=4.04 w=1 l=0.15 nf=1
X782 VDD18 S16 eeg_afe_pga_0/eeg_inv_2/Y VDD18 sky130_fd_pr__pfet_01v8 ad=2.04 pd=6.04 as=2.04 ps=6.04 w=2 l=0.15 nf=1
X783 VSS S16 eeg_afe_pga_0/eeg_inv_2/Y VSS sky130_fd_pr__nfet_01v8 ad=1.02 pd=4.04 as=1.02 ps=4.04 w=1 l=0.15 nf=1
X784 VDD18 S8 eeg_afe_pga_0/eeg_inv_3/Y VDD18 sky130_fd_pr__pfet_01v8 ad=2.04 pd=6.04 as=2.04 ps=6.04 w=2 l=0.15 nf=1
X785 VSS S8 eeg_afe_pga_0/eeg_inv_3/Y VSS sky130_fd_pr__nfet_01v8 ad=1.02 pd=4.04 as=1.02 ps=4.04 w=1 l=0.15 nf=1
CMIM786 eeg_afe_pga_0/eeg_tg_lowq_3/B ELN 3.200000e-11
CMIM788 eeg_afe_pga_0/eeg_tg_lowq_7/B ELP 3.200000e-11
CMIM792 eeg_afe_pga_0/eeg_tg_lowq_5/A PGA_OUTN 3.500000e-12
CMIM793 eeg_afe_pga_0/eeg_tg_lowq_0/A PGA_OUTP 1.500000e-12
CMIM815 eeg_afe_pga_0/eeg_tg_lowq_6/A PGA_OUTN 1.500000e-12
CMIM819 eeg_afe_pga_0/eeg_tg_lowq_3/B PGA_OUTP 5.000000e-13
CMIM823 eeg_afe_pga_0/eeg_tg_lowq_1/A PGA_OUTP 3.500000e-12
CMIM827 eeg_afe_pga_0/eeg_tg_lowq_7/A PGA_OUTN 5.000000e-13
CMIM842 eeg_afe_pga_0/eeg_tg_lowq_3/A PGA_OUTP 5.000000e-13
CMIM864 eeg_afe_pga_0/eeg_tg_lowq_7/B PGA_OUTN 5.000000e-13
R890 eeg_sdm1ct_0/eeg_pseudo_res_0/B eeg_sdm1ct_0/m1_55941_64136# 100000
R891 eeg_sdm1ct_0/m1_57141_55443# eeg_sdm1ct_0/eeg_tg_lowq_3/A 100000
R892 eeg_sdm1ct_0/m1_56741_48136# eeg_sdm1ct_0/m1_57141_55443# 100000
R893 eeg_sdm1ct_0/m1_56341_55443# eeg_sdm1ct_0/m1_56741_48136# 100000
R894 eeg_sdm1ct_0/m1_55941_48136# eeg_sdm1ct_0/m1_56341_55443# 100000
R895 eeg_sdm1ct_0/eeg_pseudo_res_1/B eeg_sdm1ct_0/m1_55941_48136# 100000
R896 eeg_sdm1ct_0/m1_57141_39443# eeg_sdm1ct_0/eeg_pseudo_res_0/B 100000
R897 eeg_sdm1ct_0/m1_56741_32136# eeg_sdm1ct_0/m1_57141_39443# 100000
X898 eeg_sdm1ct_0/eeg_pseudo_res_0/B eeg_sdm1ct_0/eeg_pseudo_res_0/m1_68_66# eeg_sdm1ct_0/eeg_pseudo_res_0/m1_68_66# eeg_sdm1ct_0/eeg_pseudo_res_0/B sky130_fd_pr__pfet_01v8 ad=1.02 pd=4.04 as=1.02 ps=4.04 w=1 l=4 nf=1
X899 eeg_sdm1ct_0/OINTP eeg_sdm1ct_0/eeg_pseudo_res_0/m1_68_66# eeg_sdm1ct_0/eeg_pseudo_res_0/m1_68_66# eeg_sdm1ct_0/OINTP sky130_fd_pr__pfet_01v8 ad=1.02 pd=4.04 as=1.02 ps=4.04 w=1 l=4 nf=1
R900 eeg_sdm1ct_0/m1_56341_39443# eeg_sdm1ct_0/m1_56741_32136# 100000
X901 eeg_sdm1ct_0/eeg_pseudo_res_1/B eeg_sdm1ct_0/eeg_pseudo_res_1/m1_68_66# eeg_sdm1ct_0/eeg_pseudo_res_1/m1_68_66# eeg_sdm1ct_0/eeg_pseudo_res_1/B sky130_fd_pr__pfet_01v8 ad=1.02 pd=4.04 as=1.02 ps=4.04 w=1 l=4 nf=1
X902 eeg_sdm1ct_0/OINTN eeg_sdm1ct_0/eeg_pseudo_res_1/m1_68_66# eeg_sdm1ct_0/eeg_pseudo_res_1/m1_68_66# eeg_sdm1ct_0/OINTN sky130_fd_pr__pfet_01v8 ad=1.02 pd=4.04 as=1.02 ps=4.04 w=1 l=4 nf=1
R903 eeg_sdm1ct_0/m1_55941_32136# eeg_sdm1ct_0/m1_56341_39443# 100000
R904 PGA_OUTN eeg_sdm1ct_0/m1_55941_32136# 100000
R905 eeg_sdm1ct_0/m1_57141_23443# eeg_sdm1ct_0/eeg_pseudo_res_1/B 100000
R906 eeg_sdm1ct_0/m1_56741_16136# eeg_sdm1ct_0/m1_57141_23443# 100000
R907 eeg_sdm1ct_0/m1_56341_23443# eeg_sdm1ct_0/m1_56741_16136# 100000
R908 eeg_sdm1ct_0/m1_55941_16136# eeg_sdm1ct_0/m1_56341_23443# 100000
R909 PGA_OUTP eeg_sdm1ct_0/m1_55941_16136# 100000
X910 VP eeg_sdm1ct_0/eeg_inv_0/Y VP VDD18 sky130_fd_pr__pfet_01v8 ad=0.5544 pd=3 as=0.5544 ps=3 w=0.84 l=0.15 nf=1
X911 eeg_sdm1ct_0/eeg_tg_lowq_1/A BIT eeg_sdm1ct_0/eeg_tg_lowq_1/A VSS sky130_fd_pr__nfet_01v8 ad=0.126 pd=1.44 as=0.126 ps=1.44 w=0.42 l=0.15 nf=1
X912 VP BIT VP VSS sky130_fd_pr__nfet_01v8 ad=0.126 pd=1.44 as=0.126 ps=1.44 w=0.42 l=0.15 nf=1
X913 VP BIT eeg_sdm1ct_0/eeg_tg_lowq_1/A VDD18 sky130_fd_pr__pfet_01v8 ad=1.7136 pd=5.4 as=1.7136 ps=5.4 w=1.68 l=0.15 nf=1
X914 eeg_sdm1ct_0/eeg_tg_lowq_1/A eeg_sdm1ct_0/eeg_inv_0/Y eeg_sdm1ct_0/eeg_tg_lowq_1/A VDD18 sky130_fd_pr__pfet_01v8 ad=0.5544 pd=3 as=0.5544 ps=3 w=0.84 l=0.15 nf=1
X915 VP eeg_sdm1ct_0/eeg_inv_0/Y eeg_sdm1ct_0/eeg_tg_lowq_1/A VSS sky130_fd_pr__nfet_01v8 ad=0.5544 pd=3 as=0.5544 ps=3 w=0.84 l=0.15 nf=1
X916 VDD18 eeg_sdm1ct_0/eeg_nand2_0/A NBIT VDD18 sky130_fd_pr__pfet_01v8 ad=2.04 pd=6.04 as=2.04 ps=6.04 w=2 l=0.15 nf=1
X917 eeg_sdm1ct_0/eeg_nand2_0/m1_302_66# eeg_sdm1ct_0/eeg_nand2_0/A NBIT VSS sky130_fd_pr__nfet_01v8 ad=1.02 pd=4.04 as=1.02 ps=4.04 w=1 l=0.15 nf=1
X918 VDD18 BIT NBIT VDD18 sky130_fd_pr__pfet_01v8 ad=2.04 pd=6.04 as=2.04 ps=6.04 w=2 l=0.15 nf=1
X919 VSS BIT eeg_sdm1ct_0/eeg_nand2_0/m1_302_66# VSS sky130_fd_pr__nfet_01v8 ad=1.02 pd=4.04 as=1.02 ps=4.04 w=1 l=0.15 nf=1
X920 VN BIT VN VDD18 sky130_fd_pr__pfet_01v8 ad=0.5544 pd=3 as=0.5544 ps=3 w=0.84 l=0.15 nf=1
X921 eeg_sdm1ct_0/eeg_tg_lowq_1/A eeg_sdm1ct_0/eeg_inv_0/Y eeg_sdm1ct_0/eeg_tg_lowq_1/A VSS sky130_fd_pr__nfet_01v8 ad=0.126 pd=1.44 as=0.126 ps=1.44 w=0.42 l=0.15 nf=1
X922 VN eeg_sdm1ct_0/eeg_inv_0/Y VN VSS sky130_fd_pr__nfet_01v8 ad=0.126 pd=1.44 as=0.126 ps=1.44 w=0.42 l=0.15 nf=1
X923 VN eeg_sdm1ct_0/eeg_inv_0/Y eeg_sdm1ct_0/eeg_tg_lowq_1/A VDD18 sky130_fd_pr__pfet_01v8 ad=1.7136 pd=5.4 as=1.7136 ps=5.4 w=1.68 l=0.15 nf=1
X924 eeg_sdm1ct_0/eeg_tg_lowq_1/A BIT eeg_sdm1ct_0/eeg_tg_lowq_1/A VDD18 sky130_fd_pr__pfet_01v8 ad=0.5544 pd=3 as=0.5544 ps=3 w=0.84 l=0.15 nf=1
X925 VN BIT eeg_sdm1ct_0/eeg_tg_lowq_1/A VSS sky130_fd_pr__nfet_01v8 ad=0.5544 pd=3 as=0.5544 ps=3 w=0.84 l=0.15 nf=1
X926 VDD18 eeg_sdm1ct_0/eeg_nand2_1/A BIT VDD18 sky130_fd_pr__pfet_01v8 ad=2.04 pd=6.04 as=2.04 ps=6.04 w=2 l=0.15 nf=1
X927 eeg_sdm1ct_0/eeg_nand2_1/m1_302_66# eeg_sdm1ct_0/eeg_nand2_1/A BIT VSS sky130_fd_pr__nfet_01v8 ad=1.02 pd=4.04 as=1.02 ps=4.04 w=1 l=0.15 nf=1
X928 VDD18 NBIT BIT VDD18 sky130_fd_pr__pfet_01v8 ad=2.04 pd=6.04 as=2.04 ps=6.04 w=2 l=0.15 nf=1
X929 VSS NBIT eeg_sdm1ct_0/eeg_nand2_1/m1_302_66# VSS sky130_fd_pr__nfet_01v8 ad=1.02 pd=4.04 as=1.02 ps=4.04 w=1 l=0.15 nf=1
X930 VN eeg_sdm1ct_0/eeg_inv_0/Y VN VDD18 sky130_fd_pr__pfet_01v8 ad=0.5544 pd=3 as=0.5544 ps=3 w=0.84 l=0.15 nf=1
X931 eeg_sdm1ct_0/eeg_tg_lowq_3/A BIT eeg_sdm1ct_0/eeg_tg_lowq_3/A VSS sky130_fd_pr__nfet_01v8 ad=0.126 pd=1.44 as=0.126 ps=1.44 w=0.42 l=0.15 nf=1
X932 VN BIT VN VSS sky130_fd_pr__nfet_01v8 ad=0.126 pd=1.44 as=0.126 ps=1.44 w=0.42 l=0.15 nf=1
X933 VN BIT eeg_sdm1ct_0/eeg_tg_lowq_3/A VDD18 sky130_fd_pr__pfet_01v8 ad=1.7136 pd=5.4 as=1.7136 ps=5.4 w=1.68 l=0.15 nf=1
X934 eeg_sdm1ct_0/eeg_tg_lowq_3/A eeg_sdm1ct_0/eeg_inv_0/Y eeg_sdm1ct_0/eeg_tg_lowq_3/A VDD18 sky130_fd_pr__pfet_01v8 ad=0.5544 pd=3 as=0.5544 ps=3 w=0.84 l=0.15 nf=1
X935 VN eeg_sdm1ct_0/eeg_inv_0/Y eeg_sdm1ct_0/eeg_tg_lowq_3/A VSS sky130_fd_pr__nfet_01v8 ad=0.5544 pd=3 as=0.5544 ps=3 w=0.84 l=0.15 nf=1
X936 VP BIT VP VDD18 sky130_fd_pr__pfet_01v8 ad=0.5544 pd=3 as=0.5544 ps=3 w=0.84 l=0.15 nf=1
X937 eeg_sdm1ct_0/eeg_tg_lowq_3/A eeg_sdm1ct_0/eeg_inv_0/Y eeg_sdm1ct_0/eeg_tg_lowq_3/A VSS sky130_fd_pr__nfet_01v8 ad=0.126 pd=1.44 as=0.126 ps=1.44 w=0.42 l=0.15 nf=1
X938 VP eeg_sdm1ct_0/eeg_inv_0/Y VP VSS sky130_fd_pr__nfet_01v8 ad=0.126 pd=1.44 as=0.126 ps=1.44 w=0.42 l=0.15 nf=1
X939 VP eeg_sdm1ct_0/eeg_inv_0/Y eeg_sdm1ct_0/eeg_tg_lowq_3/A VDD18 sky130_fd_pr__pfet_01v8 ad=1.7136 pd=5.4 as=1.7136 ps=5.4 w=1.68 l=0.15 nf=1
X940 eeg_sdm1ct_0/eeg_tg_lowq_3/A BIT eeg_sdm1ct_0/eeg_tg_lowq_3/A VDD18 sky130_fd_pr__pfet_01v8 ad=0.5544 pd=3 as=0.5544 ps=3 w=0.84 l=0.15 nf=1
X941 VP BIT eeg_sdm1ct_0/eeg_tg_lowq_3/A VSS sky130_fd_pr__nfet_01v8 ad=0.5544 pd=3 as=0.5544 ps=3 w=0.84 l=0.15 nf=1
X942 VDD18 eeg_sdm1ct_0/eeg_fd_ota_full2_nc_0/eeg_bias_gen_0/VBP eeg_sdm1ct_0/eeg_fd_ota_full2_nc_0/eeg_bias_gen_0/VBN VDD18 sky130_fd_pr__pfet_01v8 ad=5.1 pd=12.04 as=1.25 ps=5.5 w=5 l=4 nf=1
X943 eeg_sdm1ct_0/eeg_fd_ota_full2_nc_0/eeg_bias_gen_0/VBN eeg_sdm1ct_0/eeg_fd_ota_full2_nc_0/eeg_bias_gen_0/VBP VDD18 VDD18 sky130_fd_pr__pfet_01v8 ad=1.25 pd=5.5 as=5.1 ps=12.04 w=5 l=4 nf=1
R944 eeg_sdm1ct_0/eeg_fd_ota_full2_nc_0/eeg_bias_gen_0/m1_6341_n27552# eeg_sdm1ct_0/eeg_fd_ota_full2_nc_0/eeg_bias_gen_0/m1_6741_n20245# 100000
X945 eeg_sdm1ct_0/eeg_fd_ota_full2_nc_0/eeg_bias_gen_0/VBN eeg_sdm1ct_0/eeg_fd_ota_full2_nc_0/eeg_bias_gen_0/eeg_pseudo_res_0/m1_68_66# eeg_sdm1ct_0/eeg_fd_ota_full2_nc_0/eeg_bias_gen_0/eeg_pseudo_res_0/m1_68_66# eeg_sdm1ct_0/eeg_fd_ota_full2_nc_0/eeg_bias_gen_0/VBN sky130_fd_pr__pfet_01v8 ad=1.02 pd=4.04 as=1.02 ps=4.04 w=1 l=4 nf=1
X946 VDD18 eeg_sdm1ct_0/eeg_fd_ota_full2_nc_0/eeg_bias_gen_0/eeg_pseudo_res_0/m1_68_66# eeg_sdm1ct_0/eeg_fd_ota_full2_nc_0/eeg_bias_gen_0/eeg_pseudo_res_0/m1_68_66# VDD18 sky130_fd_pr__pfet_01v8 ad=1.02 pd=4.04 as=1.02 ps=4.04 w=1 l=4 nf=1
R947 eeg_sdm1ct_0/eeg_fd_ota_full2_nc_0/eeg_bias_gen_0/m1_10859_n29089# eeg_sdm1ct_0/eeg_fd_ota_full2_nc_0/eeg_bias_gen_0/m1_10459_n36396# 100000
X948 eeg_sdm1ct_0/eeg_fd_ota_full2_nc_0/eeg_bias_gen_0/VBN eeg_sdm1ct_0/eeg_fd_ota_full2_nc_0/eeg_bias_gen_0/VBN VSS VSS sky130_fd_pr__nfet_01v8 ad=1.25 pd=5.5 as=5.1 ps=12.04 w=5 l=4 nf=1
X949 VSS eeg_sdm1ct_0/eeg_fd_ota_full2_nc_0/eeg_bias_gen_0/VBN eeg_sdm1ct_0/eeg_fd_ota_full2_nc_0/eeg_bias_gen_0/VBN VSS sky130_fd_pr__nfet_01v8 ad=5.1 pd=12.04 as=1.25 ps=5.5 w=5 l=4 nf=1
R950 eeg_sdm1ct_0/eeg_fd_ota_full2_nc_0/eeg_bias_gen_0/m1_5941_n20245# eeg_sdm1ct_0/eeg_fd_ota_full2_nc_0/eeg_bias_gen_0/m1_6341_n27552# 100000
R951 eeg_sdm1ct_0/eeg_fd_ota_full2_nc_0/eeg_bias_gen_0/m1_10341_n27552# eeg_sdm1ct_0/eeg_fd_ota_full2_nc_0/eeg_bias_gen_0/m1_10741_n20245# 100000
R952 eeg_sdm1ct_0/eeg_fd_ota_full2_nc_0/eeg_bias_gen_0/m1_2524_466# VSS 24985.5
R953 eeg_sdm1ct_0/eeg_fd_ota_full2_nc_0/eeg_bias_gen_0/m1_11259_n36396# eeg_sdm1ct_0/eeg_fd_ota_full2_nc_0/eeg_bias_gen_0/m1_10859_n29089# 100000
R954 eeg_sdm1ct_0/eeg_fd_ota_full2_nc_0/eeg_bias_gen_0/m1_11141_n9864# eeg_sdm1ct_0/eeg_fd_ota_full2_nc_0/eeg_bias_gen_0/VBNF 100000
R955 eeg_sdm1ct_0/eeg_fd_ota_full2_nc_0/eeg_bias_gen_0/m1_11541_n37933# eeg_sdm1ct_0/eeg_fd_ota_full2_nc_0/eeg_bias_gen_0/m1_11259_n36396# 100000
R956 eeg_sdm1ct_0/eeg_fd_ota_full2_nc_0/eeg_bias_gen_0/m1_5541_n27552# eeg_sdm1ct_0/eeg_fd_ota_full2_nc_0/eeg_bias_gen_0/m1_5941_n20245# 100000
R957 eeg_sdm1ct_0/eeg_fd_ota_full2_nc_0/eeg_bias_gen_0/m1_9941_n20245# eeg_sdm1ct_0/eeg_fd_ota_full2_nc_0/eeg_bias_gen_0/m1_10341_n27552# 100000
R958 eeg_sdm1ct_0/eeg_fd_ota_full2_nc_0/eeg_bias_gen_0/m1_10741_n2557# eeg_sdm1ct_0/eeg_fd_ota_full2_nc_0/eeg_bias_gen_0/m1_11141_n9864# 100000
R959 eeg_sdm1ct_0/eeg_fd_ota_full2_nc_0/eeg_bias_gen_0/m1_5141_n20245# eeg_sdm1ct_0/eeg_fd_ota_full2_nc_0/eeg_bias_gen_0/m1_5541_n27552# 100000
R960 eeg_sdm1ct_0/eeg_fd_ota_full2_nc_0/eeg_bias_gen_0/m1_9541_n27552# eeg_sdm1ct_0/eeg_fd_ota_full2_nc_0/eeg_bias_gen_0/m1_9941_n20245# 100000
R961 eeg_sdm1ct_0/eeg_fd_ota_full2_nc_0/eeg_bias_gen_0/m1_5259_n11401# eeg_sdm1ct_0/eeg_fd_ota_full2_nc_0/eeg_bias_gen_0/m1_4859_n18708# 100000
R962 eeg_sdm1ct_0/eeg_fd_ota_full2_nc_0/eeg_bias_gen_0/m1_11141_n45240# eeg_sdm1ct_0/eeg_fd_ota_full2_nc_0/eeg_bias_gen_0/m1_11541_n37933# 100000
R963 eeg_sdm1ct_0/eeg_fd_ota_full2_nc_0/eeg_bias_gen_0/m1_10341_n9864# eeg_sdm1ct_0/eeg_fd_ota_full2_nc_0/eeg_bias_gen_0/m1_10741_n2557# 100000
R964 eeg_sdm1ct_0/eeg_fd_ota_full2_nc_0/eeg_bias_gen_0/m1_4741_n27552# eeg_sdm1ct_0/eeg_fd_ota_full2_nc_0/eeg_bias_gen_0/m1_5141_n20245# 100000
R965 eeg_sdm1ct_0/eeg_fd_ota_full2_nc_0/eeg_bias_gen_0/m1_9141_n20245# eeg_sdm1ct_0/eeg_fd_ota_full2_nc_0/eeg_bias_gen_0/m1_9541_n27552# 100000
R966 eeg_sdm1ct_0/eeg_fd_ota_full2_nc_0/eeg_bias_gen_0/m1_5659_n18708# eeg_sdm1ct_0/eeg_fd_ota_full2_nc_0/eeg_bias_gen_0/m1_5259_n11401# 100000
R967 eeg_sdm1ct_0/eeg_fd_ota_full2_nc_0/eeg_bias_gen_0/m1_5941_n2557# eeg_sdm1ct_0/eeg_fd_ota_full2_nc_0/eeg_bias_gen_0/m1_6341_n9864# 100000
R968 eeg_sdm1ct_0/eeg_fd_ota_full2_nc_0/eeg_bias_gen_0/m1_10741_n37933# eeg_sdm1ct_0/eeg_fd_ota_full2_nc_0/eeg_bias_gen_0/m1_11141_n45240# 100000
R969 eeg_sdm1ct_0/eeg_fd_ota_full2_nc_0/eeg_bias_gen_0/m1_4341_n20245# eeg_sdm1ct_0/eeg_fd_ota_full2_nc_0/eeg_bias_gen_0/m1_4741_n27552# 100000
R970 eeg_sdm1ct_0/eeg_fd_ota_full2_nc_0/eeg_bias_gen_0/m1_8741_n27552# eeg_sdm1ct_0/eeg_fd_ota_full2_nc_0/eeg_bias_gen_0/m1_9141_n20245# 100000
R971 eeg_sdm1ct_0/eeg_fd_ota_full2_nc_0/eeg_bias_gen_0/m1_6059_n11401# eeg_sdm1ct_0/eeg_fd_ota_full2_nc_0/eeg_bias_gen_0/m1_5659_n18708# 100000
R972 eeg_sdm1ct_0/eeg_fd_ota_full2_nc_0/eeg_bias_gen_0/m1_10059_n11401# eeg_sdm1ct_0/eeg_fd_ota_full2_nc_0/eeg_bias_gen_0/m1_9659_n18708# 100000
R973 eeg_sdm1ct_0/eeg_fd_ota_full2_nc_0/eeg_bias_gen_0/m1_10859_n11401# eeg_sdm1ct_0/eeg_fd_ota_full2_nc_0/eeg_bias_gen_0/m1_10459_n18708# 100000
R974 eeg_sdm1ct_0/eeg_fd_ota_full2_nc_0/eeg_bias_gen_0/m1_5541_n9864# eeg_sdm1ct_0/eeg_fd_ota_full2_nc_0/eeg_bias_gen_0/m1_5941_n2557# 100000
R975 eeg_sdm1ct_0/eeg_fd_ota_full2_nc_0/eeg_bias_gen_0/m1_10341_n45240# eeg_sdm1ct_0/eeg_fd_ota_full2_nc_0/eeg_bias_gen_0/m1_10741_n37933# 100000
X976 VDD18 eeg_sdm1ct_0/eeg_fd_ota_full2_nc_0/eeg_bias_gen_0/VBP eeg_sdm1ct_0/eeg_fd_ota_full2_nc_0/eeg_bias_gen_0/VBP VDD18 sky130_fd_pr__pfet_01v8 ad=5.1 pd=12.04 as=1.25 ps=5.5 w=5 l=4 nf=1
X977 eeg_sdm1ct_0/eeg_fd_ota_full2_nc_0/eeg_bias_gen_0/VBP eeg_sdm1ct_0/eeg_fd_ota_full2_nc_0/eeg_bias_gen_0/VBP VDD18 VDD18 sky130_fd_pr__pfet_01v8 ad=1.25 pd=5.5 as=5.1 ps=12.04 w=5 l=4 nf=1
R978 eeg_sdm1ct_0/eeg_fd_ota_full2_nc_0/eeg_bias_gen_0/m1_5941_n37933# eeg_sdm1ct_0/eeg_fd_ota_full2_nc_0/eeg_bias_gen_0/m1_6341_n45240# 100000
R979 eeg_sdm1ct_0/eeg_fd_ota_full2_nc_0/eeg_bias_gen_0/m1_3941_n27552# eeg_sdm1ct_0/eeg_fd_ota_full2_nc_0/eeg_bias_gen_0/m1_4341_n20245# 100000
R980 eeg_sdm1ct_0/eeg_fd_ota_full2_nc_0/eeg_bias_gen_0/m1_8341_n20245# eeg_sdm1ct_0/eeg_fd_ota_full2_nc_0/eeg_bias_gen_0/m1_8741_n27552# 100000
R981 eeg_sdm1ct_0/eeg_fd_ota_full2_nc_0/eeg_bias_gen_0/m1_6459_n18708# eeg_sdm1ct_0/eeg_fd_ota_full2_nc_0/eeg_bias_gen_0/m1_6059_n11401# 100000
R982 eeg_sdm1ct_0/eeg_fd_ota_full2_nc_0/eeg_bias_gen_0/m1_11259_n18708# eeg_sdm1ct_0/eeg_fd_ota_full2_nc_0/eeg_bias_gen_0/m1_10859_n11401# 100000
R983 eeg_sdm1ct_0/eeg_fd_ota_full2_nc_0/eeg_bias_gen_0/m1_5141_n2557# eeg_sdm1ct_0/eeg_fd_ota_full2_nc_0/eeg_bias_gen_0/m1_5541_n9864# 100000
R984 eeg_sdm1ct_0/eeg_fd_ota_full2_nc_0/eeg_bias_gen_0/m1_9541_n9864# eeg_sdm1ct_0/eeg_fd_ota_full2_nc_0/eeg_bias_gen_0/m1_9941_n2557# 100000
R985 eeg_sdm1ct_0/eeg_fd_ota_full2_nc_0/eeg_bias_gen_0/m1_5259_n29089# eeg_sdm1ct_0/eeg_fd_ota_full2_nc_0/eeg_bias_gen_0/m1_4859_n36396# 100000
R986 eeg_sdm1ct_0/eeg_fd_ota_full2_nc_0/eeg_bias_gen_0/VBN eeg_sdm1ct_0/eeg_fd_ota_full2_nc_0/eeg_bias_gen_0/m1_3941_n45240# 100000
R987 eeg_sdm1ct_0/eeg_fd_ota_full2_nc_0/eeg_bias_gen_0/m1_5541_n45240# eeg_sdm1ct_0/eeg_fd_ota_full2_nc_0/eeg_bias_gen_0/m1_5941_n37933# 100000
R988 eeg_sdm1ct_0/eeg_fd_ota_full2_nc_0/eeg_bias_gen_0/m1_3701_n29089# eeg_sdm1ct_0/eeg_fd_ota_full2_nc_0/eeg_bias_gen_0/m1_3941_n27552# 100000
R989 eeg_sdm1ct_0/eeg_fd_ota_full2_nc_0/eeg_bias_gen_0/m1_7941_n27552# eeg_sdm1ct_0/eeg_fd_ota_full2_nc_0/eeg_bias_gen_0/m1_8341_n20245# 100000
R990 eeg_sdm1ct_0/eeg_fd_ota_full2_nc_0/eeg_bias_gen_0/m1_6859_n11401# eeg_sdm1ct_0/eeg_fd_ota_full2_nc_0/eeg_bias_gen_0/m1_6459_n18708# 100000
R991 eeg_sdm1ct_0/eeg_fd_ota_full2_nc_0/eeg_bias_gen_0/m1_11541_n20245# eeg_sdm1ct_0/eeg_fd_ota_full2_nc_0/eeg_bias_gen_0/m1_11259_n18708# 100000
R992 eeg_sdm1ct_0/eeg_fd_ota_full2_nc_0/eeg_bias_gen_0/m1_4741_n9864# eeg_sdm1ct_0/eeg_fd_ota_full2_nc_0/eeg_bias_gen_0/m1_5141_n2557# 100000
R993 eeg_sdm1ct_0/eeg_fd_ota_full2_nc_0/eeg_bias_gen_0/m1_9141_n2557# eeg_sdm1ct_0/eeg_fd_ota_full2_nc_0/eeg_bias_gen_0/m1_9541_n9864# 100000
R994 eeg_sdm1ct_0/eeg_fd_ota_full2_nc_0/eeg_bias_gen_0/m1_5659_n36396# eeg_sdm1ct_0/eeg_fd_ota_full2_nc_0/eeg_bias_gen_0/m1_5259_n29089# 100000
R995 eeg_sdm1ct_0/eeg_fd_ota_full2_nc_0/eeg_bias_gen_0/m1_9941_n2557# eeg_sdm1ct_0/eeg_fd_ota_full2_nc_0/eeg_bias_gen_0/m1_10341_n9864# 100000
R996 eeg_sdm1ct_0/eeg_fd_ota_full2_nc_0/eeg_bias_gen_0/m1_5141_n37933# eeg_sdm1ct_0/eeg_fd_ota_full2_nc_0/eeg_bias_gen_0/m1_5541_n45240# 100000
R997 eeg_sdm1ct_0/eeg_fd_ota_full2_nc_0/eeg_bias_gen_0/m1_9541_n45240# eeg_sdm1ct_0/eeg_fd_ota_full2_nc_0/eeg_bias_gen_0/m1_9941_n37933# 100000
R998 eeg_sdm1ct_0/eeg_fd_ota_full2_nc_0/eeg_bias_gen_0/m1_6859_n29089# eeg_sdm1ct_0/eeg_fd_ota_full2_nc_0/eeg_bias_gen_0/m1_6459_n36396# 100000
R999 eeg_sdm1ct_0/eeg_fd_ota_full2_nc_0/eeg_bias_gen_0/m1_10459_n36396# eeg_sdm1ct_0/eeg_fd_ota_full2_nc_0/eeg_bias_gen_0/m1_10059_n29089# 100000
R1000 eeg_sdm1ct_0/eeg_fd_ota_full2_nc_0/eeg_bias_gen_0/m1_7541_n20245# eeg_sdm1ct_0/eeg_fd_ota_full2_nc_0/eeg_bias_gen_0/m1_7941_n27552# 100000
R1001 eeg_sdm1ct_0/eeg_fd_ota_full2_nc_0/eeg_bias_gen_0/m1_7259_n18708# eeg_sdm1ct_0/eeg_fd_ota_full2_nc_0/eeg_bias_gen_0/m1_6859_n11401# 100000
R1002 eeg_sdm1ct_0/eeg_fd_ota_full2_nc_0/eeg_bias_gen_0/m1_4341_n2557# eeg_sdm1ct_0/eeg_fd_ota_full2_nc_0/eeg_bias_gen_0/m1_4741_n9864# 100000
R1003 eeg_sdm1ct_0/eeg_fd_ota_full2_nc_0/eeg_bias_gen_0/m1_8741_n9864# eeg_sdm1ct_0/eeg_fd_ota_full2_nc_0/eeg_bias_gen_0/m1_9141_n2557# 100000
R1004 eeg_sdm1ct_0/eeg_fd_ota_full2_nc_0/eeg_bias_gen_0/m1_6059_n29089# eeg_sdm1ct_0/eeg_fd_ota_full2_nc_0/eeg_bias_gen_0/m1_5659_n36396# 100000
R1005 eeg_sdm1ct_0/eeg_fd_ota_full2_nc_0/eeg_bias_gen_0/m1_4741_n45240# eeg_sdm1ct_0/eeg_fd_ota_full2_nc_0/eeg_bias_gen_0/m1_5141_n37933# 100000
R1006 eeg_sdm1ct_0/eeg_fd_ota_full2_nc_0/eeg_bias_gen_0/m1_9141_n37933# eeg_sdm1ct_0/eeg_fd_ota_full2_nc_0/eeg_bias_gen_0/m1_9541_n45240# 100000
R1007 eeg_sdm1ct_0/eeg_fd_ota_full2_nc_0/eeg_bias_gen_0/m1_9941_n37933# eeg_sdm1ct_0/eeg_fd_ota_full2_nc_0/eeg_bias_gen_0/m1_10341_n45240# 100000
R1008 eeg_sdm1ct_0/eeg_fd_ota_full2_nc_0/eeg_bias_gen_0/m1_7259_n36396# eeg_sdm1ct_0/eeg_fd_ota_full2_nc_0/eeg_bias_gen_0/m1_6859_n29089# 100000
R1009 eeg_sdm1ct_0/eeg_fd_ota_full2_nc_0/eeg_bias_gen_0/m1_7141_n27552# eeg_sdm1ct_0/eeg_fd_ota_full2_nc_0/eeg_bias_gen_0/m1_7541_n20245# 100000
R1010 eeg_sdm1ct_0/eeg_fd_ota_full2_nc_0/eeg_bias_gen_0/m1_7659_n11401# eeg_sdm1ct_0/eeg_fd_ota_full2_nc_0/eeg_bias_gen_0/m1_7259_n18708# 100000
R1011 eeg_sdm1ct_0/eeg_fd_ota_full2_nc_0/eeg_bias_gen_0/m1_10459_n18708# eeg_sdm1ct_0/eeg_fd_ota_full2_nc_0/eeg_bias_gen_0/m1_10059_n11401# 100000
R1012 eeg_sdm1ct_0/eeg_fd_ota_full2_nc_0/eeg_bias_gen_0/m1_3941_n9864# eeg_sdm1ct_0/eeg_fd_ota_full2_nc_0/eeg_bias_gen_0/m1_4341_n2557# 100000
R1013 eeg_sdm1ct_0/eeg_fd_ota_full2_nc_0/eeg_bias_gen_0/m1_8341_n2557# eeg_sdm1ct_0/eeg_fd_ota_full2_nc_0/eeg_bias_gen_0/m1_8741_n9864# 100000
R1014 eeg_sdm1ct_0/eeg_fd_ota_full2_nc_0/eeg_bias_gen_0/m1_6459_n36396# eeg_sdm1ct_0/eeg_fd_ota_full2_nc_0/eeg_bias_gen_0/m1_6059_n29089# 100000
R1015 eeg_sdm1ct_0/eeg_fd_ota_full2_nc_0/eeg_bias_gen_0/m1_4341_n37933# eeg_sdm1ct_0/eeg_fd_ota_full2_nc_0/eeg_bias_gen_0/m1_4741_n45240# 100000
R1016 eeg_sdm1ct_0/eeg_fd_ota_full2_nc_0/eeg_bias_gen_0/m1_8741_n45240# eeg_sdm1ct_0/eeg_fd_ota_full2_nc_0/eeg_bias_gen_0/m1_9141_n37933# 100000
R1017 eeg_sdm1ct_0/eeg_fd_ota_full2_nc_0/eeg_bias_gen_0/m1_7659_n29089# eeg_sdm1ct_0/eeg_fd_ota_full2_nc_0/eeg_bias_gen_0/m1_7259_n36396# 100000
R1018 eeg_sdm1ct_0/eeg_fd_ota_full2_nc_0/eeg_bias_gen_0/m1_6741_n20245# eeg_sdm1ct_0/eeg_fd_ota_full2_nc_0/eeg_bias_gen_0/m1_7141_n27552# 100000
R1019 eeg_sdm1ct_0/eeg_fd_ota_full2_nc_0/eeg_bias_gen_0/m1_11141_n27552# eeg_sdm1ct_0/eeg_fd_ota_full2_nc_0/eeg_bias_gen_0/m1_11541_n20245# 100000
R1020 eeg_sdm1ct_0/eeg_fd_ota_full2_nc_0/eeg_bias_gen_0/m1_8059_n18708# eeg_sdm1ct_0/eeg_fd_ota_full2_nc_0/eeg_bias_gen_0/m1_7659_n11401# 100000
R1021 eeg_sdm1ct_0/eeg_fd_ota_full2_nc_0/eeg_bias_gen_0/m1_3701_n11401# eeg_sdm1ct_0/eeg_fd_ota_full2_nc_0/eeg_bias_gen_0/m1_3941_n9864# 100000
R1022 eeg_sdm1ct_0/eeg_fd_ota_full2_nc_0/eeg_bias_gen_0/m1_7941_n9864# eeg_sdm1ct_0/eeg_fd_ota_full2_nc_0/eeg_bias_gen_0/m1_8341_n2557# 100000
R1023 eeg_sdm1ct_0/eeg_fd_ota_full2_nc_0/eeg_bias_gen_0/m1_8341_n37933# eeg_sdm1ct_0/eeg_fd_ota_full2_nc_0/eeg_bias_gen_0/m1_8741_n45240# 100000
R1024 eeg_sdm1ct_0/eeg_fd_ota_full2_nc_0/eeg_bias_gen_0/m1_4059_n36396# eeg_sdm1ct_0/eeg_fd_ota_full2_nc_0/eeg_bias_gen_0/m1_3701_n29089# 100000
R1025 eeg_sdm1ct_0/eeg_fd_ota_full2_nc_0/eeg_bias_gen_0/m1_8059_n36396# eeg_sdm1ct_0/eeg_fd_ota_full2_nc_0/eeg_bias_gen_0/m1_7659_n29089# 100000
R1026 eeg_sdm1ct_0/eeg_fd_ota_full2_nc_0/eeg_bias_gen_0/m1_10741_n20245# eeg_sdm1ct_0/eeg_fd_ota_full2_nc_0/eeg_bias_gen_0/m1_11141_n27552# 100000
R1027 eeg_sdm1ct_0/eeg_fd_ota_full2_nc_0/eeg_bias_gen_0/m1_4059_n18708# eeg_sdm1ct_0/eeg_fd_ota_full2_nc_0/eeg_bias_gen_0/m1_3701_n11401# 100000
R1028 eeg_sdm1ct_0/eeg_fd_ota_full2_nc_0/eeg_bias_gen_0/m1_8459_n11401# eeg_sdm1ct_0/eeg_fd_ota_full2_nc_0/eeg_bias_gen_0/m1_8059_n18708# 100000
R1029 eeg_sdm1ct_0/eeg_fd_ota_full2_nc_0/eeg_bias_gen_0/m1_7541_n2557# eeg_sdm1ct_0/eeg_fd_ota_full2_nc_0/eeg_bias_gen_0/m1_7941_n9864# 100000
R1030 eeg_sdm1ct_0/eeg_fd_ota_full2_nc_0/eeg_bias_gen_0/m1_7941_n45240# eeg_sdm1ct_0/eeg_fd_ota_full2_nc_0/eeg_bias_gen_0/m1_8341_n37933# 100000
R1031 eeg_sdm1ct_0/eeg_fd_ota_full2_nc_0/eeg_bias_gen_0/m1_4459_n29089# eeg_sdm1ct_0/eeg_fd_ota_full2_nc_0/eeg_bias_gen_0/m1_4059_n36396# 100000
R1032 eeg_sdm1ct_0/eeg_fd_ota_full2_nc_0/eeg_bias_gen_0/m1_8459_n29089# eeg_sdm1ct_0/eeg_fd_ota_full2_nc_0/eeg_bias_gen_0/m1_8059_n36396# 100000
R1033 eeg_sdm1ct_0/eeg_fd_ota_full2_nc_0/eeg_bias_gen_0/m1_4459_n11401# eeg_sdm1ct_0/eeg_fd_ota_full2_nc_0/eeg_bias_gen_0/m1_4059_n18708# 100000
R1034 eeg_sdm1ct_0/eeg_fd_ota_full2_nc_0/eeg_bias_gen_0/m1_8859_n18708# eeg_sdm1ct_0/eeg_fd_ota_full2_nc_0/eeg_bias_gen_0/m1_8459_n11401# 100000
R1035 eeg_sdm1ct_0/eeg_fd_ota_full2_nc_0/eeg_bias_gen_0/m1_7141_n9864# eeg_sdm1ct_0/eeg_fd_ota_full2_nc_0/eeg_bias_gen_0/m1_7541_n2557# 100000
R1036 eeg_sdm1ct_0/eeg_fd_ota_full2_nc_0/eeg_bias_gen_0/m1_7541_n37933# eeg_sdm1ct_0/eeg_fd_ota_full2_nc_0/eeg_bias_gen_0/m1_7941_n45240# 100000
R1037 eeg_sdm1ct_0/eeg_fd_ota_full2_nc_0/eeg_bias_gen_0/m1_4859_n36396# eeg_sdm1ct_0/eeg_fd_ota_full2_nc_0/eeg_bias_gen_0/m1_4459_n29089# 100000
R1038 eeg_sdm1ct_0/eeg_fd_ota_full2_nc_0/eeg_bias_gen_0/m1_8859_n36396# eeg_sdm1ct_0/eeg_fd_ota_full2_nc_0/eeg_bias_gen_0/m1_8459_n29089# 100000
R1039 eeg_sdm1ct_0/eeg_fd_ota_full2_nc_0/eeg_bias_gen_0/m1_4859_n18708# eeg_sdm1ct_0/eeg_fd_ota_full2_nc_0/eeg_bias_gen_0/m1_4459_n11401# 100000
R1040 eeg_sdm1ct_0/eeg_fd_ota_full2_nc_0/eeg_bias_gen_0/m1_6741_n2557# eeg_sdm1ct_0/eeg_fd_ota_full2_nc_0/eeg_bias_gen_0/m1_7141_n9864# 100000
R1041 eeg_sdm1ct_0/eeg_fd_ota_full2_nc_0/eeg_bias_gen_0/m1_7141_n45240# eeg_sdm1ct_0/eeg_fd_ota_full2_nc_0/eeg_bias_gen_0/m1_7541_n37933# 100000
R1042 eeg_sdm1ct_0/eeg_fd_ota_full2_nc_0/eeg_bias_gen_0/m1_9259_n29089# eeg_sdm1ct_0/eeg_fd_ota_full2_nc_0/eeg_bias_gen_0/m1_8859_n36396# 100000
R1043 eeg_sdm1ct_0/eeg_fd_ota_full2_nc_0/eeg_bias_gen_0/m1_9259_n11401# eeg_sdm1ct_0/eeg_fd_ota_full2_nc_0/eeg_bias_gen_0/m1_8859_n18708# 100000
R1044 eeg_sdm1ct_0/eeg_fd_ota_full2_nc_0/eeg_bias_gen_0/m1_6341_n9864# eeg_sdm1ct_0/eeg_fd_ota_full2_nc_0/eeg_bias_gen_0/m1_6741_n2557# 100000
R1045 eeg_sdm1ct_0/eeg_fd_ota_full2_nc_0/eeg_bias_gen_0/m1_6741_n37933# eeg_sdm1ct_0/eeg_fd_ota_full2_nc_0/eeg_bias_gen_0/m1_7141_n45240# 100000
R1046 eeg_sdm1ct_0/eeg_fd_ota_full2_nc_0/eeg_bias_gen_0/m1_9659_n36396# eeg_sdm1ct_0/eeg_fd_ota_full2_nc_0/eeg_bias_gen_0/m1_9259_n29089# 100000
R1047 eeg_sdm1ct_0/eeg_fd_ota_full2_nc_0/eeg_bias_gen_0/m1_9659_n18708# eeg_sdm1ct_0/eeg_fd_ota_full2_nc_0/eeg_bias_gen_0/m1_9259_n11401# 100000
R1048 eeg_sdm1ct_0/eeg_fd_ota_full2_nc_0/eeg_bias_gen_0/m1_6341_n45240# eeg_sdm1ct_0/eeg_fd_ota_full2_nc_0/eeg_bias_gen_0/m1_6741_n37933# 100000
R1049 eeg_sdm1ct_0/eeg_fd_ota_full2_nc_0/eeg_bias_gen_0/m1_10059_n29089# eeg_sdm1ct_0/eeg_fd_ota_full2_nc_0/eeg_bias_gen_0/m1_9659_n36396# 100000
R1050 eeg_sdm1ct_0/eeg_fd_ota_full2_nc_0/eeg_bias_gen_0/m1_3941_n45240# eeg_sdm1ct_0/eeg_fd_ota_full2_nc_0/eeg_bias_gen_0/m1_4341_n37933# 100000
X1051 eeg_sdm1ct_0/eeg_fd_ota_full2_nc_0/eeg_bias_gen_0/VBP eeg_sdm1ct_0/eeg_fd_ota_full2_nc_0/eeg_bias_gen_0/VBN eeg_sdm1ct_0/eeg_fd_ota_full2_nc_0/eeg_bias_gen_0/m1_2524_466# VSS sky130_fd_pr__nfet_01v8 ad=5 pd=22 as=8.85 ps=28.54 w=20 l=4 nf=4
X1054 eeg_sdm1ct_0/eeg_fd_ota_full2_nc_0/eeg_bias_gen_0/m1_2524_466# eeg_sdm1ct_0/eeg_fd_ota_full2_nc_0/eeg_bias_gen_0/VBN eeg_sdm1ct_0/eeg_fd_ota_full2_nc_0/eeg_bias_gen_0/VBP VSS sky130_fd_pr__nfet_01v8 ad=8.85 pd=28.54 as=5 ps=22 w=20 l=4 nf=4
CMIM1059 eeg_sdm1ct_0/eeg_fd_ota_full2_nc_0/eeg_bias_gen_0/VBNF VSS 1.000000e-10
X1184 eeg_sdm1ct_0/eeg_fd_ota_full2_nc_0/eeg_cmfb_amp_dl2_s2_0/m1_370_1493# eeg_sdm1ct_0/eeg_fd_ota_full2_nc_0/eeg_cmfb_amp_dl2_s2_0/m1_370_1493# VDD18 VDD18 sky130_fd_pr__pfet_01v8 ad=2.04 pd=6.04 as=2.04 ps=6.04 w=2 l=2 nf=1
X1185 eeg_sdm1ct_0/eeg_fd_ota_full2_nc_0/eeg_cmfb_amp_dl2_s2_0/m1_370_1493# eeg_sdm1ct_0/eeg_fd_ota_full2_nc_0/stage2_0/VCM2 eeg_sdm1ct_0/eeg_fd_ota_full2_nc_0/eeg_cmfb_amp_dl2_s2_0/m1_68_166# VSS sky130_fd_pr__nfet_01v8 ad=2.04 pd=6.04 as=2.04 ps=6.04 w=2 l=2 nf=1
X1186 eeg_sdm1ct_0/eeg_fd_ota_full2_nc_0/eeg_cmfb_amp_dl2_s2_0/m1_68_166# eeg_sdm1ct_0/eeg_fd_ota_full2_nc_0/eeg_bias_gen_0/VBNF VSS VSS sky130_fd_pr__nfet_01v8 ad=1.5 pd=6.5 as=6.12 ps=14.04 w=6 l=4 nf=1
X1187 VSS eeg_sdm1ct_0/eeg_fd_ota_full2_nc_0/eeg_bias_gen_0/VBNF eeg_sdm1ct_0/eeg_fd_ota_full2_nc_0/eeg_cmfb_amp_dl2_s2_0/m1_68_166# VSS sky130_fd_pr__nfet_01v8 ad=6.12 pd=14.04 as=1.5 ps=6.5 w=6 l=4 nf=1
X1188 eeg_sdm1ct_0/eeg_fd_ota_full2_nc_0/stage2_0/VBP2 eeg_sdm1ct_0/eeg_fd_ota_full2_nc_0/stage2_0/VBP2 VDD18 VDD18 sky130_fd_pr__pfet_01v8 ad=0.15 pd=1.6 as=0.15 ps=1.6 w=0.5 l=4 nf=1
X1189 eeg_sdm1ct_0/eeg_fd_ota_full2_nc_0/stage2_0/VBP2 VCM_REF eeg_sdm1ct_0/eeg_fd_ota_full2_nc_0/eeg_cmfb_amp_dl2_s2_0/m1_68_166# VSS sky130_fd_pr__nfet_01v8 ad=2.04 pd=6.04 as=2.04 ps=6.04 w=2 l=2 nf=1
X1190 eeg_sdm1ct_0/eeg_fd_ota_full2_nc_0/eeg_cmfb_amp_dl2_0/VBP eeg_sdm1ct_0/eeg_fd_ota_full2_nc_0/eeg_cmfb_amp_dl2_0/VBP VDD18 VDD18 sky130_fd_pr__pfet_01v8 ad=4.08 pd=10.04 as=4.08 ps=10.04 w=4 l=4 nf=1
X1191 eeg_sdm1ct_0/eeg_fd_ota_full2_nc_0/eeg_cmfb_amp_dl2_0/VBP VCM_REF eeg_sdm1ct_0/eeg_fd_ota_full2_nc_0/eeg_cmfb_amp_dl2_0/m1_68_166# VSS sky130_fd_pr__nfet_01v8 ad=2.04 pd=6.04 as=2.04 ps=6.04 w=2 l=2 nf=1
X1192 eeg_sdm1ct_0/eeg_fd_ota_full2_nc_0/eeg_cmfb_amp_dl2_0/m1_68_166# eeg_sdm1ct_0/eeg_fd_ota_full2_nc_0/eeg_bias_gen_0/VBNF VSS VSS sky130_fd_pr__nfet_01v8 ad=1.5 pd=6.5 as=6.12 ps=14.04 w=6 l=4 nf=1
X1193 VSS eeg_sdm1ct_0/eeg_fd_ota_full2_nc_0/eeg_bias_gen_0/VBNF eeg_sdm1ct_0/eeg_fd_ota_full2_nc_0/eeg_cmfb_amp_dl2_0/m1_68_166# VSS sky130_fd_pr__nfet_01v8 ad=6.12 pd=14.04 as=1.5 ps=6.5 w=6 l=4 nf=1
X1194 eeg_sdm1ct_0/eeg_fd_ota_full2_nc_0/eeg_cmfb_amp_dl2_0/m1_370_1493# eeg_sdm1ct_0/eeg_fd_ota_full2_nc_0/eeg_cmfb_amp_dl2_0/m1_370_1493# VDD18 VDD18 sky130_fd_pr__pfet_01v8 ad=2.04 pd=6.04 as=2.04 ps=6.04 w=2 l=2 nf=1
X1195 eeg_sdm1ct_0/eeg_fd_ota_full2_nc_0/eeg_cmfb_amp_dl2_0/m1_370_1493# eeg_sdm1ct_0/eeg_fd_ota_full2_nc_0/eeg_cmfb_amp_dl2_0/VCM_SENSE eeg_sdm1ct_0/eeg_fd_ota_full2_nc_0/eeg_cmfb_amp_dl2_0/m1_68_166# VSS sky130_fd_pr__nfet_01v8 ad=2.04 pd=6.04 as=2.04 ps=6.04 w=2 l=2 nf=1
R1196 eeg_sdm1ct_0/eeg_fd_ota_full2_nc_0/stage2_0/m1_58341_n8557# eeg_sdm1ct_0/eeg_fd_ota_full2_nc_0/stage2_0/m1_58741_n15864# 100000
R1197 eeg_sdm1ct_0/eeg_fd_ota_full2_nc_0/stage2_0/m1_24741_n15864# eeg_sdm1ct_0/eeg_fd_ota_full2_nc_0/stage2_0/m1_25141_n8557# 100000
R1198 eeg_sdm1ct_0/eeg_fd_ota_full2_nc_0/stage2_0/m1_20341_n8557# eeg_sdm1ct_0/eeg_fd_ota_full2_nc_0/stage2_0/m1_20741_n15864# 100000
R1199 eeg_sdm1ct_0/eeg_fd_ota_full2_nc_0/stage2_0/m1_35941_n15864# eeg_sdm1ct_0/eeg_fd_ota_full2_nc_0/stage2_0/m1_36341_n8557# 100000
R1200 eeg_sdm1ct_0/eeg_fd_ota_full2_nc_0/stage2_0/m1_79941_n8557# eeg_sdm1ct_0/eeg_fd_ota_full2_nc_0/stage2_0/m1_80341_n15864# 100000
R1201 eeg_sdm1ct_0/eeg_fd_ota_full2_nc_0/stage2_0/m1_75541_n15864# eeg_sdm1ct_0/eeg_fd_ota_full2_nc_0/stage2_0/m1_75941_n8557# 100000
R1202 eeg_sdm1ct_0/eeg_fd_ota_full2_nc_0/stage2_0/m1_69141_n8557# eeg_sdm1ct_0/eeg_fd_ota_full2_nc_0/stage2_0/m1_69541_n15864# 100000
R1203 eeg_sdm1ct_0/eeg_fd_ota_full2_nc_0/stage2_0/m1_64741_n15864# eeg_sdm1ct_0/eeg_fd_ota_full2_nc_0/stage2_0/m1_65141_n8557# 100000
R1204 eeg_sdm1ct_0/eeg_fd_ota_full2_nc_0/stage2_0/m1_57941_n15864# eeg_sdm1ct_0/eeg_fd_ota_full2_nc_0/stage2_0/m1_58341_n8557# 100000
R1205 eeg_sdm1ct_0/eeg_fd_ota_full2_nc_0/stage2_0/m1_28741_n15864# eeg_sdm1ct_0/eeg_fd_ota_full2_nc_0/stage2_0/m1_29141_n8557# 100000
R1206 eeg_sdm1ct_0/eeg_fd_ota_full2_nc_0/stage2_0/m1_24341_n8557# eeg_sdm1ct_0/eeg_fd_ota_full2_nc_0/stage2_0/m1_24741_n15864# 100000
R1207 eeg_sdm1ct_0/eeg_fd_ota_full2_nc_0/stage2_0/m1_19941_n15864# eeg_sdm1ct_0/eeg_fd_ota_full2_nc_0/stage2_0/m1_20341_n8557# 100000
R1208 eeg_sdm1ct_0/eeg_fd_ota_full2_nc_0/stage2_0/m1_35541_n8557# eeg_sdm1ct_0/eeg_fd_ota_full2_nc_0/stage2_0/m1_35941_n15864# 100000
R1209 eeg_sdm1ct_0/eeg_fd_ota_full2_nc_0/stage2_0/m1_79541_n15864# eeg_sdm1ct_0/eeg_fd_ota_full2_nc_0/stage2_0/m1_79941_n8557# 100000
R1210 eeg_sdm1ct_0/eeg_fd_ota_full2_nc_0/stage2_0/m1_75141_n8557# eeg_sdm1ct_0/eeg_fd_ota_full2_nc_0/stage2_0/m1_75541_n15864# 100000
R1211 eeg_sdm1ct_0/eeg_fd_ota_full2_nc_0/stage2_0/m1_68741_n15864# eeg_sdm1ct_0/eeg_fd_ota_full2_nc_0/stage2_0/m1_69141_n8557# 100000
R1212 eeg_sdm1ct_0/eeg_fd_ota_full2_nc_0/stage2_0/m1_64341_n8557# eeg_sdm1ct_0/eeg_fd_ota_full2_nc_0/stage2_0/m1_64741_n15864# 100000
R1213 eeg_sdm1ct_0/eeg_fd_ota_full2_nc_0/stage2_0/m1_57541_n8557# eeg_sdm1ct_0/eeg_fd_ota_full2_nc_0/stage2_0/m1_57941_n15864# 100000
R1214 eeg_sdm1ct_0/eeg_fd_ota_full2_nc_0/stage2_0/m1_28341_n8557# eeg_sdm1ct_0/eeg_fd_ota_full2_nc_0/stage2_0/m1_28741_n15864# 100000
R1215 eeg_sdm1ct_0/eeg_fd_ota_full2_nc_0/stage2_0/m1_23941_n15864# eeg_sdm1ct_0/eeg_fd_ota_full2_nc_0/stage2_0/m1_24341_n8557# 100000
R1216 eeg_sdm1ct_0/OINTP eeg_sdm1ct_0/eeg_fd_ota_full2_nc_0/stage2_0/m1_19941_n15864# 100000
R1217 eeg_sdm1ct_0/eeg_fd_ota_full2_nc_0/stage2_0/m1_35141_n15864# eeg_sdm1ct_0/eeg_fd_ota_full2_nc_0/stage2_0/m1_35541_n8557# 100000
R1218 eeg_sdm1ct_0/eeg_fd_ota_full2_nc_0/stage2_0/m1_79141_n8557# eeg_sdm1ct_0/eeg_fd_ota_full2_nc_0/stage2_0/m1_79541_n15864# 100000
R1219 eeg_sdm1ct_0/eeg_fd_ota_full2_nc_0/stage2_0/m1_74741_n15864# eeg_sdm1ct_0/eeg_fd_ota_full2_nc_0/stage2_0/m1_75141_n8557# 100000
R1220 eeg_sdm1ct_0/eeg_fd_ota_full2_nc_0/stage2_0/m1_68341_n8557# eeg_sdm1ct_0/eeg_fd_ota_full2_nc_0/stage2_0/m1_68741_n15864# 100000
R1221 eeg_sdm1ct_0/eeg_fd_ota_full2_nc_0/stage2_0/m1_63941_n15864# eeg_sdm1ct_0/eeg_fd_ota_full2_nc_0/stage2_0/m1_64341_n8557# 100000
R1222 eeg_sdm1ct_0/eeg_fd_ota_full2_nc_0/stage2_0/m1_27941_n15864# eeg_sdm1ct_0/eeg_fd_ota_full2_nc_0/stage2_0/m1_28341_n8557# 100000
R1223 eeg_sdm1ct_0/eeg_fd_ota_full2_nc_0/stage2_0/m1_23541_n8557# eeg_sdm1ct_0/eeg_fd_ota_full2_nc_0/stage2_0/m1_23941_n15864# 100000
R1224 eeg_sdm1ct_0/eeg_fd_ota_full2_nc_0/stage2_0/m1_39141_n15864# eeg_sdm1ct_0/eeg_fd_ota_full2_nc_0/stage2_0/VCM2 100000
R1225 eeg_sdm1ct_0/eeg_fd_ota_full2_nc_0/stage2_0/m1_34741_n8557# eeg_sdm1ct_0/eeg_fd_ota_full2_nc_0/stage2_0/m1_35141_n15864# 100000
R1226 eeg_sdm1ct_0/eeg_fd_ota_full2_nc_0/stage2_0/m1_78741_n15864# eeg_sdm1ct_0/eeg_fd_ota_full2_nc_0/stage2_0/m1_79141_n8557# 100000
R1227 eeg_sdm1ct_0/eeg_fd_ota_full2_nc_0/stage2_0/m1_74341_n8557# eeg_sdm1ct_0/eeg_fd_ota_full2_nc_0/stage2_0/m1_74741_n15864# 100000
R1228 eeg_sdm1ct_0/eeg_fd_ota_full2_nc_0/stage2_0/m1_67941_n15864# eeg_sdm1ct_0/eeg_fd_ota_full2_nc_0/stage2_0/m1_68341_n8557# 100000
R1229 eeg_sdm1ct_0/OINTP eeg_sdm1ct_0/eeg_fd_ota_full2_nc_0/stage2_0/m1_63941_n15864# 100000
R1230 eeg_sdm1ct_0/eeg_fd_ota_full2_nc_0/stage2_0/m1_27541_n8557# eeg_sdm1ct_0/eeg_fd_ota_full2_nc_0/stage2_0/m1_27941_n15864# 100000
R1231 eeg_sdm1ct_0/eeg_fd_ota_full2_nc_0/stage2_0/m1_23141_n15864# eeg_sdm1ct_0/eeg_fd_ota_full2_nc_0/stage2_0/m1_23541_n8557# 100000
R1232 eeg_sdm1ct_0/eeg_fd_ota_full2_nc_0/stage2_0/m1_38741_n8557# eeg_sdm1ct_0/eeg_fd_ota_full2_nc_0/stage2_0/m1_39141_n15864# 100000
R1233 eeg_sdm1ct_0/eeg_fd_ota_full2_nc_0/stage2_0/m1_34341_n15864# eeg_sdm1ct_0/eeg_fd_ota_full2_nc_0/stage2_0/m1_34741_n8557# 100000
R1234 eeg_sdm1ct_0/eeg_fd_ota_full2_nc_0/stage2_0/m1_78341_n8557# eeg_sdm1ct_0/eeg_fd_ota_full2_nc_0/stage2_0/m1_78741_n15864# 100000
R1235 eeg_sdm1ct_0/eeg_fd_ota_full2_nc_0/stage2_0/m1_73941_n15864# eeg_sdm1ct_0/eeg_fd_ota_full2_nc_0/stage2_0/m1_74341_n8557# 100000
R1236 eeg_sdm1ct_0/eeg_fd_ota_full2_nc_0/stage2_0/m1_67541_n8557# eeg_sdm1ct_0/eeg_fd_ota_full2_nc_0/stage2_0/m1_67941_n15864# 100000
R1237 eeg_sdm1ct_0/eeg_fd_ota_full2_nc_0/stage2_0/m1_27141_n15864# eeg_sdm1ct_0/eeg_fd_ota_full2_nc_0/stage2_0/m1_27541_n8557# 100000
R1238 eeg_sdm1ct_0/eeg_fd_ota_full2_nc_0/stage2_0/m1_22741_n8557# eeg_sdm1ct_0/eeg_fd_ota_full2_nc_0/stage2_0/m1_23141_n15864# 100000
R1239 eeg_sdm1ct_0/eeg_fd_ota_full2_nc_0/stage2_0/m1_38341_n15864# eeg_sdm1ct_0/eeg_fd_ota_full2_nc_0/stage2_0/m1_38741_n8557# 100000
R1240 eeg_sdm1ct_0/eeg_fd_ota_full2_nc_0/stage2_0/m1_33941_n8557# eeg_sdm1ct_0/eeg_fd_ota_full2_nc_0/stage2_0/m1_34341_n15864# 100000
R1241 eeg_sdm1ct_0/eeg_fd_ota_full2_nc_0/stage2_0/m1_77941_n15864# eeg_sdm1ct_0/eeg_fd_ota_full2_nc_0/stage2_0/m1_78341_n8557# 100000
R1242 eeg_sdm1ct_0/OINTN eeg_sdm1ct_0/eeg_fd_ota_full2_nc_0/stage2_0/m1_73941_n15864# 100000
R1243 eeg_sdm1ct_0/eeg_fd_ota_full2_nc_0/stage2_0/m1_26741_n8557# eeg_sdm1ct_0/eeg_fd_ota_full2_nc_0/stage2_0/m1_27141_n15864# 100000
R1244 eeg_sdm1ct_0/eeg_fd_ota_full2_nc_0/stage2_0/m1_22341_n15864# eeg_sdm1ct_0/eeg_fd_ota_full2_nc_0/stage2_0/m1_22741_n8557# 100000
R1245 eeg_sdm1ct_0/eeg_fd_ota_full2_nc_0/stage2_0/m1_37941_n8557# eeg_sdm1ct_0/eeg_fd_ota_full2_nc_0/stage2_0/m1_38341_n15864# 100000
R1246 eeg_sdm1ct_0/eeg_fd_ota_full2_nc_0/stage2_0/m1_33541_n15864# eeg_sdm1ct_0/eeg_fd_ota_full2_nc_0/stage2_0/m1_33941_n8557# 100000
R1247 eeg_sdm1ct_0/eeg_fd_ota_full2_nc_0/stage2_0/m1_77541_n8557# eeg_sdm1ct_0/eeg_fd_ota_full2_nc_0/stage2_0/m1_77941_n15864# 100000
R1248 eeg_sdm1ct_0/eeg_fd_ota_full2_nc_0/stage2_0/m1_26341_n15864# eeg_sdm1ct_0/eeg_fd_ota_full2_nc_0/stage2_0/m1_26741_n8557# 100000
R1249 eeg_sdm1ct_0/eeg_fd_ota_full2_nc_0/stage2_0/m1_21941_n8557# eeg_sdm1ct_0/eeg_fd_ota_full2_nc_0/stage2_0/m1_22341_n15864# 100000
R1250 eeg_sdm1ct_0/eeg_fd_ota_full2_nc_0/stage2_0/m1_37541_n15864# eeg_sdm1ct_0/eeg_fd_ota_full2_nc_0/stage2_0/m1_37941_n8557# 100000
R1251 eeg_sdm1ct_0/eeg_fd_ota_full2_nc_0/stage2_0/m1_33141_n8557# eeg_sdm1ct_0/eeg_fd_ota_full2_nc_0/stage2_0/m1_33541_n15864# 100000
R1252 eeg_sdm1ct_0/eeg_fd_ota_full2_nc_0/stage2_0/m1_25941_n8557# eeg_sdm1ct_0/eeg_fd_ota_full2_nc_0/stage2_0/m1_26341_n15864# 100000
R1253 eeg_sdm1ct_0/eeg_fd_ota_full2_nc_0/stage2_0/m1_21541_n15864# eeg_sdm1ct_0/eeg_fd_ota_full2_nc_0/stage2_0/m1_21941_n8557# 100000
R1254 eeg_sdm1ct_0/eeg_fd_ota_full2_nc_0/stage2_0/m1_37141_n8557# eeg_sdm1ct_0/eeg_fd_ota_full2_nc_0/stage2_0/m1_37541_n15864# 100000
R1255 eeg_sdm1ct_0/eeg_fd_ota_full2_nc_0/stage2_0/m1_25541_n15864# eeg_sdm1ct_0/eeg_fd_ota_full2_nc_0/stage2_0/m1_25941_n8557# 100000
R1256 eeg_sdm1ct_0/eeg_fd_ota_full2_nc_0/stage2_0/m1_21141_n8557# eeg_sdm1ct_0/eeg_fd_ota_full2_nc_0/stage2_0/m1_21541_n15864# 100000
R1257 eeg_sdm1ct_0/eeg_fd_ota_full2_nc_0/stage2_0/m1_25141_n8557# eeg_sdm1ct_0/eeg_fd_ota_full2_nc_0/stage2_0/m1_25541_n15864# 100000
X1258 eeg_sdm1ct_0/OINTN eeg_sdm1ct_0/eeg_fd_ota_full2_nc_0/stage2_0/VBP2 VDD18 VDD18 sky130_fd_pr__pfet_01v8 ad=6 pd=26 as=10.62 ps=33.54 w=24 l=12 nf=4
X1259 VDD18 eeg_sdm1ct_0/eeg_fd_ota_full2_nc_0/stage2_0/VBP2 eeg_sdm1ct_0/OINTN VDD18 sky130_fd_pr__pfet_01v8 ad=10.62 pd=33.54 as=6 ps=26 w=24 l=12 nf=4
R1266 eeg_sdm1ct_0/eeg_fd_ota_full2_nc_0/stage2_0/m1_32741_n15864# eeg_sdm1ct_0/eeg_fd_ota_full2_nc_0/stage2_0/m1_33141_n8557# 100000
X1267 eeg_sdm1ct_0/OINTN eeg_sdm1ct_0/eeg_fd_ota_full2_nc_0/stage2_0/N2N VSS VSS sky130_fd_pr__nfet_01v8 ad=1.5 pd=6.5 as=6.12 ps=14.04 w=6 l=12 nf=1
X1268 VSS eeg_sdm1ct_0/eeg_fd_ota_full2_nc_0/stage2_0/N2N eeg_sdm1ct_0/OINTN VSS sky130_fd_pr__nfet_01v8 ad=6.12 pd=14.04 as=1.5 ps=6.5 w=6 l=12 nf=1
R1269 eeg_sdm1ct_0/eeg_fd_ota_full2_nc_0/stage2_0/m1_32341_n8557# eeg_sdm1ct_0/eeg_fd_ota_full2_nc_0/stage2_0/m1_32741_n15864# 100000
R1270 eeg_sdm1ct_0/eeg_fd_ota_full2_nc_0/stage2_0/m1_31941_n15864# eeg_sdm1ct_0/eeg_fd_ota_full2_nc_0/stage2_0/m1_32341_n8557# 100000
R1271 eeg_sdm1ct_0/eeg_fd_ota_full2_nc_0/stage2_0/m1_31541_n8557# eeg_sdm1ct_0/eeg_fd_ota_full2_nc_0/stage2_0/m1_31941_n15864# 100000
R1272 eeg_sdm1ct_0/eeg_fd_ota_full2_nc_0/stage2_0/m1_31141_n15864# eeg_sdm1ct_0/eeg_fd_ota_full2_nc_0/stage2_0/m1_31541_n8557# 100000
R1273 eeg_sdm1ct_0/eeg_fd_ota_full2_nc_0/stage2_0/m1_30741_n8557# eeg_sdm1ct_0/eeg_fd_ota_full2_nc_0/stage2_0/m1_31141_n15864# 100000
R1274 eeg_sdm1ct_0/eeg_fd_ota_full2_nc_0/stage2_0/m1_30341_n15864# eeg_sdm1ct_0/eeg_fd_ota_full2_nc_0/stage2_0/m1_30741_n8557# 100000
R1275 eeg_sdm1ct_0/eeg_fd_ota_full2_nc_0/stage2_0/N2N eeg_sdm1ct_0/eeg_fd_ota_full2_nc_0/stage2_0/m1_12966_n5928# 20000
R1276 eeg_sdm1ct_0/eeg_fd_ota_full2_nc_0/stage2_0/m1_29941_n8557# eeg_sdm1ct_0/eeg_fd_ota_full2_nc_0/stage2_0/m1_30341_n15864# 100000
R1277 eeg_sdm1ct_0/eeg_fd_ota_full2_nc_0/stage2_0/m1_45141_n15864# eeg_sdm1ct_0/eeg_fd_ota_full2_nc_0/stage2_0/m1_45541_n8557# 100000
R1278 eeg_sdm1ct_0/eeg_fd_ota_full2_nc_0/stage2_0/N2P eeg_sdm1ct_0/eeg_fd_ota_full2_nc_0/stage2_0/m1_3966_n5928# 20000
R1279 eeg_sdm1ct_0/eeg_fd_ota_full2_nc_0/stage2_0/m1_29541_n15864# eeg_sdm1ct_0/eeg_fd_ota_full2_nc_0/stage2_0/m1_29941_n8557# 100000
R1280 eeg_sdm1ct_0/eeg_fd_ota_full2_nc_0/stage2_0/m1_44741_n8557# eeg_sdm1ct_0/eeg_fd_ota_full2_nc_0/stage2_0/m1_45141_n15864# 100000
R1281 eeg_sdm1ct_0/eeg_fd_ota_full2_nc_0/stage2_0/m1_49141_n15864# eeg_sdm1ct_0/eeg_fd_ota_full2_nc_0/stage2_0/m1_49541_n8557# 100000
R1282 eeg_sdm1ct_0/eeg_fd_ota_full2_nc_0/stage2_0/m1_29141_n8557# eeg_sdm1ct_0/eeg_fd_ota_full2_nc_0/stage2_0/m1_29541_n15864# 100000
R1283 eeg_sdm1ct_0/eeg_fd_ota_full2_nc_0/stage2_0/m1_44341_n15864# eeg_sdm1ct_0/eeg_fd_ota_full2_nc_0/stage2_0/m1_44741_n8557# 100000
R1284 eeg_sdm1ct_0/eeg_fd_ota_full2_nc_0/stage2_0/m1_48741_n8557# eeg_sdm1ct_0/eeg_fd_ota_full2_nc_0/stage2_0/m1_49141_n15864# 100000
R1285 eeg_sdm1ct_0/eeg_fd_ota_full2_nc_0/stage2_0/m1_53141_n15864# eeg_sdm1ct_0/eeg_fd_ota_full2_nc_0/stage2_0/m1_53541_n8557# 100000
R1286 eeg_sdm1ct_0/eeg_fd_ota_full2_nc_0/stage2_0/m1_43941_n8557# eeg_sdm1ct_0/eeg_fd_ota_full2_nc_0/stage2_0/m1_44341_n15864# 100000
R1287 eeg_sdm1ct_0/eeg_fd_ota_full2_nc_0/stage2_0/m1_48341_n15864# eeg_sdm1ct_0/eeg_fd_ota_full2_nc_0/stage2_0/m1_48741_n8557# 100000
R1288 eeg_sdm1ct_0/eeg_fd_ota_full2_nc_0/stage2_0/m1_52741_n8557# eeg_sdm1ct_0/eeg_fd_ota_full2_nc_0/stage2_0/m1_53141_n15864# 100000
R1289 eeg_sdm1ct_0/eeg_fd_ota_full2_nc_0/stage2_0/m1_57141_n15864# eeg_sdm1ct_0/eeg_fd_ota_full2_nc_0/stage2_0/m1_57541_n8557# 100000
R1290 eeg_sdm1ct_0/eeg_fd_ota_full2_nc_0/stage2_0/m1_43541_n15864# eeg_sdm1ct_0/eeg_fd_ota_full2_nc_0/stage2_0/m1_43941_n8557# 100000
R1291 eeg_sdm1ct_0/eeg_fd_ota_full2_nc_0/stage2_0/m1_47941_n8557# eeg_sdm1ct_0/eeg_fd_ota_full2_nc_0/stage2_0/m1_48341_n15864# 100000
R1292 eeg_sdm1ct_0/eeg_fd_ota_full2_nc_0/stage2_0/m1_52341_n15864# eeg_sdm1ct_0/eeg_fd_ota_full2_nc_0/stage2_0/m1_52741_n8557# 100000
R1293 eeg_sdm1ct_0/eeg_fd_ota_full2_nc_0/stage2_0/m1_56741_n8557# eeg_sdm1ct_0/eeg_fd_ota_full2_nc_0/stage2_0/m1_57141_n15864# 100000
R1294 eeg_sdm1ct_0/eeg_fd_ota_full2_nc_0/stage2_0/m1_43141_n8557# eeg_sdm1ct_0/eeg_fd_ota_full2_nc_0/stage2_0/m1_43541_n15864# 100000
R1295 eeg_sdm1ct_0/eeg_fd_ota_full2_nc_0/stage2_0/m1_47541_n15864# eeg_sdm1ct_0/eeg_fd_ota_full2_nc_0/stage2_0/m1_47941_n8557# 100000
R1296 eeg_sdm1ct_0/eeg_fd_ota_full2_nc_0/stage2_0/m1_51941_n8557# eeg_sdm1ct_0/eeg_fd_ota_full2_nc_0/stage2_0/m1_52341_n15864# 100000
R1297 eeg_sdm1ct_0/eeg_fd_ota_full2_nc_0/stage2_0/m1_56341_n15864# eeg_sdm1ct_0/eeg_fd_ota_full2_nc_0/stage2_0/m1_56741_n8557# 100000
R1298 eeg_sdm1ct_0/eeg_fd_ota_full2_nc_0/stage2_0/m1_42741_n15864# eeg_sdm1ct_0/eeg_fd_ota_full2_nc_0/stage2_0/m1_43141_n8557# 100000
R1299 eeg_sdm1ct_0/eeg_fd_ota_full2_nc_0/stage2_0/m1_47141_n8557# eeg_sdm1ct_0/eeg_fd_ota_full2_nc_0/stage2_0/m1_47541_n15864# 100000
R1300 eeg_sdm1ct_0/eeg_fd_ota_full2_nc_0/stage2_0/m1_51541_n15864# eeg_sdm1ct_0/eeg_fd_ota_full2_nc_0/stage2_0/m1_51941_n8557# 100000
R1301 eeg_sdm1ct_0/eeg_fd_ota_full2_nc_0/stage2_0/m1_55941_n8557# eeg_sdm1ct_0/eeg_fd_ota_full2_nc_0/stage2_0/m1_56341_n15864# 100000
R1302 eeg_sdm1ct_0/eeg_fd_ota_full2_nc_0/stage2_0/m1_61141_n15864# eeg_sdm1ct_0/eeg_fd_ota_full2_nc_0/stage2_0/VCM2 100000
R1303 eeg_sdm1ct_0/eeg_fd_ota_full2_nc_0/stage2_0/m1_42341_n8557# eeg_sdm1ct_0/eeg_fd_ota_full2_nc_0/stage2_0/m1_42741_n15864# 100000
R1304 eeg_sdm1ct_0/eeg_fd_ota_full2_nc_0/stage2_0/m1_46741_n15864# eeg_sdm1ct_0/eeg_fd_ota_full2_nc_0/stage2_0/m1_47141_n8557# 100000
R1305 eeg_sdm1ct_0/eeg_fd_ota_full2_nc_0/stage2_0/m1_51141_n8557# eeg_sdm1ct_0/eeg_fd_ota_full2_nc_0/stage2_0/m1_51541_n15864# 100000
R1306 eeg_sdm1ct_0/eeg_fd_ota_full2_nc_0/stage2_0/m1_55541_n15864# eeg_sdm1ct_0/eeg_fd_ota_full2_nc_0/stage2_0/m1_55941_n8557# 100000
R1307 eeg_sdm1ct_0/eeg_fd_ota_full2_nc_0/stage2_0/m1_60741_n8557# eeg_sdm1ct_0/eeg_fd_ota_full2_nc_0/stage2_0/m1_61141_n15864# 100000
R1308 eeg_sdm1ct_0/eeg_fd_ota_full2_nc_0/stage2_0/m1_67141_n15864# eeg_sdm1ct_0/eeg_fd_ota_full2_nc_0/stage2_0/m1_67541_n8557# 100000
R1309 eeg_sdm1ct_0/eeg_fd_ota_full2_nc_0/stage2_0/m1_41941_n15864# eeg_sdm1ct_0/eeg_fd_ota_full2_nc_0/stage2_0/m1_42341_n8557# 100000
R1310 eeg_sdm1ct_0/eeg_fd_ota_full2_nc_0/stage2_0/m1_46341_n8557# eeg_sdm1ct_0/eeg_fd_ota_full2_nc_0/stage2_0/m1_46741_n15864# 100000
R1311 eeg_sdm1ct_0/eeg_fd_ota_full2_nc_0/stage2_0/m1_50741_n15864# eeg_sdm1ct_0/eeg_fd_ota_full2_nc_0/stage2_0/m1_51141_n8557# 100000
R1312 eeg_sdm1ct_0/eeg_fd_ota_full2_nc_0/stage2_0/m1_55141_n8557# eeg_sdm1ct_0/eeg_fd_ota_full2_nc_0/stage2_0/m1_55541_n15864# 100000
R1313 eeg_sdm1ct_0/eeg_fd_ota_full2_nc_0/stage2_0/m1_60341_n15864# eeg_sdm1ct_0/eeg_fd_ota_full2_nc_0/stage2_0/m1_60741_n8557# 100000
R1314 eeg_sdm1ct_0/eeg_fd_ota_full2_nc_0/stage2_0/m1_71141_n15864# VCM_REF 100000
R1315 eeg_sdm1ct_0/eeg_fd_ota_full2_nc_0/stage2_0/m1_66741_n8557# eeg_sdm1ct_0/eeg_fd_ota_full2_nc_0/stage2_0/m1_67141_n15864# 100000
R1316 eeg_sdm1ct_0/OINTN eeg_sdm1ct_0/eeg_fd_ota_full2_nc_0/stage2_0/m1_41941_n15864# 100000
R1317 eeg_sdm1ct_0/eeg_fd_ota_full2_nc_0/stage2_0/m1_45941_n15864# eeg_sdm1ct_0/eeg_fd_ota_full2_nc_0/stage2_0/m1_46341_n8557# 100000
R1318 eeg_sdm1ct_0/eeg_fd_ota_full2_nc_0/stage2_0/m1_50341_n8557# eeg_sdm1ct_0/eeg_fd_ota_full2_nc_0/stage2_0/m1_50741_n15864# 100000
R1319 eeg_sdm1ct_0/eeg_fd_ota_full2_nc_0/stage2_0/m1_54741_n15864# eeg_sdm1ct_0/eeg_fd_ota_full2_nc_0/stage2_0/m1_55141_n8557# 100000
R1320 eeg_sdm1ct_0/eeg_fd_ota_full2_nc_0/stage2_0/m1_59941_n8557# eeg_sdm1ct_0/eeg_fd_ota_full2_nc_0/stage2_0/m1_60341_n15864# 100000
R1321 eeg_sdm1ct_0/eeg_fd_ota_full2_nc_0/stage2_0/m1_77141_n15864# eeg_sdm1ct_0/eeg_fd_ota_full2_nc_0/stage2_0/m1_77541_n8557# 100000
R1322 eeg_sdm1ct_0/eeg_fd_ota_full2_nc_0/stage2_0/m1_70741_n8557# eeg_sdm1ct_0/eeg_fd_ota_full2_nc_0/stage2_0/m1_71141_n15864# 100000
R1323 eeg_sdm1ct_0/eeg_fd_ota_full2_nc_0/stage2_0/m1_66341_n15864# eeg_sdm1ct_0/eeg_fd_ota_full2_nc_0/stage2_0/m1_66741_n8557# 100000
X1324 eeg_sdm1ct_0/OINTP eeg_sdm1ct_0/eeg_fd_ota_full2_nc_0/stage2_0/VBP2 VDD18 VDD18 sky130_fd_pr__pfet_01v8 ad=6 pd=26 as=10.62 ps=33.54 w=24 l=12 nf=4
X1325 VDD18 eeg_sdm1ct_0/eeg_fd_ota_full2_nc_0/stage2_0/VBP2 eeg_sdm1ct_0/OINTP VDD18 sky130_fd_pr__pfet_01v8 ad=10.62 pd=33.54 as=6 ps=26 w=24 l=12 nf=4
R1332 eeg_sdm1ct_0/eeg_fd_ota_full2_nc_0/stage2_0/m1_45541_n8557# eeg_sdm1ct_0/eeg_fd_ota_full2_nc_0/stage2_0/m1_45941_n15864# 100000
R1333 eeg_sdm1ct_0/eeg_fd_ota_full2_nc_0/stage2_0/m1_49941_n15864# eeg_sdm1ct_0/eeg_fd_ota_full2_nc_0/stage2_0/m1_50341_n8557# 100000
R1334 eeg_sdm1ct_0/eeg_fd_ota_full2_nc_0/stage2_0/m1_54341_n8557# eeg_sdm1ct_0/eeg_fd_ota_full2_nc_0/stage2_0/m1_54741_n15864# 100000
R1335 eeg_sdm1ct_0/eeg_fd_ota_full2_nc_0/stage2_0/m1_59541_n15864# eeg_sdm1ct_0/eeg_fd_ota_full2_nc_0/stage2_0/m1_59941_n8557# 100000
R1336 eeg_sdm1ct_0/eeg_fd_ota_full2_nc_0/stage2_0/m1_81141_n15864# VCM_REF 100000
R1337 eeg_sdm1ct_0/eeg_fd_ota_full2_nc_0/stage2_0/m1_76741_n8557# eeg_sdm1ct_0/eeg_fd_ota_full2_nc_0/stage2_0/m1_77141_n15864# 100000
R1338 eeg_sdm1ct_0/eeg_fd_ota_full2_nc_0/stage2_0/m1_70341_n15864# eeg_sdm1ct_0/eeg_fd_ota_full2_nc_0/stage2_0/m1_70741_n8557# 100000
R1339 eeg_sdm1ct_0/eeg_fd_ota_full2_nc_0/stage2_0/m1_65941_n8557# eeg_sdm1ct_0/eeg_fd_ota_full2_nc_0/stage2_0/m1_66341_n15864# 100000
R1340 eeg_sdm1ct_0/eeg_fd_ota_full2_nc_0/stage2_0/m1_49541_n8557# eeg_sdm1ct_0/eeg_fd_ota_full2_nc_0/stage2_0/m1_49941_n15864# 100000
R1341 eeg_sdm1ct_0/eeg_fd_ota_full2_nc_0/stage2_0/m1_53941_n15864# eeg_sdm1ct_0/eeg_fd_ota_full2_nc_0/stage2_0/m1_54341_n8557# 100000
R1342 eeg_sdm1ct_0/eeg_fd_ota_full2_nc_0/stage2_0/m1_59141_n8557# eeg_sdm1ct_0/eeg_fd_ota_full2_nc_0/stage2_0/m1_59541_n15864# 100000
R1343 eeg_sdm1ct_0/eeg_fd_ota_full2_nc_0/stage2_0/m1_36741_n15864# eeg_sdm1ct_0/eeg_fd_ota_full2_nc_0/stage2_0/m1_37141_n8557# 100000
R1344 eeg_sdm1ct_0/eeg_fd_ota_full2_nc_0/stage2_0/m1_80741_n8557# eeg_sdm1ct_0/eeg_fd_ota_full2_nc_0/stage2_0/m1_81141_n15864# 100000
R1345 eeg_sdm1ct_0/eeg_fd_ota_full2_nc_0/stage2_0/m1_76341_n15864# eeg_sdm1ct_0/eeg_fd_ota_full2_nc_0/stage2_0/m1_76741_n8557# 100000
R1346 eeg_sdm1ct_0/eeg_fd_ota_full2_nc_0/stage2_0/m1_69941_n8557# eeg_sdm1ct_0/eeg_fd_ota_full2_nc_0/stage2_0/m1_70341_n15864# 100000
R1347 eeg_sdm1ct_0/eeg_fd_ota_full2_nc_0/stage2_0/m1_65541_n15864# eeg_sdm1ct_0/eeg_fd_ota_full2_nc_0/stage2_0/m1_65941_n8557# 100000
R1348 eeg_sdm1ct_0/eeg_fd_ota_full2_nc_0/stage2_0/m1_53541_n8557# eeg_sdm1ct_0/eeg_fd_ota_full2_nc_0/stage2_0/m1_53941_n15864# 100000
R1349 eeg_sdm1ct_0/eeg_fd_ota_full2_nc_0/stage2_0/m1_58741_n15864# eeg_sdm1ct_0/eeg_fd_ota_full2_nc_0/stage2_0/m1_59141_n8557# 100000
R1350 eeg_sdm1ct_0/eeg_fd_ota_full2_nc_0/stage2_0/m1_20741_n15864# eeg_sdm1ct_0/eeg_fd_ota_full2_nc_0/stage2_0/m1_21141_n8557# 100000
R1351 eeg_sdm1ct_0/eeg_fd_ota_full2_nc_0/stage2_0/m1_36341_n8557# eeg_sdm1ct_0/eeg_fd_ota_full2_nc_0/stage2_0/m1_36741_n15864# 100000
R1352 eeg_sdm1ct_0/eeg_fd_ota_full2_nc_0/stage2_0/m1_80341_n15864# eeg_sdm1ct_0/eeg_fd_ota_full2_nc_0/stage2_0/m1_80741_n8557# 100000
R1353 eeg_sdm1ct_0/eeg_fd_ota_full2_nc_0/stage2_0/m1_75941_n8557# eeg_sdm1ct_0/eeg_fd_ota_full2_nc_0/stage2_0/m1_76341_n15864# 100000
R1354 eeg_sdm1ct_0/eeg_fd_ota_full2_nc_0/stage2_0/m1_69541_n15864# eeg_sdm1ct_0/eeg_fd_ota_full2_nc_0/stage2_0/m1_69941_n8557# 100000
R1355 eeg_sdm1ct_0/eeg_fd_ota_full2_nc_0/stage2_0/m1_65141_n8557# eeg_sdm1ct_0/eeg_fd_ota_full2_nc_0/stage2_0/m1_65541_n15864# 100000
X1356 eeg_sdm1ct_0/OINTP eeg_sdm1ct_0/eeg_fd_ota_full2_nc_0/stage2_0/N2P VSS VSS sky130_fd_pr__nfet_01v8 ad=1.5 pd=6.5 as=6.12 ps=14.04 w=6 l=12 nf=1
X1357 VSS eeg_sdm1ct_0/eeg_fd_ota_full2_nc_0/stage2_0/N2P eeg_sdm1ct_0/OINTP VSS sky130_fd_pr__nfet_01v8 ad=6.12 pd=14.04 as=1.5 ps=6.5 w=6 l=12 nf=1
CMIM1358 eeg_sdm1ct_0/eeg_fd_ota_full2_nc_0/stage2_0/m1_3966_n5928# eeg_sdm1ct_0/OINTP 1.000000e-11
CMIM1359 eeg_sdm1ct_0/eeg_fd_ota_full2_nc_0/stage2_0/m1_12966_n5928# eeg_sdm1ct_0/OINTN 1.000000e-11
R1398 eeg_sdm1ct_0/eeg_fd_ota_full2_nc_0/eeg_fd_ota_core_soft_0/m1_n51659_3443# eeg_sdm1ct_0/eeg_fd_ota_full2_nc_0/eeg_fd_ota_core_soft_0/m1_n51259_n3864# 100000
R1399 eeg_sdm1ct_0/eeg_fd_ota_full2_nc_0/eeg_fd_ota_core_soft_0/m1_n52059_n3864# eeg_sdm1ct_0/eeg_fd_ota_full2_nc_0/eeg_fd_ota_core_soft_0/m1_n51659_3443# 100000
R1400 eeg_sdm1ct_0/eeg_fd_ota_full2_nc_0/eeg_fd_ota_core_soft_0/m1_n52459_3443# eeg_sdm1ct_0/eeg_fd_ota_full2_nc_0/eeg_fd_ota_core_soft_0/m1_n52059_n3864# 100000
R1401 eeg_sdm1ct_0/eeg_fd_ota_full2_nc_0/eeg_fd_ota_core_soft_0/m1_n52859_n3864# eeg_sdm1ct_0/eeg_fd_ota_full2_nc_0/eeg_fd_ota_core_soft_0/m1_n52459_3443# 100000
R1402 eeg_sdm1ct_0/eeg_fd_ota_full2_nc_0/eeg_fd_ota_core_soft_0/m1_n53259_3443# eeg_sdm1ct_0/eeg_fd_ota_full2_nc_0/eeg_fd_ota_core_soft_0/m1_n52859_n3864# 100000
X1403 VSS eeg_sdm1ct_0/eeg_fd_ota_full2_nc_0/eeg_bias_gen_0/VBNF eeg_sdm1ct_0/eeg_fd_ota_full2_nc_0/eeg_fd_ota_core_soft_0/m1_n22658_111# VSS sky130_fd_pr__nfet_01v8 ad=16.62 pd=59.54 as=12 ps=52 w=48 l=4 nf=8
X1404 eeg_sdm1ct_0/eeg_fd_ota_full2_nc_0/eeg_fd_ota_core_soft_0/m1_n22658_111# eeg_sdm1ct_0/eeg_fd_ota_full2_nc_0/eeg_bias_gen_0/VBNF VSS VSS sky130_fd_pr__nfet_01v8 ad=12 pd=52 as=16.62 ps=59.54 w=48 l=4 nf=8
R1419 eeg_sdm1ct_0/eeg_fd_ota_full2_nc_0/eeg_fd_ota_core_soft_0/m1_n53659_n3864# eeg_sdm1ct_0/eeg_fd_ota_full2_nc_0/eeg_fd_ota_core_soft_0/m1_n53259_3443# 100000
R1420 eeg_sdm1ct_0/eeg_fd_ota_full2_nc_0/eeg_fd_ota_core_soft_0/m1_31541_n3864# eeg_sdm1ct_0/eeg_fd_ota_full2_nc_0/eeg_fd_ota_core_soft_0/m1_31941_3443# 100000
R1421 eeg_sdm1ct_0/eeg_fd_ota_full2_nc_0/eeg_fd_ota_core_soft_0/m1_n54059_3443# eeg_sdm1ct_0/eeg_fd_ota_full2_nc_0/eeg_fd_ota_core_soft_0/m1_n53659_n3864# 100000
R1422 eeg_sdm1ct_0/eeg_fd_ota_full2_nc_0/eeg_fd_ota_core_soft_0/m1_31141_3443# eeg_sdm1ct_0/eeg_fd_ota_full2_nc_0/eeg_fd_ota_core_soft_0/m1_31541_n3864# 100000
R1423 eeg_sdm1ct_0/eeg_fd_ota_full2_nc_0/eeg_fd_ota_core_soft_0/m1_35541_n3864# eeg_sdm1ct_0/eeg_fd_ota_full2_nc_0/eeg_fd_ota_core_soft_0/m1_35941_3443# 100000
R1424 eeg_sdm1ct_0/eeg_fd_ota_full2_nc_0/eeg_fd_ota_core_soft_0/m1_n54459_n3864# eeg_sdm1ct_0/eeg_fd_ota_full2_nc_0/eeg_fd_ota_core_soft_0/m1_n54059_3443# 100000
R1425 eeg_sdm1ct_0/eeg_fd_ota_full2_nc_0/eeg_fd_ota_core_soft_0/m1_39541_n3864# eeg_sdm1ct_0/eeg_fd_ota_full2_nc_0/eeg_fd_ota_core_soft_0/m1_39941_3443# 100000
R1426 eeg_sdm1ct_0/eeg_fd_ota_full2_nc_0/eeg_fd_ota_core_soft_0/m1_30741_n3864# eeg_sdm1ct_0/eeg_fd_ota_full2_nc_0/eeg_fd_ota_core_soft_0/m1_31141_3443# 100000
R1427 eeg_sdm1ct_0/eeg_fd_ota_full2_nc_0/eeg_fd_ota_core_soft_0/m1_35141_3443# eeg_sdm1ct_0/eeg_fd_ota_full2_nc_0/eeg_fd_ota_core_soft_0/m1_35541_n3864# 100000
R1428 eeg_sdm1ct_0/eeg_fd_ota_full2_nc_0/eeg_fd_ota_core_soft_0/m1_n54859_3443# eeg_sdm1ct_0/eeg_fd_ota_full2_nc_0/eeg_fd_ota_core_soft_0/m1_n54459_n3864# 100000
R1429 eeg_sdm1ct_0/eeg_fd_ota_full2_nc_0/eeg_fd_ota_core_soft_0/m1_43541_n3864# eeg_sdm1ct_0/eeg_fd_ota_full2_nc_0/eeg_fd_ota_core_soft_0/m1_43941_3443# 100000
R1430 eeg_sdm1ct_0/eeg_fd_ota_full2_nc_0/eeg_fd_ota_core_soft_0/m1_39141_3443# eeg_sdm1ct_0/eeg_fd_ota_full2_nc_0/eeg_fd_ota_core_soft_0/m1_39541_n3864# 100000
R1431 eeg_sdm1ct_0/eeg_fd_ota_full2_nc_0/eeg_fd_ota_core_soft_0/m1_30341_3443# eeg_sdm1ct_0/eeg_fd_ota_full2_nc_0/eeg_fd_ota_core_soft_0/m1_30741_n3864# 100000
R1432 eeg_sdm1ct_0/eeg_fd_ota_full2_nc_0/eeg_fd_ota_core_soft_0/m1_34741_n3864# eeg_sdm1ct_0/eeg_fd_ota_full2_nc_0/eeg_fd_ota_core_soft_0/m1_35141_3443# 100000
R1433 eeg_sdm1ct_0/eeg_fd_ota_full2_nc_0/eeg_fd_ota_core_soft_0/m1_n55259_n3864# eeg_sdm1ct_0/eeg_fd_ota_full2_nc_0/eeg_fd_ota_core_soft_0/m1_n54859_3443# 100000
R1434 eeg_sdm1ct_0/eeg_fd_ota_full2_nc_0/eeg_fd_ota_core_soft_0/m1_43141_3443# eeg_sdm1ct_0/eeg_fd_ota_full2_nc_0/eeg_fd_ota_core_soft_0/m1_43541_n3864# 100000
R1435 eeg_sdm1ct_0/eeg_fd_ota_full2_nc_0/eeg_fd_ota_core_soft_0/m1_38741_n3864# eeg_sdm1ct_0/eeg_fd_ota_full2_nc_0/eeg_fd_ota_core_soft_0/m1_39141_3443# 100000
R1436 eeg_sdm1ct_0/eeg_fd_ota_full2_nc_0/eeg_fd_ota_core_soft_0/m1_29941_n3864# eeg_sdm1ct_0/eeg_fd_ota_full2_nc_0/eeg_fd_ota_core_soft_0/m1_30341_3443# 100000
R1437 eeg_sdm1ct_0/eeg_fd_ota_full2_nc_0/eeg_fd_ota_core_soft_0/m1_34341_3443# eeg_sdm1ct_0/eeg_fd_ota_full2_nc_0/eeg_fd_ota_core_soft_0/m1_34741_n3864# 100000
R1438 eeg_sdm1ct_0/eeg_fd_ota_full2_nc_0/eeg_fd_ota_core_soft_0/m1_42741_n3864# eeg_sdm1ct_0/eeg_fd_ota_full2_nc_0/eeg_fd_ota_core_soft_0/m1_43141_3443# 100000
R1439 eeg_sdm1ct_0/eeg_fd_ota_full2_nc_0/eeg_fd_ota_core_soft_0/m1_38341_3443# eeg_sdm1ct_0/eeg_fd_ota_full2_nc_0/eeg_fd_ota_core_soft_0/m1_38741_n3864# 100000
R1440 eeg_sdm1ct_0/eeg_fd_ota_full2_nc_0/eeg_fd_ota_core_soft_0/m1_29541_3443# eeg_sdm1ct_0/eeg_fd_ota_full2_nc_0/eeg_fd_ota_core_soft_0/m1_29941_n3864# 100000
R1441 eeg_sdm1ct_0/eeg_fd_ota_full2_nc_0/eeg_fd_ota_core_soft_0/m1_33941_n3864# eeg_sdm1ct_0/eeg_fd_ota_full2_nc_0/eeg_fd_ota_core_soft_0/m1_34341_3443# 100000
X1442 eeg_sdm1ct_0/eeg_fd_ota_full2_nc_0/stage2_0/N2P eeg_sdm1ct_0/eeg_pseudo_res_1/B eeg_sdm1ct_0/eeg_fd_ota_full2_nc_0/eeg_fd_ota_core_soft_0/m1_n22658_111# VSS sky130_fd_pr__nfet_01v8 ad=30 pd=126 as=30 ps=126 w=120 l=4 nf=12
X1443 eeg_sdm1ct_0/eeg_fd_ota_full2_nc_0/eeg_fd_ota_core_soft_0/m1_n22658_111# eeg_sdm1ct_0/eeg_pseudo_res_0/B eeg_sdm1ct_0/eeg_fd_ota_full2_nc_0/stage2_0/N2N VSS sky130_fd_pr__nfet_01v8 ad=30 pd=126 as=30 ps=126 w=120 l=4 nf=12
X1444 eeg_sdm1ct_0/eeg_fd_ota_full2_nc_0/eeg_fd_ota_core_soft_0/m1_n22658_111# eeg_sdm1ct_0/eeg_pseudo_res_1/B eeg_sdm1ct_0/eeg_fd_ota_full2_nc_0/stage2_0/N2P VSS sky130_fd_pr__nfet_01v8 ad=30 pd=126 as=30 ps=126 w=120 l=4 nf=12
X1445 eeg_sdm1ct_0/eeg_fd_ota_full2_nc_0/stage2_0/N2N eeg_sdm1ct_0/eeg_pseudo_res_0/B eeg_sdm1ct_0/eeg_fd_ota_full2_nc_0/eeg_fd_ota_core_soft_0/m1_n22658_111# VSS sky130_fd_pr__nfet_01v8 ad=30 pd=126 as=30 ps=126 w=120 l=4 nf=12
X1454 eeg_sdm1ct_0/eeg_fd_ota_full2_nc_0/eeg_fd_ota_core_soft_0/m1_n22658_111# VSS eeg_sdm1ct_0/eeg_fd_ota_full2_nc_0/stage2_0/N2P VSS sky130_fd_pr__nfet_01v8 ad=17.4 pd=23.48 as=2.5 ps=10.5 w=10 l=4 nf=1
X1486 eeg_sdm1ct_0/eeg_fd_ota_full2_nc_0/stage2_0/N2P VSS eeg_sdm1ct_0/eeg_fd_ota_full2_nc_0/eeg_fd_ota_core_soft_0/m1_n22658_111# VSS sky130_fd_pr__nfet_01v8 ad=2.5 pd=10.5 as=17.4 ps=23.48 w=10 l=4 nf=1
R1492 eeg_sdm1ct_0/eeg_fd_ota_full2_nc_0/eeg_fd_ota_core_soft_0/m1_42341_3443# eeg_sdm1ct_0/eeg_fd_ota_full2_nc_0/eeg_fd_ota_core_soft_0/m1_42741_n3864# 100000
R1493 eeg_sdm1ct_0/eeg_fd_ota_full2_nc_0/eeg_fd_ota_core_soft_0/m1_37941_n3864# eeg_sdm1ct_0/eeg_fd_ota_full2_nc_0/eeg_fd_ota_core_soft_0/m1_38341_3443# 100000
R1494 eeg_sdm1ct_0/eeg_fd_ota_full2_nc_0/eeg_fd_ota_core_soft_0/m1_29141_n3864# eeg_sdm1ct_0/eeg_fd_ota_full2_nc_0/eeg_fd_ota_core_soft_0/m1_29541_3443# 100000
R1495 eeg_sdm1ct_0/eeg_fd_ota_full2_nc_0/eeg_fd_ota_core_soft_0/m1_33541_3443# eeg_sdm1ct_0/eeg_fd_ota_full2_nc_0/eeg_fd_ota_core_soft_0/m1_33941_n3864# 100000
R1496 eeg_sdm1ct_0/eeg_fd_ota_full2_nc_0/eeg_fd_ota_core_soft_0/m1_41941_n3864# eeg_sdm1ct_0/eeg_fd_ota_full2_nc_0/eeg_fd_ota_core_soft_0/m1_42341_3443# 100000
R1497 eeg_sdm1ct_0/eeg_fd_ota_full2_nc_0/eeg_fd_ota_core_soft_0/m1_37541_3443# eeg_sdm1ct_0/eeg_fd_ota_full2_nc_0/eeg_fd_ota_core_soft_0/m1_37941_n3864# 100000
R1498 eeg_sdm1ct_0/eeg_fd_ota_full2_nc_0/eeg_fd_ota_core_soft_0/m1_28741_3443# eeg_sdm1ct_0/eeg_fd_ota_full2_nc_0/eeg_fd_ota_core_soft_0/m1_29141_n3864# 100000
R1499 eeg_sdm1ct_0/eeg_fd_ota_full2_nc_0/eeg_fd_ota_core_soft_0/m1_33141_n3864# eeg_sdm1ct_0/eeg_fd_ota_full2_nc_0/eeg_fd_ota_core_soft_0/m1_33541_3443# 100000
R1500 eeg_sdm1ct_0/eeg_fd_ota_full2_nc_0/eeg_fd_ota_core_soft_0/m1_41541_3443# eeg_sdm1ct_0/eeg_fd_ota_full2_nc_0/eeg_fd_ota_core_soft_0/m1_41941_n3864# 100000
R1501 eeg_sdm1ct_0/eeg_fd_ota_full2_nc_0/eeg_fd_ota_core_soft_0/m1_37141_n3864# eeg_sdm1ct_0/eeg_fd_ota_full2_nc_0/eeg_fd_ota_core_soft_0/m1_37541_3443# 100000
R1502 eeg_sdm1ct_0/eeg_fd_ota_full2_nc_0/eeg_fd_ota_core_soft_0/m1_28341_n3864# eeg_sdm1ct_0/eeg_fd_ota_full2_nc_0/eeg_fd_ota_core_soft_0/m1_28741_3443# 100000
R1503 eeg_sdm1ct_0/eeg_fd_ota_full2_nc_0/eeg_fd_ota_core_soft_0/m1_32741_3443# eeg_sdm1ct_0/eeg_fd_ota_full2_nc_0/eeg_fd_ota_core_soft_0/m1_33141_n3864# 100000
R1504 eeg_sdm1ct_0/eeg_fd_ota_full2_nc_0/eeg_fd_ota_core_soft_0/m1_47541_n3864# eeg_sdm1ct_0/eeg_fd_ota_full2_nc_0/stage2_0/N2N 100000
R1505 eeg_sdm1ct_0/eeg_fd_ota_full2_nc_0/eeg_fd_ota_core_soft_0/m1_41141_n3864# eeg_sdm1ct_0/eeg_fd_ota_full2_nc_0/eeg_fd_ota_core_soft_0/m1_41541_3443# 100000
R1506 eeg_sdm1ct_0/eeg_fd_ota_full2_nc_0/eeg_cmfb_amp_dl2_0/VCM_SENSE eeg_sdm1ct_0/eeg_fd_ota_full2_nc_0/eeg_fd_ota_core_soft_0/m1_28341_n3864# 100000
R1507 eeg_sdm1ct_0/eeg_fd_ota_full2_nc_0/eeg_fd_ota_core_soft_0/m1_32341_n3864# eeg_sdm1ct_0/eeg_fd_ota_full2_nc_0/eeg_fd_ota_core_soft_0/m1_32741_3443# 100000
R1508 eeg_sdm1ct_0/eeg_fd_ota_full2_nc_0/eeg_fd_ota_core_soft_0/m1_36741_3443# eeg_sdm1ct_0/eeg_fd_ota_full2_nc_0/eeg_fd_ota_core_soft_0/m1_37141_n3864# 100000
R1509 eeg_sdm1ct_0/eeg_fd_ota_full2_nc_0/eeg_fd_ota_core_soft_0/m1_53941_n3864# eeg_sdm1ct_0/eeg_fd_ota_full2_nc_0/eeg_fd_ota_core_soft_0/m1_54341_3443# 100000
R1510 eeg_sdm1ct_0/eeg_fd_ota_full2_nc_0/eeg_fd_ota_core_soft_0/m1_47141_3443# eeg_sdm1ct_0/eeg_fd_ota_full2_nc_0/eeg_fd_ota_core_soft_0/m1_47541_n3864# 100000
R1511 eeg_sdm1ct_0/eeg_fd_ota_full2_nc_0/eeg_fd_ota_core_soft_0/m1_40741_3443# eeg_sdm1ct_0/eeg_fd_ota_full2_nc_0/eeg_fd_ota_core_soft_0/m1_41141_n3864# 100000
R1512 eeg_sdm1ct_0/eeg_fd_ota_full2_nc_0/eeg_fd_ota_core_soft_0/m1_36341_n3864# eeg_sdm1ct_0/eeg_fd_ota_full2_nc_0/eeg_fd_ota_core_soft_0/m1_36741_3443# 100000
R1513 eeg_sdm1ct_0/eeg_fd_ota_full2_nc_0/eeg_fd_ota_core_soft_0/m1_31941_3443# eeg_sdm1ct_0/eeg_fd_ota_full2_nc_0/eeg_fd_ota_core_soft_0/m1_32341_n3864# 100000
R1514 eeg_sdm1ct_0/eeg_fd_ota_full2_nc_0/eeg_fd_ota_core_soft_0/m1_57941_n3864# eeg_sdm1ct_0/eeg_fd_ota_full2_nc_0/stage2_0/N2N 100000
R1515 eeg_sdm1ct_0/eeg_fd_ota_full2_nc_0/eeg_fd_ota_core_soft_0/m1_53541_3443# eeg_sdm1ct_0/eeg_fd_ota_full2_nc_0/eeg_fd_ota_core_soft_0/m1_53941_n3864# 100000
R1516 eeg_sdm1ct_0/eeg_fd_ota_full2_nc_0/eeg_fd_ota_core_soft_0/m1_46741_n3864# eeg_sdm1ct_0/eeg_fd_ota_full2_nc_0/eeg_fd_ota_core_soft_0/m1_47141_3443# 100000
R1517 eeg_sdm1ct_0/eeg_fd_ota_full2_nc_0/eeg_fd_ota_core_soft_0/m1_40341_n3864# eeg_sdm1ct_0/eeg_fd_ota_full2_nc_0/eeg_fd_ota_core_soft_0/m1_40741_3443# 100000
R1518 eeg_sdm1ct_0/eeg_fd_ota_full2_nc_0/eeg_fd_ota_core_soft_0/m1_35941_3443# eeg_sdm1ct_0/eeg_fd_ota_full2_nc_0/eeg_fd_ota_core_soft_0/m1_36341_n3864# 100000
R1519 eeg_sdm1ct_0/eeg_fd_ota_full2_nc_0/eeg_fd_ota_core_soft_0/m1_57541_3443# eeg_sdm1ct_0/eeg_fd_ota_full2_nc_0/eeg_fd_ota_core_soft_0/m1_57941_n3864# 100000
R1520 eeg_sdm1ct_0/eeg_fd_ota_full2_nc_0/eeg_fd_ota_core_soft_0/m1_53141_n3864# eeg_sdm1ct_0/eeg_fd_ota_full2_nc_0/eeg_fd_ota_core_soft_0/m1_53541_3443# 100000
R1521 eeg_sdm1ct_0/eeg_fd_ota_full2_nc_0/eeg_fd_ota_core_soft_0/m1_46341_3443# eeg_sdm1ct_0/eeg_fd_ota_full2_nc_0/eeg_fd_ota_core_soft_0/m1_46741_n3864# 100000
R1522 eeg_sdm1ct_0/eeg_fd_ota_full2_nc_0/eeg_fd_ota_core_soft_0/m1_n45259_3443# eeg_sdm1ct_0/eeg_fd_ota_full2_nc_0/eeg_fd_ota_core_soft_0/m1_n44859_n3864# 100000
R1523 eeg_sdm1ct_0/eeg_fd_ota_full2_nc_0/eeg_fd_ota_core_soft_0/m1_39941_3443# eeg_sdm1ct_0/eeg_fd_ota_full2_nc_0/eeg_fd_ota_core_soft_0/m1_40341_n3864# 100000
R1524 eeg_sdm1ct_0/eeg_fd_ota_full2_nc_0/eeg_fd_ota_core_soft_0/m1_57141_n3864# eeg_sdm1ct_0/eeg_fd_ota_full2_nc_0/eeg_fd_ota_core_soft_0/m1_57541_3443# 100000
R1525 eeg_sdm1ct_0/eeg_fd_ota_full2_nc_0/eeg_fd_ota_core_soft_0/m1_52741_3443# eeg_sdm1ct_0/eeg_fd_ota_full2_nc_0/eeg_fd_ota_core_soft_0/m1_53141_n3864# 100000
R1526 eeg_sdm1ct_0/eeg_fd_ota_full2_nc_0/eeg_fd_ota_core_soft_0/m1_45941_n3864# eeg_sdm1ct_0/eeg_fd_ota_full2_nc_0/eeg_fd_ota_core_soft_0/m1_46341_3443# 100000
R1527 eeg_sdm1ct_0/eeg_fd_ota_full2_nc_0/eeg_fd_ota_core_soft_0/m1_n45659_n3864# eeg_sdm1ct_0/eeg_fd_ota_full2_nc_0/eeg_fd_ota_core_soft_0/m1_n45259_3443# 100000
R1528 eeg_sdm1ct_0/eeg_fd_ota_full2_nc_0/eeg_fd_ota_core_soft_0/m1_n41259_3443# eeg_sdm1ct_0/eeg_fd_ota_full2_nc_0/eeg_fd_ota_core_soft_0/m1_n40859_n3864# 100000
R1529 eeg_sdm1ct_0/eeg_fd_ota_full2_nc_0/eeg_fd_ota_core_soft_0/m1_56741_3443# eeg_sdm1ct_0/eeg_fd_ota_full2_nc_0/eeg_fd_ota_core_soft_0/m1_57141_n3864# 100000
R1530 eeg_sdm1ct_0/eeg_fd_ota_full2_nc_0/eeg_fd_ota_core_soft_0/m1_52341_n3864# eeg_sdm1ct_0/eeg_fd_ota_full2_nc_0/eeg_fd_ota_core_soft_0/m1_52741_3443# 100000
R1531 eeg_sdm1ct_0/eeg_fd_ota_full2_nc_0/eeg_fd_ota_core_soft_0/m1_45541_3443# eeg_sdm1ct_0/eeg_fd_ota_full2_nc_0/eeg_fd_ota_core_soft_0/m1_45941_n3864# 100000
R1532 eeg_sdm1ct_0/eeg_fd_ota_full2_nc_0/eeg_fd_ota_core_soft_0/m1_n46059_3443# eeg_sdm1ct_0/eeg_fd_ota_full2_nc_0/eeg_fd_ota_core_soft_0/m1_n45659_n3864# 100000
R1533 eeg_sdm1ct_0/eeg_fd_ota_full2_nc_0/eeg_fd_ota_core_soft_0/m1_n41659_n3864# eeg_sdm1ct_0/eeg_fd_ota_full2_nc_0/eeg_fd_ota_core_soft_0/m1_n41259_3443# 100000
R1534 eeg_sdm1ct_0/eeg_fd_ota_full2_nc_0/eeg_fd_ota_core_soft_0/m1_n37259_3443# eeg_sdm1ct_0/eeg_fd_ota_full2_nc_0/eeg_fd_ota_core_soft_0/m1_n36859_n3864# 100000
R1535 eeg_sdm1ct_0/eeg_fd_ota_full2_nc_0/eeg_fd_ota_core_soft_0/m1_56341_n3864# eeg_sdm1ct_0/eeg_fd_ota_full2_nc_0/eeg_fd_ota_core_soft_0/m1_56741_3443# 100000
R1536 eeg_sdm1ct_0/eeg_fd_ota_full2_nc_0/eeg_fd_ota_core_soft_0/m1_51941_3443# eeg_sdm1ct_0/eeg_fd_ota_full2_nc_0/eeg_fd_ota_core_soft_0/m1_52341_n3864# 100000
R1537 eeg_sdm1ct_0/eeg_fd_ota_full2_nc_0/eeg_fd_ota_core_soft_0/m1_45141_n3864# eeg_sdm1ct_0/eeg_fd_ota_full2_nc_0/eeg_fd_ota_core_soft_0/m1_45541_3443# 100000
R1538 eeg_sdm1ct_0/eeg_fd_ota_full2_nc_0/eeg_fd_ota_core_soft_0/m1_n46459_n3864# eeg_sdm1ct_0/eeg_fd_ota_full2_nc_0/eeg_fd_ota_core_soft_0/m1_n46059_3443# 100000
R1539 eeg_sdm1ct_0/eeg_fd_ota_full2_nc_0/eeg_fd_ota_core_soft_0/m1_n42059_3443# eeg_sdm1ct_0/eeg_fd_ota_full2_nc_0/eeg_fd_ota_core_soft_0/m1_n41659_n3864# 100000
R1540 eeg_sdm1ct_0/eeg_fd_ota_full2_nc_0/eeg_fd_ota_core_soft_0/m1_n37659_n3864# eeg_sdm1ct_0/eeg_fd_ota_full2_nc_0/eeg_fd_ota_core_soft_0/m1_n37259_3443# 100000
R1541 eeg_sdm1ct_0/eeg_fd_ota_full2_nc_0/eeg_fd_ota_core_soft_0/m1_n33259_3443# eeg_sdm1ct_0/eeg_fd_ota_full2_nc_0/eeg_fd_ota_core_soft_0/m1_n32859_n3864# 100000
R1542 eeg_sdm1ct_0/eeg_fd_ota_full2_nc_0/eeg_fd_ota_core_soft_0/m1_55941_3443# eeg_sdm1ct_0/eeg_fd_ota_full2_nc_0/eeg_fd_ota_core_soft_0/m1_56341_n3864# 100000
R1543 eeg_sdm1ct_0/eeg_fd_ota_full2_nc_0/eeg_fd_ota_core_soft_0/m1_51541_n3864# eeg_sdm1ct_0/eeg_fd_ota_full2_nc_0/eeg_fd_ota_core_soft_0/m1_51941_3443# 100000
R1544 eeg_sdm1ct_0/eeg_fd_ota_full2_nc_0/eeg_fd_ota_core_soft_0/m1_44741_3443# eeg_sdm1ct_0/eeg_fd_ota_full2_nc_0/eeg_fd_ota_core_soft_0/m1_45141_n3864# 100000
R1545 eeg_sdm1ct_0/eeg_fd_ota_full2_nc_0/eeg_fd_ota_core_soft_0/m1_n46859_3443# eeg_sdm1ct_0/eeg_fd_ota_full2_nc_0/eeg_fd_ota_core_soft_0/m1_n46459_n3864# 100000
R1546 eeg_sdm1ct_0/eeg_fd_ota_full2_nc_0/eeg_fd_ota_core_soft_0/m1_n42459_n3864# eeg_sdm1ct_0/eeg_fd_ota_full2_nc_0/eeg_fd_ota_core_soft_0/m1_n42059_3443# 100000
R1547 eeg_sdm1ct_0/eeg_fd_ota_full2_nc_0/eeg_fd_ota_core_soft_0/m1_n38059_3443# eeg_sdm1ct_0/eeg_fd_ota_full2_nc_0/eeg_fd_ota_core_soft_0/m1_n37659_n3864# 100000
R1548 eeg_sdm1ct_0/eeg_fd_ota_full2_nc_0/eeg_fd_ota_core_soft_0/m1_n33659_n3864# eeg_sdm1ct_0/eeg_fd_ota_full2_nc_0/eeg_fd_ota_core_soft_0/m1_n33259_3443# 100000
R1549 eeg_sdm1ct_0/eeg_fd_ota_full2_nc_0/eeg_fd_ota_core_soft_0/m1_n29259_3443# eeg_sdm1ct_0/eeg_fd_ota_full2_nc_0/eeg_fd_ota_core_soft_0/m1_n28859_n3864# 100000
X1550 eeg_sdm1ct_0/eeg_fd_ota_full2_nc_0/stage2_0/N2P eeg_sdm1ct_0/eeg_fd_ota_full2_nc_0/eeg_cmfb_amp_dl2_0/VBP VDD18 VDD18 sky130_fd_pr__pfet_01v8 ad=6 pd=26 as=10.62 ps=33.54 w=24 l=4 nf=4
X1551 VDD18 eeg_sdm1ct_0/eeg_fd_ota_full2_nc_0/eeg_cmfb_amp_dl2_0/VBP eeg_sdm1ct_0/eeg_fd_ota_full2_nc_0/stage2_0/N2P VDD18 sky130_fd_pr__pfet_01v8 ad=10.62 pd=33.54 as=6 ps=26 w=24 l=4 nf=4
R1558 eeg_sdm1ct_0/eeg_fd_ota_full2_nc_0/eeg_fd_ota_core_soft_0/m1_55541_n3864# eeg_sdm1ct_0/eeg_fd_ota_full2_nc_0/eeg_fd_ota_core_soft_0/m1_55941_3443# 100000
R1559 eeg_sdm1ct_0/eeg_fd_ota_full2_nc_0/eeg_fd_ota_core_soft_0/m1_51141_3443# eeg_sdm1ct_0/eeg_fd_ota_full2_nc_0/eeg_fd_ota_core_soft_0/m1_51541_n3864# 100000
R1560 eeg_sdm1ct_0/eeg_fd_ota_full2_nc_0/eeg_fd_ota_core_soft_0/m1_44341_n3864# eeg_sdm1ct_0/eeg_fd_ota_full2_nc_0/eeg_fd_ota_core_soft_0/m1_44741_3443# 100000
R1561 eeg_sdm1ct_0/eeg_fd_ota_full2_nc_0/eeg_fd_ota_core_soft_0/m1_n55659_3443# eeg_sdm1ct_0/eeg_fd_ota_full2_nc_0/eeg_fd_ota_core_soft_0/m1_n55259_n3864# 100000
R1562 eeg_sdm1ct_0/eeg_fd_ota_full2_nc_0/eeg_fd_ota_core_soft_0/m1_n47259_n3864# eeg_sdm1ct_0/eeg_fd_ota_full2_nc_0/eeg_fd_ota_core_soft_0/m1_n46859_3443# 100000
R1563 eeg_sdm1ct_0/eeg_fd_ota_full2_nc_0/eeg_fd_ota_core_soft_0/m1_n42859_3443# eeg_sdm1ct_0/eeg_fd_ota_full2_nc_0/eeg_fd_ota_core_soft_0/m1_n42459_n3864# 100000
R1564 eeg_sdm1ct_0/eeg_fd_ota_full2_nc_0/eeg_fd_ota_core_soft_0/m1_n38459_n3864# eeg_sdm1ct_0/eeg_fd_ota_full2_nc_0/eeg_fd_ota_core_soft_0/m1_n38059_3443# 100000
R1565 eeg_sdm1ct_0/eeg_fd_ota_full2_nc_0/eeg_fd_ota_core_soft_0/m1_n34059_3443# eeg_sdm1ct_0/eeg_fd_ota_full2_nc_0/eeg_fd_ota_core_soft_0/m1_n33659_n3864# 100000
R1566 eeg_sdm1ct_0/eeg_fd_ota_full2_nc_0/eeg_fd_ota_core_soft_0/m1_n29659_n3864# eeg_sdm1ct_0/eeg_fd_ota_full2_nc_0/eeg_fd_ota_core_soft_0/m1_n29259_3443# 100000
R1567 eeg_sdm1ct_0/eeg_fd_ota_full2_nc_0/eeg_fd_ota_core_soft_0/m1_55141_3443# eeg_sdm1ct_0/eeg_fd_ota_full2_nc_0/eeg_fd_ota_core_soft_0/m1_55541_n3864# 100000
R1568 eeg_sdm1ct_0/eeg_fd_ota_full2_nc_0/eeg_fd_ota_core_soft_0/m1_50741_n3864# eeg_sdm1ct_0/eeg_fd_ota_full2_nc_0/eeg_fd_ota_core_soft_0/m1_51141_3443# 100000
R1569 eeg_sdm1ct_0/eeg_fd_ota_full2_nc_0/eeg_fd_ota_core_soft_0/m1_43941_3443# eeg_sdm1ct_0/eeg_fd_ota_full2_nc_0/eeg_fd_ota_core_soft_0/m1_44341_n3864# 100000
R1570 eeg_sdm1ct_0/eeg_fd_ota_full2_nc_0/eeg_fd_ota_core_soft_0/m1_n56059_n3864# eeg_sdm1ct_0/eeg_fd_ota_full2_nc_0/eeg_fd_ota_core_soft_0/m1_n55659_3443# 100000
R1571 eeg_sdm1ct_0/eeg_fd_ota_full2_nc_0/eeg_fd_ota_core_soft_0/m1_n47659_3443# eeg_sdm1ct_0/eeg_fd_ota_full2_nc_0/eeg_fd_ota_core_soft_0/m1_n47259_n3864# 100000
R1572 eeg_sdm1ct_0/eeg_fd_ota_full2_nc_0/eeg_fd_ota_core_soft_0/m1_n43259_n3864# eeg_sdm1ct_0/eeg_fd_ota_full2_nc_0/eeg_fd_ota_core_soft_0/m1_n42859_3443# 100000
R1573 eeg_sdm1ct_0/eeg_fd_ota_full2_nc_0/eeg_fd_ota_core_soft_0/m1_n38859_3443# eeg_sdm1ct_0/eeg_fd_ota_full2_nc_0/eeg_fd_ota_core_soft_0/m1_n38459_n3864# 100000
R1574 eeg_sdm1ct_0/eeg_fd_ota_full2_nc_0/eeg_fd_ota_core_soft_0/m1_n34459_n3864# eeg_sdm1ct_0/eeg_fd_ota_full2_nc_0/eeg_fd_ota_core_soft_0/m1_n34059_3443# 100000
R1575 eeg_sdm1ct_0/eeg_fd_ota_full2_nc_0/eeg_fd_ota_core_soft_0/m1_n30059_3443# eeg_sdm1ct_0/eeg_fd_ota_full2_nc_0/eeg_fd_ota_core_soft_0/m1_n29659_n3864# 100000
R1576 eeg_sdm1ct_0/eeg_fd_ota_full2_nc_0/eeg_fd_ota_core_soft_0/m1_54741_n3864# eeg_sdm1ct_0/eeg_fd_ota_full2_nc_0/eeg_fd_ota_core_soft_0/m1_55141_3443# 100000
R1577 VCM_REF eeg_sdm1ct_0/eeg_fd_ota_full2_nc_0/eeg_fd_ota_core_soft_0/m1_50741_n3864# 100000
R1578 eeg_sdm1ct_0/eeg_fd_ota_full2_nc_0/eeg_fd_ota_core_soft_0/m1_n56459_3443# eeg_sdm1ct_0/eeg_fd_ota_full2_nc_0/eeg_fd_ota_core_soft_0/m1_n56059_n3864# 100000
R1579 eeg_sdm1ct_0/eeg_fd_ota_full2_nc_0/eeg_fd_ota_core_soft_0/m1_n48059_n3864# eeg_sdm1ct_0/eeg_fd_ota_full2_nc_0/eeg_fd_ota_core_soft_0/m1_n47659_3443# 100000
R1580 eeg_sdm1ct_0/eeg_fd_ota_full2_nc_0/eeg_fd_ota_core_soft_0/m1_n43659_3443# eeg_sdm1ct_0/eeg_fd_ota_full2_nc_0/eeg_fd_ota_core_soft_0/m1_n43259_n3864# 100000
R1581 eeg_sdm1ct_0/eeg_fd_ota_full2_nc_0/eeg_fd_ota_core_soft_0/m1_n39259_n3864# eeg_sdm1ct_0/eeg_fd_ota_full2_nc_0/eeg_fd_ota_core_soft_0/m1_n38859_3443# 100000
R1582 eeg_sdm1ct_0/eeg_fd_ota_full2_nc_0/eeg_fd_ota_core_soft_0/m1_n34859_3443# eeg_sdm1ct_0/eeg_fd_ota_full2_nc_0/eeg_fd_ota_core_soft_0/m1_n34459_n3864# 100000
R1583 eeg_sdm1ct_0/eeg_fd_ota_full2_nc_0/eeg_fd_ota_core_soft_0/m1_n30459_n3864# eeg_sdm1ct_0/eeg_fd_ota_full2_nc_0/eeg_fd_ota_core_soft_0/m1_n30059_3443# 100000
R1584 eeg_sdm1ct_0/eeg_fd_ota_full2_nc_0/eeg_fd_ota_core_soft_0/m1_54341_3443# eeg_sdm1ct_0/eeg_fd_ota_full2_nc_0/eeg_fd_ota_core_soft_0/m1_54741_n3864# 100000
R1585 eeg_sdm1ct_0/eeg_fd_ota_full2_nc_0/eeg_fd_ota_core_soft_0/m1_n56859_n3864# eeg_sdm1ct_0/eeg_fd_ota_full2_nc_0/eeg_fd_ota_core_soft_0/m1_n56459_3443# 100000
R1586 eeg_sdm1ct_0/eeg_fd_ota_full2_nc_0/stage2_0/N2P eeg_sdm1ct_0/eeg_fd_ota_full2_nc_0/eeg_fd_ota_core_soft_0/m1_n48059_n3864# 100000
R1587 eeg_sdm1ct_0/eeg_fd_ota_full2_nc_0/eeg_fd_ota_core_soft_0/m1_n44059_n3864# eeg_sdm1ct_0/eeg_fd_ota_full2_nc_0/eeg_fd_ota_core_soft_0/m1_n43659_3443# 100000
R1588 eeg_sdm1ct_0/eeg_fd_ota_full2_nc_0/eeg_fd_ota_core_soft_0/m1_n39659_3443# eeg_sdm1ct_0/eeg_fd_ota_full2_nc_0/eeg_fd_ota_core_soft_0/m1_n39259_n3864# 100000
R1589 eeg_sdm1ct_0/eeg_fd_ota_full2_nc_0/eeg_fd_ota_core_soft_0/m1_n35259_n3864# eeg_sdm1ct_0/eeg_fd_ota_full2_nc_0/eeg_fd_ota_core_soft_0/m1_n34859_3443# 100000
R1590 eeg_sdm1ct_0/eeg_fd_ota_full2_nc_0/eeg_fd_ota_core_soft_0/m1_n30859_3443# eeg_sdm1ct_0/eeg_fd_ota_full2_nc_0/eeg_fd_ota_core_soft_0/m1_n30459_n3864# 100000
R1591 eeg_sdm1ct_0/eeg_fd_ota_full2_nc_0/eeg_fd_ota_core_soft_0/m1_n57259_3443# eeg_sdm1ct_0/eeg_fd_ota_full2_nc_0/eeg_fd_ota_core_soft_0/m1_n56859_n3864# 100000
R1592 eeg_sdm1ct_0/eeg_fd_ota_full2_nc_0/eeg_fd_ota_core_soft_0/m1_n51259_n3864# VCM_REF 100000
R1593 eeg_sdm1ct_0/eeg_fd_ota_full2_nc_0/eeg_fd_ota_core_soft_0/m1_n44459_3443# eeg_sdm1ct_0/eeg_fd_ota_full2_nc_0/eeg_fd_ota_core_soft_0/m1_n44059_n3864# 100000
R1594 eeg_sdm1ct_0/eeg_fd_ota_full2_nc_0/eeg_fd_ota_core_soft_0/m1_n40059_n3864# eeg_sdm1ct_0/eeg_fd_ota_full2_nc_0/eeg_fd_ota_core_soft_0/m1_n39659_3443# 100000
R1595 eeg_sdm1ct_0/eeg_fd_ota_full2_nc_0/eeg_fd_ota_core_soft_0/m1_n35659_3443# eeg_sdm1ct_0/eeg_fd_ota_full2_nc_0/eeg_fd_ota_core_soft_0/m1_n35259_n3864# 100000
R1596 eeg_sdm1ct_0/eeg_fd_ota_full2_nc_0/eeg_fd_ota_core_soft_0/m1_n31259_n3864# eeg_sdm1ct_0/eeg_fd_ota_full2_nc_0/eeg_fd_ota_core_soft_0/m1_n30859_3443# 100000
R1597 eeg_sdm1ct_0/eeg_fd_ota_full2_nc_0/eeg_fd_ota_core_soft_0/m1_n57659_n3864# eeg_sdm1ct_0/eeg_fd_ota_full2_nc_0/eeg_fd_ota_core_soft_0/m1_n57259_3443# 100000
R1598 eeg_sdm1ct_0/eeg_fd_ota_full2_nc_0/eeg_fd_ota_core_soft_0/m1_n44859_n3864# eeg_sdm1ct_0/eeg_fd_ota_full2_nc_0/eeg_fd_ota_core_soft_0/m1_n44459_3443# 100000
R1599 eeg_sdm1ct_0/eeg_fd_ota_full2_nc_0/eeg_fd_ota_core_soft_0/m1_n40459_3443# eeg_sdm1ct_0/eeg_fd_ota_full2_nc_0/eeg_fd_ota_core_soft_0/m1_n40059_n3864# 100000
R1600 eeg_sdm1ct_0/eeg_fd_ota_full2_nc_0/eeg_fd_ota_core_soft_0/m1_n36059_n3864# eeg_sdm1ct_0/eeg_fd_ota_full2_nc_0/eeg_fd_ota_core_soft_0/m1_n35659_3443# 100000
R1601 eeg_sdm1ct_0/eeg_fd_ota_full2_nc_0/eeg_fd_ota_core_soft_0/m1_n31659_3443# eeg_sdm1ct_0/eeg_fd_ota_full2_nc_0/eeg_fd_ota_core_soft_0/m1_n31259_n3864# 100000
X1602 eeg_sdm1ct_0/eeg_fd_ota_full2_nc_0/stage2_0/N2N eeg_sdm1ct_0/eeg_fd_ota_full2_nc_0/eeg_cmfb_amp_dl2_0/VBP VDD18 VDD18 sky130_fd_pr__pfet_01v8 ad=6 pd=26 as=10.62 ps=33.54 w=24 l=4 nf=4
X1603 VDD18 eeg_sdm1ct_0/eeg_fd_ota_full2_nc_0/eeg_cmfb_amp_dl2_0/VBP eeg_sdm1ct_0/eeg_fd_ota_full2_nc_0/stage2_0/N2N VDD18 sky130_fd_pr__pfet_01v8 ad=10.62 pd=33.54 as=6 ps=26 w=24 l=4 nf=4
R1610 eeg_sdm1ct_0/eeg_fd_ota_full2_nc_0/eeg_fd_ota_core_soft_0/m1_n58059_3443# eeg_sdm1ct_0/eeg_fd_ota_full2_nc_0/eeg_fd_ota_core_soft_0/m1_n57659_n3864# 100000
R1611 eeg_sdm1ct_0/eeg_fd_ota_full2_nc_0/eeg_fd_ota_core_soft_0/m1_n40859_n3864# eeg_sdm1ct_0/eeg_fd_ota_full2_nc_0/eeg_fd_ota_core_soft_0/m1_n40459_3443# 100000
R1612 eeg_sdm1ct_0/eeg_fd_ota_full2_nc_0/eeg_fd_ota_core_soft_0/m1_n36459_3443# eeg_sdm1ct_0/eeg_fd_ota_full2_nc_0/eeg_fd_ota_core_soft_0/m1_n36059_n3864# 100000
R1613 eeg_sdm1ct_0/eeg_fd_ota_full2_nc_0/eeg_fd_ota_core_soft_0/m1_n32059_n3864# eeg_sdm1ct_0/eeg_fd_ota_full2_nc_0/eeg_fd_ota_core_soft_0/m1_n31659_3443# 100000
R1614 eeg_sdm1ct_0/eeg_fd_ota_full2_nc_0/eeg_fd_ota_core_soft_0/m1_n58459_n3864# eeg_sdm1ct_0/eeg_fd_ota_full2_nc_0/eeg_fd_ota_core_soft_0/m1_n58059_3443# 100000
R1615 eeg_sdm1ct_0/eeg_fd_ota_full2_nc_0/eeg_fd_ota_core_soft_0/m1_n36859_n3864# eeg_sdm1ct_0/eeg_fd_ota_full2_nc_0/eeg_fd_ota_core_soft_0/m1_n36459_3443# 100000
R1616 eeg_sdm1ct_0/eeg_fd_ota_full2_nc_0/eeg_fd_ota_core_soft_0/m1_n32459_3443# eeg_sdm1ct_0/eeg_fd_ota_full2_nc_0/eeg_fd_ota_core_soft_0/m1_n32059_n3864# 100000
R1617 eeg_sdm1ct_0/eeg_fd_ota_full2_nc_0/stage2_0/N2P eeg_sdm1ct_0/eeg_fd_ota_full2_nc_0/eeg_fd_ota_core_soft_0/m1_n58459_n3864# 100000
R1618 eeg_sdm1ct_0/eeg_fd_ota_full2_nc_0/eeg_fd_ota_core_soft_0/m1_n32859_n3864# eeg_sdm1ct_0/eeg_fd_ota_full2_nc_0/eeg_fd_ota_core_soft_0/m1_n32459_3443# 100000
R1619 eeg_sdm1ct_0/eeg_fd_ota_full2_nc_0/eeg_fd_ota_core_soft_0/m1_n28859_n3864# eeg_sdm1ct_0/eeg_fd_ota_full2_nc_0/eeg_cmfb_amp_dl2_0/VCM_SENSE 100000
X1620 VDD18 BIT eeg_sdm1ct_0/eeg_inv_0/Y VDD18 sky130_fd_pr__pfet_01v8 ad=2.04 pd=6.04 as=2.04 ps=6.04 w=2 l=0.15 nf=1
X1621 VSS BIT eeg_sdm1ct_0/eeg_inv_0/Y VSS sky130_fd_pr__nfet_01v8 ad=1.02 pd=4.04 as=1.02 ps=4.04 w=1 l=0.15 nf=1
X1622 eeg_sdm1ct_0/eeg_strongarm_0/m1_250_166# CLK16 VSS VSS sky130_fd_pr__nfet_01v8 ad=1 pd=5 as=2.54 ps=8.54 w=4 l=0.15 nf=2
X1623 VSS CLK16 eeg_sdm1ct_0/eeg_strongarm_0/m1_250_166# VSS sky130_fd_pr__nfet_01v8 ad=2.54 pd=8.54 as=1 ps=5 w=4 l=0.15 nf=2
X1626 eeg_sdm1ct_0/eeg_strongarm_0/m1_2620_1559# CLK16 VDD18 VDD18 sky130_fd_pr__pfet_01v8 ad=1.02 pd=4.04 as=1.02 ps=4.04 w=1 l=0.15 nf=1
X1627 eeg_sdm1ct_0/eeg_strongarm_0/m1_n4_2402# CLK16 VDD18 VDD18 sky130_fd_pr__pfet_01v8 ad=1.02 pd=4.04 as=1.02 ps=4.04 w=1 l=0.15 nf=1
X1628 VDD18 CLK16 eeg_sdm1ct_0/eeg_nand2_0/A VDD18 sky130_fd_pr__pfet_01v8 ad=1.02 pd=4.04 as=0.25 ps=1.5 w=1 l=0.15 nf=1
X1629 eeg_sdm1ct_0/eeg_nand2_0/A CLK16 VDD18 VDD18 sky130_fd_pr__pfet_01v8 ad=0.25 pd=1.5 as=1.02 ps=4.04 w=1 l=0.15 nf=1
X1630 VDD18 CLK16 eeg_sdm1ct_0/eeg_nand2_1/A VDD18 sky130_fd_pr__pfet_01v8 ad=1.02 pd=4.04 as=0.25 ps=1.5 w=1 l=0.15 nf=1
X1631 eeg_sdm1ct_0/eeg_nand2_1/A CLK16 VDD18 VDD18 sky130_fd_pr__pfet_01v8 ad=0.25 pd=1.5 as=1.02 ps=4.04 w=1 l=0.15 nf=1
X1632 eeg_sdm1ct_0/eeg_nand2_0/A eeg_sdm1ct_0/eeg_nand2_1/A VDD18 VDD18 sky130_fd_pr__pfet_01v8 ad=0.125 pd=1 as=0.15 ps=1.6 w=0.5 l=0.15 nf=1
X1633 VDD18 eeg_sdm1ct_0/eeg_nand2_1/A eeg_sdm1ct_0/eeg_nand2_0/A VDD18 sky130_fd_pr__pfet_01v8 ad=0.15 pd=1.6 as=0.125 ps=1 w=0.5 l=0.15 nf=1
X1634 eeg_sdm1ct_0/eeg_nand2_1/A eeg_sdm1ct_0/eeg_nand2_0/A VDD18 VDD18 sky130_fd_pr__pfet_01v8 ad=0.125 pd=1 as=0.15 ps=1.6 w=0.5 l=0.15 nf=1
X1635 VDD18 eeg_sdm1ct_0/eeg_nand2_0/A eeg_sdm1ct_0/eeg_nand2_1/A VDD18 sky130_fd_pr__pfet_01v8 ad=0.15 pd=1.6 as=0.125 ps=1 w=0.5 l=0.15 nf=1
X1636 eeg_sdm1ct_0/eeg_nand2_0/A eeg_sdm1ct_0/eeg_nand2_1/A eeg_sdm1ct_0/eeg_strongarm_0/m1_n4_2402# VSS sky130_fd_pr__nfet_01v8 ad=0.125 pd=1 as=0.15 ps=1.6 w=0.5 l=0.15 nf=1
X1637 eeg_sdm1ct_0/eeg_strongarm_0/m1_n4_2402# eeg_sdm1ct_0/eeg_nand2_1/A eeg_sdm1ct_0/eeg_nand2_0/A VSS sky130_fd_pr__nfet_01v8 ad=0.15 pd=1.6 as=0.125 ps=1 w=0.5 l=0.15 nf=1
X1638 eeg_sdm1ct_0/eeg_nand2_1/A eeg_sdm1ct_0/eeg_nand2_0/A eeg_sdm1ct_0/eeg_strongarm_0/m1_2620_1559# VSS sky130_fd_pr__nfet_01v8 ad=0.125 pd=1 as=0.15 ps=1.6 w=0.5 l=0.15 nf=1
X1639 eeg_sdm1ct_0/eeg_strongarm_0/m1_2620_1559# eeg_sdm1ct_0/eeg_nand2_0/A eeg_sdm1ct_0/eeg_nand2_1/A VSS sky130_fd_pr__nfet_01v8 ad=0.15 pd=1.6 as=0.125 ps=1 w=0.5 l=0.15 nf=1
X1640 eeg_sdm1ct_0/eeg_strongarm_0/m1_2620_1559# eeg_sdm1ct_0/OINTN eeg_sdm1ct_0/eeg_strongarm_0/m1_250_166# VSS sky130_fd_pr__nfet_01v8 ad=0.5 pd=3 as=1.27 ps=5.54 w=2 l=0.5 nf=2
X1641 eeg_sdm1ct_0/eeg_strongarm_0/m1_250_166# eeg_sdm1ct_0/OINTN eeg_sdm1ct_0/eeg_strongarm_0/m1_2620_1559# VSS sky130_fd_pr__nfet_01v8 ad=1.27 pd=5.54 as=0.5 ps=3 w=2 l=0.5 nf=2
X1644 eeg_sdm1ct_0/eeg_strongarm_0/m1_n4_2402# eeg_sdm1ct_0/OINTP eeg_sdm1ct_0/eeg_strongarm_0/m1_250_166# VSS sky130_fd_pr__nfet_01v8 ad=0.5 pd=3 as=1.27 ps=5.54 w=2 l=0.5 nf=2
X1645 eeg_sdm1ct_0/eeg_strongarm_0/m1_250_166# eeg_sdm1ct_0/OINTP eeg_sdm1ct_0/eeg_strongarm_0/m1_n4_2402# VSS sky130_fd_pr__nfet_01v8 ad=1.27 pd=5.54 as=0.5 ps=3 w=2 l=0.5 nf=2
R1648 eeg_sdm1ct_0/m1_57141_71443# eeg_sdm1ct_0/eeg_tg_lowq_1/A 100000
R1649 eeg_sdm1ct_0/m1_56741_64136# eeg_sdm1ct_0/m1_57141_71443# 100000
R1650 eeg_sdm1ct_0/m1_56341_71443# eeg_sdm1ct_0/m1_56741_64136# 100000
R1651 eeg_sdm1ct_0/m1_55941_64136# eeg_sdm1ct_0/m1_56341_71443# 100000
CMIM1652 VSS eeg_sdm1ct_0/eeg_nand2_0/A 1.000000e-12
CMIM1653 eeg_sdm1ct_0/eeg_pseudo_res_1/B eeg_sdm1ct_0/OINTN 2.000000e-11
CMIM1654 eeg_sdm1ct_0/eeg_pseudo_res_0/B eeg_sdm1ct_0/OINTP 2.000000e-11
CMIM1678 VSS eeg_sdm1ct_0/eeg_nand2_1/A 1.000000e-12
C0 BIT VDD18 1.630085e-16
C3 BIT VSS 2.477510e-16
C4 CLK16 NCLK16 7.364243e-17
C6 CLK16 VSS 5.362503e-16
C8 CLK16 eeg_sdm1ct_0/eeg_pseudo_res_1/B 3.422310e-17
C9 ELN VSS 2.477510e-16
C11 ELP VSS 2.477510e-16
C13 NBIT VDD18 4.116660e-17
C14 NBIT VSS 2.690423e-16
C15 NCLK16 VSS 2.471373e-16
C18 NPHIBI PHIBI 4.888966e-16
C19 NPHIBI VSS 8.094543e-16
C22 NPHIBM NPHIM 1.102720e-16
C23 NPHIBM PHIBM 4.379757e-16
C24 NPHIBM PHIM 1.337170e-16
C26 NPHIBM VDD18 2.879170e-16
C27 NPHIBM VSS 4.067405e-16
C29 NPHII PHIBI 6.586069e-16
C30 NPHII PHII 8.280726e-16
C31 NPHII VSS 6.319223e-16
C33 NPHII eeg_afe_pga_0/eeg_fd_ota_chopped_full2_0/eeg_fd_ota_core_soft_0/OUTP 1.226115e-16
C36 NPHII eeg_afe_pga_0/eeg_fd_ota_chopped_full2_0/eeg_fd_ota_core_soft_0/m1_n58059_3443# 4.859960e-17
C37 NPHIM PHIBM 7.502322e-16
C38 NPHIM PHIM 1.086422e-15
C40 NPHIM VDD18 2.337410e-16
C41 NPHIM VSS 7.347933e-16
C42 NPHIM PGA_OUTN 2.360112e-17
C44 PHIBI VSS 4.927140e-16
C46 PHIBI eeg_afe_pga_0/eeg_fd_ota_chopped_full2_0/eeg_fd_ota_core_soft_0/OUTP 2.487401e-17
C49 PHIBM PHIM 1.306746e-16
C51 PHIBM VDD18 2.337410e-16
C52 PHIBM VSS 6.763340e-16
C53 PHIBM PGA_OUTN 2.755440e-17
C54 PHII VSS 1.275583e-15
C55 PHII eeg_afe_pga_0/eeg_fd_ota_chopped_full2_0/eeg_fd_ota_core_soft_0/INN 3.258350e-16
C57 PHII eeg_afe_pga_0/eeg_fd_ota_chopped_full2_0/eeg_fd_ota_core_soft_0/OUTP 1.315708e-16
C60 PHII eeg_afe_pga_0/eeg_fd_ota_chopped_full2_0/eeg_fd_ota_core_soft_0/m1_n57259_3443# 2.791270e-17
C61 PHII eeg_afe_pga_0/eeg_fd_ota_chopped_full2_0/eeg_fd_ota_core_soft_0/m1_n58059_3443# 2.828190e-17
C62 PHIM VCM_REF 1.833550e-16
C63 PHIM VDD18 2.897180e-16
C64 PHIM VSS 1.498722e-15
C65 PHIM PGA_OUTN 2.063980e-17
C66 S16 S32 8.502417e-17
C67 S16 S8 8.436167e-17
C68 S16 VSS 2.522186e-16
C74 S32 VSS 2.888541e-16
C79 S64 VSS 2.480095e-16
C85 S8 VSS 2.517511e-16
C89 VCM_REF VDD18 1.122034e-15
C90 VCM_REF VSS 1.578799e-13
C91 VCM_REF eeg_afe_pga_0/eeg_fd_ota_chopped_full2_0/eeg_bias_gen_0/VBNF 7.567152e-17
C92 VCM_REF PGA_OUTN 3.292556e-16
C93 VCM_REF PGA_OUTP 3.292556e-16
C94 VCM_REF eeg_sdm1ct_0/eeg_fd_ota_full2_nc_0/eeg_bias_gen_0/VBNF 3.580094e-16
C95 VCM_REF eeg_sdm1ct_0/eeg_fd_ota_full2_nc_0/stage2_0/VBP2 8.192024e-16
C96 VCM_REF eeg_sdm1ct_0/eeg_fd_ota_full2_nc_0/stage2_0/VCM2 1.260568e-16
C100 VCM_REF eeg_sdm1ct_0/eeg_fd_ota_full2_nc_0/stage2_0/m1_79941_n8557# 2.252100e-17
C101 VCM_REF eeg_sdm1ct_0/eeg_fd_ota_full2_nc_0/stage2_0/m1_80341_n15864# 4.530660e-17
C102 VCM_REF eeg_sdm1ct_0/eeg_fd_ota_full2_nc_0/stage2_0/m1_80741_n8557# 8.863370e-17
C103 VCM_REF eeg_sdm1ct_0/eeg_fd_ota_full2_nc_0/stage2_0/m1_81141_n15864# 4.530650e-17
C104 VDD18 VN 4.524057e-17
C106 VDD18 VSS 2.410943e-13
C107 VDD18 eeg_sdm1ct_0/OINTN 3.180218e-16
C108 VDD18 eeg_sdm1ct_0/OINTP 2.547926e-16
C109 VDD18 PGA_OUTN 3.248550e-16
C110 VDD18 PGA_OUTP 3.292560e-16
C111 VDD18 eeg_sdm1ct_0/eeg_fd_ota_full2_nc_0/eeg_bias_gen_0/VBNF 6.959890e-16
C112 VDD18 eeg_sdm1ct_0/eeg_fd_ota_full2_nc_0/eeg_cmfb_amp_dl2_0/VBP 1.819151e-16
C113 VDD18 eeg_sdm1ct_0/eeg_fd_ota_full2_nc_0/eeg_cmfb_amp_dl2_0/VCM_SENSE 1.040760e-16
C114 VDD18 eeg_sdm1ct_0/eeg_fd_ota_full2_nc_0/eeg_fd_ota_core_soft_0/m1_n22658_111# 2.247274e-16
C115 VDD18 eeg_sdm1ct_0/eeg_fd_ota_full2_nc_0/stage2_0/N2N 1.296651e-16
C116 VDD18 eeg_sdm1ct_0/eeg_fd_ota_full2_nc_0/stage2_0/N2P 5.138845e-16
C117 VDD18 eeg_sdm1ct_0/eeg_fd_ota_full2_nc_0/stage2_0/VBP2 3.292560e-16
C118 VDD18 eeg_sdm1ct_0/eeg_inv_0/Y 4.853469e-17
C119 VDD18 eeg_sdm1ct_0/eeg_pseudo_res_0/B 7.073571e-16
C120 VDD18 eeg_sdm1ct_0/eeg_pseudo_res_1/B 3.319154e-14
C121 VDD18 eeg_sdm1ct_0/eeg_tg_lowq_1/A 4.134821e-16
C122 VDD18 eeg_sdm1ct_0/eeg_tg_lowq_3/A 6.097854e-16
C124 VN VSS 2.482072e-16
C126 VN eeg_sdm1ct_0/eeg_tg_lowq_3/A 4.505180e-17
C127 VP VSS 2.497790e-16
C129 VP eeg_sdm1ct_0/eeg_tg_lowq_3/A 4.932662e-17
C130 VSS eeg_afe_pga_0/eeg_fd_ota_chopped_full2_0/eeg_bias_gen_0/VBNF 1.785428e-15
C131 VSS eeg_afe_pga_0/eeg_fd_ota_chopped_full2_0/eeg_fd_ota_core_soft_0/INN 2.047417e-15
C132 VSS eeg_afe_pga_0/eeg_fd_ota_chopped_full2_0/eeg_fd_ota_core_soft_0/INP 1.647608e-15
C133 VSS eeg_afe_pga_0/eeg_fd_ota_chopped_full2_0/eeg_fd_ota_core_soft_0/OUTN 7.006609e-17
C134 VSS eeg_afe_pga_0/eeg_fd_ota_chopped_full2_0/eeg_fd_ota_core_soft_0/OUTP 7.356599e-17
C135 VSS eeg_afe_pga_0/eeg_fd_ota_chopped_full2_0/eeg_fd_ota_core_soft_0/m1_n22658_111# 3.742021e-15
C136 VSS eeg_afe_pga_0/eeg_fd_ota_chopped_full2_0/stage2_0/N2N 1.829147e-16
C137 VSS eeg_afe_pga_0/eeg_fd_ota_chopped_full2_0/stage2_0/N2P 1.946840e-16
C138 VSS eeg_afe_pga_0/eeg_fd_ota_chopped_full2_0/stage2_0/VBP2 2.711029e-15
C139 VSS eeg_afe_pga_0/eeg_inv_0/Y 1.330455e-16
C142 VSS eeg_afe_pga_0/eeg_tg_lowq_3/B 3.282854e-17
C143 VSS eeg_afe_pga_0/eeg_tg_lowq_7/B 3.266086e-17
C144 VSS PGA_OUTN 5.322801e-16
C145 VSS PGA_OUTP 1.211256e-15
C146 VSS eeg_sdm1ct_0/eeg_fd_ota_full2_nc_0/eeg_bias_gen_0/VBN 2.166943e-16
C147 VSS eeg_sdm1ct_0/eeg_fd_ota_full2_nc_0/eeg_bias_gen_0/VBNF 1.068361e-15
C148 VSS eeg_sdm1ct_0/eeg_fd_ota_full2_nc_0/eeg_bias_gen_0/VBP 1.449107e-16
C150 VSS eeg_sdm1ct_0/eeg_fd_ota_full2_nc_0/eeg_bias_gen_0/m1_2524_466# 2.174539e-16
C152 VSS eeg_sdm1ct_0/eeg_fd_ota_full2_nc_0/eeg_bias_gen_0/m1_9141_n2557# 2.558010e-17
C153 VSS eeg_sdm1ct_0/eeg_fd_ota_full2_nc_0/eeg_bias_gen_0/m1_9941_n2557# 6.854310e-17
C157 eeg_afe_pga_0/eeg_tg_lowq_0/A PGA_OUTN 1.107281e-14
C158 eeg_afe_pga_0/eeg_tg_lowq_0/A PGA_OUTP 3.494452e-17
C159 eeg_sdm1ct_0/OINTN VSS 2.470030e-16
C160 eeg_sdm1ct_0/OINTN eeg_sdm1ct_0/OINTP 8.356280e-17
C162 eeg_sdm1ct_0/OINTP VSS 2.470030e-16
C163 PGA_OUTN VSS 3.745080e-14
C164 PGA_OUTN PGA_OUTP 1.052809e-15
C165 PGA_OUTN eeg_sdm1ct_0/eeg_pseudo_res_0/B 1.573388e-16
C166 PGA_OUTN eeg_sdm1ct_0/eeg_pseudo_res_1/B 7.648020e-17
C168 PGA_OUTP VSS 2.913950e-14
C169 PGA_OUTP eeg_sdm1ct_0/eeg_pseudo_res_1/B 7.554730e-17
C170 PGA_OUTP eeg_sdm1ct_0/m1_55941_16136# 2.152830e-17
C175 ELN VSS 2.638090e-13
C176 ELN eeg_afe_pga_0/eeg_tg_lowq_3/B 1.649640e-12
C178 ELP VSS 2.637180e-13
C179 ELP eeg_afe_pga_0/eeg_tg_lowq_7/B 1.649630e-12
C180 ELP PGA_OUTP 4.077110e-17
C181 NPHIBM PGA_OUTN 7.152395e-15
C189 PHIM VCM_REF 3.178203e-15
C191 S16 S32 2.965713e-15
C192 S16 S8 2.936220e-15
C193 S16 VCM_REF 2.334550e-16
C194 S16 VDD18 8.569851e-16
C195 S16 VSS 1.360933e-14
C196 S16 eeg_afe_pga_0/eeg_inv_0/Y 5.250760e-16
C197 S16 eeg_afe_pga_0/eeg_inv_1/Y 1.635210e-16
C198 S16 eeg_afe_pga_0/eeg_inv_2/Y 3.874150e-15
C199 S16 eeg_afe_pga_0/eeg_inv_3/Y 1.963939e-16
C202 S16 eeg_afe_pga_0/eeg_tg_lowq_3/B 4.070530e-16
C206 S16 eeg_afe_pga_0/eeg_tg_lowq_7/B 1.862787e-16
C208 S32 S8 2.830191e-16
C209 S32 VDD18 5.584713e-16
C210 S32 VSS 9.102582e-15
C211 S32 eeg_afe_pga_0/eeg_inv_0/Y 8.054320e-17
C212 S32 eeg_afe_pga_0/eeg_inv_1/Y 3.842403e-15
C213 S32 eeg_afe_pga_0/eeg_inv_2/Y 1.807890e-16
C214 S32 eeg_afe_pga_0/eeg_inv_3/Y 2.594502e-16
C215 S32 eeg_afe_pga_0/eeg_tg_lowq_3/A 2.504586e-16
C216 S32 eeg_afe_pga_0/eeg_tg_lowq_3/B 6.058147e-16
C219 S32 eeg_afe_pga_0/eeg_tg_lowq_7/B 2.202522e-16
C221 S64 VSS 1.829050e-16
C222 S64 eeg_afe_pga_0/eeg_inv_0/Y 2.522730e-17
C223 S8 VDD18 4.441547e-16
C224 S8 VSS 8.759420e-15
C225 S8 eeg_afe_pga_0/eeg_inv_0/Y 9.197810e-17
C226 S8 eeg_afe_pga_0/eeg_inv_1/Y 1.969573e-16
C227 S8 eeg_afe_pga_0/eeg_inv_2/Y 1.710919e-16
C228 S8 eeg_afe_pga_0/eeg_inv_3/Y 3.687484e-15
C230 S8 eeg_afe_pga_0/eeg_tg_lowq_1/A 2.528970e-16
C231 S8 eeg_afe_pga_0/eeg_tg_lowq_3/B 1.831371e-16
C234 S8 eeg_afe_pga_0/eeg_tg_lowq_7/B 3.632385e-16
C236 VCM_REF VDD18 5.403918e-15
C237 VCM_REF VSS 5.261101e-14
C238 VCM_REF eeg_afe_pga_0/eeg_inv_0/Y 1.134379e-16
C239 VCM_REF eeg_afe_pga_0/eeg_inv_2/Y 2.559587e-16
C240 VCM_REF eeg_afe_pga_0/eeg_pseudo_res_0/m1_68_66# 8.033591e-17
C242 VCM_REF eeg_afe_pga_0/eeg_tg_lowq_0/A 1.151090e-16
C243 VCM_REF eeg_afe_pga_0/eeg_tg_lowq_1/A 1.158659e-16
C245 VCM_REF eeg_afe_pga_0/eeg_tg_lowq_3/B 1.703838e-15
C246 VCM_REF eeg_afe_pga_0/eeg_tg_lowq_5/A 1.152887e-16
C247 VCM_REF eeg_afe_pga_0/eeg_tg_lowq_6/A 3.273310e-16
C249 VCM_REF eeg_afe_pga_0/eeg_tg_lowq_7/B 1.258160e-15
C250 VCM_REF PGA_OUTN 1.401636e-15
C251 VCM_REF PGA_OUTP 5.351555e-15
C252 VDD18 VSS 3.861065e-14
C254 VDD18 eeg_afe_pga_0/eeg_inv_0/Y 1.144057e-15
C255 VDD18 eeg_afe_pga_0/eeg_inv_1/Y 3.732202e-16
C256 VDD18 eeg_afe_pga_0/eeg_inv_2/Y 8.589415e-16
C257 VDD18 eeg_afe_pga_0/eeg_inv_3/Y 4.824141e-16
C258 VDD18 eeg_afe_pga_0/eeg_pseudo_res_0/m1_68_66# 3.773776e-17
C260 VDD18 eeg_afe_pga_0/eeg_tg_lowq_0/A 1.288053e-16
C261 VDD18 eeg_afe_pga_0/eeg_tg_lowq_1/A 2.765245e-16
C262 VDD18 eeg_afe_pga_0/eeg_tg_lowq_3/A 2.494412e-16
C263 VDD18 eeg_afe_pga_0/eeg_tg_lowq_3/B 2.300143e-15
C267 VDD18 eeg_afe_pga_0/eeg_tg_lowq_7/B 2.110887e-15
C268 VDD18 PGA_OUTN 4.215517e-16
C269 VDD18 PGA_OUTP 3.299253e-16
C275 VSS eeg_afe_pga_0/eeg_inv_0/Y 2.528170e-15
C276 VSS eeg_afe_pga_0/eeg_inv_1/Y 9.912649e-16
C277 VSS eeg_afe_pga_0/eeg_inv_2/Y 1.738263e-15
C278 VSS eeg_afe_pga_0/eeg_inv_3/Y 2.362128e-15
C279 VSS eeg_afe_pga_0/eeg_pseudo_res_0/m1_68_66# 1.014106e-16
C280 VSS eeg_afe_pga_0/eeg_pseudo_res_1/m1_68_66# 1.013884e-16
C281 VSS eeg_afe_pga_0/eeg_tg_lowq_0/A 1.774290e-16
C282 VSS eeg_afe_pga_0/eeg_tg_lowq_1/A 2.172052e-16
C283 VSS eeg_afe_pga_0/eeg_tg_lowq_3/A 2.161019e-16
C284 VSS eeg_afe_pga_0/eeg_tg_lowq_3/B 1.438985e-15
C288 VSS eeg_afe_pga_0/eeg_tg_lowq_7/B 1.393810e-15
C289 VSS PGA_OUTN 2.741759e-16
C290 VSS PGA_OUTP 8.798251e-16
C292 eeg_afe_pga_0/eeg_fd_ota_chopped_full2_0/eeg_bias_gen_0/VBN PGA_OUTN 1.426901e-15
C293 eeg_afe_pga_0/eeg_fd_ota_chopped_full2_0/eeg_bias_gen_0/VBN PGA_OUTP 2.810870e-16
C296 eeg_afe_pga_0/eeg_fd_ota_chopped_full2_0/eeg_bias_gen_0/VBNF PGA_OUTN 7.085244e-16
C297 eeg_afe_pga_0/eeg_fd_ota_chopped_full2_0/eeg_bias_gen_0/VBNF PGA_OUTP 5.446466e-16
C298 eeg_afe_pga_0/eeg_fd_ota_chopped_full2_0/eeg_bias_gen_0/VBP PGA_OUTN 1.088385e-15
C299 eeg_afe_pga_0/eeg_fd_ota_chopped_full2_0/eeg_bias_gen_0/VBP PGA_OUTP 1.778339e-16
C300 eeg_afe_pga_0/eeg_fd_ota_chopped_full2_0/eeg_bias_gen_0/m1_2524_466# PGA_OUTN 2.249370e-16
C301 eeg_afe_pga_0/eeg_fd_ota_chopped_full2_0/eeg_bias_gen_0/m1_2524_466# PGA_OUTP 4.808215e-17
C302 eeg_afe_pga_0/eeg_fd_ota_chopped_full2_0/stage2_0/VBP2 PGA_OUTN 1.189328e-15
C303 eeg_afe_pga_0/eeg_fd_ota_chopped_full2_0/stage2_0/VBP2 PGA_OUTP 2.745872e-16
C304 eeg_afe_pga_0/eeg_fd_ota_chopped_full2_0/stage2_0/VCM2 PGA_OUTP 4.872794e-16
C305 eeg_afe_pga_0/eeg_inv_0/Y VSS 1.661140e-14
C306 eeg_afe_pga_0/eeg_inv_0/Y eeg_afe_pga_0/eeg_inv_1/Y 2.847579e-15
C307 eeg_afe_pga_0/eeg_inv_0/Y eeg_afe_pga_0/eeg_inv_2/Y 3.177184e-15
C308 eeg_afe_pga_0/eeg_inv_0/Y eeg_afe_pga_0/eeg_inv_3/Y 1.808354e-16
C309 eeg_afe_pga_0/eeg_inv_0/Y eeg_afe_pga_0/eeg_pseudo_res_1/m1_68_66# 2.454043e-17
C310 eeg_afe_pga_0/eeg_inv_0/Y eeg_afe_pga_0/eeg_tg_lowq_3/B 5.508493e-16
C311 eeg_afe_pga_0/eeg_inv_0/Y eeg_afe_pga_0/eeg_tg_lowq_7/B 5.955675e-16
C313 eeg_afe_pga_0/eeg_inv_1/Y VSS 6.503700e-15
C314 eeg_afe_pga_0/eeg_inv_1/Y eeg_afe_pga_0/eeg_inv_2/Y 2.945199e-15
C315 eeg_afe_pga_0/eeg_inv_1/Y eeg_afe_pga_0/eeg_inv_3/Y 2.199884e-16
C316 eeg_afe_pga_0/eeg_inv_1/Y eeg_afe_pga_0/eeg_tg_lowq_3/A 1.831984e-16
C317 eeg_afe_pga_0/eeg_inv_1/Y eeg_afe_pga_0/eeg_tg_lowq_3/B 5.751400e-16
C319 eeg_afe_pga_0/eeg_inv_1/Y eeg_afe_pga_0/eeg_tg_lowq_7/B 4.810019e-16
C321 eeg_afe_pga_0/eeg_inv_2/Y VSS 1.035860e-14
C322 eeg_afe_pga_0/eeg_inv_2/Y eeg_afe_pga_0/eeg_inv_3/Y 3.285369e-15
C324 eeg_afe_pga_0/eeg_inv_2/Y eeg_afe_pga_0/eeg_tg_lowq_3/B 3.442526e-16
C326 eeg_afe_pga_0/eeg_inv_2/Y eeg_afe_pga_0/eeg_tg_lowq_7/B 1.837304e-16
C328 eeg_afe_pga_0/eeg_inv_3/Y VSS 7.444670e-15
C330 eeg_afe_pga_0/eeg_inv_3/Y eeg_afe_pga_0/eeg_tg_lowq_1/A 1.931899e-16
C331 eeg_afe_pga_0/eeg_inv_3/Y eeg_afe_pga_0/eeg_tg_lowq_3/B 1.869698e-16
C333 eeg_afe_pga_0/eeg_inv_3/Y eeg_afe_pga_0/eeg_tg_lowq_7/B 2.928868e-16
C335 eeg_afe_pga_0/eeg_pseudo_res_0/m1_68_66# eeg_afe_pga_0/eeg_pseudo_res_1/m1_68_66# 5.733833e-17
C340 eeg_afe_pga_0/eeg_tg_lowq_0/A VSS 2.551130e-14
C341 eeg_afe_pga_0/eeg_tg_lowq_0/A eeg_afe_pga_0/eeg_tg_lowq_1/A 3.736297e-16
C342 eeg_afe_pga_0/eeg_tg_lowq_0/A eeg_afe_pga_0/eeg_tg_lowq_3/B 4.501243e-17
C344 eeg_afe_pga_0/eeg_tg_lowq_0/A eeg_afe_pga_0/eeg_tg_lowq_7/B 5.672617e-16
C345 eeg_afe_pga_0/eeg_tg_lowq_0/A PGA_OUTN 1.531580e-15
C346 eeg_afe_pga_0/eeg_tg_lowq_0/A PGA_OUTP 7.468640e-14
C347 eeg_afe_pga_0/eeg_tg_lowq_1/A VSS 3.182830e-14
C348 eeg_afe_pga_0/eeg_tg_lowq_1/A eeg_afe_pga_0/eeg_tg_lowq_3/B 3.185743e-17
C349 eeg_afe_pga_0/eeg_tg_lowq_1/A eeg_afe_pga_0/eeg_tg_lowq_5/A 1.416121e-15
C350 eeg_afe_pga_0/eeg_tg_lowq_1/A eeg_afe_pga_0/eeg_tg_lowq_7/B 3.342168e-16
C351 eeg_afe_pga_0/eeg_tg_lowq_1/A PGA_OUTN 1.215850e-14
C352 eeg_afe_pga_0/eeg_tg_lowq_1/A PGA_OUTP 1.869058e-13
C353 eeg_afe_pga_0/eeg_tg_lowq_3/A VSS 2.189780e-14
C354 eeg_afe_pga_0/eeg_tg_lowq_3/A eeg_afe_pga_0/eeg_tg_lowq_3/B 5.800602e-16
C355 eeg_afe_pga_0/eeg_tg_lowq_3/A eeg_afe_pga_0/eeg_tg_lowq_7/A 3.495687e-16
C356 eeg_afe_pga_0/eeg_tg_lowq_3/A eeg_afe_pga_0/eeg_tg_lowq_7/B 4.334840e-16
C357 eeg_afe_pga_0/eeg_tg_lowq_3/A PGA_OUTN 1.520450e-15
C358 eeg_afe_pga_0/eeg_tg_lowq_3/A PGA_OUTP 2.326716e-14
C359 eeg_afe_pga_0/eeg_tg_lowq_3/B VSS 4.877290e-14
C360 eeg_afe_pga_0/eeg_tg_lowq_3/B eeg_afe_pga_0/eeg_tg_lowq_7/B 1.023261e-14
C362 eeg_afe_pga_0/eeg_tg_lowq_3/B PGA_OUTP 2.348810e-14
C363 eeg_afe_pga_0/eeg_tg_lowq_5/A VSS 2.132890e-14
C364 eeg_afe_pga_0/eeg_tg_lowq_5/A eeg_afe_pga_0/eeg_tg_lowq_6/A 3.984771e-17
C365 eeg_afe_pga_0/eeg_tg_lowq_5/A eeg_afe_pga_0/eeg_tg_lowq_7/B 3.369303e-17
C366 eeg_afe_pga_0/eeg_tg_lowq_5/A PGA_OUTN 1.872870e-13
C367 eeg_afe_pga_0/eeg_tg_lowq_5/A PGA_OUTP 9.308394e-16
C368 eeg_afe_pga_0/eeg_tg_lowq_6/A VSS 1.131540e-14
C369 eeg_afe_pga_0/eeg_tg_lowq_6/A eeg_afe_pga_0/eeg_tg_lowq_7/A 2.534778e-17
C371 eeg_afe_pga_0/eeg_tg_lowq_6/A PGA_OUTN 7.889160e-14
C372 eeg_afe_pga_0/eeg_tg_lowq_6/A PGA_OUTP 9.388685e-16
C373 eeg_afe_pga_0/eeg_tg_lowq_7/A VSS 4.047010e-15
C374 eeg_afe_pga_0/eeg_tg_lowq_7/A eeg_afe_pga_0/eeg_tg_lowq_7/B 1.355538e-16
C375 eeg_afe_pga_0/eeg_tg_lowq_7/A PGA_OUTN 2.359180e-14
C376 eeg_afe_pga_0/eeg_tg_lowq_7/A PGA_OUTP 9.581515e-16
C377 eeg_afe_pga_0/eeg_tg_lowq_7/B VSS 6.170890e-14
C378 eeg_afe_pga_0/eeg_tg_lowq_7/B PGA_OUTN 2.421910e-14
C379 eeg_afe_pga_0/eeg_tg_lowq_7/B PGA_OUTP 1.189056e-15
C380 PGA_OUTN VSS 1.656860e-13
C381 PGA_OUTN PGA_OUTP 4.993308e-14
C382 PGA_OUTP VSS 2.022910e-13
C385 NPHIBM NPHIM 1.278695e-16
C386 NPHIBM PHIBM 3.689518e-14
C387 NPHIBM PHIM 1.340413e-16
C388 NPHIBM VCM_REF 1.502170e-16
C389 NPHIBM VDD18 1.525209e-16
C390 NPHIBM VSS 3.774740e-14
C391 NPHIBM eeg_afe_pga_0/eeg_fd_ota_chopped_full2_0/eeg_bias_gen_0/VBNF 1.413920e-16
C393 NPHIBM eeg_afe_pga_0/eeg_fd_ota_chopped_full2_0/eeg_fd_ota_core_soft_0/OUTN 1.767125e-16
C394 NPHIBM eeg_afe_pga_0/eeg_fd_ota_chopped_full2_0/eeg_fd_ota_core_soft_0/OUTP 1.189021e-16
C400 NPHIM PHIBM 3.680056e-14
C401 NPHIM PHIM 3.702725e-14
C402 NPHIM VCM_REF 1.652870e-16
C403 NPHIM VDD18 1.530988e-16
C404 NPHIM VSS 8.383554e-15
C405 NPHIM eeg_afe_pga_0/eeg_fd_ota_chopped_full2_0/eeg_bias_gen_0/VBNF 1.364720e-16
C407 NPHIM eeg_afe_pga_0/eeg_fd_ota_chopped_full2_0/eeg_fd_ota_core_soft_0/OUTN 1.516516e-16
C408 NPHIM eeg_afe_pga_0/eeg_fd_ota_chopped_full2_0/eeg_fd_ota_core_soft_0/OUTP 1.024342e-15
C414 PHIBM PHIM 1.120990e-16
C415 PHIBM VCM_REF 1.651930e-16
C416 PHIBM VDD18 1.567750e-16
C417 PHIBM VSS 9.079500e-15
C418 PHIBM eeg_afe_pga_0/eeg_fd_ota_chopped_full2_0/eeg_bias_gen_0/VBNF 1.386430e-16
C420 PHIBM eeg_afe_pga_0/eeg_fd_ota_chopped_full2_0/eeg_fd_ota_core_soft_0/OUTN 2.135593e-16
C421 PHIBM eeg_afe_pga_0/eeg_fd_ota_chopped_full2_0/eeg_fd_ota_core_soft_0/OUTP 8.573296e-16
C422 PHIBM eeg_afe_pga_0/eeg_fd_ota_chopped_full2_0/stage2_0/N2N 2.818096e-17
C429 PHIM VCM_REF 1.597600e-15
C430 PHIM VDD18 1.593344e-16
C431 PHIM VSS 2.788475e-14
C432 PHIM eeg_afe_pga_0/eeg_fd_ota_chopped_full2_0/eeg_bias_gen_0/VBNF 1.393190e-16
C433 PHIM eeg_afe_pga_0/eeg_fd_ota_chopped_full2_0/eeg_cmfb_amp_dl2_0/VBP 3.735676e-15
C434 PHIM eeg_afe_pga_0/eeg_fd_ota_chopped_full2_0/eeg_fd_ota_core_soft_0/OUTN 1.626646e-16
C435 PHIM eeg_afe_pga_0/eeg_fd_ota_chopped_full2_0/eeg_fd_ota_core_soft_0/OUTP 2.696166e-16
C438 VCM_REF VDD18 2.925411e-15
C439 VCM_REF VSS 4.378994e-14
C440 VCM_REF eeg_afe_pga_0/eeg_fd_ota_chopped_full2_0/eeg_bias_gen_0/VBNF 1.760523e-14
C441 VCM_REF eeg_afe_pga_0/eeg_fd_ota_chopped_full2_0/eeg_cmfb_amp_dl2_0/VBP 3.039269e-15
C442 VCM_REF eeg_afe_pga_0/eeg_fd_ota_chopped_full2_0/eeg_cmfb_amp_dl2_0/VCM_SENSE 2.946854e-16
C447 VCM_REF eeg_afe_pga_0/eeg_fd_ota_chopped_full2_0/eeg_fd_ota_core_soft_0/OUTN 1.978812e-16
C448 VCM_REF eeg_afe_pga_0/eeg_fd_ota_chopped_full2_0/eeg_fd_ota_core_soft_0/OUTP 3.238353e-16
C449 VCM_REF eeg_afe_pga_0/eeg_fd_ota_chopped_full2_0/stage2_0/VBP2 4.836588e-15
C450 VCM_REF eeg_afe_pga_0/eeg_fd_ota_chopped_full2_0/stage2_0/VCM2 1.339766e-16
C451 VDD18 VSS 1.098004e-13
C453 VDD18 eeg_afe_pga_0/eeg_fd_ota_chopped_full2_0/eeg_bias_gen_0/VBNF 2.280093e-14
C454 VDD18 eeg_afe_pga_0/eeg_fd_ota_chopped_full2_0/eeg_bias_gen_0/eeg_pseudo_res_0/m1_68_66# 9.173609e-17
C455 VDD18 eeg_afe_pga_0/eeg_fd_ota_chopped_full2_0/eeg_cmfb_amp_dl2_0/VBP 5.412926e-16
C456 VDD18 eeg_afe_pga_0/eeg_fd_ota_chopped_full2_0/eeg_cmfb_amp_dl2_0/VCM_SENSE 6.617475e-16
C461 VDD18 eeg_afe_pga_0/eeg_fd_ota_chopped_full2_0/eeg_fd_ota_core_soft_0/OUTN 1.485477e-16
C462 VDD18 eeg_afe_pga_0/eeg_fd_ota_chopped_full2_0/eeg_fd_ota_core_soft_0/OUTP 3.204062e-16
C463 VDD18 eeg_afe_pga_0/eeg_fd_ota_chopped_full2_0/stage2_0/N2N 8.484494e-17
C464 VDD18 eeg_afe_pga_0/eeg_fd_ota_chopped_full2_0/stage2_0/N2P 1.115579e-16
C465 VDD18 eeg_afe_pga_0/eeg_fd_ota_chopped_full2_0/stage2_0/VBP2 2.659302e-16
C471 VSS eeg_afe_pga_0/eeg_fd_ota_chopped_full2_0/eeg_bias_gen_0/VBN 6.624060e-17
C472 VSS eeg_afe_pga_0/eeg_fd_ota_chopped_full2_0/eeg_bias_gen_0/VBNF 7.394524e-15
C475 VSS eeg_afe_pga_0/eeg_fd_ota_chopped_full2_0/eeg_bias_gen_0/m1_3701_n11401# 5.414340e-17
C476 VSS eeg_afe_pga_0/eeg_fd_ota_chopped_full2_0/eeg_bias_gen_0/m1_4341_n2557# 6.618650e-17
C477 VSS eeg_afe_pga_0/eeg_fd_ota_chopped_full2_0/eeg_bias_gen_0/m1_5141_n2557# 6.618650e-17
C478 VSS eeg_afe_pga_0/eeg_fd_ota_chopped_full2_0/eeg_bias_gen_0/m1_5941_n2557# 6.618650e-17
C479 VSS eeg_afe_pga_0/eeg_fd_ota_chopped_full2_0/eeg_bias_gen_0/m1_6741_n2557# 6.618650e-17
C480 VSS eeg_afe_pga_0/eeg_fd_ota_chopped_full2_0/eeg_bias_gen_0/m1_7541_n2557# 6.637850e-17
C481 VSS eeg_afe_pga_0/eeg_fd_ota_chopped_full2_0/eeg_bias_gen_0/m1_8341_n2557# 7.296267e-17
C482 VSS eeg_afe_pga_0/eeg_fd_ota_chopped_full2_0/eeg_bias_gen_0/m1_9141_n2557# 8.982074e-17
C483 VSS eeg_afe_pga_0/eeg_fd_ota_chopped_full2_0/eeg_bias_gen_0/m1_9941_n2557# 3.857350e-17
C484 VSS eeg_afe_pga_0/eeg_fd_ota_chopped_full2_0/eeg_cmfb_amp_dl2_0/VCM_SENSE 2.286714e-16
C486 VSS eeg_afe_pga_0/eeg_fd_ota_chopped_full2_0/eeg_fd_ota_core_soft_0/INN 5.272137e-16
C487 VSS eeg_afe_pga_0/eeg_fd_ota_chopped_full2_0/eeg_fd_ota_core_soft_0/INP 2.553497e-16
C488 VSS eeg_afe_pga_0/eeg_fd_ota_chopped_full2_0/eeg_fd_ota_core_soft_0/OUTN 5.400498e-16
C489 VSS eeg_afe_pga_0/eeg_fd_ota_chopped_full2_0/eeg_fd_ota_core_soft_0/OUTP 2.642600e-16
C497 VSS eeg_afe_pga_0/eeg_fd_ota_chopped_full2_0/eeg_fd_ota_core_soft_0/m1_31941_3443# 5.111280e-17
C499 VSS eeg_afe_pga_0/eeg_fd_ota_chopped_full2_0/eeg_fd_ota_core_soft_0/m1_32741_3443# 3.687720e-17
C530 VSS eeg_afe_pga_0/eeg_fd_ota_chopped_full2_0/eeg_fd_ota_core_soft_0/m1_n22658_111# 4.238442e-16
C566 VSS eeg_afe_pga_0/eeg_fd_ota_chopped_full2_0/stage2_0/N2N 3.219981e-16
C567 VSS eeg_afe_pga_0/eeg_fd_ota_chopped_full2_0/stage2_0/N2P 2.741467e-16
C568 VSS eeg_afe_pga_0/eeg_fd_ota_chopped_full2_0/stage2_0/VBP2 5.043700e-15
C569 VSS eeg_afe_pga_0/eeg_fd_ota_chopped_full2_0/stage2_0/VCM2 6.769180e-16
C571 VSS PGA_OUTN 4.571667e-16
C572 VSS PGA_OUTP 3.752509e-16
C573 eeg_afe_pga_0/eeg_fd_ota_chopped_full2_0/eeg_bias_gen_0/VBN eeg_afe_pga_0/eeg_fd_ota_chopped_full2_0/eeg_bias_gen_0/VBNF 4.256316e-16
C574 eeg_afe_pga_0/eeg_fd_ota_chopped_full2_0/eeg_bias_gen_0/VBNF VSS 6.367410e-14
C576 eeg_afe_pga_0/eeg_fd_ota_chopped_full2_0/eeg_bias_gen_0/VBNF eeg_afe_pga_0/eeg_fd_ota_chopped_full2_0/eeg_bias_gen_0/eeg_pseudo_res_0/m1_68_66# 1.772757e-16
C580 eeg_afe_pga_0/eeg_fd_ota_chopped_full2_0/eeg_bias_gen_0/VBNF eeg_afe_pga_0/eeg_fd_ota_chopped_full2_0/eeg_cmfb_amp_dl2_0/VBP 2.452100e-16
C581 eeg_afe_pga_0/eeg_fd_ota_chopped_full2_0/eeg_bias_gen_0/VBNF eeg_afe_pga_0/eeg_fd_ota_chopped_full2_0/eeg_cmfb_amp_dl2_0/VCM_SENSE 2.222844e-16
C582 eeg_afe_pga_0/eeg_fd_ota_chopped_full2_0/eeg_bias_gen_0/VBNF eeg_afe_pga_0/eeg_fd_ota_chopped_full2_0/eeg_cmfb_amp_dl2_0/m1_370_1493# 4.385375e-17
C583 eeg_afe_pga_0/eeg_fd_ota_chopped_full2_0/eeg_bias_gen_0/VBNF eeg_afe_pga_0/eeg_fd_ota_chopped_full2_0/eeg_cmfb_amp_dl2_0/m1_68_166# 3.222660e-17
C584 eeg_afe_pga_0/eeg_fd_ota_chopped_full2_0/eeg_bias_gen_0/VBNF eeg_afe_pga_0/eeg_fd_ota_chopped_full2_0/eeg_cmfb_amp_dl2_s2_0/m1_370_1493# 4.385371e-17
C586 eeg_afe_pga_0/eeg_fd_ota_chopped_full2_0/eeg_bias_gen_0/VBNF eeg_afe_pga_0/eeg_fd_ota_chopped_full2_0/eeg_fd_ota_core_soft_0/OUTN 2.279440e-16
C587 eeg_afe_pga_0/eeg_fd_ota_chopped_full2_0/eeg_bias_gen_0/VBNF eeg_afe_pga_0/eeg_fd_ota_chopped_full2_0/eeg_fd_ota_core_soft_0/OUTP 3.766246e-16
C588 eeg_afe_pga_0/eeg_fd_ota_chopped_full2_0/eeg_bias_gen_0/VBNF eeg_afe_pga_0/eeg_fd_ota_chopped_full2_0/eeg_fd_ota_core_soft_0/m1_28341_n3864# 5.192510e-17
C589 eeg_afe_pga_0/eeg_fd_ota_chopped_full2_0/eeg_bias_gen_0/VBNF eeg_afe_pga_0/eeg_fd_ota_chopped_full2_0/eeg_fd_ota_core_soft_0/m1_29141_n3864# 5.057920e-17
C590 eeg_afe_pga_0/eeg_fd_ota_chopped_full2_0/eeg_bias_gen_0/VBNF eeg_afe_pga_0/eeg_fd_ota_chopped_full2_0/eeg_fd_ota_core_soft_0/m1_29941_n3864# 5.057930e-17
C591 eeg_afe_pga_0/eeg_fd_ota_chopped_full2_0/eeg_bias_gen_0/VBNF eeg_afe_pga_0/eeg_fd_ota_chopped_full2_0/eeg_fd_ota_core_soft_0/m1_30741_n3864# 5.057930e-17
C592 eeg_afe_pga_0/eeg_fd_ota_chopped_full2_0/eeg_bias_gen_0/VBNF eeg_afe_pga_0/eeg_fd_ota_chopped_full2_0/eeg_fd_ota_core_soft_0/m1_31541_n3864# 5.057930e-17
C593 eeg_afe_pga_0/eeg_fd_ota_chopped_full2_0/eeg_bias_gen_0/VBNF eeg_afe_pga_0/eeg_fd_ota_chopped_full2_0/eeg_fd_ota_core_soft_0/m1_32341_n3864# 5.057928e-17
C594 eeg_afe_pga_0/eeg_fd_ota_chopped_full2_0/eeg_bias_gen_0/VBNF eeg_afe_pga_0/eeg_fd_ota_chopped_full2_0/eeg_fd_ota_core_soft_0/m1_33141_n3864# 5.057930e-17
C595 eeg_afe_pga_0/eeg_fd_ota_chopped_full2_0/eeg_bias_gen_0/VBNF eeg_afe_pga_0/eeg_fd_ota_chopped_full2_0/eeg_fd_ota_core_soft_0/m1_33941_n3864# 5.057930e-17
C596 eeg_afe_pga_0/eeg_fd_ota_chopped_full2_0/eeg_bias_gen_0/VBNF eeg_afe_pga_0/eeg_fd_ota_chopped_full2_0/eeg_fd_ota_core_soft_0/m1_34741_n3864# 5.057920e-17
C597 eeg_afe_pga_0/eeg_fd_ota_chopped_full2_0/eeg_bias_gen_0/VBNF eeg_afe_pga_0/eeg_fd_ota_chopped_full2_0/eeg_fd_ota_core_soft_0/m1_35541_n3864# 5.057930e-17
C598 eeg_afe_pga_0/eeg_fd_ota_chopped_full2_0/eeg_bias_gen_0/VBNF eeg_afe_pga_0/eeg_fd_ota_chopped_full2_0/eeg_fd_ota_core_soft_0/m1_36341_n3864# 5.057930e-17
C599 eeg_afe_pga_0/eeg_fd_ota_chopped_full2_0/eeg_bias_gen_0/VBNF eeg_afe_pga_0/eeg_fd_ota_chopped_full2_0/eeg_fd_ota_core_soft_0/m1_37141_n3864# 5.057930e-17
C600 eeg_afe_pga_0/eeg_fd_ota_chopped_full2_0/eeg_bias_gen_0/VBNF eeg_afe_pga_0/eeg_fd_ota_chopped_full2_0/eeg_fd_ota_core_soft_0/m1_37941_n3864# 5.057928e-17
C601 eeg_afe_pga_0/eeg_fd_ota_chopped_full2_0/eeg_bias_gen_0/VBNF eeg_afe_pga_0/eeg_fd_ota_chopped_full2_0/eeg_fd_ota_core_soft_0/m1_38741_n3864# 5.057930e-17
C602 eeg_afe_pga_0/eeg_fd_ota_chopped_full2_0/eeg_bias_gen_0/VBNF eeg_afe_pga_0/eeg_fd_ota_chopped_full2_0/eeg_fd_ota_core_soft_0/m1_39541_n3864# 5.057930e-17
C603 eeg_afe_pga_0/eeg_fd_ota_chopped_full2_0/eeg_bias_gen_0/VBNF eeg_afe_pga_0/eeg_fd_ota_chopped_full2_0/eeg_fd_ota_core_soft_0/m1_40341_n3864# 5.057920e-17
C604 eeg_afe_pga_0/eeg_fd_ota_chopped_full2_0/eeg_bias_gen_0/VBNF eeg_afe_pga_0/eeg_fd_ota_chopped_full2_0/eeg_fd_ota_core_soft_0/m1_41141_n3864# 5.057930e-17
C605 eeg_afe_pga_0/eeg_fd_ota_chopped_full2_0/eeg_bias_gen_0/VBNF eeg_afe_pga_0/eeg_fd_ota_chopped_full2_0/eeg_fd_ota_core_soft_0/m1_41941_n3864# 5.057930e-17
C606 eeg_afe_pga_0/eeg_fd_ota_chopped_full2_0/eeg_bias_gen_0/VBNF eeg_afe_pga_0/eeg_fd_ota_chopped_full2_0/eeg_fd_ota_core_soft_0/m1_42741_n3864# 5.057930e-17
C607 eeg_afe_pga_0/eeg_fd_ota_chopped_full2_0/eeg_bias_gen_0/VBNF eeg_afe_pga_0/eeg_fd_ota_chopped_full2_0/eeg_fd_ota_core_soft_0/m1_43541_n3864# 5.057928e-17
C608 eeg_afe_pga_0/eeg_fd_ota_chopped_full2_0/eeg_bias_gen_0/VBNF eeg_afe_pga_0/eeg_fd_ota_chopped_full2_0/eeg_fd_ota_core_soft_0/m1_44341_n3864# 5.057930e-17
C609 eeg_afe_pga_0/eeg_fd_ota_chopped_full2_0/eeg_bias_gen_0/VBNF eeg_afe_pga_0/eeg_fd_ota_chopped_full2_0/eeg_fd_ota_core_soft_0/m1_45141_n3864# 5.057930e-17
C610 eeg_afe_pga_0/eeg_fd_ota_chopped_full2_0/eeg_bias_gen_0/VBNF eeg_afe_pga_0/eeg_fd_ota_chopped_full2_0/eeg_fd_ota_core_soft_0/m1_45941_n3864# 5.057920e-17
C611 eeg_afe_pga_0/eeg_fd_ota_chopped_full2_0/eeg_bias_gen_0/VBNF eeg_afe_pga_0/eeg_fd_ota_chopped_full2_0/eeg_fd_ota_core_soft_0/m1_46741_n3864# 5.057930e-17
C612 eeg_afe_pga_0/eeg_fd_ota_chopped_full2_0/eeg_bias_gen_0/VBNF eeg_afe_pga_0/eeg_fd_ota_chopped_full2_0/eeg_fd_ota_core_soft_0/m1_47541_n3864# 5.192520e-17
C613 eeg_afe_pga_0/eeg_fd_ota_chopped_full2_0/eeg_bias_gen_0/VBNF eeg_afe_pga_0/eeg_fd_ota_chopped_full2_0/eeg_fd_ota_core_soft_0/m1_50741_n3864# 5.192510e-17
C614 eeg_afe_pga_0/eeg_fd_ota_chopped_full2_0/eeg_bias_gen_0/VBNF eeg_afe_pga_0/eeg_fd_ota_chopped_full2_0/eeg_fd_ota_core_soft_0/m1_51541_n3864# 5.057920e-17
C615 eeg_afe_pga_0/eeg_fd_ota_chopped_full2_0/eeg_bias_gen_0/VBNF eeg_afe_pga_0/eeg_fd_ota_chopped_full2_0/eeg_fd_ota_core_soft_0/m1_52341_n3864# 5.057930e-17
C616 eeg_afe_pga_0/eeg_fd_ota_chopped_full2_0/eeg_bias_gen_0/VBNF eeg_afe_pga_0/eeg_fd_ota_chopped_full2_0/eeg_fd_ota_core_soft_0/m1_53141_n3864# 5.057930e-17
C617 eeg_afe_pga_0/eeg_fd_ota_chopped_full2_0/eeg_bias_gen_0/VBNF eeg_afe_pga_0/eeg_fd_ota_chopped_full2_0/eeg_fd_ota_core_soft_0/m1_53941_n3864# 5.057930e-17
C618 eeg_afe_pga_0/eeg_fd_ota_chopped_full2_0/eeg_bias_gen_0/VBNF eeg_afe_pga_0/eeg_fd_ota_chopped_full2_0/eeg_fd_ota_core_soft_0/m1_54741_n3864# 5.057928e-17
C619 eeg_afe_pga_0/eeg_fd_ota_chopped_full2_0/eeg_bias_gen_0/VBNF eeg_afe_pga_0/eeg_fd_ota_chopped_full2_0/eeg_fd_ota_core_soft_0/m1_55541_n3864# 5.057930e-17
C620 eeg_afe_pga_0/eeg_fd_ota_chopped_full2_0/eeg_bias_gen_0/VBNF eeg_afe_pga_0/eeg_fd_ota_chopped_full2_0/eeg_fd_ota_core_soft_0/m1_56341_n3864# 5.057930e-17
C621 eeg_afe_pga_0/eeg_fd_ota_chopped_full2_0/eeg_bias_gen_0/VBNF eeg_afe_pga_0/eeg_fd_ota_chopped_full2_0/eeg_fd_ota_core_soft_0/m1_57141_n3864# 5.057920e-17
C622 eeg_afe_pga_0/eeg_fd_ota_chopped_full2_0/eeg_bias_gen_0/VBNF eeg_afe_pga_0/eeg_fd_ota_chopped_full2_0/eeg_fd_ota_core_soft_0/m1_57941_n3864# 5.192510e-17
C624 eeg_afe_pga_0/eeg_fd_ota_chopped_full2_0/eeg_bias_gen_0/VBNF eeg_afe_pga_0/eeg_fd_ota_chopped_full2_0/stage2_0/N2N 1.432650e-16
C625 eeg_afe_pga_0/eeg_fd_ota_chopped_full2_0/eeg_bias_gen_0/VBNF eeg_afe_pga_0/eeg_fd_ota_chopped_full2_0/stage2_0/N2P 5.740518e-16
C626 eeg_afe_pga_0/eeg_fd_ota_chopped_full2_0/eeg_bias_gen_0/VBNF eeg_afe_pga_0/eeg_fd_ota_chopped_full2_0/stage2_0/VBP2 1.125264e-15
C627 eeg_afe_pga_0/eeg_fd_ota_chopped_full2_0/eeg_bias_gen_0/VBNF eeg_afe_pga_0/eeg_fd_ota_chopped_full2_0/stage2_0/VCM2 3.880654e-16
C628 eeg_afe_pga_0/eeg_fd_ota_chopped_full2_0/eeg_bias_gen_0/VBNF PGA_OUTN 1.365910e-16
C629 eeg_afe_pga_0/eeg_fd_ota_chopped_full2_0/eeg_bias_gen_0/VBNF PGA_OUTP 2.070634e-16
C630 eeg_afe_pga_0/eeg_fd_ota_chopped_full2_0/eeg_cmfb_amp_dl2_0/VBP VSS 8.757940e-15
C631 eeg_afe_pga_0/eeg_fd_ota_chopped_full2_0/eeg_cmfb_amp_dl2_0/VBP eeg_afe_pga_0/eeg_fd_ota_chopped_full2_0/eeg_cmfb_amp_dl2_0/VCM_SENSE 3.069697e-16
C633 eeg_afe_pga_0/eeg_fd_ota_chopped_full2_0/eeg_cmfb_amp_dl2_0/VBP eeg_afe_pga_0/eeg_fd_ota_chopped_full2_0/eeg_fd_ota_core_soft_0/INP 3.185804e-17
C634 eeg_afe_pga_0/eeg_fd_ota_chopped_full2_0/eeg_cmfb_amp_dl2_0/VBP eeg_afe_pga_0/eeg_fd_ota_chopped_full2_0/eeg_fd_ota_core_soft_0/OUTP 1.614594e-16
C635 eeg_afe_pga_0/eeg_fd_ota_chopped_full2_0/eeg_cmfb_amp_dl2_0/VCM_SENSE VSS 1.553050e-14
C636 eeg_afe_pga_0/eeg_fd_ota_chopped_full2_0/eeg_cmfb_amp_dl2_0/VCM_SENSE eeg_afe_pga_0/eeg_fd_ota_chopped_full2_0/eeg_cmfb_amp_dl2_0/m1_370_1493# 9.450030e-17
C637 eeg_afe_pga_0/eeg_fd_ota_chopped_full2_0/eeg_cmfb_amp_dl2_0/VCM_SENSE eeg_afe_pga_0/eeg_fd_ota_chopped_full2_0/eeg_cmfb_amp_dl2_0/m1_68_166# 1.874925e-16
C640 eeg_afe_pga_0/eeg_fd_ota_chopped_full2_0/eeg_cmfb_amp_dl2_0/VCM_SENSE eeg_afe_pga_0/eeg_fd_ota_chopped_full2_0/eeg_fd_ota_core_soft_0/OUTN 1.526407e-16
C641 eeg_afe_pga_0/eeg_fd_ota_chopped_full2_0/eeg_cmfb_amp_dl2_0/VCM_SENSE eeg_afe_pga_0/eeg_fd_ota_chopped_full2_0/eeg_fd_ota_core_soft_0/OUTP 3.196946e-16
C643 eeg_afe_pga_0/eeg_fd_ota_chopped_full2_0/eeg_cmfb_amp_dl2_0/m1_68_166# eeg_afe_pga_0/eeg_fd_ota_chopped_full2_0/eeg_fd_ota_core_soft_0/OUTP 2.370169e-17
C645 eeg_afe_pga_0/eeg_fd_ota_chopped_full2_0/eeg_cmfb_amp_dl2_s2_0/m1_68_166# eeg_afe_pga_0/eeg_fd_ota_chopped_full2_0/stage2_0/VCM2 3.437010e-17
C646 eeg_afe_pga_0/eeg_fd_ota_chopped_full2_0/eeg_fd_ota_core_soft_0/INN VSS 2.020630e-14
C647 eeg_afe_pga_0/eeg_fd_ota_chopped_full2_0/eeg_fd_ota_core_soft_0/INN eeg_afe_pga_0/eeg_fd_ota_chopped_full2_0/eeg_fd_ota_core_soft_0/INP 1.586935e-14
C648 eeg_afe_pga_0/eeg_fd_ota_chopped_full2_0/eeg_fd_ota_core_soft_0/INN eeg_afe_pga_0/eeg_fd_ota_chopped_full2_0/eeg_fd_ota_core_soft_0/OUTN 7.513171e-15
C649 eeg_afe_pga_0/eeg_fd_ota_chopped_full2_0/eeg_fd_ota_core_soft_0/INN eeg_afe_pga_0/eeg_fd_ota_chopped_full2_0/eeg_fd_ota_core_soft_0/OUTP 1.119515e-14
C651 eeg_afe_pga_0/eeg_fd_ota_chopped_full2_0/eeg_fd_ota_core_soft_0/INN eeg_afe_pga_0/eeg_fd_ota_chopped_full2_0/eeg_fd_ota_core_soft_0/m1_n29259_3443# 2.303073e-17
C652 eeg_afe_pga_0/eeg_fd_ota_chopped_full2_0/eeg_fd_ota_core_soft_0/INN eeg_afe_pga_0/eeg_fd_ota_chopped_full2_0/eeg_fd_ota_core_soft_0/m1_n30059_3443# 2.303071e-17
C653 eeg_afe_pga_0/eeg_fd_ota_chopped_full2_0/eeg_fd_ota_core_soft_0/INN eeg_afe_pga_0/eeg_fd_ota_chopped_full2_0/eeg_fd_ota_core_soft_0/m1_n30859_3443# 2.303073e-17
C654 eeg_afe_pga_0/eeg_fd_ota_chopped_full2_0/eeg_fd_ota_core_soft_0/INN eeg_afe_pga_0/eeg_fd_ota_chopped_full2_0/eeg_fd_ota_core_soft_0/m1_n31659_3443# 2.303071e-17
C655 eeg_afe_pga_0/eeg_fd_ota_chopped_full2_0/eeg_fd_ota_core_soft_0/INN eeg_afe_pga_0/eeg_fd_ota_chopped_full2_0/eeg_fd_ota_core_soft_0/m1_n32459_3443# 2.303071e-17
C656 eeg_afe_pga_0/eeg_fd_ota_chopped_full2_0/eeg_fd_ota_core_soft_0/INN eeg_afe_pga_0/eeg_fd_ota_chopped_full2_0/eeg_fd_ota_core_soft_0/m1_n33259_3443# 2.303071e-17
C657 eeg_afe_pga_0/eeg_fd_ota_chopped_full2_0/eeg_fd_ota_core_soft_0/INN eeg_afe_pga_0/eeg_fd_ota_chopped_full2_0/eeg_fd_ota_core_soft_0/m1_n34059_3443# 2.303071e-17
C658 eeg_afe_pga_0/eeg_fd_ota_chopped_full2_0/eeg_fd_ota_core_soft_0/INN eeg_afe_pga_0/eeg_fd_ota_chopped_full2_0/eeg_fd_ota_core_soft_0/m1_n34859_3443# 2.303073e-17
C659 eeg_afe_pga_0/eeg_fd_ota_chopped_full2_0/eeg_fd_ota_core_soft_0/INN eeg_afe_pga_0/eeg_fd_ota_chopped_full2_0/eeg_fd_ota_core_soft_0/m1_n35659_3443# 2.303071e-17
C660 eeg_afe_pga_0/eeg_fd_ota_chopped_full2_0/eeg_fd_ota_core_soft_0/INN eeg_afe_pga_0/eeg_fd_ota_chopped_full2_0/eeg_fd_ota_core_soft_0/m1_n36459_3443# 2.303073e-17
C661 eeg_afe_pga_0/eeg_fd_ota_chopped_full2_0/eeg_fd_ota_core_soft_0/INN eeg_afe_pga_0/eeg_fd_ota_chopped_full2_0/eeg_fd_ota_core_soft_0/m1_n37259_3443# 2.303071e-17
C662 eeg_afe_pga_0/eeg_fd_ota_chopped_full2_0/eeg_fd_ota_core_soft_0/INN eeg_afe_pga_0/eeg_fd_ota_chopped_full2_0/eeg_fd_ota_core_soft_0/m1_n38059_3443# 2.303071e-17
C663 eeg_afe_pga_0/eeg_fd_ota_chopped_full2_0/eeg_fd_ota_core_soft_0/INN eeg_afe_pga_0/eeg_fd_ota_chopped_full2_0/eeg_fd_ota_core_soft_0/m1_n38859_3443# 2.303071e-17
C664 eeg_afe_pga_0/eeg_fd_ota_chopped_full2_0/eeg_fd_ota_core_soft_0/INN eeg_afe_pga_0/eeg_fd_ota_chopped_full2_0/eeg_fd_ota_core_soft_0/m1_n39659_3443# 2.303071e-17
C665 eeg_afe_pga_0/eeg_fd_ota_chopped_full2_0/eeg_fd_ota_core_soft_0/INN eeg_afe_pga_0/eeg_fd_ota_chopped_full2_0/eeg_fd_ota_core_soft_0/m1_n40459_3443# 2.303073e-17
C666 eeg_afe_pga_0/eeg_fd_ota_chopped_full2_0/eeg_fd_ota_core_soft_0/INN eeg_afe_pga_0/eeg_fd_ota_chopped_full2_0/eeg_fd_ota_core_soft_0/m1_n41259_3443# 2.303071e-17
C667 eeg_afe_pga_0/eeg_fd_ota_chopped_full2_0/eeg_fd_ota_core_soft_0/INN eeg_afe_pga_0/eeg_fd_ota_chopped_full2_0/eeg_fd_ota_core_soft_0/m1_n42059_3443# 2.303073e-17
C668 eeg_afe_pga_0/eeg_fd_ota_chopped_full2_0/eeg_fd_ota_core_soft_0/INN eeg_afe_pga_0/eeg_fd_ota_chopped_full2_0/eeg_fd_ota_core_soft_0/m1_n42859_3443# 2.303071e-17
C669 eeg_afe_pga_0/eeg_fd_ota_chopped_full2_0/eeg_fd_ota_core_soft_0/INN eeg_afe_pga_0/eeg_fd_ota_chopped_full2_0/eeg_fd_ota_core_soft_0/m1_n43659_3443# 2.303071e-17
C670 eeg_afe_pga_0/eeg_fd_ota_chopped_full2_0/eeg_fd_ota_core_soft_0/INN eeg_afe_pga_0/eeg_fd_ota_chopped_full2_0/eeg_fd_ota_core_soft_0/m1_n44459_3443# 2.303071e-17
C671 eeg_afe_pga_0/eeg_fd_ota_chopped_full2_0/eeg_fd_ota_core_soft_0/INN eeg_afe_pga_0/eeg_fd_ota_chopped_full2_0/eeg_fd_ota_core_soft_0/m1_n45259_3443# 2.303071e-17
C672 eeg_afe_pga_0/eeg_fd_ota_chopped_full2_0/eeg_fd_ota_core_soft_0/INN eeg_afe_pga_0/eeg_fd_ota_chopped_full2_0/eeg_fd_ota_core_soft_0/m1_n46059_3443# 2.303073e-17
C673 eeg_afe_pga_0/eeg_fd_ota_chopped_full2_0/eeg_fd_ota_core_soft_0/INN eeg_afe_pga_0/eeg_fd_ota_chopped_full2_0/eeg_fd_ota_core_soft_0/m1_n46859_3443# 2.303071e-17
C674 eeg_afe_pga_0/eeg_fd_ota_chopped_full2_0/eeg_fd_ota_core_soft_0/INN eeg_afe_pga_0/eeg_fd_ota_chopped_full2_0/eeg_fd_ota_core_soft_0/m1_n47659_3443# 2.303073e-17
C675 eeg_afe_pga_0/eeg_fd_ota_chopped_full2_0/eeg_fd_ota_core_soft_0/INN eeg_afe_pga_0/eeg_fd_ota_chopped_full2_0/eeg_fd_ota_core_soft_0/m1_n51659_3443# 2.303073e-17
C676 eeg_afe_pga_0/eeg_fd_ota_chopped_full2_0/eeg_fd_ota_core_soft_0/INN eeg_afe_pga_0/eeg_fd_ota_chopped_full2_0/eeg_fd_ota_core_soft_0/m1_n52459_3443# 2.303071e-17
C677 eeg_afe_pga_0/eeg_fd_ota_chopped_full2_0/eeg_fd_ota_core_soft_0/INN eeg_afe_pga_0/eeg_fd_ota_chopped_full2_0/eeg_fd_ota_core_soft_0/m1_n53259_3443# 2.303073e-17
C678 eeg_afe_pga_0/eeg_fd_ota_chopped_full2_0/eeg_fd_ota_core_soft_0/INN eeg_afe_pga_0/eeg_fd_ota_chopped_full2_0/eeg_fd_ota_core_soft_0/m1_n54059_3443# 2.303071e-17
C679 eeg_afe_pga_0/eeg_fd_ota_chopped_full2_0/eeg_fd_ota_core_soft_0/INN eeg_afe_pga_0/eeg_fd_ota_chopped_full2_0/eeg_fd_ota_core_soft_0/m1_n54859_3443# 2.303071e-17
C680 eeg_afe_pga_0/eeg_fd_ota_chopped_full2_0/eeg_fd_ota_core_soft_0/INN eeg_afe_pga_0/eeg_fd_ota_chopped_full2_0/eeg_fd_ota_core_soft_0/m1_n55659_3443# 2.303071e-17
C681 eeg_afe_pga_0/eeg_fd_ota_chopped_full2_0/eeg_fd_ota_core_soft_0/INN eeg_afe_pga_0/eeg_fd_ota_chopped_full2_0/eeg_fd_ota_core_soft_0/m1_n56459_3443# 2.303071e-17
C682 eeg_afe_pga_0/eeg_fd_ota_chopped_full2_0/eeg_fd_ota_core_soft_0/INN eeg_afe_pga_0/eeg_fd_ota_chopped_full2_0/eeg_fd_ota_core_soft_0/m1_n57259_3443# 2.303073e-17
C683 eeg_afe_pga_0/eeg_fd_ota_chopped_full2_0/eeg_fd_ota_core_soft_0/INN eeg_afe_pga_0/eeg_fd_ota_chopped_full2_0/eeg_fd_ota_core_soft_0/m1_n58059_3443# 2.303071e-17
C685 eeg_afe_pga_0/eeg_fd_ota_chopped_full2_0/eeg_fd_ota_core_soft_0/INP VSS 2.075320e-14
C686 eeg_afe_pga_0/eeg_fd_ota_chopped_full2_0/eeg_fd_ota_core_soft_0/INP eeg_afe_pga_0/eeg_fd_ota_chopped_full2_0/eeg_fd_ota_core_soft_0/OUTN 1.573698e-15
C687 eeg_afe_pga_0/eeg_fd_ota_chopped_full2_0/eeg_fd_ota_core_soft_0/INP eeg_afe_pga_0/eeg_fd_ota_chopped_full2_0/eeg_fd_ota_core_soft_0/OUTP 1.386070e-15
C688 eeg_afe_pga_0/eeg_fd_ota_chopped_full2_0/eeg_fd_ota_core_soft_0/INP eeg_afe_pga_0/eeg_fd_ota_chopped_full2_0/eeg_fd_ota_core_soft_0/m1_n22658_111# 6.056700e-16
C724 eeg_afe_pga_0/eeg_fd_ota_chopped_full2_0/eeg_fd_ota_core_soft_0/OUTN VSS 2.208780e-14
C725 eeg_afe_pga_0/eeg_fd_ota_chopped_full2_0/eeg_fd_ota_core_soft_0/OUTN eeg_afe_pga_0/eeg_fd_ota_chopped_full2_0/eeg_fd_ota_core_soft_0/OUTP 8.022897e-15
C726 eeg_afe_pga_0/eeg_fd_ota_chopped_full2_0/eeg_fd_ota_core_soft_0/OUTN eeg_afe_pga_0/eeg_fd_ota_chopped_full2_0/stage2_0/N2N 5.693808e-17
C727 eeg_afe_pga_0/eeg_fd_ota_chopped_full2_0/eeg_fd_ota_core_soft_0/OUTN eeg_afe_pga_0/eeg_fd_ota_chopped_full2_0/stage2_0/N2P 2.063072e-17
C730 eeg_afe_pga_0/eeg_fd_ota_chopped_full2_0/eeg_fd_ota_core_soft_0/OUTP VSS 3.127310e-14
C733 eeg_afe_pga_0/eeg_fd_ota_chopped_full2_0/stage2_0/N2N VSS 2.694470e-15
C734 eeg_afe_pga_0/eeg_fd_ota_chopped_full2_0/stage2_0/N2N eeg_afe_pga_0/eeg_fd_ota_chopped_full2_0/stage2_0/N2P 2.211146e-15
C736 eeg_afe_pga_0/eeg_fd_ota_chopped_full2_0/stage2_0/N2P VSS 2.461200e-15
C737 eeg_afe_pga_0/eeg_fd_ota_chopped_full2_0/stage2_0/N2P eeg_afe_pga_0/eeg_fd_ota_chopped_full2_0/stage2_0/VBP2 9.732430e-17
C740 eeg_afe_pga_0/eeg_fd_ota_chopped_full2_0/stage2_0/VBP2 VSS 3.113330e-14
C741 eeg_afe_pga_0/eeg_fd_ota_chopped_full2_0/stage2_0/VBP2 eeg_afe_pga_0/eeg_fd_ota_chopped_full2_0/stage2_0/VCM2 1.483105e-16
C742 eeg_afe_pga_0/eeg_fd_ota_chopped_full2_0/stage2_0/VBP2 PGA_OUTN 6.053202e-15
C744 eeg_afe_pga_0/eeg_fd_ota_chopped_full2_0/stage2_0/VCM2 VSS 4.437230e-15
C745 eeg_afe_pga_0/eeg_fd_ota_chopped_full2_0/stage2_0/VCM2 PGA_OUTN 1.365910e-16
C746 eeg_afe_pga_0/eeg_fd_ota_chopped_full2_0/stage2_0/VCM2 PGA_OUTP 1.333710e-16
C747 VDD18 VSS 1.072390e-14
C748 VDD18 eeg_afe_pga_0/eeg_fd_ota_chopped_full2_0/eeg_bias_gen_0/VBN 1.083494e-15
C749 VDD18 eeg_afe_pga_0/eeg_fd_ota_chopped_full2_0/eeg_bias_gen_0/VBNF 1.335704e-15
C750 VDD18 eeg_afe_pga_0/eeg_fd_ota_chopped_full2_0/eeg_bias_gen_0/VBP 1.406448e-15
C751 VDD18 eeg_afe_pga_0/eeg_fd_ota_chopped_full2_0/eeg_bias_gen_0/eeg_pseudo_res_0/m1_68_66# 4.622759e-16
C752 VDD18 eeg_afe_pga_0/eeg_fd_ota_chopped_full2_0/eeg_bias_gen_0/m1_2524_466# 2.065494e-15
C753 VSS eeg_afe_pga_0/eeg_fd_ota_chopped_full2_0/eeg_bias_gen_0/VBN 1.960641e-15
C754 VSS eeg_afe_pga_0/eeg_fd_ota_chopped_full2_0/eeg_bias_gen_0/VBNF 5.192045e-12
C755 VSS eeg_afe_pga_0/eeg_fd_ota_chopped_full2_0/eeg_bias_gen_0/VBP 5.474732e-16
C756 VSS eeg_afe_pga_0/eeg_fd_ota_chopped_full2_0/eeg_bias_gen_0/m1_10341_n45240# 2.586160e-17
C758 VSS eeg_afe_pga_0/eeg_fd_ota_chopped_full2_0/eeg_bias_gen_0/m1_11141_n45240# 2.586160e-17
C760 VSS eeg_afe_pga_0/eeg_fd_ota_chopped_full2_0/eeg_bias_gen_0/m1_2524_466# 5.870937e-16
C762 VSS eeg_afe_pga_0/eeg_fd_ota_chopped_full2_0/eeg_bias_gen_0/m1_3941_n45240# 2.586160e-17
C764 VSS eeg_afe_pga_0/eeg_fd_ota_chopped_full2_0/eeg_bias_gen_0/m1_4741_n45240# 2.586160e-17
C766 VSS eeg_afe_pga_0/eeg_fd_ota_chopped_full2_0/eeg_bias_gen_0/m1_5541_n45240# 2.586160e-17
C768 VSS eeg_afe_pga_0/eeg_fd_ota_chopped_full2_0/eeg_bias_gen_0/m1_6341_n45240# 2.586160e-17
C770 VSS eeg_afe_pga_0/eeg_fd_ota_chopped_full2_0/eeg_bias_gen_0/m1_7141_n45240# 2.586160e-17
C772 VSS eeg_afe_pga_0/eeg_fd_ota_chopped_full2_0/eeg_bias_gen_0/m1_7941_n45240# 2.586160e-17
C774 VSS eeg_afe_pga_0/eeg_fd_ota_chopped_full2_0/eeg_bias_gen_0/m1_8741_n45240# 2.586160e-17
C776 VSS eeg_afe_pga_0/eeg_fd_ota_chopped_full2_0/eeg_bias_gen_0/m1_9541_n45240# 2.586160e-17
C778 eeg_afe_pga_0/eeg_fd_ota_chopped_full2_0/eeg_bias_gen_0/VBN VSS 2.467770e-14
C779 eeg_afe_pga_0/eeg_fd_ota_chopped_full2_0/eeg_bias_gen_0/VBN eeg_afe_pga_0/eeg_fd_ota_chopped_full2_0/eeg_bias_gen_0/VBNF 3.771753e-15
C780 eeg_afe_pga_0/eeg_fd_ota_chopped_full2_0/eeg_bias_gen_0/VBN eeg_afe_pga_0/eeg_fd_ota_chopped_full2_0/eeg_bias_gen_0/VBP 4.597047e-15
C781 eeg_afe_pga_0/eeg_fd_ota_chopped_full2_0/eeg_bias_gen_0/VBN eeg_afe_pga_0/eeg_fd_ota_chopped_full2_0/eeg_bias_gen_0/eeg_pseudo_res_0/m1_68_66# 4.676611e-16
C782 eeg_afe_pga_0/eeg_fd_ota_chopped_full2_0/eeg_bias_gen_0/VBN eeg_afe_pga_0/eeg_fd_ota_chopped_full2_0/eeg_bias_gen_0/m1_2524_466# 1.449157e-15
C783 eeg_afe_pga_0/eeg_fd_ota_chopped_full2_0/eeg_bias_gen_0/VBN eeg_afe_pga_0/eeg_fd_ota_chopped_full2_0/eeg_bias_gen_0/m1_3701_n11401# 9.237684e-16
C784 eeg_afe_pga_0/eeg_fd_ota_chopped_full2_0/eeg_bias_gen_0/VBN eeg_afe_pga_0/eeg_fd_ota_chopped_full2_0/eeg_bias_gen_0/m1_3701_n29089# 9.231557e-16
C785 eeg_afe_pga_0/eeg_fd_ota_chopped_full2_0/eeg_bias_gen_0/VBN eeg_afe_pga_0/eeg_fd_ota_chopped_full2_0/eeg_bias_gen_0/m1_3941_n27552# 3.117144e-16
C786 eeg_afe_pga_0/eeg_fd_ota_chopped_full2_0/eeg_bias_gen_0/VBN eeg_afe_pga_0/eeg_fd_ota_chopped_full2_0/eeg_bias_gen_0/m1_3941_n9864# 3.117144e-16
C787 eeg_afe_pga_0/eeg_fd_ota_chopped_full2_0/eeg_bias_gen_0/VBN eeg_afe_pga_0/eeg_fd_ota_chopped_full2_0/eeg_bias_gen_0/m1_4059_n18708# 3.117150e-16
C788 eeg_afe_pga_0/eeg_fd_ota_chopped_full2_0/eeg_bias_gen_0/VBN eeg_afe_pga_0/eeg_fd_ota_chopped_full2_0/eeg_bias_gen_0/m1_4059_n36396# 3.171103e-16
C791 eeg_afe_pga_0/eeg_fd_ota_chopped_full2_0/eeg_bias_gen_0/VBN eeg_afe_pga_0/eeg_fd_ota_chopped_full2_0/eeg_bias_gen_0/m1_4341_n37933# 7.669240e-17
C807 eeg_afe_pga_0/eeg_fd_ota_chopped_full2_0/eeg_bias_gen_0/VBNF VSS 7.281980e-14
C808 eeg_afe_pga_0/eeg_fd_ota_chopped_full2_0/eeg_bias_gen_0/VBNF eeg_afe_pga_0/eeg_fd_ota_chopped_full2_0/eeg_bias_gen_0/VBP 2.246044e-15
C809 eeg_afe_pga_0/eeg_fd_ota_chopped_full2_0/eeg_bias_gen_0/VBNF eeg_afe_pga_0/eeg_fd_ota_chopped_full2_0/eeg_bias_gen_0/m1_10059_n11401# 3.343550e-17
C810 eeg_afe_pga_0/eeg_fd_ota_chopped_full2_0/eeg_bias_gen_0/VBNF eeg_afe_pga_0/eeg_fd_ota_chopped_full2_0/eeg_bias_gen_0/m1_10059_n29089# 3.343556e-17
C811 eeg_afe_pga_0/eeg_fd_ota_chopped_full2_0/eeg_bias_gen_0/VBNF eeg_afe_pga_0/eeg_fd_ota_chopped_full2_0/eeg_bias_gen_0/m1_10341_n27552# 1.024404e-16
C812 eeg_afe_pga_0/eeg_fd_ota_chopped_full2_0/eeg_bias_gen_0/VBNF eeg_afe_pga_0/eeg_fd_ota_chopped_full2_0/eeg_bias_gen_0/m1_10341_n45240# 1.116124e-16
C813 eeg_afe_pga_0/eeg_fd_ota_chopped_full2_0/eeg_bias_gen_0/VBNF eeg_afe_pga_0/eeg_fd_ota_chopped_full2_0/eeg_bias_gen_0/m1_10341_n9864# 1.024404e-16
C814 eeg_afe_pga_0/eeg_fd_ota_chopped_full2_0/eeg_bias_gen_0/VBNF eeg_afe_pga_0/eeg_fd_ota_chopped_full2_0/eeg_bias_gen_0/m1_10459_n18708# 1.024404e-16
C815 eeg_afe_pga_0/eeg_fd_ota_chopped_full2_0/eeg_bias_gen_0/VBNF eeg_afe_pga_0/eeg_fd_ota_chopped_full2_0/eeg_bias_gen_0/m1_10459_n36396# 1.024404e-16
C816 eeg_afe_pga_0/eeg_fd_ota_chopped_full2_0/eeg_bias_gen_0/VBNF eeg_afe_pga_0/eeg_fd_ota_chopped_full2_0/eeg_bias_gen_0/m1_10741_n20245# 1.793252e-16
C817 eeg_afe_pga_0/eeg_fd_ota_chopped_full2_0/eeg_bias_gen_0/VBNF eeg_afe_pga_0/eeg_fd_ota_chopped_full2_0/eeg_bias_gen_0/m1_10741_n2557# 2.584588e-16
C818 eeg_afe_pga_0/eeg_fd_ota_chopped_full2_0/eeg_bias_gen_0/VBNF eeg_afe_pga_0/eeg_fd_ota_chopped_full2_0/eeg_bias_gen_0/m1_10741_n37933# 1.793251e-16
C819 eeg_afe_pga_0/eeg_fd_ota_chopped_full2_0/eeg_bias_gen_0/VBNF eeg_afe_pga_0/eeg_fd_ota_chopped_full2_0/eeg_bias_gen_0/m1_10859_n11401# 1.793252e-16
C820 eeg_afe_pga_0/eeg_fd_ota_chopped_full2_0/eeg_bias_gen_0/VBNF eeg_afe_pga_0/eeg_fd_ota_chopped_full2_0/eeg_bias_gen_0/m1_10859_n29089# 1.793253e-16
C821 eeg_afe_pga_0/eeg_fd_ota_chopped_full2_0/eeg_bias_gen_0/VBNF eeg_afe_pga_0/eeg_fd_ota_chopped_full2_0/eeg_bias_gen_0/m1_11141_n27552# 1.024404e-16
C822 eeg_afe_pga_0/eeg_fd_ota_chopped_full2_0/eeg_bias_gen_0/VBNF eeg_afe_pga_0/eeg_fd_ota_chopped_full2_0/eeg_bias_gen_0/m1_11141_n45240# 1.116125e-16
C823 eeg_afe_pga_0/eeg_fd_ota_chopped_full2_0/eeg_bias_gen_0/VBNF eeg_afe_pga_0/eeg_fd_ota_chopped_full2_0/eeg_bias_gen_0/m1_11141_n9864# 1.024404e-16
C824 eeg_afe_pga_0/eeg_fd_ota_chopped_full2_0/eeg_bias_gen_0/VBNF eeg_afe_pga_0/eeg_fd_ota_chopped_full2_0/eeg_bias_gen_0/m1_11259_n18708# 1.024404e-16
C825 eeg_afe_pga_0/eeg_fd_ota_chopped_full2_0/eeg_bias_gen_0/VBNF eeg_afe_pga_0/eeg_fd_ota_chopped_full2_0/eeg_bias_gen_0/m1_11259_n36396# 1.024404e-16
C826 eeg_afe_pga_0/eeg_fd_ota_chopped_full2_0/eeg_bias_gen_0/VBNF eeg_afe_pga_0/eeg_fd_ota_chopped_full2_0/eeg_bias_gen_0/m1_11541_n20245# 2.847116e-16
C827 eeg_afe_pga_0/eeg_fd_ota_chopped_full2_0/eeg_bias_gen_0/VBNF eeg_afe_pga_0/eeg_fd_ota_chopped_full2_0/eeg_bias_gen_0/m1_11541_n37933# 2.847116e-16
C828 eeg_afe_pga_0/eeg_fd_ota_chopped_full2_0/eeg_bias_gen_0/VBNF eeg_afe_pga_0/eeg_fd_ota_chopped_full2_0/eeg_bias_gen_0/m1_2524_466# 5.686547e-16
C836 eeg_afe_pga_0/eeg_fd_ota_chopped_full2_0/eeg_bias_gen_0/VBNF eeg_afe_pga_0/eeg_fd_ota_chopped_full2_0/eeg_bias_gen_0/m1_8741_n45240# 2.017146e-17
C846 eeg_afe_pga_0/eeg_fd_ota_chopped_full2_0/eeg_bias_gen_0/VBNF eeg_afe_pga_0/eeg_fd_ota_chopped_full2_0/eeg_bias_gen_0/m1_9541_n45240# 3.497385e-17
C850 eeg_afe_pga_0/eeg_fd_ota_chopped_full2_0/eeg_bias_gen_0/VBNF eeg_afe_pga_0/eeg_fd_ota_chopped_full2_0/eeg_bias_gen_0/m1_9941_n20245# 3.343550e-17
C851 eeg_afe_pga_0/eeg_fd_ota_chopped_full2_0/eeg_bias_gen_0/VBNF eeg_afe_pga_0/eeg_fd_ota_chopped_full2_0/eeg_bias_gen_0/m1_9941_n2557# 3.464034e-17
C852 eeg_afe_pga_0/eeg_fd_ota_chopped_full2_0/eeg_bias_gen_0/VBNF eeg_afe_pga_0/eeg_fd_ota_chopped_full2_0/eeg_bias_gen_0/m1_9941_n37933# 3.343550e-17
C853 eeg_afe_pga_0/eeg_fd_ota_chopped_full2_0/eeg_bias_gen_0/VBP VSS 5.243180e-15
C854 eeg_afe_pga_0/eeg_fd_ota_chopped_full2_0/eeg_bias_gen_0/VBP eeg_afe_pga_0/eeg_fd_ota_chopped_full2_0/eeg_bias_gen_0/m1_2524_466# 4.554927e-15
C855 eeg_afe_pga_0/eeg_fd_ota_chopped_full2_0/eeg_bias_gen_0/m1_10059_n11401# VSS 2.918310e-16
C857 eeg_afe_pga_0/eeg_fd_ota_chopped_full2_0/eeg_bias_gen_0/m1_10059_n11401# eeg_afe_pga_0/eeg_fd_ota_chopped_full2_0/eeg_bias_gen_0/m1_10859_n11401# 6.789047e-17
C859 eeg_afe_pga_0/eeg_fd_ota_chopped_full2_0/eeg_bias_gen_0/m1_10059_n11401# eeg_afe_pga_0/eeg_fd_ota_chopped_full2_0/eeg_bias_gen_0/m1_9259_n11401# 6.789047e-17
C861 eeg_afe_pga_0/eeg_fd_ota_chopped_full2_0/eeg_bias_gen_0/m1_10059_n29089# VSS 2.918310e-16
C863 eeg_afe_pga_0/eeg_fd_ota_chopped_full2_0/eeg_bias_gen_0/m1_10059_n29089# eeg_afe_pga_0/eeg_fd_ota_chopped_full2_0/eeg_bias_gen_0/m1_10859_n29089# 6.789043e-17
C865 eeg_afe_pga_0/eeg_fd_ota_chopped_full2_0/eeg_bias_gen_0/m1_10059_n29089# eeg_afe_pga_0/eeg_fd_ota_chopped_full2_0/eeg_bias_gen_0/m1_9259_n29089# 6.789040e-17
C867 eeg_afe_pga_0/eeg_fd_ota_chopped_full2_0/eeg_bias_gen_0/m1_10341_n27552# VSS 4.190540e-16
C869 eeg_afe_pga_0/eeg_fd_ota_chopped_full2_0/eeg_bias_gen_0/m1_10341_n27552# eeg_afe_pga_0/eeg_fd_ota_chopped_full2_0/eeg_bias_gen_0/m1_11141_n27552# 6.789050e-17
C870 eeg_afe_pga_0/eeg_fd_ota_chopped_full2_0/eeg_bias_gen_0/m1_10341_n27552# eeg_afe_pga_0/eeg_fd_ota_chopped_full2_0/eeg_bias_gen_0/m1_9541_n27552# 6.789050e-17
C871 eeg_afe_pga_0/eeg_fd_ota_chopped_full2_0/eeg_bias_gen_0/m1_10341_n45240# VSS 4.190540e-16
C872 eeg_afe_pga_0/eeg_fd_ota_chopped_full2_0/eeg_bias_gen_0/m1_10341_n45240# eeg_afe_pga_0/eeg_fd_ota_chopped_full2_0/eeg_bias_gen_0/m1_11141_n45240# 6.789050e-17
C873 eeg_afe_pga_0/eeg_fd_ota_chopped_full2_0/eeg_bias_gen_0/m1_10341_n45240# eeg_afe_pga_0/eeg_fd_ota_chopped_full2_0/eeg_bias_gen_0/m1_9541_n45240# 6.789050e-17
C874 eeg_afe_pga_0/eeg_fd_ota_chopped_full2_0/eeg_bias_gen_0/m1_10341_n9864# VSS 4.190540e-16
C876 eeg_afe_pga_0/eeg_fd_ota_chopped_full2_0/eeg_bias_gen_0/m1_10341_n9864# eeg_afe_pga_0/eeg_fd_ota_chopped_full2_0/eeg_bias_gen_0/m1_11141_n9864# 6.789050e-17
C877 eeg_afe_pga_0/eeg_fd_ota_chopped_full2_0/eeg_bias_gen_0/m1_10341_n9864# eeg_afe_pga_0/eeg_fd_ota_chopped_full2_0/eeg_bias_gen_0/m1_9541_n9864# 6.789050e-17
C878 eeg_afe_pga_0/eeg_fd_ota_chopped_full2_0/eeg_bias_gen_0/m1_10459_n18708# VSS 2.918310e-16
C880 eeg_afe_pga_0/eeg_fd_ota_chopped_full2_0/eeg_bias_gen_0/m1_10459_n18708# eeg_afe_pga_0/eeg_fd_ota_chopped_full2_0/eeg_bias_gen_0/m1_11259_n18708# 6.789040e-17
C882 eeg_afe_pga_0/eeg_fd_ota_chopped_full2_0/eeg_bias_gen_0/m1_10459_n18708# eeg_afe_pga_0/eeg_fd_ota_chopped_full2_0/eeg_bias_gen_0/m1_9659_n18708# 6.789043e-17
C884 eeg_afe_pga_0/eeg_fd_ota_chopped_full2_0/eeg_bias_gen_0/m1_10459_n36396# VSS 2.918310e-16
C886 eeg_afe_pga_0/eeg_fd_ota_chopped_full2_0/eeg_bias_gen_0/m1_10459_n36396# eeg_afe_pga_0/eeg_fd_ota_chopped_full2_0/eeg_bias_gen_0/m1_11259_n36396# 6.789050e-17
C888 eeg_afe_pga_0/eeg_fd_ota_chopped_full2_0/eeg_bias_gen_0/m1_10459_n36396# eeg_afe_pga_0/eeg_fd_ota_chopped_full2_0/eeg_bias_gen_0/m1_9659_n36396# 6.789043e-17
C890 eeg_afe_pga_0/eeg_fd_ota_chopped_full2_0/eeg_bias_gen_0/m1_10741_n20245# VSS 4.190540e-16
C892 eeg_afe_pga_0/eeg_fd_ota_chopped_full2_0/eeg_bias_gen_0/m1_10741_n20245# eeg_afe_pga_0/eeg_fd_ota_chopped_full2_0/eeg_bias_gen_0/m1_11541_n20245# 6.794053e-17
C893 eeg_afe_pga_0/eeg_fd_ota_chopped_full2_0/eeg_bias_gen_0/m1_10741_n20245# eeg_afe_pga_0/eeg_fd_ota_chopped_full2_0/eeg_bias_gen_0/m1_9941_n20245# 6.789050e-17
C894 eeg_afe_pga_0/eeg_fd_ota_chopped_full2_0/eeg_bias_gen_0/m1_10741_n2557# VSS 4.623640e-16
C895 eeg_afe_pga_0/eeg_fd_ota_chopped_full2_0/eeg_bias_gen_0/m1_10741_n2557# eeg_afe_pga_0/eeg_fd_ota_chopped_full2_0/eeg_bias_gen_0/m1_9941_n2557# 6.789050e-17
C896 eeg_afe_pga_0/eeg_fd_ota_chopped_full2_0/eeg_bias_gen_0/m1_10741_n37933# VSS 4.190540e-16
C898 eeg_afe_pga_0/eeg_fd_ota_chopped_full2_0/eeg_bias_gen_0/m1_10741_n37933# eeg_afe_pga_0/eeg_fd_ota_chopped_full2_0/eeg_bias_gen_0/m1_11541_n37933# 6.794053e-17
C899 eeg_afe_pga_0/eeg_fd_ota_chopped_full2_0/eeg_bias_gen_0/m1_10741_n37933# eeg_afe_pga_0/eeg_fd_ota_chopped_full2_0/eeg_bias_gen_0/m1_9941_n37933# 6.789050e-17
C900 eeg_afe_pga_0/eeg_fd_ota_chopped_full2_0/eeg_bias_gen_0/m1_10859_n11401# VSS 2.849110e-16
C902 eeg_afe_pga_0/eeg_fd_ota_chopped_full2_0/eeg_bias_gen_0/m1_10859_n11401# eeg_afe_pga_0/eeg_fd_ota_chopped_full2_0/eeg_bias_gen_0/m1_11541_n20245# 6.796552e-17
C903 eeg_afe_pga_0/eeg_fd_ota_chopped_full2_0/eeg_bias_gen_0/m1_10859_n29089# VSS 2.849110e-16
C905 eeg_afe_pga_0/eeg_fd_ota_chopped_full2_0/eeg_bias_gen_0/m1_10859_n29089# eeg_afe_pga_0/eeg_fd_ota_chopped_full2_0/eeg_bias_gen_0/m1_11541_n37933# 6.796554e-17
C906 eeg_afe_pga_0/eeg_fd_ota_chopped_full2_0/eeg_bias_gen_0/m1_11141_n27552# VSS 4.651810e-16
C908 eeg_afe_pga_0/eeg_fd_ota_chopped_full2_0/eeg_bias_gen_0/m1_11141_n45240# VSS 4.702790e-16
C909 eeg_afe_pga_0/eeg_fd_ota_chopped_full2_0/eeg_bias_gen_0/m1_11141_n9864# VSS 4.651810e-16
C911 eeg_afe_pga_0/eeg_fd_ota_chopped_full2_0/eeg_bias_gen_0/m1_11259_n18708# VSS 2.743410e-16
C912 eeg_afe_pga_0/eeg_fd_ota_chopped_full2_0/eeg_bias_gen_0/m1_11259_n18708# eeg_afe_pga_0/eeg_fd_ota_chopped_full2_0/eeg_bias_gen_0/m1_11541_n20245# 6.171110e-17
C913 eeg_afe_pga_0/eeg_fd_ota_chopped_full2_0/eeg_bias_gen_0/m1_11259_n36396# VSS 2.743410e-16
C914 eeg_afe_pga_0/eeg_fd_ota_chopped_full2_0/eeg_bias_gen_0/m1_11259_n36396# eeg_afe_pga_0/eeg_fd_ota_chopped_full2_0/eeg_bias_gen_0/m1_11541_n37933# 6.171107e-17
C915 eeg_afe_pga_0/eeg_fd_ota_chopped_full2_0/eeg_bias_gen_0/m1_11541_n20245# VSS 4.394320e-15
C917 eeg_afe_pga_0/eeg_fd_ota_chopped_full2_0/eeg_bias_gen_0/m1_11541_n37933# VSS 4.394320e-15
C919 eeg_afe_pga_0/eeg_fd_ota_chopped_full2_0/eeg_bias_gen_0/m1_2524_466# VSS 6.618010e-15
C920 eeg_afe_pga_0/eeg_fd_ota_chopped_full2_0/eeg_bias_gen_0/m1_3701_n11401# VSS 4.381540e-15
C921 eeg_afe_pga_0/eeg_fd_ota_chopped_full2_0/eeg_bias_gen_0/m1_3701_n11401# eeg_afe_pga_0/eeg_fd_ota_chopped_full2_0/eeg_bias_gen_0/m1_3941_n9864# 6.171105e-17
C922 eeg_afe_pga_0/eeg_fd_ota_chopped_full2_0/eeg_bias_gen_0/m1_3701_n11401# eeg_afe_pga_0/eeg_fd_ota_chopped_full2_0/eeg_bias_gen_0/m1_4341_n2557# 6.796550e-17
C923 eeg_afe_pga_0/eeg_fd_ota_chopped_full2_0/eeg_bias_gen_0/m1_3701_n11401# eeg_afe_pga_0/eeg_fd_ota_chopped_full2_0/eeg_bias_gen_0/m1_4459_n11401# 6.794051e-17
C927 eeg_afe_pga_0/eeg_fd_ota_chopped_full2_0/eeg_bias_gen_0/m1_3701_n29089# VSS 4.381540e-15
C928 eeg_afe_pga_0/eeg_fd_ota_chopped_full2_0/eeg_bias_gen_0/m1_3701_n29089# eeg_afe_pga_0/eeg_fd_ota_chopped_full2_0/eeg_bias_gen_0/m1_3941_n27552# 6.171109e-17
C930 eeg_afe_pga_0/eeg_fd_ota_chopped_full2_0/eeg_bias_gen_0/m1_3701_n29089# eeg_afe_pga_0/eeg_fd_ota_chopped_full2_0/eeg_bias_gen_0/m1_4341_n20245# 6.796550e-17
C931 eeg_afe_pga_0/eeg_fd_ota_chopped_full2_0/eeg_bias_gen_0/m1_3701_n29089# eeg_afe_pga_0/eeg_fd_ota_chopped_full2_0/eeg_bias_gen_0/m1_4459_n29089# 6.794050e-17
C935 eeg_afe_pga_0/eeg_fd_ota_chopped_full2_0/eeg_bias_gen_0/m1_3941_n27552# VSS 3.999630e-16
C937 eeg_afe_pga_0/eeg_fd_ota_chopped_full2_0/eeg_bias_gen_0/m1_3941_n27552# eeg_afe_pga_0/eeg_fd_ota_chopped_full2_0/eeg_bias_gen_0/m1_4741_n27552# 6.789050e-17
C938 eeg_afe_pga_0/eeg_fd_ota_chopped_full2_0/eeg_bias_gen_0/m1_3941_n45240# VSS 4.702790e-16
C939 eeg_afe_pga_0/eeg_fd_ota_chopped_full2_0/eeg_bias_gen_0/m1_3941_n45240# eeg_afe_pga_0/eeg_fd_ota_chopped_full2_0/eeg_bias_gen_0/m1_4741_n45240# 6.789050e-17
C940 eeg_afe_pga_0/eeg_fd_ota_chopped_full2_0/eeg_bias_gen_0/m1_3941_n9864# VSS 3.999630e-16
C942 eeg_afe_pga_0/eeg_fd_ota_chopped_full2_0/eeg_bias_gen_0/m1_3941_n9864# eeg_afe_pga_0/eeg_fd_ota_chopped_full2_0/eeg_bias_gen_0/m1_4741_n9864# 6.789050e-17
C943 eeg_afe_pga_0/eeg_fd_ota_chopped_full2_0/eeg_bias_gen_0/m1_4059_n18708# VSS 3.267770e-16
C945 eeg_afe_pga_0/eeg_fd_ota_chopped_full2_0/eeg_bias_gen_0/m1_4059_n18708# eeg_afe_pga_0/eeg_fd_ota_chopped_full2_0/eeg_bias_gen_0/m1_4859_n18708# 6.789043e-17
C946 eeg_afe_pga_0/eeg_fd_ota_chopped_full2_0/eeg_bias_gen_0/m1_4059_n36396# VSS 3.267770e-16
C948 eeg_afe_pga_0/eeg_fd_ota_chopped_full2_0/eeg_bias_gen_0/m1_4059_n36396# eeg_afe_pga_0/eeg_fd_ota_chopped_full2_0/eeg_bias_gen_0/m1_4859_n36396# 6.789043e-17
C949 eeg_afe_pga_0/eeg_fd_ota_chopped_full2_0/eeg_bias_gen_0/m1_4341_n20245# VSS 4.190540e-16
C951 eeg_afe_pga_0/eeg_fd_ota_chopped_full2_0/eeg_bias_gen_0/m1_4341_n20245# eeg_afe_pga_0/eeg_fd_ota_chopped_full2_0/eeg_bias_gen_0/m1_5141_n20245# 6.789050e-17
C952 eeg_afe_pga_0/eeg_fd_ota_chopped_full2_0/eeg_bias_gen_0/m1_4341_n2557# VSS 4.190540e-16
C953 eeg_afe_pga_0/eeg_fd_ota_chopped_full2_0/eeg_bias_gen_0/m1_4341_n2557# eeg_afe_pga_0/eeg_fd_ota_chopped_full2_0/eeg_bias_gen_0/m1_5141_n2557# 6.789050e-17
C954 eeg_afe_pga_0/eeg_fd_ota_chopped_full2_0/eeg_bias_gen_0/m1_4341_n37933# VSS 4.624800e-16
C956 eeg_afe_pga_0/eeg_fd_ota_chopped_full2_0/eeg_bias_gen_0/m1_4341_n37933# eeg_afe_pga_0/eeg_fd_ota_chopped_full2_0/eeg_bias_gen_0/m1_5141_n37933# 6.789050e-17
C957 eeg_afe_pga_0/eeg_fd_ota_chopped_full2_0/eeg_bias_gen_0/m1_4459_n11401# VSS 2.849110e-16
C959 eeg_afe_pga_0/eeg_fd_ota_chopped_full2_0/eeg_bias_gen_0/m1_4459_n11401# eeg_afe_pga_0/eeg_fd_ota_chopped_full2_0/eeg_bias_gen_0/m1_5259_n11401# 6.789047e-17
C960 eeg_afe_pga_0/eeg_fd_ota_chopped_full2_0/eeg_bias_gen_0/m1_4459_n29089# VSS 2.849110e-16
C962 eeg_afe_pga_0/eeg_fd_ota_chopped_full2_0/eeg_bias_gen_0/m1_4459_n29089# eeg_afe_pga_0/eeg_fd_ota_chopped_full2_0/eeg_bias_gen_0/m1_5259_n29089# 6.789043e-17
C963 eeg_afe_pga_0/eeg_fd_ota_chopped_full2_0/eeg_bias_gen_0/m1_4741_n27552# VSS 4.190540e-16
C965 eeg_afe_pga_0/eeg_fd_ota_chopped_full2_0/eeg_bias_gen_0/m1_4741_n27552# eeg_afe_pga_0/eeg_fd_ota_chopped_full2_0/eeg_bias_gen_0/m1_5541_n27552# 6.789050e-17
C966 eeg_afe_pga_0/eeg_fd_ota_chopped_full2_0/eeg_bias_gen_0/m1_4741_n45240# VSS 4.190540e-16
C967 eeg_afe_pga_0/eeg_fd_ota_chopped_full2_0/eeg_bias_gen_0/m1_4741_n45240# eeg_afe_pga_0/eeg_fd_ota_chopped_full2_0/eeg_bias_gen_0/m1_5541_n45240# 6.789050e-17
C968 eeg_afe_pga_0/eeg_fd_ota_chopped_full2_0/eeg_bias_gen_0/m1_4741_n9864# VSS 4.190540e-16
C970 eeg_afe_pga_0/eeg_fd_ota_chopped_full2_0/eeg_bias_gen_0/m1_4741_n9864# eeg_afe_pga_0/eeg_fd_ota_chopped_full2_0/eeg_bias_gen_0/m1_5541_n9864# 6.789050e-17
C971 eeg_afe_pga_0/eeg_fd_ota_chopped_full2_0/eeg_bias_gen_0/m1_4859_n18708# VSS 2.918310e-16
C973 eeg_afe_pga_0/eeg_fd_ota_chopped_full2_0/eeg_bias_gen_0/m1_4859_n18708# eeg_afe_pga_0/eeg_fd_ota_chopped_full2_0/eeg_bias_gen_0/m1_5659_n18708# 6.789040e-17
C974 eeg_afe_pga_0/eeg_fd_ota_chopped_full2_0/eeg_bias_gen_0/m1_4859_n36396# VSS 2.918310e-16
C976 eeg_afe_pga_0/eeg_fd_ota_chopped_full2_0/eeg_bias_gen_0/m1_4859_n36396# eeg_afe_pga_0/eeg_fd_ota_chopped_full2_0/eeg_bias_gen_0/m1_5659_n36396# 6.789050e-17
C977 eeg_afe_pga_0/eeg_fd_ota_chopped_full2_0/eeg_bias_gen_0/m1_5141_n20245# VSS 4.190540e-16
C979 eeg_afe_pga_0/eeg_fd_ota_chopped_full2_0/eeg_bias_gen_0/m1_5141_n20245# eeg_afe_pga_0/eeg_fd_ota_chopped_full2_0/eeg_bias_gen_0/m1_5941_n20245# 6.789050e-17
C980 eeg_afe_pga_0/eeg_fd_ota_chopped_full2_0/eeg_bias_gen_0/m1_5141_n2557# VSS 4.190540e-16
C981 eeg_afe_pga_0/eeg_fd_ota_chopped_full2_0/eeg_bias_gen_0/m1_5141_n2557# eeg_afe_pga_0/eeg_fd_ota_chopped_full2_0/eeg_bias_gen_0/m1_5941_n2557# 6.789050e-17
C982 eeg_afe_pga_0/eeg_fd_ota_chopped_full2_0/eeg_bias_gen_0/m1_5141_n37933# VSS 4.190540e-16
C984 eeg_afe_pga_0/eeg_fd_ota_chopped_full2_0/eeg_bias_gen_0/m1_5141_n37933# eeg_afe_pga_0/eeg_fd_ota_chopped_full2_0/eeg_bias_gen_0/m1_5941_n37933# 6.789050e-17
C985 eeg_afe_pga_0/eeg_fd_ota_chopped_full2_0/eeg_bias_gen_0/m1_5259_n11401# VSS 2.918310e-16
C987 eeg_afe_pga_0/eeg_fd_ota_chopped_full2_0/eeg_bias_gen_0/m1_5259_n11401# eeg_afe_pga_0/eeg_fd_ota_chopped_full2_0/eeg_bias_gen_0/m1_6059_n11401# 6.789047e-17
C988 eeg_afe_pga_0/eeg_fd_ota_chopped_full2_0/eeg_bias_gen_0/m1_5259_n29089# VSS 2.918310e-16
C990 eeg_afe_pga_0/eeg_fd_ota_chopped_full2_0/eeg_bias_gen_0/m1_5259_n29089# eeg_afe_pga_0/eeg_fd_ota_chopped_full2_0/eeg_bias_gen_0/m1_6059_n29089# 6.789040e-17
C991 eeg_afe_pga_0/eeg_fd_ota_chopped_full2_0/eeg_bias_gen_0/m1_5541_n27552# VSS 4.190540e-16
C993 eeg_afe_pga_0/eeg_fd_ota_chopped_full2_0/eeg_bias_gen_0/m1_5541_n27552# eeg_afe_pga_0/eeg_fd_ota_chopped_full2_0/eeg_bias_gen_0/m1_6341_n27552# 6.789040e-17
C994 eeg_afe_pga_0/eeg_fd_ota_chopped_full2_0/eeg_bias_gen_0/m1_5541_n45240# VSS 4.190540e-16
C995 eeg_afe_pga_0/eeg_fd_ota_chopped_full2_0/eeg_bias_gen_0/m1_5541_n45240# eeg_afe_pga_0/eeg_fd_ota_chopped_full2_0/eeg_bias_gen_0/m1_6341_n45240# 6.789040e-17
C996 eeg_afe_pga_0/eeg_fd_ota_chopped_full2_0/eeg_bias_gen_0/m1_5541_n9864# VSS 4.190540e-16
C998 eeg_afe_pga_0/eeg_fd_ota_chopped_full2_0/eeg_bias_gen_0/m1_5541_n9864# eeg_afe_pga_0/eeg_fd_ota_chopped_full2_0/eeg_bias_gen_0/m1_6341_n9864# 6.789040e-17
C999 eeg_afe_pga_0/eeg_fd_ota_chopped_full2_0/eeg_bias_gen_0/m1_5659_n18708# VSS 2.918310e-16
C1001 eeg_afe_pga_0/eeg_fd_ota_chopped_full2_0/eeg_bias_gen_0/m1_5659_n18708# eeg_afe_pga_0/eeg_fd_ota_chopped_full2_0/eeg_bias_gen_0/m1_6459_n18708# 6.789050e-17
C1002 eeg_afe_pga_0/eeg_fd_ota_chopped_full2_0/eeg_bias_gen_0/m1_5659_n36396# VSS 2.918310e-16
C1004 eeg_afe_pga_0/eeg_fd_ota_chopped_full2_0/eeg_bias_gen_0/m1_5659_n36396# eeg_afe_pga_0/eeg_fd_ota_chopped_full2_0/eeg_bias_gen_0/m1_6459_n36396# 6.789046e-17
C1005 eeg_afe_pga_0/eeg_fd_ota_chopped_full2_0/eeg_bias_gen_0/m1_5941_n20245# VSS 4.190540e-16
C1007 eeg_afe_pga_0/eeg_fd_ota_chopped_full2_0/eeg_bias_gen_0/m1_5941_n20245# eeg_afe_pga_0/eeg_fd_ota_chopped_full2_0/eeg_bias_gen_0/m1_6741_n20245# 6.789050e-17
C1008 eeg_afe_pga_0/eeg_fd_ota_chopped_full2_0/eeg_bias_gen_0/m1_5941_n2557# VSS 4.190540e-16
C1009 eeg_afe_pga_0/eeg_fd_ota_chopped_full2_0/eeg_bias_gen_0/m1_5941_n2557# eeg_afe_pga_0/eeg_fd_ota_chopped_full2_0/eeg_bias_gen_0/m1_6741_n2557# 6.789050e-17
C1010 eeg_afe_pga_0/eeg_fd_ota_chopped_full2_0/eeg_bias_gen_0/m1_5941_n37933# VSS 4.190540e-16
C1012 eeg_afe_pga_0/eeg_fd_ota_chopped_full2_0/eeg_bias_gen_0/m1_5941_n37933# eeg_afe_pga_0/eeg_fd_ota_chopped_full2_0/eeg_bias_gen_0/m1_6741_n37933# 6.789050e-17
C1013 eeg_afe_pga_0/eeg_fd_ota_chopped_full2_0/eeg_bias_gen_0/m1_6059_n11401# VSS 2.918310e-16
C1015 eeg_afe_pga_0/eeg_fd_ota_chopped_full2_0/eeg_bias_gen_0/m1_6059_n11401# eeg_afe_pga_0/eeg_fd_ota_chopped_full2_0/eeg_bias_gen_0/m1_6859_n11401# 6.789047e-17
C1016 eeg_afe_pga_0/eeg_fd_ota_chopped_full2_0/eeg_bias_gen_0/m1_6059_n29089# VSS 2.918310e-16
C1018 eeg_afe_pga_0/eeg_fd_ota_chopped_full2_0/eeg_bias_gen_0/m1_6059_n29089# eeg_afe_pga_0/eeg_fd_ota_chopped_full2_0/eeg_bias_gen_0/m1_6859_n29089# 6.789040e-17
C1019 eeg_afe_pga_0/eeg_fd_ota_chopped_full2_0/eeg_bias_gen_0/m1_6341_n27552# VSS 4.190540e-16
C1021 eeg_afe_pga_0/eeg_fd_ota_chopped_full2_0/eeg_bias_gen_0/m1_6341_n27552# eeg_afe_pga_0/eeg_fd_ota_chopped_full2_0/eeg_bias_gen_0/m1_7141_n27552# 6.789050e-17
C1022 eeg_afe_pga_0/eeg_fd_ota_chopped_full2_0/eeg_bias_gen_0/m1_6341_n45240# VSS 4.190540e-16
C1023 eeg_afe_pga_0/eeg_fd_ota_chopped_full2_0/eeg_bias_gen_0/m1_6341_n45240# eeg_afe_pga_0/eeg_fd_ota_chopped_full2_0/eeg_bias_gen_0/m1_7141_n45240# 6.789050e-17
C1024 eeg_afe_pga_0/eeg_fd_ota_chopped_full2_0/eeg_bias_gen_0/m1_6341_n9864# VSS 4.190540e-16
C1026 eeg_afe_pga_0/eeg_fd_ota_chopped_full2_0/eeg_bias_gen_0/m1_6341_n9864# eeg_afe_pga_0/eeg_fd_ota_chopped_full2_0/eeg_bias_gen_0/m1_7141_n9864# 6.789050e-17
C1027 eeg_afe_pga_0/eeg_fd_ota_chopped_full2_0/eeg_bias_gen_0/m1_6459_n18708# VSS 2.918310e-16
C1029 eeg_afe_pga_0/eeg_fd_ota_chopped_full2_0/eeg_bias_gen_0/m1_6459_n18708# eeg_afe_pga_0/eeg_fd_ota_chopped_full2_0/eeg_bias_gen_0/m1_7259_n18708# 6.789040e-17
C1030 eeg_afe_pga_0/eeg_fd_ota_chopped_full2_0/eeg_bias_gen_0/m1_6459_n36396# VSS 2.918310e-16
C1032 eeg_afe_pga_0/eeg_fd_ota_chopped_full2_0/eeg_bias_gen_0/m1_6459_n36396# eeg_afe_pga_0/eeg_fd_ota_chopped_full2_0/eeg_bias_gen_0/m1_7259_n36396# 6.789050e-17
C1033 eeg_afe_pga_0/eeg_fd_ota_chopped_full2_0/eeg_bias_gen_0/m1_6741_n20245# VSS 4.190540e-16
C1035 eeg_afe_pga_0/eeg_fd_ota_chopped_full2_0/eeg_bias_gen_0/m1_6741_n20245# eeg_afe_pga_0/eeg_fd_ota_chopped_full2_0/eeg_bias_gen_0/m1_7541_n20245# 6.789050e-17
C1036 eeg_afe_pga_0/eeg_fd_ota_chopped_full2_0/eeg_bias_gen_0/m1_6741_n2557# VSS 4.190540e-16
C1037 eeg_afe_pga_0/eeg_fd_ota_chopped_full2_0/eeg_bias_gen_0/m1_6741_n2557# eeg_afe_pga_0/eeg_fd_ota_chopped_full2_0/eeg_bias_gen_0/m1_7541_n2557# 6.789050e-17
C1038 eeg_afe_pga_0/eeg_fd_ota_chopped_full2_0/eeg_bias_gen_0/m1_6741_n37933# VSS 4.190540e-16
C1040 eeg_afe_pga_0/eeg_fd_ota_chopped_full2_0/eeg_bias_gen_0/m1_6741_n37933# eeg_afe_pga_0/eeg_fd_ota_chopped_full2_0/eeg_bias_gen_0/m1_7541_n37933# 6.789050e-17
C1041 eeg_afe_pga_0/eeg_fd_ota_chopped_full2_0/eeg_bias_gen_0/m1_6859_n11401# VSS 2.918310e-16
C1043 eeg_afe_pga_0/eeg_fd_ota_chopped_full2_0/eeg_bias_gen_0/m1_6859_n11401# eeg_afe_pga_0/eeg_fd_ota_chopped_full2_0/eeg_bias_gen_0/m1_7659_n11401# 6.789047e-17
C1044 eeg_afe_pga_0/eeg_fd_ota_chopped_full2_0/eeg_bias_gen_0/m1_6859_n29089# VSS 2.918310e-16
C1046 eeg_afe_pga_0/eeg_fd_ota_chopped_full2_0/eeg_bias_gen_0/m1_6859_n29089# eeg_afe_pga_0/eeg_fd_ota_chopped_full2_0/eeg_bias_gen_0/m1_7659_n29089# 6.789043e-17
C1047 eeg_afe_pga_0/eeg_fd_ota_chopped_full2_0/eeg_bias_gen_0/m1_7141_n27552# VSS 4.190540e-16
C1049 eeg_afe_pga_0/eeg_fd_ota_chopped_full2_0/eeg_bias_gen_0/m1_7141_n27552# eeg_afe_pga_0/eeg_fd_ota_chopped_full2_0/eeg_bias_gen_0/m1_7941_n27552# 6.789050e-17
C1050 eeg_afe_pga_0/eeg_fd_ota_chopped_full2_0/eeg_bias_gen_0/m1_7141_n45240# VSS 4.190540e-16
C1051 eeg_afe_pga_0/eeg_fd_ota_chopped_full2_0/eeg_bias_gen_0/m1_7141_n45240# eeg_afe_pga_0/eeg_fd_ota_chopped_full2_0/eeg_bias_gen_0/m1_7941_n45240# 6.789050e-17
C1052 eeg_afe_pga_0/eeg_fd_ota_chopped_full2_0/eeg_bias_gen_0/m1_7141_n9864# VSS 4.190540e-16
C1054 eeg_afe_pga_0/eeg_fd_ota_chopped_full2_0/eeg_bias_gen_0/m1_7141_n9864# eeg_afe_pga_0/eeg_fd_ota_chopped_full2_0/eeg_bias_gen_0/m1_7941_n9864# 6.789050e-17
C1055 eeg_afe_pga_0/eeg_fd_ota_chopped_full2_0/eeg_bias_gen_0/m1_7259_n18708# VSS 2.918310e-16
C1057 eeg_afe_pga_0/eeg_fd_ota_chopped_full2_0/eeg_bias_gen_0/m1_7259_n18708# eeg_afe_pga_0/eeg_fd_ota_chopped_full2_0/eeg_bias_gen_0/m1_8059_n18708# 6.789043e-17
C1058 eeg_afe_pga_0/eeg_fd_ota_chopped_full2_0/eeg_bias_gen_0/m1_7259_n36396# VSS 2.918310e-16
C1060 eeg_afe_pga_0/eeg_fd_ota_chopped_full2_0/eeg_bias_gen_0/m1_7259_n36396# eeg_afe_pga_0/eeg_fd_ota_chopped_full2_0/eeg_bias_gen_0/m1_8059_n36396# 6.789043e-17
C1061 eeg_afe_pga_0/eeg_fd_ota_chopped_full2_0/eeg_bias_gen_0/m1_7541_n20245# VSS 4.190540e-16
C1063 eeg_afe_pga_0/eeg_fd_ota_chopped_full2_0/eeg_bias_gen_0/m1_7541_n20245# eeg_afe_pga_0/eeg_fd_ota_chopped_full2_0/eeg_bias_gen_0/m1_8341_n20245# 6.789050e-17
C1064 eeg_afe_pga_0/eeg_fd_ota_chopped_full2_0/eeg_bias_gen_0/m1_7541_n2557# VSS 4.190540e-16
C1065 eeg_afe_pga_0/eeg_fd_ota_chopped_full2_0/eeg_bias_gen_0/m1_7541_n2557# eeg_afe_pga_0/eeg_fd_ota_chopped_full2_0/eeg_bias_gen_0/m1_8341_n2557# 6.789050e-17
C1066 eeg_afe_pga_0/eeg_fd_ota_chopped_full2_0/eeg_bias_gen_0/m1_7541_n37933# VSS 4.190540e-16
C1068 eeg_afe_pga_0/eeg_fd_ota_chopped_full2_0/eeg_bias_gen_0/m1_7541_n37933# eeg_afe_pga_0/eeg_fd_ota_chopped_full2_0/eeg_bias_gen_0/m1_8341_n37933# 6.789050e-17
C1069 eeg_afe_pga_0/eeg_fd_ota_chopped_full2_0/eeg_bias_gen_0/m1_7659_n11401# VSS 2.918310e-16
C1071 eeg_afe_pga_0/eeg_fd_ota_chopped_full2_0/eeg_bias_gen_0/m1_7659_n11401# eeg_afe_pga_0/eeg_fd_ota_chopped_full2_0/eeg_bias_gen_0/m1_8459_n11401# 6.789047e-17
C1072 eeg_afe_pga_0/eeg_fd_ota_chopped_full2_0/eeg_bias_gen_0/m1_7659_n29089# VSS 2.918310e-16
C1074 eeg_afe_pga_0/eeg_fd_ota_chopped_full2_0/eeg_bias_gen_0/m1_7659_n29089# eeg_afe_pga_0/eeg_fd_ota_chopped_full2_0/eeg_bias_gen_0/m1_8459_n29089# 6.789040e-17
C1075 eeg_afe_pga_0/eeg_fd_ota_chopped_full2_0/eeg_bias_gen_0/m1_7941_n27552# VSS 4.190540e-16
C1077 eeg_afe_pga_0/eeg_fd_ota_chopped_full2_0/eeg_bias_gen_0/m1_7941_n27552# eeg_afe_pga_0/eeg_fd_ota_chopped_full2_0/eeg_bias_gen_0/m1_8741_n27552# 6.789050e-17
C1078 eeg_afe_pga_0/eeg_fd_ota_chopped_full2_0/eeg_bias_gen_0/m1_7941_n45240# VSS 4.190540e-16
C1079 eeg_afe_pga_0/eeg_fd_ota_chopped_full2_0/eeg_bias_gen_0/m1_7941_n45240# eeg_afe_pga_0/eeg_fd_ota_chopped_full2_0/eeg_bias_gen_0/m1_8741_n45240# 6.789050e-17
C1080 eeg_afe_pga_0/eeg_fd_ota_chopped_full2_0/eeg_bias_gen_0/m1_7941_n9864# VSS 4.190540e-16
C1082 eeg_afe_pga_0/eeg_fd_ota_chopped_full2_0/eeg_bias_gen_0/m1_7941_n9864# eeg_afe_pga_0/eeg_fd_ota_chopped_full2_0/eeg_bias_gen_0/m1_8741_n9864# 6.789050e-17
C1083 eeg_afe_pga_0/eeg_fd_ota_chopped_full2_0/eeg_bias_gen_0/m1_8059_n18708# VSS 2.918310e-16
C1085 eeg_afe_pga_0/eeg_fd_ota_chopped_full2_0/eeg_bias_gen_0/m1_8059_n18708# eeg_afe_pga_0/eeg_fd_ota_chopped_full2_0/eeg_bias_gen_0/m1_8859_n18708# 6.789040e-17
C1086 eeg_afe_pga_0/eeg_fd_ota_chopped_full2_0/eeg_bias_gen_0/m1_8059_n36396# VSS 2.918310e-16
C1088 eeg_afe_pga_0/eeg_fd_ota_chopped_full2_0/eeg_bias_gen_0/m1_8059_n36396# eeg_afe_pga_0/eeg_fd_ota_chopped_full2_0/eeg_bias_gen_0/m1_8859_n36396# 6.789050e-17
C1089 eeg_afe_pga_0/eeg_fd_ota_chopped_full2_0/eeg_bias_gen_0/m1_8341_n20245# VSS 4.190540e-16
C1091 eeg_afe_pga_0/eeg_fd_ota_chopped_full2_0/eeg_bias_gen_0/m1_8341_n20245# eeg_afe_pga_0/eeg_fd_ota_chopped_full2_0/eeg_bias_gen_0/m1_9141_n20245# 6.789040e-17
C1092 eeg_afe_pga_0/eeg_fd_ota_chopped_full2_0/eeg_bias_gen_0/m1_8341_n2557# VSS 4.190540e-16
C1093 eeg_afe_pga_0/eeg_fd_ota_chopped_full2_0/eeg_bias_gen_0/m1_8341_n2557# eeg_afe_pga_0/eeg_fd_ota_chopped_full2_0/eeg_bias_gen_0/m1_9141_n2557# 6.789040e-17
C1094 eeg_afe_pga_0/eeg_fd_ota_chopped_full2_0/eeg_bias_gen_0/m1_8341_n37933# VSS 4.190540e-16
C1096 eeg_afe_pga_0/eeg_fd_ota_chopped_full2_0/eeg_bias_gen_0/m1_8341_n37933# eeg_afe_pga_0/eeg_fd_ota_chopped_full2_0/eeg_bias_gen_0/m1_9141_n37933# 6.789052e-17
C1097 eeg_afe_pga_0/eeg_fd_ota_chopped_full2_0/eeg_bias_gen_0/m1_8459_n11401# VSS 2.918310e-16
C1099 eeg_afe_pga_0/eeg_fd_ota_chopped_full2_0/eeg_bias_gen_0/m1_8459_n11401# eeg_afe_pga_0/eeg_fd_ota_chopped_full2_0/eeg_bias_gen_0/m1_9259_n11401# 6.789036e-17
C1100 eeg_afe_pga_0/eeg_fd_ota_chopped_full2_0/eeg_bias_gen_0/m1_8459_n29089# VSS 2.918310e-16
C1102 eeg_afe_pga_0/eeg_fd_ota_chopped_full2_0/eeg_bias_gen_0/m1_8459_n29089# eeg_afe_pga_0/eeg_fd_ota_chopped_full2_0/eeg_bias_gen_0/m1_9259_n29089# 6.789050e-17
C1103 eeg_afe_pga_0/eeg_fd_ota_chopped_full2_0/eeg_bias_gen_0/m1_8741_n27552# VSS 4.190540e-16
C1105 eeg_afe_pga_0/eeg_fd_ota_chopped_full2_0/eeg_bias_gen_0/m1_8741_n27552# eeg_afe_pga_0/eeg_fd_ota_chopped_full2_0/eeg_bias_gen_0/m1_9541_n27552# 6.789050e-17
C1106 eeg_afe_pga_0/eeg_fd_ota_chopped_full2_0/eeg_bias_gen_0/m1_8741_n45240# VSS 4.190540e-16
C1107 eeg_afe_pga_0/eeg_fd_ota_chopped_full2_0/eeg_bias_gen_0/m1_8741_n45240# eeg_afe_pga_0/eeg_fd_ota_chopped_full2_0/eeg_bias_gen_0/m1_9541_n45240# 6.789050e-17
C1108 eeg_afe_pga_0/eeg_fd_ota_chopped_full2_0/eeg_bias_gen_0/m1_8741_n9864# VSS 4.190540e-16
C1110 eeg_afe_pga_0/eeg_fd_ota_chopped_full2_0/eeg_bias_gen_0/m1_8741_n9864# eeg_afe_pga_0/eeg_fd_ota_chopped_full2_0/eeg_bias_gen_0/m1_9541_n9864# 6.789050e-17
C1111 eeg_afe_pga_0/eeg_fd_ota_chopped_full2_0/eeg_bias_gen_0/m1_8859_n18708# VSS 2.918310e-16
C1113 eeg_afe_pga_0/eeg_fd_ota_chopped_full2_0/eeg_bias_gen_0/m1_8859_n18708# eeg_afe_pga_0/eeg_fd_ota_chopped_full2_0/eeg_bias_gen_0/m1_9659_n18708# 6.789040e-17
C1114 eeg_afe_pga_0/eeg_fd_ota_chopped_full2_0/eeg_bias_gen_0/m1_8859_n36396# VSS 2.918310e-16
C1116 eeg_afe_pga_0/eeg_fd_ota_chopped_full2_0/eeg_bias_gen_0/m1_8859_n36396# eeg_afe_pga_0/eeg_fd_ota_chopped_full2_0/eeg_bias_gen_0/m1_9659_n36396# 6.789050e-17
C1117 eeg_afe_pga_0/eeg_fd_ota_chopped_full2_0/eeg_bias_gen_0/m1_9141_n20245# VSS 4.190540e-16
C1119 eeg_afe_pga_0/eeg_fd_ota_chopped_full2_0/eeg_bias_gen_0/m1_9141_n20245# eeg_afe_pga_0/eeg_fd_ota_chopped_full2_0/eeg_bias_gen_0/m1_9941_n20245# 6.789050e-17
C1120 eeg_afe_pga_0/eeg_fd_ota_chopped_full2_0/eeg_bias_gen_0/m1_9141_n2557# VSS 4.190540e-16
C1121 eeg_afe_pga_0/eeg_fd_ota_chopped_full2_0/eeg_bias_gen_0/m1_9141_n2557# eeg_afe_pga_0/eeg_fd_ota_chopped_full2_0/eeg_bias_gen_0/m1_9941_n2557# 6.789050e-17
C1122 eeg_afe_pga_0/eeg_fd_ota_chopped_full2_0/eeg_bias_gen_0/m1_9141_n37933# VSS 4.190540e-16
C1124 eeg_afe_pga_0/eeg_fd_ota_chopped_full2_0/eeg_bias_gen_0/m1_9141_n37933# eeg_afe_pga_0/eeg_fd_ota_chopped_full2_0/eeg_bias_gen_0/m1_9941_n37933# 6.789050e-17
C1125 eeg_afe_pga_0/eeg_fd_ota_chopped_full2_0/eeg_bias_gen_0/m1_9259_n11401# VSS 2.918310e-16
C1127 eeg_afe_pga_0/eeg_fd_ota_chopped_full2_0/eeg_bias_gen_0/m1_9259_n29089# VSS 2.918310e-16
C1129 eeg_afe_pga_0/eeg_fd_ota_chopped_full2_0/eeg_bias_gen_0/m1_9541_n27552# VSS 4.190540e-16
C1130 eeg_afe_pga_0/eeg_fd_ota_chopped_full2_0/eeg_bias_gen_0/m1_9541_n45240# VSS 4.190540e-16
C1131 eeg_afe_pga_0/eeg_fd_ota_chopped_full2_0/eeg_bias_gen_0/m1_9541_n9864# VSS 4.190540e-16
C1132 eeg_afe_pga_0/eeg_fd_ota_chopped_full2_0/eeg_bias_gen_0/m1_9659_n18708# VSS 2.918310e-16
C1134 eeg_afe_pga_0/eeg_fd_ota_chopped_full2_0/eeg_bias_gen_0/m1_9659_n36396# VSS 2.918310e-16
C1136 eeg_afe_pga_0/eeg_fd_ota_chopped_full2_0/eeg_bias_gen_0/m1_9941_n20245# VSS 4.190540e-16
C1137 eeg_afe_pga_0/eeg_fd_ota_chopped_full2_0/eeg_bias_gen_0/m1_9941_n2557# VSS 4.190540e-16
C1138 eeg_afe_pga_0/eeg_fd_ota_chopped_full2_0/eeg_bias_gen_0/m1_9941_n37933# VSS 4.190540e-16
C1139 VDD18 VSS 1.198063e-14
C1140 VDD18 eeg_afe_pga_0/eeg_fd_ota_chopped_full2_0/eeg_bias_gen_0/VBN 2.562736e-16
C1141 VDD18 eeg_afe_pga_0/eeg_fd_ota_chopped_full2_0/eeg_bias_gen_0/VBP 2.977050e-15
C1142 eeg_afe_pga_0/eeg_fd_ota_chopped_full2_0/eeg_bias_gen_0/VBN eeg_afe_pga_0/eeg_fd_ota_chopped_full2_0/eeg_bias_gen_0/VBP 6.762340e-16
C1143 eeg_afe_pga_0/eeg_fd_ota_chopped_full2_0/eeg_bias_gen_0/VBP VSS 6.072420e-16
C1144 eeg_afe_pga_0/eeg_fd_ota_chopped_full2_0/eeg_bias_gen_0/m1_6341_n27552# VSS 6.746650e-16
C1145 eeg_afe_pga_0/eeg_fd_ota_chopped_full2_0/eeg_bias_gen_0/m1_6741_n20245# VSS 6.746650e-16
C1146 VDD18 VSS 8.414800e-16
C1147 VDD18 eeg_afe_pga_0/eeg_fd_ota_chopped_full2_0/eeg_bias_gen_0/VBN 8.460309e-16
C1148 VDD18 eeg_afe_pga_0/eeg_fd_ota_chopped_full2_0/eeg_bias_gen_0/eeg_pseudo_res_0/m1_68_66# 1.314672e-15
C1149 eeg_afe_pga_0/eeg_fd_ota_chopped_full2_0/eeg_bias_gen_0/VBN VSS 1.699680e-15
C1150 eeg_afe_pga_0/eeg_fd_ota_chopped_full2_0/eeg_bias_gen_0/VBN eeg_afe_pga_0/eeg_fd_ota_chopped_full2_0/eeg_bias_gen_0/eeg_pseudo_res_0/m1_68_66# 5.017998e-16
C1151 eeg_afe_pga_0/eeg_fd_ota_chopped_full2_0/eeg_bias_gen_0/eeg_pseudo_res_0/m1_68_66# VSS 3.582030e-15
C1152 eeg_afe_pga_0/eeg_fd_ota_chopped_full2_0/eeg_bias_gen_0/VBN VSS 3.678650e-15
C1153 eeg_afe_pga_0/eeg_fd_ota_chopped_full2_0/eeg_bias_gen_0/VBN eeg_afe_pga_0/eeg_fd_ota_chopped_full2_0/eeg_bias_gen_0/eeg_pseudo_res_0/m1_68_66# 1.322042e-15
C1154 eeg_afe_pga_0/eeg_fd_ota_chopped_full2_0/eeg_bias_gen_0/eeg_pseudo_res_0/m1_68_66# VSS 4.103261e-16
C1155 VDD18 VSS 3.678650e-15
C1156 VDD18 eeg_afe_pga_0/eeg_fd_ota_chopped_full2_0/eeg_bias_gen_0/eeg_pseudo_res_0/m1_68_66# 1.322042e-15
C1157 eeg_afe_pga_0/eeg_fd_ota_chopped_full2_0/eeg_bias_gen_0/eeg_pseudo_res_0/m1_68_66# VSS 4.103261e-16
C1158 eeg_afe_pga_0/eeg_fd_ota_chopped_full2_0/eeg_bias_gen_0/m1_10459_n36396# VSS 6.746650e-16
C1159 eeg_afe_pga_0/eeg_fd_ota_chopped_full2_0/eeg_bias_gen_0/m1_10859_n29089# VSS 6.746650e-16
C1160 VSS eeg_afe_pga_0/eeg_fd_ota_chopped_full2_0/eeg_bias_gen_0/VBN 8.327656e-16
C1161 eeg_afe_pga_0/eeg_fd_ota_chopped_full2_0/eeg_bias_gen_0/VBN VSS 2.737979e-15
C1162 eeg_afe_pga_0/eeg_fd_ota_chopped_full2_0/eeg_bias_gen_0/m1_5941_n20245# VSS 6.746650e-16
C1163 eeg_afe_pga_0/eeg_fd_ota_chopped_full2_0/eeg_bias_gen_0/m1_6341_n27552# VSS 6.746650e-16
C1164 eeg_afe_pga_0/eeg_fd_ota_chopped_full2_0/eeg_bias_gen_0/m1_10341_n27552# VSS 6.746650e-16
C1165 eeg_afe_pga_0/eeg_fd_ota_chopped_full2_0/eeg_bias_gen_0/m1_10741_n20245# VSS 6.746650e-16
C1166 eeg_afe_pga_0/eeg_fd_ota_chopped_full2_0/eeg_bias_gen_0/m1_2524_466# VSS 6.747650e-16
C1167 eeg_afe_pga_0/eeg_fd_ota_chopped_full2_0/eeg_bias_gen_0/m1_10859_n29089# VSS 6.746650e-16
C1168 eeg_afe_pga_0/eeg_fd_ota_chopped_full2_0/eeg_bias_gen_0/m1_11259_n36396# VSS 6.746650e-16
C1169 eeg_afe_pga_0/eeg_fd_ota_chopped_full2_0/eeg_bias_gen_0/VBNF VSS 6.746650e-16
C1170 eeg_afe_pga_0/eeg_fd_ota_chopped_full2_0/eeg_bias_gen_0/m1_11141_n9864# VSS 6.746650e-16
C1171 eeg_afe_pga_0/eeg_fd_ota_chopped_full2_0/eeg_bias_gen_0/m1_11259_n36396# VSS 6.746650e-16
C1172 eeg_afe_pga_0/eeg_fd_ota_chopped_full2_0/eeg_bias_gen_0/m1_11541_n37933# VSS 6.746650e-16
C1173 eeg_afe_pga_0/eeg_fd_ota_chopped_full2_0/eeg_bias_gen_0/m1_5541_n27552# VSS 6.746650e-16
C1174 eeg_afe_pga_0/eeg_fd_ota_chopped_full2_0/eeg_bias_gen_0/m1_5941_n20245# VSS 6.746650e-16
C1175 eeg_afe_pga_0/eeg_fd_ota_chopped_full2_0/eeg_bias_gen_0/m1_10341_n27552# VSS 6.746650e-16
C1176 eeg_afe_pga_0/eeg_fd_ota_chopped_full2_0/eeg_bias_gen_0/m1_9941_n20245# VSS 6.746650e-16
C1177 eeg_afe_pga_0/eeg_fd_ota_chopped_full2_0/eeg_bias_gen_0/m1_10741_n2557# VSS 6.746650e-16
C1178 eeg_afe_pga_0/eeg_fd_ota_chopped_full2_0/eeg_bias_gen_0/m1_11141_n9864# VSS 6.746650e-16
C1179 eeg_afe_pga_0/eeg_fd_ota_chopped_full2_0/eeg_bias_gen_0/m1_5141_n20245# VSS 6.746650e-16
C1180 eeg_afe_pga_0/eeg_fd_ota_chopped_full2_0/eeg_bias_gen_0/m1_5541_n27552# VSS 6.746650e-16
C1181 eeg_afe_pga_0/eeg_fd_ota_chopped_full2_0/eeg_bias_gen_0/m1_9541_n27552# VSS 6.746650e-16
C1182 eeg_afe_pga_0/eeg_fd_ota_chopped_full2_0/eeg_bias_gen_0/m1_9941_n20245# VSS 6.746650e-16
C1183 eeg_afe_pga_0/eeg_fd_ota_chopped_full2_0/eeg_bias_gen_0/m1_4859_n18708# VSS 6.746650e-16
C1184 eeg_afe_pga_0/eeg_fd_ota_chopped_full2_0/eeg_bias_gen_0/m1_5259_n11401# VSS 6.746650e-16
C1185 eeg_afe_pga_0/eeg_fd_ota_chopped_full2_0/eeg_bias_gen_0/m1_11141_n45240# VSS 6.746650e-16
C1186 eeg_afe_pga_0/eeg_fd_ota_chopped_full2_0/eeg_bias_gen_0/m1_11541_n37933# VSS 6.746650e-16
C1187 eeg_afe_pga_0/eeg_fd_ota_chopped_full2_0/eeg_bias_gen_0/m1_10341_n9864# VSS 6.746650e-16
C1188 eeg_afe_pga_0/eeg_fd_ota_chopped_full2_0/eeg_bias_gen_0/m1_10741_n2557# VSS 6.746650e-16
C1189 eeg_afe_pga_0/eeg_fd_ota_chopped_full2_0/eeg_bias_gen_0/m1_4741_n27552# VSS 6.746650e-16
C1190 eeg_afe_pga_0/eeg_fd_ota_chopped_full2_0/eeg_bias_gen_0/m1_5141_n20245# VSS 6.746650e-16
C1191 eeg_afe_pga_0/eeg_fd_ota_chopped_full2_0/eeg_bias_gen_0/m1_9141_n20245# VSS 6.746650e-16
C1192 eeg_afe_pga_0/eeg_fd_ota_chopped_full2_0/eeg_bias_gen_0/m1_9541_n27552# VSS 6.746650e-16
C1193 eeg_afe_pga_0/eeg_fd_ota_chopped_full2_0/eeg_bias_gen_0/m1_5259_n11401# VSS 6.746650e-16
C1194 eeg_afe_pga_0/eeg_fd_ota_chopped_full2_0/eeg_bias_gen_0/m1_5659_n18708# VSS 6.746650e-16
C1195 eeg_afe_pga_0/eeg_fd_ota_chopped_full2_0/eeg_bias_gen_0/m1_5941_n2557# VSS 6.746650e-16
C1196 eeg_afe_pga_0/eeg_fd_ota_chopped_full2_0/eeg_bias_gen_0/m1_6341_n9864# VSS 6.746650e-16
C1197 eeg_afe_pga_0/eeg_fd_ota_chopped_full2_0/eeg_bias_gen_0/m1_10741_n37933# VSS 6.746650e-16
C1198 eeg_afe_pga_0/eeg_fd_ota_chopped_full2_0/eeg_bias_gen_0/m1_11141_n45240# VSS 6.746650e-16
C1199 eeg_afe_pga_0/eeg_fd_ota_chopped_full2_0/eeg_bias_gen_0/m1_4341_n20245# VSS 6.746650e-16
C1200 eeg_afe_pga_0/eeg_fd_ota_chopped_full2_0/eeg_bias_gen_0/m1_4741_n27552# VSS 6.746650e-16
C1201 eeg_afe_pga_0/eeg_fd_ota_chopped_full2_0/eeg_bias_gen_0/m1_8741_n27552# VSS 6.746650e-16
C1202 eeg_afe_pga_0/eeg_fd_ota_chopped_full2_0/eeg_bias_gen_0/m1_9141_n20245# VSS 6.746650e-16
C1203 eeg_afe_pga_0/eeg_fd_ota_chopped_full2_0/eeg_bias_gen_0/m1_5659_n18708# VSS 6.746650e-16
C1204 eeg_afe_pga_0/eeg_fd_ota_chopped_full2_0/eeg_bias_gen_0/m1_6059_n11401# VSS 6.746650e-16
C1205 eeg_afe_pga_0/eeg_fd_ota_chopped_full2_0/eeg_bias_gen_0/m1_10059_n11401# VSS 6.746650e-16
C1206 eeg_afe_pga_0/eeg_fd_ota_chopped_full2_0/eeg_bias_gen_0/m1_9659_n18708# VSS 6.746650e-16
C1207 eeg_afe_pga_0/eeg_fd_ota_chopped_full2_0/eeg_bias_gen_0/m1_10459_n18708# VSS 6.746650e-16
C1208 eeg_afe_pga_0/eeg_fd_ota_chopped_full2_0/eeg_bias_gen_0/m1_10859_n11401# VSS 6.746650e-16
C1209 eeg_afe_pga_0/eeg_fd_ota_chopped_full2_0/eeg_bias_gen_0/m1_5541_n9864# VSS 6.746650e-16
C1210 eeg_afe_pga_0/eeg_fd_ota_chopped_full2_0/eeg_bias_gen_0/m1_5941_n2557# VSS 6.746650e-16
C1211 eeg_afe_pga_0/eeg_fd_ota_chopped_full2_0/eeg_bias_gen_0/m1_10341_n45240# VSS 6.746650e-16
C1212 eeg_afe_pga_0/eeg_fd_ota_chopped_full2_0/eeg_bias_gen_0/m1_10741_n37933# VSS 6.746650e-16
C1213 VDD18 VSS 1.198063e-14
C1214 VDD18 eeg_afe_pga_0/eeg_fd_ota_chopped_full2_0/eeg_bias_gen_0/VBP 3.233324e-15
C1215 eeg_afe_pga_0/eeg_fd_ota_chopped_full2_0/eeg_bias_gen_0/VBP VSS 6.072420e-16
C1216 eeg_afe_pga_0/eeg_fd_ota_chopped_full2_0/eeg_bias_gen_0/m1_5941_n37933# VSS 6.746650e-16
C1217 eeg_afe_pga_0/eeg_fd_ota_chopped_full2_0/eeg_bias_gen_0/m1_6341_n45240# VSS 6.746650e-16
C1218 eeg_afe_pga_0/eeg_fd_ota_chopped_full2_0/eeg_bias_gen_0/m1_3941_n27552# VSS 6.746650e-16
C1219 eeg_afe_pga_0/eeg_fd_ota_chopped_full2_0/eeg_bias_gen_0/m1_4341_n20245# VSS 6.746650e-16
C1220 eeg_afe_pga_0/eeg_fd_ota_chopped_full2_0/eeg_bias_gen_0/m1_8341_n20245# VSS 6.746650e-16
C1221 eeg_afe_pga_0/eeg_fd_ota_chopped_full2_0/eeg_bias_gen_0/m1_8741_n27552# VSS 6.746650e-16
C1222 eeg_afe_pga_0/eeg_fd_ota_chopped_full2_0/eeg_bias_gen_0/m1_6059_n11401# VSS 6.746650e-16
C1223 eeg_afe_pga_0/eeg_fd_ota_chopped_full2_0/eeg_bias_gen_0/m1_6459_n18708# VSS 6.746650e-16
C1224 eeg_afe_pga_0/eeg_fd_ota_chopped_full2_0/eeg_bias_gen_0/m1_10859_n11401# VSS 6.746650e-16
C1225 eeg_afe_pga_0/eeg_fd_ota_chopped_full2_0/eeg_bias_gen_0/m1_11259_n18708# VSS 6.746650e-16
C1226 eeg_afe_pga_0/eeg_fd_ota_chopped_full2_0/eeg_bias_gen_0/m1_5141_n2557# VSS 6.746650e-16
C1227 eeg_afe_pga_0/eeg_fd_ota_chopped_full2_0/eeg_bias_gen_0/m1_5541_n9864# VSS 6.746650e-16
C1228 eeg_afe_pga_0/eeg_fd_ota_chopped_full2_0/eeg_bias_gen_0/m1_9541_n9864# VSS 6.746650e-16
C1229 eeg_afe_pga_0/eeg_fd_ota_chopped_full2_0/eeg_bias_gen_0/m1_9941_n2557# VSS 6.746650e-16
C1230 eeg_afe_pga_0/eeg_fd_ota_chopped_full2_0/eeg_bias_gen_0/m1_4859_n36396# VSS 6.746650e-16
C1231 eeg_afe_pga_0/eeg_fd_ota_chopped_full2_0/eeg_bias_gen_0/m1_5259_n29089# VSS 6.746650e-16
C1232 eeg_afe_pga_0/eeg_fd_ota_chopped_full2_0/eeg_bias_gen_0/VBN VSS 6.746650e-16
C1233 eeg_afe_pga_0/eeg_fd_ota_chopped_full2_0/eeg_bias_gen_0/m1_3941_n45240# VSS 6.746650e-16
C1234 eeg_afe_pga_0/eeg_fd_ota_chopped_full2_0/eeg_bias_gen_0/m1_5541_n45240# VSS 6.746650e-16
C1235 eeg_afe_pga_0/eeg_fd_ota_chopped_full2_0/eeg_bias_gen_0/m1_5941_n37933# VSS 6.746650e-16
C1236 eeg_afe_pga_0/eeg_fd_ota_chopped_full2_0/eeg_bias_gen_0/m1_3701_n29089# VSS 6.746650e-16
C1237 eeg_afe_pga_0/eeg_fd_ota_chopped_full2_0/eeg_bias_gen_0/m1_3941_n27552# VSS 6.746650e-16
C1238 eeg_afe_pga_0/eeg_fd_ota_chopped_full2_0/eeg_bias_gen_0/m1_7941_n27552# VSS 6.746650e-16
C1239 eeg_afe_pga_0/eeg_fd_ota_chopped_full2_0/eeg_bias_gen_0/m1_8341_n20245# VSS 6.746650e-16
C1240 eeg_afe_pga_0/eeg_fd_ota_chopped_full2_0/eeg_bias_gen_0/m1_6459_n18708# VSS 6.746650e-16
C1241 eeg_afe_pga_0/eeg_fd_ota_chopped_full2_0/eeg_bias_gen_0/m1_6859_n11401# VSS 6.746650e-16
C1242 eeg_afe_pga_0/eeg_fd_ota_chopped_full2_0/eeg_bias_gen_0/m1_11259_n18708# VSS 6.746650e-16
C1243 eeg_afe_pga_0/eeg_fd_ota_chopped_full2_0/eeg_bias_gen_0/m1_11541_n20245# VSS 6.746650e-16
C1244 eeg_afe_pga_0/eeg_fd_ota_chopped_full2_0/eeg_bias_gen_0/m1_4741_n9864# VSS 6.746650e-16
C1245 eeg_afe_pga_0/eeg_fd_ota_chopped_full2_0/eeg_bias_gen_0/m1_5141_n2557# VSS 6.746650e-16
C1246 eeg_afe_pga_0/eeg_fd_ota_chopped_full2_0/eeg_bias_gen_0/m1_9141_n2557# VSS 6.746650e-16
C1247 eeg_afe_pga_0/eeg_fd_ota_chopped_full2_0/eeg_bias_gen_0/m1_9541_n9864# VSS 6.746650e-16
C1248 eeg_afe_pga_0/eeg_fd_ota_chopped_full2_0/eeg_bias_gen_0/m1_5259_n29089# VSS 6.746650e-16
C1249 eeg_afe_pga_0/eeg_fd_ota_chopped_full2_0/eeg_bias_gen_0/m1_5659_n36396# VSS 6.746650e-16
C1250 eeg_afe_pga_0/eeg_fd_ota_chopped_full2_0/eeg_bias_gen_0/m1_10341_n9864# VSS 6.746650e-16
C1251 eeg_afe_pga_0/eeg_fd_ota_chopped_full2_0/eeg_bias_gen_0/m1_9941_n2557# VSS 6.746650e-16
C1252 eeg_afe_pga_0/eeg_fd_ota_chopped_full2_0/eeg_bias_gen_0/m1_5141_n37933# VSS 6.746650e-16
C1253 eeg_afe_pga_0/eeg_fd_ota_chopped_full2_0/eeg_bias_gen_0/m1_5541_n45240# VSS 6.746650e-16
C1254 eeg_afe_pga_0/eeg_fd_ota_chopped_full2_0/eeg_bias_gen_0/m1_9541_n45240# VSS 6.746650e-16
C1255 eeg_afe_pga_0/eeg_fd_ota_chopped_full2_0/eeg_bias_gen_0/m1_9941_n37933# VSS 6.746650e-16
C1256 eeg_afe_pga_0/eeg_fd_ota_chopped_full2_0/eeg_bias_gen_0/m1_6459_n36396# VSS 6.746650e-16
C1257 eeg_afe_pga_0/eeg_fd_ota_chopped_full2_0/eeg_bias_gen_0/m1_6859_n29089# VSS 6.746650e-16
C1258 eeg_afe_pga_0/eeg_fd_ota_chopped_full2_0/eeg_bias_gen_0/m1_10059_n29089# VSS 6.746650e-16
C1259 eeg_afe_pga_0/eeg_fd_ota_chopped_full2_0/eeg_bias_gen_0/m1_10459_n36396# VSS 6.746650e-16
C1260 eeg_afe_pga_0/eeg_fd_ota_chopped_full2_0/eeg_bias_gen_0/m1_7541_n20245# VSS 6.746650e-16
C1261 eeg_afe_pga_0/eeg_fd_ota_chopped_full2_0/eeg_bias_gen_0/m1_7941_n27552# VSS 6.746650e-16
C1262 eeg_afe_pga_0/eeg_fd_ota_chopped_full2_0/eeg_bias_gen_0/m1_6859_n11401# VSS 6.746650e-16
C1263 eeg_afe_pga_0/eeg_fd_ota_chopped_full2_0/eeg_bias_gen_0/m1_7259_n18708# VSS 6.746650e-16
C1264 eeg_afe_pga_0/eeg_fd_ota_chopped_full2_0/eeg_bias_gen_0/m1_4341_n2557# VSS 6.746650e-16
C1265 eeg_afe_pga_0/eeg_fd_ota_chopped_full2_0/eeg_bias_gen_0/m1_4741_n9864# VSS 6.746650e-16
C1266 eeg_afe_pga_0/eeg_fd_ota_chopped_full2_0/eeg_bias_gen_0/m1_8741_n9864# VSS 6.746650e-16
C1267 eeg_afe_pga_0/eeg_fd_ota_chopped_full2_0/eeg_bias_gen_0/m1_9141_n2557# VSS 6.746650e-16
C1268 eeg_afe_pga_0/eeg_fd_ota_chopped_full2_0/eeg_bias_gen_0/m1_5659_n36396# VSS 6.746650e-16
C1269 eeg_afe_pga_0/eeg_fd_ota_chopped_full2_0/eeg_bias_gen_0/m1_6059_n29089# VSS 6.746650e-16
C1270 eeg_afe_pga_0/eeg_fd_ota_chopped_full2_0/eeg_bias_gen_0/m1_4741_n45240# VSS 6.746650e-16
C1271 eeg_afe_pga_0/eeg_fd_ota_chopped_full2_0/eeg_bias_gen_0/m1_5141_n37933# VSS 6.746650e-16
C1272 eeg_afe_pga_0/eeg_fd_ota_chopped_full2_0/eeg_bias_gen_0/m1_9141_n37933# VSS 6.746650e-16
C1273 eeg_afe_pga_0/eeg_fd_ota_chopped_full2_0/eeg_bias_gen_0/m1_9541_n45240# VSS 6.746650e-16
C1274 eeg_afe_pga_0/eeg_fd_ota_chopped_full2_0/eeg_bias_gen_0/m1_10341_n45240# VSS 6.746650e-16
C1275 eeg_afe_pga_0/eeg_fd_ota_chopped_full2_0/eeg_bias_gen_0/m1_9941_n37933# VSS 6.746650e-16
C1276 eeg_afe_pga_0/eeg_fd_ota_chopped_full2_0/eeg_bias_gen_0/m1_6859_n29089# VSS 6.746650e-16
C1277 eeg_afe_pga_0/eeg_fd_ota_chopped_full2_0/eeg_bias_gen_0/m1_7259_n36396# VSS 6.746650e-16
C1278 eeg_afe_pga_0/eeg_fd_ota_chopped_full2_0/eeg_bias_gen_0/m1_7141_n27552# VSS 6.746650e-16
C1279 eeg_afe_pga_0/eeg_fd_ota_chopped_full2_0/eeg_bias_gen_0/m1_7541_n20245# VSS 6.746650e-16
C1280 eeg_afe_pga_0/eeg_fd_ota_chopped_full2_0/eeg_bias_gen_0/m1_7259_n18708# VSS 6.746650e-16
C1281 eeg_afe_pga_0/eeg_fd_ota_chopped_full2_0/eeg_bias_gen_0/m1_7659_n11401# VSS 6.746650e-16
C1282 eeg_afe_pga_0/eeg_fd_ota_chopped_full2_0/eeg_bias_gen_0/m1_10059_n11401# VSS 6.746650e-16
C1283 eeg_afe_pga_0/eeg_fd_ota_chopped_full2_0/eeg_bias_gen_0/m1_10459_n18708# VSS 6.746650e-16
C1284 eeg_afe_pga_0/eeg_fd_ota_chopped_full2_0/eeg_bias_gen_0/m1_3941_n9864# VSS 6.746650e-16
C1285 eeg_afe_pga_0/eeg_fd_ota_chopped_full2_0/eeg_bias_gen_0/m1_4341_n2557# VSS 6.746650e-16
C1286 eeg_afe_pga_0/eeg_fd_ota_chopped_full2_0/eeg_bias_gen_0/m1_8341_n2557# VSS 6.746650e-16
C1287 eeg_afe_pga_0/eeg_fd_ota_chopped_full2_0/eeg_bias_gen_0/m1_8741_n9864# VSS 6.746650e-16
C1288 eeg_afe_pga_0/eeg_fd_ota_chopped_full2_0/eeg_bias_gen_0/m1_6059_n29089# VSS 6.746650e-16
C1289 eeg_afe_pga_0/eeg_fd_ota_chopped_full2_0/eeg_bias_gen_0/m1_6459_n36396# VSS 6.746650e-16
C1290 eeg_afe_pga_0/eeg_fd_ota_chopped_full2_0/eeg_bias_gen_0/m1_4341_n37933# VSS 6.746650e-16
C1291 eeg_afe_pga_0/eeg_fd_ota_chopped_full2_0/eeg_bias_gen_0/m1_4741_n45240# VSS 6.746650e-16
C1292 eeg_afe_pga_0/eeg_fd_ota_chopped_full2_0/eeg_bias_gen_0/m1_8741_n45240# VSS 6.746650e-16
C1293 eeg_afe_pga_0/eeg_fd_ota_chopped_full2_0/eeg_bias_gen_0/m1_9141_n37933# VSS 6.746650e-16
C1294 eeg_afe_pga_0/eeg_fd_ota_chopped_full2_0/eeg_bias_gen_0/m1_7259_n36396# VSS 6.746650e-16
C1295 eeg_afe_pga_0/eeg_fd_ota_chopped_full2_0/eeg_bias_gen_0/m1_7659_n29089# VSS 6.746650e-16
C1296 eeg_afe_pga_0/eeg_fd_ota_chopped_full2_0/eeg_bias_gen_0/m1_6741_n20245# VSS 6.746650e-16
C1297 eeg_afe_pga_0/eeg_fd_ota_chopped_full2_0/eeg_bias_gen_0/m1_7141_n27552# VSS 6.746650e-16
C1298 eeg_afe_pga_0/eeg_fd_ota_chopped_full2_0/eeg_bias_gen_0/m1_11141_n27552# VSS 6.746650e-16
C1299 eeg_afe_pga_0/eeg_fd_ota_chopped_full2_0/eeg_bias_gen_0/m1_11541_n20245# VSS 6.746650e-16
C1300 eeg_afe_pga_0/eeg_fd_ota_chopped_full2_0/eeg_bias_gen_0/m1_7659_n11401# VSS 6.746650e-16
C1301 eeg_afe_pga_0/eeg_fd_ota_chopped_full2_0/eeg_bias_gen_0/m1_8059_n18708# VSS 6.746650e-16
C1302 eeg_afe_pga_0/eeg_fd_ota_chopped_full2_0/eeg_bias_gen_0/m1_3701_n11401# VSS 6.746650e-16
C1303 eeg_afe_pga_0/eeg_fd_ota_chopped_full2_0/eeg_bias_gen_0/m1_3941_n9864# VSS 6.746650e-16
C1304 eeg_afe_pga_0/eeg_fd_ota_chopped_full2_0/eeg_bias_gen_0/m1_7941_n9864# VSS 6.746650e-16
C1305 eeg_afe_pga_0/eeg_fd_ota_chopped_full2_0/eeg_bias_gen_0/m1_8341_n2557# VSS 6.746650e-16
C1306 eeg_afe_pga_0/eeg_fd_ota_chopped_full2_0/eeg_bias_gen_0/m1_8341_n37933# VSS 6.746650e-16
C1307 eeg_afe_pga_0/eeg_fd_ota_chopped_full2_0/eeg_bias_gen_0/m1_8741_n45240# VSS 6.746650e-16
C1308 eeg_afe_pga_0/eeg_fd_ota_chopped_full2_0/eeg_bias_gen_0/m1_3701_n29089# VSS 6.746650e-16
C1309 eeg_afe_pga_0/eeg_fd_ota_chopped_full2_0/eeg_bias_gen_0/m1_4059_n36396# VSS 6.746650e-16
C1310 eeg_afe_pga_0/eeg_fd_ota_chopped_full2_0/eeg_bias_gen_0/m1_7659_n29089# VSS 6.746650e-16
C1311 eeg_afe_pga_0/eeg_fd_ota_chopped_full2_0/eeg_bias_gen_0/m1_8059_n36396# VSS 6.746650e-16
C1312 eeg_afe_pga_0/eeg_fd_ota_chopped_full2_0/eeg_bias_gen_0/m1_10741_n20245# VSS 6.746650e-16
C1313 eeg_afe_pga_0/eeg_fd_ota_chopped_full2_0/eeg_bias_gen_0/m1_11141_n27552# VSS 6.746650e-16
C1314 eeg_afe_pga_0/eeg_fd_ota_chopped_full2_0/eeg_bias_gen_0/m1_3701_n11401# VSS 6.746650e-16
C1315 eeg_afe_pga_0/eeg_fd_ota_chopped_full2_0/eeg_bias_gen_0/m1_4059_n18708# VSS 6.746650e-16
C1316 eeg_afe_pga_0/eeg_fd_ota_chopped_full2_0/eeg_bias_gen_0/m1_8059_n18708# VSS 6.746650e-16
C1317 eeg_afe_pga_0/eeg_fd_ota_chopped_full2_0/eeg_bias_gen_0/m1_8459_n11401# VSS 6.746650e-16
C1318 eeg_afe_pga_0/eeg_fd_ota_chopped_full2_0/eeg_bias_gen_0/m1_7541_n2557# VSS 6.746650e-16
C1319 eeg_afe_pga_0/eeg_fd_ota_chopped_full2_0/eeg_bias_gen_0/m1_7941_n9864# VSS 6.746650e-16
C1320 eeg_afe_pga_0/eeg_fd_ota_chopped_full2_0/eeg_bias_gen_0/m1_7941_n45240# VSS 6.746650e-16
C1321 eeg_afe_pga_0/eeg_fd_ota_chopped_full2_0/eeg_bias_gen_0/m1_8341_n37933# VSS 6.746650e-16
C1322 eeg_afe_pga_0/eeg_fd_ota_chopped_full2_0/eeg_bias_gen_0/m1_4059_n36396# VSS 6.746650e-16
C1323 eeg_afe_pga_0/eeg_fd_ota_chopped_full2_0/eeg_bias_gen_0/m1_4459_n29089# VSS 6.746650e-16
C1324 eeg_afe_pga_0/eeg_fd_ota_chopped_full2_0/eeg_bias_gen_0/m1_8059_n36396# VSS 6.746650e-16
C1325 eeg_afe_pga_0/eeg_fd_ota_chopped_full2_0/eeg_bias_gen_0/m1_8459_n29089# VSS 6.746650e-16
C1326 eeg_afe_pga_0/eeg_fd_ota_chopped_full2_0/eeg_bias_gen_0/m1_4059_n18708# VSS 6.746650e-16
C1327 eeg_afe_pga_0/eeg_fd_ota_chopped_full2_0/eeg_bias_gen_0/m1_4459_n11401# VSS 6.746650e-16
C1328 eeg_afe_pga_0/eeg_fd_ota_chopped_full2_0/eeg_bias_gen_0/m1_8459_n11401# VSS 6.746650e-16
C1329 eeg_afe_pga_0/eeg_fd_ota_chopped_full2_0/eeg_bias_gen_0/m1_8859_n18708# VSS 6.746650e-16
C1330 eeg_afe_pga_0/eeg_fd_ota_chopped_full2_0/eeg_bias_gen_0/m1_7141_n9864# VSS 6.746650e-16
C1331 eeg_afe_pga_0/eeg_fd_ota_chopped_full2_0/eeg_bias_gen_0/m1_7541_n2557# VSS 6.746650e-16
C1332 eeg_afe_pga_0/eeg_fd_ota_chopped_full2_0/eeg_bias_gen_0/m1_7541_n37933# VSS 6.746650e-16
C1333 eeg_afe_pga_0/eeg_fd_ota_chopped_full2_0/eeg_bias_gen_0/m1_7941_n45240# VSS 6.746650e-16
C1334 eeg_afe_pga_0/eeg_fd_ota_chopped_full2_0/eeg_bias_gen_0/m1_4459_n29089# VSS 6.746650e-16
C1335 eeg_afe_pga_0/eeg_fd_ota_chopped_full2_0/eeg_bias_gen_0/m1_4859_n36396# VSS 6.746650e-16
C1336 eeg_afe_pga_0/eeg_fd_ota_chopped_full2_0/eeg_bias_gen_0/m1_8459_n29089# VSS 6.746650e-16
C1337 eeg_afe_pga_0/eeg_fd_ota_chopped_full2_0/eeg_bias_gen_0/m1_8859_n36396# VSS 6.746650e-16
C1338 eeg_afe_pga_0/eeg_fd_ota_chopped_full2_0/eeg_bias_gen_0/m1_4459_n11401# VSS 6.746650e-16
C1339 eeg_afe_pga_0/eeg_fd_ota_chopped_full2_0/eeg_bias_gen_0/m1_4859_n18708# VSS 6.746650e-16
C1340 eeg_afe_pga_0/eeg_fd_ota_chopped_full2_0/eeg_bias_gen_0/m1_6741_n2557# VSS 6.746650e-16
C1341 eeg_afe_pga_0/eeg_fd_ota_chopped_full2_0/eeg_bias_gen_0/m1_7141_n9864# VSS 6.746650e-16
C1342 eeg_afe_pga_0/eeg_fd_ota_chopped_full2_0/eeg_bias_gen_0/m1_7141_n45240# VSS 6.746650e-16
C1343 eeg_afe_pga_0/eeg_fd_ota_chopped_full2_0/eeg_bias_gen_0/m1_7541_n37933# VSS 6.746650e-16
C1344 eeg_afe_pga_0/eeg_fd_ota_chopped_full2_0/eeg_bias_gen_0/m1_8859_n36396# VSS 6.746650e-16
C1345 eeg_afe_pga_0/eeg_fd_ota_chopped_full2_0/eeg_bias_gen_0/m1_9259_n29089# VSS 6.746650e-16
C1346 eeg_afe_pga_0/eeg_fd_ota_chopped_full2_0/eeg_bias_gen_0/m1_8859_n18708# VSS 6.746650e-16
C1347 eeg_afe_pga_0/eeg_fd_ota_chopped_full2_0/eeg_bias_gen_0/m1_9259_n11401# VSS 6.746650e-16
C1348 eeg_afe_pga_0/eeg_fd_ota_chopped_full2_0/eeg_bias_gen_0/m1_6341_n9864# VSS 6.746650e-16
C1349 eeg_afe_pga_0/eeg_fd_ota_chopped_full2_0/eeg_bias_gen_0/m1_6741_n2557# VSS 6.746650e-16
C1350 eeg_afe_pga_0/eeg_fd_ota_chopped_full2_0/eeg_bias_gen_0/m1_6741_n37933# VSS 6.746650e-16
C1351 eeg_afe_pga_0/eeg_fd_ota_chopped_full2_0/eeg_bias_gen_0/m1_7141_n45240# VSS 6.746650e-16
C1352 eeg_afe_pga_0/eeg_fd_ota_chopped_full2_0/eeg_bias_gen_0/m1_9259_n29089# VSS 6.746650e-16
C1353 eeg_afe_pga_0/eeg_fd_ota_chopped_full2_0/eeg_bias_gen_0/m1_9659_n36396# VSS 6.746650e-16
C1354 eeg_afe_pga_0/eeg_fd_ota_chopped_full2_0/eeg_bias_gen_0/m1_9259_n11401# VSS 6.746650e-16
C1355 eeg_afe_pga_0/eeg_fd_ota_chopped_full2_0/eeg_bias_gen_0/m1_9659_n18708# VSS 6.746650e-16
C1356 eeg_afe_pga_0/eeg_fd_ota_chopped_full2_0/eeg_bias_gen_0/m1_6341_n45240# VSS 6.746650e-16
C1357 eeg_afe_pga_0/eeg_fd_ota_chopped_full2_0/eeg_bias_gen_0/m1_6741_n37933# VSS 6.746650e-16
C1358 eeg_afe_pga_0/eeg_fd_ota_chopped_full2_0/eeg_bias_gen_0/m1_10059_n29089# VSS 6.746650e-16
C1359 eeg_afe_pga_0/eeg_fd_ota_chopped_full2_0/eeg_bias_gen_0/m1_9659_n36396# VSS 6.746650e-16
C1360 eeg_afe_pga_0/eeg_fd_ota_chopped_full2_0/eeg_bias_gen_0/m1_3941_n45240# VSS 6.746650e-16
C1361 eeg_afe_pga_0/eeg_fd_ota_chopped_full2_0/eeg_bias_gen_0/m1_4341_n37933# VSS 6.746650e-16
C1362 eeg_afe_pga_0/eeg_fd_ota_chopped_full2_0/eeg_bias_gen_0/VBN VSS 1.059610e-14
C1363 eeg_afe_pga_0/eeg_fd_ota_chopped_full2_0/eeg_bias_gen_0/VBN eeg_afe_pga_0/eeg_fd_ota_chopped_full2_0/eeg_bias_gen_0/VBP 2.704936e-15
C1364 eeg_afe_pga_0/eeg_fd_ota_chopped_full2_0/eeg_bias_gen_0/VBN eeg_afe_pga_0/eeg_fd_ota_chopped_full2_0/eeg_bias_gen_0/m1_2524_466# 2.781792e-15
C1365 eeg_afe_pga_0/eeg_fd_ota_chopped_full2_0/eeg_bias_gen_0/VBP VSS 1.199796e-16
C1366 eeg_afe_pga_0/eeg_fd_ota_chopped_full2_0/eeg_bias_gen_0/VBP eeg_afe_pga_0/eeg_fd_ota_chopped_full2_0/eeg_bias_gen_0/m1_2524_466# 3.225268e-16
C1367 eeg_afe_pga_0/eeg_fd_ota_chopped_full2_0/eeg_bias_gen_0/m1_2524_466# VSS 9.907064e-16
C1369 VCM_REF VSS 6.240538e-16
C1370 VCM_REF eeg_afe_pga_0/eeg_fd_ota_chopped_full2_0/eeg_bias_gen_0/VBNF 2.510694e-16
C1372 VCM_REF eeg_afe_pga_0/eeg_fd_ota_chopped_full2_0/eeg_cmfb_amp_dl2_s2_0/m1_68_166# 2.427824e-16
C1373 VCM_REF eeg_afe_pga_0/eeg_fd_ota_chopped_full2_0/stage2_0/VBP2 4.094696e-17
C1375 VDD18 VSS 2.668463e-15
C1376 VDD18 eeg_afe_pga_0/eeg_fd_ota_chopped_full2_0/eeg_cmfb_amp_dl2_s2_0/m1_370_1493# 2.840876e-16
C1378 VDD18 eeg_afe_pga_0/eeg_fd_ota_chopped_full2_0/stage2_0/VBP2 7.519594e-16
C1380 VSS eeg_afe_pga_0/eeg_fd_ota_chopped_full2_0/eeg_bias_gen_0/VBNF 2.369513e-15
C1381 VSS eeg_afe_pga_0/eeg_fd_ota_chopped_full2_0/eeg_cmfb_amp_dl2_s2_0/m1_370_1493# 5.700428e-17
C1382 VSS eeg_afe_pga_0/eeg_fd_ota_chopped_full2_0/eeg_cmfb_amp_dl2_s2_0/m1_68_166# 5.221927e-16
C1383 VSS eeg_afe_pga_0/eeg_fd_ota_chopped_full2_0/stage2_0/VBP2 3.413030e-17
C1384 VSS eeg_afe_pga_0/eeg_fd_ota_chopped_full2_0/stage2_0/VCM2 2.749285e-16
C1385 eeg_afe_pga_0/eeg_fd_ota_chopped_full2_0/eeg_bias_gen_0/VBNF VSS 1.604850e-15
C1387 eeg_afe_pga_0/eeg_fd_ota_chopped_full2_0/eeg_bias_gen_0/VBNF eeg_afe_pga_0/eeg_fd_ota_chopped_full2_0/eeg_cmfb_amp_dl2_s2_0/m1_68_166# 3.152511e-16
C1389 eeg_afe_pga_0/eeg_fd_ota_chopped_full2_0/eeg_bias_gen_0/VBNF eeg_afe_pga_0/eeg_fd_ota_chopped_full2_0/stage2_0/VCM2 3.744583e-17
C1390 eeg_afe_pga_0/eeg_fd_ota_chopped_full2_0/eeg_cmfb_amp_dl2_s2_0/m1_370_1493# VSS 9.817690e-16
C1391 eeg_afe_pga_0/eeg_fd_ota_chopped_full2_0/eeg_cmfb_amp_dl2_s2_0/m1_370_1493# eeg_afe_pga_0/eeg_fd_ota_chopped_full2_0/eeg_cmfb_amp_dl2_s2_0/m1_68_166# 4.867321e-17
C1392 eeg_afe_pga_0/eeg_fd_ota_chopped_full2_0/eeg_cmfb_amp_dl2_s2_0/m1_370_1493# eeg_afe_pga_0/eeg_fd_ota_chopped_full2_0/stage2_0/VBP2 4.354865e-17
C1393 eeg_afe_pga_0/eeg_fd_ota_chopped_full2_0/eeg_cmfb_amp_dl2_s2_0/m1_370_1493# eeg_afe_pga_0/eeg_fd_ota_chopped_full2_0/stage2_0/VCM2 3.677346e-17
C1394 eeg_afe_pga_0/eeg_fd_ota_chopped_full2_0/eeg_cmfb_amp_dl2_s2_0/m1_68_166# VSS 1.236880e-15
C1396 eeg_afe_pga_0/eeg_fd_ota_chopped_full2_0/eeg_cmfb_amp_dl2_s2_0/m1_68_166# eeg_afe_pga_0/eeg_fd_ota_chopped_full2_0/stage2_0/VCM2 3.012335e-16
C1397 eeg_afe_pga_0/eeg_fd_ota_chopped_full2_0/stage2_0/VBP2 VSS 1.787320e-15
C1398 eeg_afe_pga_0/eeg_fd_ota_chopped_full2_0/stage2_0/VCM2 VSS 3.299460e-16
C1399 VDD18 VSS 3.587888e-15
C1400 VDD18 eeg_afe_pga_0/eeg_fd_ota_chopped_full2_0/eeg_cmfb_amp_dl2_s2_0/m1_370_1493# 9.654664e-16
C1401 eeg_afe_pga_0/eeg_fd_ota_chopped_full2_0/eeg_cmfb_amp_dl2_s2_0/m1_370_1493# VSS 2.472537e-16
C1402 eeg_afe_pga_0/eeg_fd_ota_chopped_full2_0/eeg_cmfb_amp_dl2_s2_0/m1_370_1493# VSS 2.522110e-16
C1403 eeg_afe_pga_0/eeg_fd_ota_chopped_full2_0/eeg_cmfb_amp_dl2_s2_0/m1_370_1493# eeg_afe_pga_0/eeg_fd_ota_chopped_full2_0/eeg_cmfb_amp_dl2_s2_0/m1_68_166# 2.845540e-17
C1404 eeg_afe_pga_0/eeg_fd_ota_chopped_full2_0/eeg_cmfb_amp_dl2_s2_0/m1_370_1493# eeg_afe_pga_0/eeg_fd_ota_chopped_full2_0/stage2_0/VCM2 1.233540e-16
C1405 eeg_afe_pga_0/eeg_fd_ota_chopped_full2_0/eeg_cmfb_amp_dl2_s2_0/m1_68_166# VSS 2.522110e-16
C1406 eeg_afe_pga_0/eeg_fd_ota_chopped_full2_0/eeg_cmfb_amp_dl2_s2_0/m1_68_166# eeg_afe_pga_0/eeg_fd_ota_chopped_full2_0/stage2_0/VCM2 1.233540e-16
C1407 eeg_afe_pga_0/eeg_fd_ota_chopped_full2_0/stage2_0/VCM2 VSS 7.517030e-16
C1408 VSS eeg_afe_pga_0/eeg_fd_ota_chopped_full2_0/eeg_bias_gen_0/VBNF 9.287020e-16
C1409 VSS eeg_afe_pga_0/eeg_fd_ota_chopped_full2_0/eeg_cmfb_amp_dl2_s2_0/m1_68_166# 9.828080e-17
C1410 eeg_afe_pga_0/eeg_fd_ota_chopped_full2_0/eeg_bias_gen_0/VBNF VSS 2.698520e-15
C1411 eeg_afe_pga_0/eeg_fd_ota_chopped_full2_0/eeg_bias_gen_0/VBNF eeg_afe_pga_0/eeg_fd_ota_chopped_full2_0/eeg_cmfb_amp_dl2_s2_0/m1_68_166# 8.339500e-16
C1412 eeg_afe_pga_0/eeg_fd_ota_chopped_full2_0/eeg_cmfb_amp_dl2_s2_0/m1_68_166# VSS 2.771420e-17
C1413 VDD18 VSS 2.586521e-15
C1414 VDD18 eeg_afe_pga_0/eeg_fd_ota_chopped_full2_0/stage2_0/VBP2 1.198369e-15
C1415 eeg_afe_pga_0/eeg_fd_ota_chopped_full2_0/stage2_0/VBP2 VSS 3.939952e-16
C1416 VCM_REF VSS 7.517030e-16
C1417 VCM_REF eeg_afe_pga_0/eeg_fd_ota_chopped_full2_0/eeg_cmfb_amp_dl2_s2_0/m1_68_166# 1.233540e-16
C1418 VCM_REF eeg_afe_pga_0/eeg_fd_ota_chopped_full2_0/stage2_0/VBP2 1.233540e-16
C1419 eeg_afe_pga_0/eeg_fd_ota_chopped_full2_0/eeg_cmfb_amp_dl2_s2_0/m1_68_166# VSS 2.522110e-16
C1420 eeg_afe_pga_0/eeg_fd_ota_chopped_full2_0/eeg_cmfb_amp_dl2_s2_0/m1_68_166# eeg_afe_pga_0/eeg_fd_ota_chopped_full2_0/stage2_0/VBP2 2.845540e-17
C1421 eeg_afe_pga_0/eeg_fd_ota_chopped_full2_0/stage2_0/VBP2 VSS 2.522110e-16
C1423 VCM_REF VSS 6.276408e-16
C1424 VCM_REF eeg_afe_pga_0/eeg_fd_ota_chopped_full2_0/eeg_bias_gen_0/VBNF 2.510694e-16
C1425 VCM_REF eeg_afe_pga_0/eeg_fd_ota_chopped_full2_0/eeg_cmfb_amp_dl2_0/VBP 4.083846e-17
C1428 VCM_REF eeg_afe_pga_0/eeg_fd_ota_chopped_full2_0/eeg_cmfb_amp_dl2_0/m1_68_166# 2.427824e-16
C1429 VDD18 VSS 2.546487e-15
C1430 VDD18 eeg_afe_pga_0/eeg_fd_ota_chopped_full2_0/eeg_cmfb_amp_dl2_0/VBP 8.003207e-16
C1432 VDD18 eeg_afe_pga_0/eeg_fd_ota_chopped_full2_0/eeg_cmfb_amp_dl2_0/m1_370_1493# 2.821268e-16
C1434 VSS eeg_afe_pga_0/eeg_fd_ota_chopped_full2_0/eeg_bias_gen_0/VBNF 2.369513e-15
C1435 VSS eeg_afe_pga_0/eeg_fd_ota_chopped_full2_0/eeg_cmfb_amp_dl2_0/VBP 3.379078e-17
C1436 VSS eeg_afe_pga_0/eeg_fd_ota_chopped_full2_0/eeg_cmfb_amp_dl2_0/VCM_SENSE 2.749285e-16
C1437 VSS eeg_afe_pga_0/eeg_fd_ota_chopped_full2_0/eeg_cmfb_amp_dl2_0/m1_370_1493# 5.700428e-17
C1438 VSS eeg_afe_pga_0/eeg_fd_ota_chopped_full2_0/eeg_cmfb_amp_dl2_0/m1_68_166# 5.221927e-16
C1439 eeg_afe_pga_0/eeg_fd_ota_chopped_full2_0/eeg_bias_gen_0/VBNF VSS 1.604850e-15
C1441 eeg_afe_pga_0/eeg_fd_ota_chopped_full2_0/eeg_bias_gen_0/VBNF eeg_afe_pga_0/eeg_fd_ota_chopped_full2_0/eeg_cmfb_amp_dl2_0/VCM_SENSE 3.744583e-17
C1443 eeg_afe_pga_0/eeg_fd_ota_chopped_full2_0/eeg_bias_gen_0/VBNF eeg_afe_pga_0/eeg_fd_ota_chopped_full2_0/eeg_cmfb_amp_dl2_0/m1_68_166# 3.152511e-16
C1444 eeg_afe_pga_0/eeg_fd_ota_chopped_full2_0/eeg_cmfb_amp_dl2_0/VBP VSS 2.231260e-15
C1445 eeg_afe_pga_0/eeg_fd_ota_chopped_full2_0/eeg_cmfb_amp_dl2_0/VBP eeg_afe_pga_0/eeg_fd_ota_chopped_full2_0/eeg_cmfb_amp_dl2_0/m1_370_1493# 4.937477e-17
C1447 eeg_afe_pga_0/eeg_fd_ota_chopped_full2_0/eeg_cmfb_amp_dl2_0/VCM_SENSE VSS 3.299460e-16
C1448 eeg_afe_pga_0/eeg_fd_ota_chopped_full2_0/eeg_cmfb_amp_dl2_0/VCM_SENSE eeg_afe_pga_0/eeg_fd_ota_chopped_full2_0/eeg_cmfb_amp_dl2_0/m1_370_1493# 3.677346e-17
C1449 eeg_afe_pga_0/eeg_fd_ota_chopped_full2_0/eeg_cmfb_amp_dl2_0/VCM_SENSE eeg_afe_pga_0/eeg_fd_ota_chopped_full2_0/eeg_cmfb_amp_dl2_0/m1_68_166# 3.012335e-16
C1450 eeg_afe_pga_0/eeg_fd_ota_chopped_full2_0/eeg_cmfb_amp_dl2_0/m1_370_1493# VSS 9.932130e-16
C1451 eeg_afe_pga_0/eeg_fd_ota_chopped_full2_0/eeg_cmfb_amp_dl2_0/m1_370_1493# eeg_afe_pga_0/eeg_fd_ota_chopped_full2_0/eeg_cmfb_amp_dl2_0/m1_68_166# 4.867321e-17
C1452 eeg_afe_pga_0/eeg_fd_ota_chopped_full2_0/eeg_cmfb_amp_dl2_0/m1_68_166# VSS 1.237070e-15
C1453 VDD18 VSS 6.757137e-15
C1454 VDD18 eeg_afe_pga_0/eeg_fd_ota_chopped_full2_0/eeg_cmfb_amp_dl2_0/VBP 1.873828e-15
C1455 eeg_afe_pga_0/eeg_fd_ota_chopped_full2_0/eeg_cmfb_amp_dl2_0/VBP VSS 4.451080e-16
C1456 VCM_REF VSS 7.517030e-16
C1457 VCM_REF eeg_afe_pga_0/eeg_fd_ota_chopped_full2_0/eeg_cmfb_amp_dl2_0/VBP 1.233540e-16
C1458 VCM_REF eeg_afe_pga_0/eeg_fd_ota_chopped_full2_0/eeg_cmfb_amp_dl2_0/m1_68_166# 1.233540e-16
C1459 eeg_afe_pga_0/eeg_fd_ota_chopped_full2_0/eeg_cmfb_amp_dl2_0/VBP VSS 2.522110e-16
C1460 eeg_afe_pga_0/eeg_fd_ota_chopped_full2_0/eeg_cmfb_amp_dl2_0/VBP eeg_afe_pga_0/eeg_fd_ota_chopped_full2_0/eeg_cmfb_amp_dl2_0/m1_68_166# 2.845540e-17
C1461 eeg_afe_pga_0/eeg_fd_ota_chopped_full2_0/eeg_cmfb_amp_dl2_0/m1_68_166# VSS 2.522110e-16
C1462 VSS eeg_afe_pga_0/eeg_fd_ota_chopped_full2_0/eeg_bias_gen_0/VBNF 9.287020e-16
C1463 VSS eeg_afe_pga_0/eeg_fd_ota_chopped_full2_0/eeg_cmfb_amp_dl2_0/m1_68_166# 9.828080e-17
C1464 eeg_afe_pga_0/eeg_fd_ota_chopped_full2_0/eeg_bias_gen_0/VBNF VSS 2.698520e-15
C1465 eeg_afe_pga_0/eeg_fd_ota_chopped_full2_0/eeg_bias_gen_0/VBNF eeg_afe_pga_0/eeg_fd_ota_chopped_full2_0/eeg_cmfb_amp_dl2_0/m1_68_166# 8.339500e-16
C1466 eeg_afe_pga_0/eeg_fd_ota_chopped_full2_0/eeg_cmfb_amp_dl2_0/m1_68_166# VSS 2.771420e-17
C1467 VDD18 VSS 3.587888e-15
C1468 VDD18 eeg_afe_pga_0/eeg_fd_ota_chopped_full2_0/eeg_cmfb_amp_dl2_0/m1_370_1493# 9.654664e-16
C1469 eeg_afe_pga_0/eeg_fd_ota_chopped_full2_0/eeg_cmfb_amp_dl2_0/m1_370_1493# VSS 2.472537e-16
C1470 eeg_afe_pga_0/eeg_fd_ota_chopped_full2_0/eeg_cmfb_amp_dl2_0/VCM_SENSE VSS 7.517030e-16
C1471 eeg_afe_pga_0/eeg_fd_ota_chopped_full2_0/eeg_cmfb_amp_dl2_0/VCM_SENSE eeg_afe_pga_0/eeg_fd_ota_chopped_full2_0/eeg_cmfb_amp_dl2_0/m1_370_1493# 1.233540e-16
C1472 eeg_afe_pga_0/eeg_fd_ota_chopped_full2_0/eeg_cmfb_amp_dl2_0/VCM_SENSE eeg_afe_pga_0/eeg_fd_ota_chopped_full2_0/eeg_cmfb_amp_dl2_0/m1_68_166# 1.233540e-16
C1473 eeg_afe_pga_0/eeg_fd_ota_chopped_full2_0/eeg_cmfb_amp_dl2_0/m1_370_1493# VSS 2.522110e-16
C1474 eeg_afe_pga_0/eeg_fd_ota_chopped_full2_0/eeg_cmfb_amp_dl2_0/m1_370_1493# eeg_afe_pga_0/eeg_fd_ota_chopped_full2_0/eeg_cmfb_amp_dl2_0/m1_68_166# 2.845540e-17
C1475 eeg_afe_pga_0/eeg_fd_ota_chopped_full2_0/eeg_cmfb_amp_dl2_0/m1_68_166# VSS 2.522110e-16
C1476 VCM_REF VDD18 7.328797e-16
C1477 VCM_REF VSS 1.680760e-14
C1478 VCM_REF eeg_afe_pga_0/eeg_fd_ota_chopped_full2_0/stage2_0/VBP2 1.491687e-16
C1479 VCM_REF eeg_afe_pga_0/eeg_fd_ota_chopped_full2_0/stage2_0/VCM2 1.478800e-14
C1481 VCM_REF eeg_afe_pga_0/eeg_fd_ota_chopped_full2_0/stage2_0/m1_70741_n8557# 7.669250e-17
C1483 VCM_REF eeg_afe_pga_0/eeg_fd_ota_chopped_full2_0/stage2_0/m1_80741_n8557# 7.669250e-17
C1484 VCM_REF PGA_OUTN 1.571540e-15
C1485 VCM_REF PGA_OUTP 1.032390e-14
C1486 VDD18 VSS 2.038645e-14
C1489 VDD18 eeg_afe_pga_0/eeg_fd_ota_chopped_full2_0/stage2_0/VBP2 1.191804e-14
C1490 VDD18 eeg_afe_pga_0/eeg_fd_ota_chopped_full2_0/stage2_0/VCM2 1.675041e-15
C1491 VDD18 PGA_OUTN 1.639622e-15
C1492 VDD18 PGA_OUTP 2.589536e-15
C1493 VSS eeg_afe_pga_0/eeg_fd_ota_chopped_full2_0/stage2_0/N2N 8.833751e-15
C1494 VSS eeg_afe_pga_0/eeg_fd_ota_chopped_full2_0/stage2_0/N2P 1.288700e-15
C1496 VSS eeg_afe_pga_0/eeg_fd_ota_chopped_full2_0/stage2_0/VCM2 1.093840e-16
C1497 VSS PGA_OUTN 3.033735e-17
C1498 VSS PGA_OUTP 3.186307e-16
C1499 eeg_afe_pga_0/eeg_fd_ota_chopped_full2_0/stage2_0/N2N VSS 6.392800e-15
C1500 eeg_afe_pga_0/eeg_fd_ota_chopped_full2_0/stage2_0/N2N eeg_afe_pga_0/eeg_fd_ota_chopped_full2_0/stage2_0/N2P 8.621393e-15
C1501 eeg_afe_pga_0/eeg_fd_ota_chopped_full2_0/stage2_0/N2N eeg_afe_pga_0/eeg_fd_ota_chopped_full2_0/stage2_0/VBP2 3.636257e-17
C1502 eeg_afe_pga_0/eeg_fd_ota_chopped_full2_0/stage2_0/N2N eeg_afe_pga_0/eeg_fd_ota_chopped_full2_0/stage2_0/VCM2 9.762040e-17
C1504 eeg_afe_pga_0/eeg_fd_ota_chopped_full2_0/stage2_0/N2N PGA_OUTN 2.525290e-16
C1505 eeg_afe_pga_0/eeg_fd_ota_chopped_full2_0/stage2_0/N2N PGA_OUTP 2.003715e-16
C1506 eeg_afe_pga_0/eeg_fd_ota_chopped_full2_0/stage2_0/N2P VSS 1.400660e-14
C1507 eeg_afe_pga_0/eeg_fd_ota_chopped_full2_0/stage2_0/N2P eeg_afe_pga_0/eeg_fd_ota_chopped_full2_0/stage2_0/VBP2 3.636256e-17
C1508 eeg_afe_pga_0/eeg_fd_ota_chopped_full2_0/stage2_0/N2P eeg_afe_pga_0/eeg_fd_ota_chopped_full2_0/stage2_0/VCM2 1.093840e-16
C1511 eeg_afe_pga_0/eeg_fd_ota_chopped_full2_0/stage2_0/N2P PGA_OUTP 4.623865e-16
C1512 eeg_afe_pga_0/eeg_fd_ota_chopped_full2_0/stage2_0/VBP2 VSS 2.125980e-14
C1513 eeg_afe_pga_0/eeg_fd_ota_chopped_full2_0/stage2_0/VBP2 eeg_afe_pga_0/eeg_fd_ota_chopped_full2_0/stage2_0/VCM2 4.555847e-15
C1514 eeg_afe_pga_0/eeg_fd_ota_chopped_full2_0/stage2_0/VBP2 PGA_OUTN 9.326616e-15
C1515 eeg_afe_pga_0/eeg_fd_ota_chopped_full2_0/stage2_0/VBP2 PGA_OUTP 4.266178e-15
C1516 eeg_afe_pga_0/eeg_fd_ota_chopped_full2_0/stage2_0/VCM2 VSS 2.633740e-14
C1517 eeg_afe_pga_0/eeg_fd_ota_chopped_full2_0/stage2_0/VCM2 eeg_afe_pga_0/eeg_fd_ota_chopped_full2_0/stage2_0/m1_12966_n5928# 1.237053e-16
C1519 eeg_afe_pga_0/eeg_fd_ota_chopped_full2_0/stage2_0/VCM2 eeg_afe_pga_0/eeg_fd_ota_chopped_full2_0/stage2_0/m1_38741_n8557# 7.669250e-17
C1521 eeg_afe_pga_0/eeg_fd_ota_chopped_full2_0/stage2_0/VCM2 eeg_afe_pga_0/eeg_fd_ota_chopped_full2_0/stage2_0/m1_60741_n8557# 7.669250e-17
C1522 eeg_afe_pga_0/eeg_fd_ota_chopped_full2_0/stage2_0/VCM2 PGA_OUTN 7.778653e-16
C1523 eeg_afe_pga_0/eeg_fd_ota_chopped_full2_0/stage2_0/VCM2 PGA_OUTP 1.597490e-16
C1524 eeg_afe_pga_0/eeg_fd_ota_chopped_full2_0/stage2_0/m1_12966_n5928# VSS 3.339850e-14
C1525 eeg_afe_pga_0/eeg_fd_ota_chopped_full2_0/stage2_0/m1_12966_n5928# eeg_afe_pga_0/eeg_fd_ota_chopped_full2_0/stage2_0/m1_20341_n8557# 2.101150e-17
C1526 eeg_afe_pga_0/eeg_fd_ota_chopped_full2_0/stage2_0/m1_12966_n5928# eeg_afe_pga_0/eeg_fd_ota_chopped_full2_0/stage2_0/m1_21141_n8557# 2.101150e-17
C1527 eeg_afe_pga_0/eeg_fd_ota_chopped_full2_0/stage2_0/m1_12966_n5928# eeg_afe_pga_0/eeg_fd_ota_chopped_full2_0/stage2_0/m1_21941_n8557# 2.101150e-17
C1528 eeg_afe_pga_0/eeg_fd_ota_chopped_full2_0/stage2_0/m1_12966_n5928# eeg_afe_pga_0/eeg_fd_ota_chopped_full2_0/stage2_0/m1_22741_n8557# 2.101150e-17
C1529 eeg_afe_pga_0/eeg_fd_ota_chopped_full2_0/stage2_0/m1_12966_n5928# eeg_afe_pga_0/eeg_fd_ota_chopped_full2_0/stage2_0/m1_23541_n8557# 2.101150e-17
C1530 eeg_afe_pga_0/eeg_fd_ota_chopped_full2_0/stage2_0/m1_12966_n5928# eeg_afe_pga_0/eeg_fd_ota_chopped_full2_0/stage2_0/m1_24341_n8557# 2.101150e-17
C1531 eeg_afe_pga_0/eeg_fd_ota_chopped_full2_0/stage2_0/m1_12966_n5928# eeg_afe_pga_0/eeg_fd_ota_chopped_full2_0/stage2_0/m1_25141_n8557# 2.101150e-17
C1532 eeg_afe_pga_0/eeg_fd_ota_chopped_full2_0/stage2_0/m1_12966_n5928# eeg_afe_pga_0/eeg_fd_ota_chopped_full2_0/stage2_0/m1_25941_n8557# 2.101150e-17
C1533 eeg_afe_pga_0/eeg_fd_ota_chopped_full2_0/stage2_0/m1_12966_n5928# eeg_afe_pga_0/eeg_fd_ota_chopped_full2_0/stage2_0/m1_26741_n8557# 2.101150e-17
C1534 eeg_afe_pga_0/eeg_fd_ota_chopped_full2_0/stage2_0/m1_12966_n5928# eeg_afe_pga_0/eeg_fd_ota_chopped_full2_0/stage2_0/m1_27541_n8557# 2.101150e-17
C1535 eeg_afe_pga_0/eeg_fd_ota_chopped_full2_0/stage2_0/m1_12966_n5928# eeg_afe_pga_0/eeg_fd_ota_chopped_full2_0/stage2_0/m1_28341_n8557# 2.101150e-17
C1536 eeg_afe_pga_0/eeg_fd_ota_chopped_full2_0/stage2_0/m1_12966_n5928# eeg_afe_pga_0/eeg_fd_ota_chopped_full2_0/stage2_0/m1_29141_n8557# 2.101150e-17
C1537 eeg_afe_pga_0/eeg_fd_ota_chopped_full2_0/stage2_0/m1_12966_n5928# eeg_afe_pga_0/eeg_fd_ota_chopped_full2_0/stage2_0/m1_29941_n8557# 2.101150e-17
C1538 eeg_afe_pga_0/eeg_fd_ota_chopped_full2_0/stage2_0/m1_12966_n5928# eeg_afe_pga_0/eeg_fd_ota_chopped_full2_0/stage2_0/m1_30741_n8557# 2.101150e-17
C1539 eeg_afe_pga_0/eeg_fd_ota_chopped_full2_0/stage2_0/m1_12966_n5928# eeg_afe_pga_0/eeg_fd_ota_chopped_full2_0/stage2_0/m1_31541_n8557# 2.101150e-17
C1540 eeg_afe_pga_0/eeg_fd_ota_chopped_full2_0/stage2_0/m1_12966_n5928# eeg_afe_pga_0/eeg_fd_ota_chopped_full2_0/stage2_0/m1_32341_n8557# 2.101150e-17
C1541 eeg_afe_pga_0/eeg_fd_ota_chopped_full2_0/stage2_0/m1_12966_n5928# eeg_afe_pga_0/eeg_fd_ota_chopped_full2_0/stage2_0/m1_33141_n8557# 2.101150e-17
C1542 eeg_afe_pga_0/eeg_fd_ota_chopped_full2_0/stage2_0/m1_12966_n5928# eeg_afe_pga_0/eeg_fd_ota_chopped_full2_0/stage2_0/m1_33941_n8557# 2.101150e-17
C1543 eeg_afe_pga_0/eeg_fd_ota_chopped_full2_0/stage2_0/m1_12966_n5928# eeg_afe_pga_0/eeg_fd_ota_chopped_full2_0/stage2_0/m1_34741_n8557# 2.101150e-17
C1544 eeg_afe_pga_0/eeg_fd_ota_chopped_full2_0/stage2_0/m1_12966_n5928# eeg_afe_pga_0/eeg_fd_ota_chopped_full2_0/stage2_0/m1_35541_n8557# 2.101150e-17
C1545 eeg_afe_pga_0/eeg_fd_ota_chopped_full2_0/stage2_0/m1_12966_n5928# eeg_afe_pga_0/eeg_fd_ota_chopped_full2_0/stage2_0/m1_36341_n8557# 2.101150e-17
C1546 eeg_afe_pga_0/eeg_fd_ota_chopped_full2_0/stage2_0/m1_12966_n5928# eeg_afe_pga_0/eeg_fd_ota_chopped_full2_0/stage2_0/m1_37141_n8557# 2.101150e-17
C1547 eeg_afe_pga_0/eeg_fd_ota_chopped_full2_0/stage2_0/m1_12966_n5928# eeg_afe_pga_0/eeg_fd_ota_chopped_full2_0/stage2_0/m1_37941_n8557# 2.101150e-17
C1548 eeg_afe_pga_0/eeg_fd_ota_chopped_full2_0/stage2_0/m1_12966_n5928# eeg_afe_pga_0/eeg_fd_ota_chopped_full2_0/stage2_0/m1_38741_n8557# 2.101150e-17
C1549 eeg_afe_pga_0/eeg_fd_ota_chopped_full2_0/stage2_0/m1_12966_n5928# eeg_afe_pga_0/eeg_fd_ota_chopped_full2_0/stage2_0/m1_3966_n5928# 2.125553e-15
C1550 eeg_afe_pga_0/eeg_fd_ota_chopped_full2_0/stage2_0/m1_12966_n5928# eeg_afe_pga_0/eeg_fd_ota_chopped_full2_0/stage2_0/m1_42341_n8557# 2.101150e-17
C1551 eeg_afe_pga_0/eeg_fd_ota_chopped_full2_0/stage2_0/m1_12966_n5928# eeg_afe_pga_0/eeg_fd_ota_chopped_full2_0/stage2_0/m1_43141_n8557# 2.101150e-17
C1552 eeg_afe_pga_0/eeg_fd_ota_chopped_full2_0/stage2_0/m1_12966_n5928# eeg_afe_pga_0/eeg_fd_ota_chopped_full2_0/stage2_0/m1_43941_n8557# 2.101150e-17
C1553 eeg_afe_pga_0/eeg_fd_ota_chopped_full2_0/stage2_0/m1_12966_n5928# eeg_afe_pga_0/eeg_fd_ota_chopped_full2_0/stage2_0/m1_44741_n8557# 2.101150e-17
C1554 eeg_afe_pga_0/eeg_fd_ota_chopped_full2_0/stage2_0/m1_12966_n5928# eeg_afe_pga_0/eeg_fd_ota_chopped_full2_0/stage2_0/m1_45541_n8557# 2.101150e-17
C1555 eeg_afe_pga_0/eeg_fd_ota_chopped_full2_0/stage2_0/m1_12966_n5928# eeg_afe_pga_0/eeg_fd_ota_chopped_full2_0/stage2_0/m1_46341_n8557# 2.101150e-17
C1558 eeg_afe_pga_0/eeg_fd_ota_chopped_full2_0/stage2_0/m1_12966_n5928# eeg_afe_pga_0/eeg_fd_ota_chopped_full2_0/stage2_0/m1_47941_n8557# 2.101150e-17
C1559 eeg_afe_pga_0/eeg_fd_ota_chopped_full2_0/stage2_0/m1_12966_n5928# eeg_afe_pga_0/eeg_fd_ota_chopped_full2_0/stage2_0/m1_48341_n15864# 2.092590e-17
C1560 eeg_afe_pga_0/eeg_fd_ota_chopped_full2_0/stage2_0/m1_12966_n5928# eeg_afe_pga_0/eeg_fd_ota_chopped_full2_0/stage2_0/m1_48741_n8557# 2.101150e-17
C1561 eeg_afe_pga_0/eeg_fd_ota_chopped_full2_0/stage2_0/m1_12966_n5928# eeg_afe_pga_0/eeg_fd_ota_chopped_full2_0/stage2_0/m1_49141_n15864# 2.092590e-17
C1562 eeg_afe_pga_0/eeg_fd_ota_chopped_full2_0/stage2_0/m1_12966_n5928# eeg_afe_pga_0/eeg_fd_ota_chopped_full2_0/stage2_0/m1_49541_n8557# 2.101150e-17
C1563 eeg_afe_pga_0/eeg_fd_ota_chopped_full2_0/stage2_0/m1_12966_n5928# eeg_afe_pga_0/eeg_fd_ota_chopped_full2_0/stage2_0/m1_49941_n15864# 2.092590e-17
C1564 eeg_afe_pga_0/eeg_fd_ota_chopped_full2_0/stage2_0/m1_12966_n5928# eeg_afe_pga_0/eeg_fd_ota_chopped_full2_0/stage2_0/m1_50341_n8557# 2.101150e-17
C1565 eeg_afe_pga_0/eeg_fd_ota_chopped_full2_0/stage2_0/m1_12966_n5928# eeg_afe_pga_0/eeg_fd_ota_chopped_full2_0/stage2_0/m1_50741_n15864# 2.092590e-17
C1566 eeg_afe_pga_0/eeg_fd_ota_chopped_full2_0/stage2_0/m1_12966_n5928# eeg_afe_pga_0/eeg_fd_ota_chopped_full2_0/stage2_0/m1_51141_n8557# 2.101150e-17
C1567 eeg_afe_pga_0/eeg_fd_ota_chopped_full2_0/stage2_0/m1_12966_n5928# eeg_afe_pga_0/eeg_fd_ota_chopped_full2_0/stage2_0/m1_51541_n15864# 2.092590e-17
C1568 eeg_afe_pga_0/eeg_fd_ota_chopped_full2_0/stage2_0/m1_12966_n5928# eeg_afe_pga_0/eeg_fd_ota_chopped_full2_0/stage2_0/m1_51941_n8557# 2.101150e-17
C1569 eeg_afe_pga_0/eeg_fd_ota_chopped_full2_0/stage2_0/m1_12966_n5928# eeg_afe_pga_0/eeg_fd_ota_chopped_full2_0/stage2_0/m1_52341_n15864# 2.092590e-17
C1570 eeg_afe_pga_0/eeg_fd_ota_chopped_full2_0/stage2_0/m1_12966_n5928# eeg_afe_pga_0/eeg_fd_ota_chopped_full2_0/stage2_0/m1_52741_n8557# 2.101150e-17
C1571 eeg_afe_pga_0/eeg_fd_ota_chopped_full2_0/stage2_0/m1_12966_n5928# eeg_afe_pga_0/eeg_fd_ota_chopped_full2_0/stage2_0/m1_53141_n15864# 2.092590e-17
C1572 eeg_afe_pga_0/eeg_fd_ota_chopped_full2_0/stage2_0/m1_12966_n5928# eeg_afe_pga_0/eeg_fd_ota_chopped_full2_0/stage2_0/m1_53541_n8557# 2.101150e-17
C1573 eeg_afe_pga_0/eeg_fd_ota_chopped_full2_0/stage2_0/m1_12966_n5928# eeg_afe_pga_0/eeg_fd_ota_chopped_full2_0/stage2_0/m1_53941_n15864# 2.092590e-17
C1574 eeg_afe_pga_0/eeg_fd_ota_chopped_full2_0/stage2_0/m1_12966_n5928# eeg_afe_pga_0/eeg_fd_ota_chopped_full2_0/stage2_0/m1_54341_n8557# 2.101150e-17
C1575 eeg_afe_pga_0/eeg_fd_ota_chopped_full2_0/stage2_0/m1_12966_n5928# eeg_afe_pga_0/eeg_fd_ota_chopped_full2_0/stage2_0/m1_54741_n15864# 2.092590e-17
C1576 eeg_afe_pga_0/eeg_fd_ota_chopped_full2_0/stage2_0/m1_12966_n5928# eeg_afe_pga_0/eeg_fd_ota_chopped_full2_0/stage2_0/m1_55141_n8557# 2.101150e-17
C1577 eeg_afe_pga_0/eeg_fd_ota_chopped_full2_0/stage2_0/m1_12966_n5928# eeg_afe_pga_0/eeg_fd_ota_chopped_full2_0/stage2_0/m1_55541_n15864# 2.092590e-17
C1578 eeg_afe_pga_0/eeg_fd_ota_chopped_full2_0/stage2_0/m1_12966_n5928# eeg_afe_pga_0/eeg_fd_ota_chopped_full2_0/stage2_0/m1_55941_n8557# 2.101150e-17
C1579 eeg_afe_pga_0/eeg_fd_ota_chopped_full2_0/stage2_0/m1_12966_n5928# eeg_afe_pga_0/eeg_fd_ota_chopped_full2_0/stage2_0/m1_56341_n15864# 2.092590e-17
C1580 eeg_afe_pga_0/eeg_fd_ota_chopped_full2_0/stage2_0/m1_12966_n5928# eeg_afe_pga_0/eeg_fd_ota_chopped_full2_0/stage2_0/m1_56741_n8557# 2.375360e-17
C1581 eeg_afe_pga_0/eeg_fd_ota_chopped_full2_0/stage2_0/m1_12966_n5928# eeg_afe_pga_0/eeg_fd_ota_chopped_full2_0/stage2_0/m1_57141_n15864# 3.119110e-17
C1582 eeg_afe_pga_0/eeg_fd_ota_chopped_full2_0/stage2_0/m1_12966_n5928# eeg_afe_pga_0/eeg_fd_ota_chopped_full2_0/stage2_0/m1_57541_n8557# 3.855600e-17
C1583 eeg_afe_pga_0/eeg_fd_ota_chopped_full2_0/stage2_0/m1_12966_n5928# eeg_afe_pga_0/eeg_fd_ota_chopped_full2_0/stage2_0/m1_57941_n15864# 5.436140e-17
C1584 eeg_afe_pga_0/eeg_fd_ota_chopped_full2_0/stage2_0/m1_12966_n5928# eeg_afe_pga_0/eeg_fd_ota_chopped_full2_0/stage2_0/m1_58341_n8557# 1.191254e-16
C1585 eeg_afe_pga_0/eeg_fd_ota_chopped_full2_0/stage2_0/m1_12966_n5928# eeg_afe_pga_0/eeg_fd_ota_chopped_full2_0/stage2_0/m1_58741_n15864# 1.705141e-16
C1586 eeg_afe_pga_0/eeg_fd_ota_chopped_full2_0/stage2_0/m1_12966_n5928# eeg_afe_pga_0/eeg_fd_ota_chopped_full2_0/stage2_0/m1_59141_n8557# 9.883835e-17
C1587 eeg_afe_pga_0/eeg_fd_ota_chopped_full2_0/stage2_0/m1_12966_n5928# eeg_afe_pga_0/eeg_fd_ota_chopped_full2_0/stage2_0/m1_59541_n15864# 5.436140e-17
C1589 eeg_afe_pga_0/eeg_fd_ota_chopped_full2_0/stage2_0/m1_12966_n5928# eeg_afe_pga_0/eeg_fd_ota_chopped_full2_0/stage2_0/m1_60341_n15864# 3.119110e-17
C1591 eeg_afe_pga_0/eeg_fd_ota_chopped_full2_0/stage2_0/m1_12966_n5928# eeg_afe_pga_0/eeg_fd_ota_chopped_full2_0/stage2_0/m1_61141_n15864# 2.092590e-17
C1592 eeg_afe_pga_0/eeg_fd_ota_chopped_full2_0/stage2_0/m1_12966_n5928# eeg_afe_pga_0/eeg_fd_ota_chopped_full2_0/stage2_0/m1_63941_n15864# 2.092590e-17
C1593 eeg_afe_pga_0/eeg_fd_ota_chopped_full2_0/stage2_0/m1_12966_n5928# eeg_afe_pga_0/eeg_fd_ota_chopped_full2_0/stage2_0/m1_64741_n15864# 2.092590e-17
C1594 eeg_afe_pga_0/eeg_fd_ota_chopped_full2_0/stage2_0/m1_12966_n5928# eeg_afe_pga_0/eeg_fd_ota_chopped_full2_0/stage2_0/m1_65541_n15864# 2.092590e-17
C1595 eeg_afe_pga_0/eeg_fd_ota_chopped_full2_0/stage2_0/m1_12966_n5928# eeg_afe_pga_0/eeg_fd_ota_chopped_full2_0/stage2_0/m1_66341_n15864# 2.092590e-17
C1596 eeg_afe_pga_0/eeg_fd_ota_chopped_full2_0/stage2_0/m1_12966_n5928# eeg_afe_pga_0/eeg_fd_ota_chopped_full2_0/stage2_0/m1_67141_n15864# 2.092590e-17
C1597 eeg_afe_pga_0/eeg_fd_ota_chopped_full2_0/stage2_0/m1_12966_n5928# eeg_afe_pga_0/eeg_fd_ota_chopped_full2_0/stage2_0/m1_67941_n15864# 2.092590e-17
C1598 eeg_afe_pga_0/eeg_fd_ota_chopped_full2_0/stage2_0/m1_12966_n5928# eeg_afe_pga_0/eeg_fd_ota_chopped_full2_0/stage2_0/m1_68741_n15864# 2.092590e-17
C1600 eeg_afe_pga_0/eeg_fd_ota_chopped_full2_0/stage2_0/m1_12966_n5928# PGA_OUTN 5.354807e-13
C1601 eeg_afe_pga_0/eeg_fd_ota_chopped_full2_0/stage2_0/m1_12966_n5928# PGA_OUTP 2.275473e-16
C1602 eeg_afe_pga_0/eeg_fd_ota_chopped_full2_0/stage2_0/m1_19941_n15864# VSS 4.702790e-16
C1603 eeg_afe_pga_0/eeg_fd_ota_chopped_full2_0/stage2_0/m1_19941_n15864# eeg_afe_pga_0/eeg_fd_ota_chopped_full2_0/stage2_0/m1_20741_n15864# 6.789059e-17
C1605 eeg_afe_pga_0/eeg_fd_ota_chopped_full2_0/stage2_0/m1_19941_n15864# PGA_OUTP 5.389540e-17
C1606 eeg_afe_pga_0/eeg_fd_ota_chopped_full2_0/stage2_0/m1_20341_n8557# VSS 4.623640e-16
C1607 eeg_afe_pga_0/eeg_fd_ota_chopped_full2_0/stage2_0/m1_20341_n8557# eeg_afe_pga_0/eeg_fd_ota_chopped_full2_0/stage2_0/m1_21141_n8557# 6.789040e-17
C1609 eeg_afe_pga_0/eeg_fd_ota_chopped_full2_0/stage2_0/m1_20341_n8557# PGA_OUTP 7.866144e-17
C1610 eeg_afe_pga_0/eeg_fd_ota_chopped_full2_0/stage2_0/m1_20741_n15864# VSS 4.190540e-16
C1611 eeg_afe_pga_0/eeg_fd_ota_chopped_full2_0/stage2_0/m1_20741_n15864# eeg_afe_pga_0/eeg_fd_ota_chopped_full2_0/stage2_0/m1_21541_n15864# 6.789049e-17
C1612 eeg_afe_pga_0/eeg_fd_ota_chopped_full2_0/stage2_0/m1_20741_n15864# eeg_afe_pga_0/eeg_fd_ota_chopped_full2_0/stage2_0/m1_3966_n5928# 2.092590e-17
C1613 eeg_afe_pga_0/eeg_fd_ota_chopped_full2_0/stage2_0/m1_20741_n15864# PGA_OUTP 3.615601e-17
C1614 eeg_afe_pga_0/eeg_fd_ota_chopped_full2_0/stage2_0/m1_21141_n8557# VSS 4.190540e-16
C1615 eeg_afe_pga_0/eeg_fd_ota_chopped_full2_0/stage2_0/m1_21141_n8557# eeg_afe_pga_0/eeg_fd_ota_chopped_full2_0/stage2_0/m1_21941_n8557# 6.789040e-17
C1618 eeg_afe_pga_0/eeg_fd_ota_chopped_full2_0/stage2_0/m1_21541_n15864# VSS 4.190540e-16
C1619 eeg_afe_pga_0/eeg_fd_ota_chopped_full2_0/stage2_0/m1_21541_n15864# eeg_afe_pga_0/eeg_fd_ota_chopped_full2_0/stage2_0/m1_22341_n15864# 6.789049e-17
C1620 eeg_afe_pga_0/eeg_fd_ota_chopped_full2_0/stage2_0/m1_21541_n15864# eeg_afe_pga_0/eeg_fd_ota_chopped_full2_0/stage2_0/m1_3966_n5928# 2.092590e-17
C1621 eeg_afe_pga_0/eeg_fd_ota_chopped_full2_0/stage2_0/m1_21541_n15864# PGA_OUTP 3.405966e-17
C1622 eeg_afe_pga_0/eeg_fd_ota_chopped_full2_0/stage2_0/m1_21941_n8557# VSS 4.190540e-16
C1623 eeg_afe_pga_0/eeg_fd_ota_chopped_full2_0/stage2_0/m1_21941_n8557# eeg_afe_pga_0/eeg_fd_ota_chopped_full2_0/stage2_0/m1_22741_n8557# 6.789040e-17
C1625 eeg_afe_pga_0/eeg_fd_ota_chopped_full2_0/stage2_0/m1_22341_n15864# VSS 4.190540e-16
C1626 eeg_afe_pga_0/eeg_fd_ota_chopped_full2_0/stage2_0/m1_22341_n15864# eeg_afe_pga_0/eeg_fd_ota_chopped_full2_0/stage2_0/m1_23141_n15864# 6.789049e-17
C1627 eeg_afe_pga_0/eeg_fd_ota_chopped_full2_0/stage2_0/m1_22341_n15864# eeg_afe_pga_0/eeg_fd_ota_chopped_full2_0/stage2_0/m1_3966_n5928# 2.092590e-17
C1628 eeg_afe_pga_0/eeg_fd_ota_chopped_full2_0/stage2_0/m1_22341_n15864# PGA_OUTP 3.405966e-17
C1629 eeg_afe_pga_0/eeg_fd_ota_chopped_full2_0/stage2_0/m1_22741_n8557# VSS 4.190540e-16
C1630 eeg_afe_pga_0/eeg_fd_ota_chopped_full2_0/stage2_0/m1_22741_n8557# eeg_afe_pga_0/eeg_fd_ota_chopped_full2_0/stage2_0/m1_23541_n8557# 6.789044e-17
C1632 eeg_afe_pga_0/eeg_fd_ota_chopped_full2_0/stage2_0/m1_23141_n15864# VSS 4.190540e-16
C1633 eeg_afe_pga_0/eeg_fd_ota_chopped_full2_0/stage2_0/m1_23141_n15864# eeg_afe_pga_0/eeg_fd_ota_chopped_full2_0/stage2_0/m1_23941_n15864# 6.789049e-17
C1634 eeg_afe_pga_0/eeg_fd_ota_chopped_full2_0/stage2_0/m1_23141_n15864# eeg_afe_pga_0/eeg_fd_ota_chopped_full2_0/stage2_0/m1_3966_n5928# 2.092590e-17
C1635 eeg_afe_pga_0/eeg_fd_ota_chopped_full2_0/stage2_0/m1_23141_n15864# PGA_OUTP 3.405966e-17
C1636 eeg_afe_pga_0/eeg_fd_ota_chopped_full2_0/stage2_0/m1_23541_n8557# VSS 4.190540e-16
C1637 eeg_afe_pga_0/eeg_fd_ota_chopped_full2_0/stage2_0/m1_23541_n8557# eeg_afe_pga_0/eeg_fd_ota_chopped_full2_0/stage2_0/m1_24341_n8557# 6.789040e-17
C1639 eeg_afe_pga_0/eeg_fd_ota_chopped_full2_0/stage2_0/m1_23941_n15864# VSS 4.190540e-16
C1640 eeg_afe_pga_0/eeg_fd_ota_chopped_full2_0/stage2_0/m1_23941_n15864# eeg_afe_pga_0/eeg_fd_ota_chopped_full2_0/stage2_0/m1_24741_n15864# 6.789049e-17
C1641 eeg_afe_pga_0/eeg_fd_ota_chopped_full2_0/stage2_0/m1_23941_n15864# eeg_afe_pga_0/eeg_fd_ota_chopped_full2_0/stage2_0/m1_3966_n5928# 2.092590e-17
C1642 eeg_afe_pga_0/eeg_fd_ota_chopped_full2_0/stage2_0/m1_23941_n15864# PGA_OUTP 3.405966e-17
C1643 eeg_afe_pga_0/eeg_fd_ota_chopped_full2_0/stage2_0/m1_24341_n8557# VSS 4.190540e-16
C1644 eeg_afe_pga_0/eeg_fd_ota_chopped_full2_0/stage2_0/m1_24341_n8557# eeg_afe_pga_0/eeg_fd_ota_chopped_full2_0/stage2_0/m1_25141_n8557# 6.789040e-17
C1646 eeg_afe_pga_0/eeg_fd_ota_chopped_full2_0/stage2_0/m1_24741_n15864# VSS 4.190540e-16
C1647 eeg_afe_pga_0/eeg_fd_ota_chopped_full2_0/stage2_0/m1_24741_n15864# eeg_afe_pga_0/eeg_fd_ota_chopped_full2_0/stage2_0/m1_25541_n15864# 6.789049e-17
C1648 eeg_afe_pga_0/eeg_fd_ota_chopped_full2_0/stage2_0/m1_24741_n15864# eeg_afe_pga_0/eeg_fd_ota_chopped_full2_0/stage2_0/m1_3966_n5928# 2.092590e-17
C1649 eeg_afe_pga_0/eeg_fd_ota_chopped_full2_0/stage2_0/m1_24741_n15864# PGA_OUTP 3.405966e-17
C1650 eeg_afe_pga_0/eeg_fd_ota_chopped_full2_0/stage2_0/m1_25141_n8557# VSS 4.190540e-16
C1651 eeg_afe_pga_0/eeg_fd_ota_chopped_full2_0/stage2_0/m1_25141_n8557# eeg_afe_pga_0/eeg_fd_ota_chopped_full2_0/stage2_0/m1_25941_n8557# 6.789040e-17
C1653 eeg_afe_pga_0/eeg_fd_ota_chopped_full2_0/stage2_0/m1_25541_n15864# VSS 4.190540e-16
C1654 eeg_afe_pga_0/eeg_fd_ota_chopped_full2_0/stage2_0/m1_25541_n15864# eeg_afe_pga_0/eeg_fd_ota_chopped_full2_0/stage2_0/m1_26341_n15864# 6.789059e-17
C1655 eeg_afe_pga_0/eeg_fd_ota_chopped_full2_0/stage2_0/m1_25541_n15864# eeg_afe_pga_0/eeg_fd_ota_chopped_full2_0/stage2_0/m1_3966_n5928# 2.092590e-17
C1656 eeg_afe_pga_0/eeg_fd_ota_chopped_full2_0/stage2_0/m1_25541_n15864# PGA_OUTP 3.405966e-17
C1657 eeg_afe_pga_0/eeg_fd_ota_chopped_full2_0/stage2_0/m1_25941_n8557# VSS 4.190540e-16
C1658 eeg_afe_pga_0/eeg_fd_ota_chopped_full2_0/stage2_0/m1_25941_n8557# eeg_afe_pga_0/eeg_fd_ota_chopped_full2_0/stage2_0/m1_26741_n8557# 6.789040e-17
C1660 eeg_afe_pga_0/eeg_fd_ota_chopped_full2_0/stage2_0/m1_26341_n15864# VSS 4.190540e-16
C1661 eeg_afe_pga_0/eeg_fd_ota_chopped_full2_0/stage2_0/m1_26341_n15864# eeg_afe_pga_0/eeg_fd_ota_chopped_full2_0/stage2_0/m1_27141_n15864# 6.789049e-17
C1662 eeg_afe_pga_0/eeg_fd_ota_chopped_full2_0/stage2_0/m1_26341_n15864# eeg_afe_pga_0/eeg_fd_ota_chopped_full2_0/stage2_0/m1_3966_n5928# 2.092590e-17
C1663 eeg_afe_pga_0/eeg_fd_ota_chopped_full2_0/stage2_0/m1_26341_n15864# PGA_OUTP 3.405966e-17
C1664 eeg_afe_pga_0/eeg_fd_ota_chopped_full2_0/stage2_0/m1_26741_n8557# VSS 4.190540e-16
C1665 eeg_afe_pga_0/eeg_fd_ota_chopped_full2_0/stage2_0/m1_26741_n8557# eeg_afe_pga_0/eeg_fd_ota_chopped_full2_0/stage2_0/m1_27541_n8557# 6.789040e-17
C1667 eeg_afe_pga_0/eeg_fd_ota_chopped_full2_0/stage2_0/m1_27141_n15864# VSS 4.190540e-16
C1668 eeg_afe_pga_0/eeg_fd_ota_chopped_full2_0/stage2_0/m1_27141_n15864# eeg_afe_pga_0/eeg_fd_ota_chopped_full2_0/stage2_0/m1_27941_n15864# 6.789049e-17
C1669 eeg_afe_pga_0/eeg_fd_ota_chopped_full2_0/stage2_0/m1_27141_n15864# eeg_afe_pga_0/eeg_fd_ota_chopped_full2_0/stage2_0/m1_3966_n5928# 2.092590e-17
C1670 eeg_afe_pga_0/eeg_fd_ota_chopped_full2_0/stage2_0/m1_27141_n15864# PGA_OUTP 3.405966e-17
C1671 eeg_afe_pga_0/eeg_fd_ota_chopped_full2_0/stage2_0/m1_27541_n8557# VSS 4.190540e-16
C1672 eeg_afe_pga_0/eeg_fd_ota_chopped_full2_0/stage2_0/m1_27541_n8557# eeg_afe_pga_0/eeg_fd_ota_chopped_full2_0/stage2_0/m1_28341_n8557# 6.789040e-17
C1674 eeg_afe_pga_0/eeg_fd_ota_chopped_full2_0/stage2_0/m1_27941_n15864# VSS 4.190540e-16
C1675 eeg_afe_pga_0/eeg_fd_ota_chopped_full2_0/stage2_0/m1_27941_n15864# eeg_afe_pga_0/eeg_fd_ota_chopped_full2_0/stage2_0/m1_28741_n15864# 6.789049e-17
C1676 eeg_afe_pga_0/eeg_fd_ota_chopped_full2_0/stage2_0/m1_27941_n15864# eeg_afe_pga_0/eeg_fd_ota_chopped_full2_0/stage2_0/m1_3966_n5928# 2.092590e-17
C1677 eeg_afe_pga_0/eeg_fd_ota_chopped_full2_0/stage2_0/m1_27941_n15864# PGA_OUTP 3.405966e-17
C1678 eeg_afe_pga_0/eeg_fd_ota_chopped_full2_0/stage2_0/m1_28341_n8557# VSS 4.190540e-16
C1679 eeg_afe_pga_0/eeg_fd_ota_chopped_full2_0/stage2_0/m1_28341_n8557# eeg_afe_pga_0/eeg_fd_ota_chopped_full2_0/stage2_0/m1_29141_n8557# 6.789044e-17
C1681 eeg_afe_pga_0/eeg_fd_ota_chopped_full2_0/stage2_0/m1_28741_n15864# VSS 4.190540e-16
C1682 eeg_afe_pga_0/eeg_fd_ota_chopped_full2_0/stage2_0/m1_28741_n15864# eeg_afe_pga_0/eeg_fd_ota_chopped_full2_0/stage2_0/m1_29541_n15864# 6.789049e-17
C1683 eeg_afe_pga_0/eeg_fd_ota_chopped_full2_0/stage2_0/m1_28741_n15864# eeg_afe_pga_0/eeg_fd_ota_chopped_full2_0/stage2_0/m1_3966_n5928# 2.366810e-17
C1684 eeg_afe_pga_0/eeg_fd_ota_chopped_full2_0/stage2_0/m1_28741_n15864# PGA_OUTP 3.405966e-17
C1685 eeg_afe_pga_0/eeg_fd_ota_chopped_full2_0/stage2_0/m1_29141_n8557# VSS 4.190540e-16
C1686 eeg_afe_pga_0/eeg_fd_ota_chopped_full2_0/stage2_0/m1_29141_n8557# eeg_afe_pga_0/eeg_fd_ota_chopped_full2_0/stage2_0/m1_29941_n8557# 6.789040e-17
C1688 eeg_afe_pga_0/eeg_fd_ota_chopped_full2_0/stage2_0/m1_29541_n15864# VSS 4.190540e-16
C1689 eeg_afe_pga_0/eeg_fd_ota_chopped_full2_0/stage2_0/m1_29541_n15864# eeg_afe_pga_0/eeg_fd_ota_chopped_full2_0/stage2_0/m1_30341_n15864# 6.789049e-17
C1690 eeg_afe_pga_0/eeg_fd_ota_chopped_full2_0/stage2_0/m1_29541_n15864# eeg_afe_pga_0/eeg_fd_ota_chopped_full2_0/stage2_0/m1_3966_n5928# 3.847050e-17
C1691 eeg_afe_pga_0/eeg_fd_ota_chopped_full2_0/stage2_0/m1_29541_n15864# PGA_OUTP 3.405966e-17
C1692 eeg_afe_pga_0/eeg_fd_ota_chopped_full2_0/stage2_0/m1_29941_n8557# VSS 4.190540e-16
C1693 eeg_afe_pga_0/eeg_fd_ota_chopped_full2_0/stage2_0/m1_29941_n8557# eeg_afe_pga_0/eeg_fd_ota_chopped_full2_0/stage2_0/m1_30741_n8557# 6.789040e-17
C1694 eeg_afe_pga_0/eeg_fd_ota_chopped_full2_0/stage2_0/m1_29941_n8557# eeg_afe_pga_0/eeg_fd_ota_chopped_full2_0/stage2_0/m1_3966_n5928# 3.505816e-17
C1695 eeg_afe_pga_0/eeg_fd_ota_chopped_full2_0/stage2_0/m1_30341_n15864# VSS 4.190540e-16
C1696 eeg_afe_pga_0/eeg_fd_ota_chopped_full2_0/stage2_0/m1_30341_n15864# eeg_afe_pga_0/eeg_fd_ota_chopped_full2_0/stage2_0/m1_31141_n15864# 6.789049e-17
C1697 eeg_afe_pga_0/eeg_fd_ota_chopped_full2_0/stage2_0/m1_30341_n15864# eeg_afe_pga_0/eeg_fd_ota_chopped_full2_0/stage2_0/m1_3966_n5928# 1.128845e-16
C1698 eeg_afe_pga_0/eeg_fd_ota_chopped_full2_0/stage2_0/m1_30341_n15864# PGA_OUTP 3.405966e-17
C1699 eeg_afe_pga_0/eeg_fd_ota_chopped_full2_0/stage2_0/m1_30741_n8557# VSS 4.190540e-16
C1700 eeg_afe_pga_0/eeg_fd_ota_chopped_full2_0/stage2_0/m1_30741_n8557# eeg_afe_pga_0/eeg_fd_ota_chopped_full2_0/stage2_0/m1_31541_n8557# 6.789040e-17
C1701 eeg_afe_pga_0/eeg_fd_ota_chopped_full2_0/stage2_0/m1_30741_n8557# eeg_afe_pga_0/eeg_fd_ota_chopped_full2_0/stage2_0/m1_3966_n5928# 1.758861e-16
C1702 eeg_afe_pga_0/eeg_fd_ota_chopped_full2_0/stage2_0/m1_31141_n15864# VSS 4.190540e-16
C1703 eeg_afe_pga_0/eeg_fd_ota_chopped_full2_0/stage2_0/m1_31141_n15864# eeg_afe_pga_0/eeg_fd_ota_chopped_full2_0/stage2_0/m1_31941_n15864# 6.789059e-17
C1704 eeg_afe_pga_0/eeg_fd_ota_chopped_full2_0/stage2_0/m1_31141_n15864# eeg_afe_pga_0/eeg_fd_ota_chopped_full2_0/stage2_0/m1_3966_n5928# 1.128845e-16
C1705 eeg_afe_pga_0/eeg_fd_ota_chopped_full2_0/stage2_0/m1_31141_n15864# PGA_OUTP 3.405966e-17
C1706 eeg_afe_pga_0/eeg_fd_ota_chopped_full2_0/stage2_0/m1_31541_n8557# VSS 4.190540e-16
C1707 eeg_afe_pga_0/eeg_fd_ota_chopped_full2_0/stage2_0/m1_31541_n8557# eeg_afe_pga_0/eeg_fd_ota_chopped_full2_0/stage2_0/m1_32341_n8557# 6.789040e-17
C1708 eeg_afe_pga_0/eeg_fd_ota_chopped_full2_0/stage2_0/m1_31541_n8557# eeg_afe_pga_0/eeg_fd_ota_chopped_full2_0/stage2_0/m1_3966_n5928# 3.343551e-17
C1709 eeg_afe_pga_0/eeg_fd_ota_chopped_full2_0/stage2_0/m1_31941_n15864# VSS 4.190540e-16
C1710 eeg_afe_pga_0/eeg_fd_ota_chopped_full2_0/stage2_0/m1_31941_n15864# eeg_afe_pga_0/eeg_fd_ota_chopped_full2_0/stage2_0/m1_32741_n15864# 6.789049e-17
C1711 eeg_afe_pga_0/eeg_fd_ota_chopped_full2_0/stage2_0/m1_31941_n15864# eeg_afe_pga_0/eeg_fd_ota_chopped_full2_0/stage2_0/m1_3966_n5928# 3.847050e-17
C1712 eeg_afe_pga_0/eeg_fd_ota_chopped_full2_0/stage2_0/m1_31941_n15864# PGA_OUTP 3.405966e-17
C1713 eeg_afe_pga_0/eeg_fd_ota_chopped_full2_0/stage2_0/m1_32341_n8557# VSS 4.190540e-16
C1714 eeg_afe_pga_0/eeg_fd_ota_chopped_full2_0/stage2_0/m1_32341_n8557# eeg_afe_pga_0/eeg_fd_ota_chopped_full2_0/stage2_0/m1_33141_n8557# 6.789040e-17
C1716 eeg_afe_pga_0/eeg_fd_ota_chopped_full2_0/stage2_0/m1_32741_n15864# VSS 4.190540e-16
C1717 eeg_afe_pga_0/eeg_fd_ota_chopped_full2_0/stage2_0/m1_32741_n15864# eeg_afe_pga_0/eeg_fd_ota_chopped_full2_0/stage2_0/m1_33541_n15864# 6.789049e-17
C1718 eeg_afe_pga_0/eeg_fd_ota_chopped_full2_0/stage2_0/m1_32741_n15864# eeg_afe_pga_0/eeg_fd_ota_chopped_full2_0/stage2_0/m1_3966_n5928# 2.366810e-17
C1719 eeg_afe_pga_0/eeg_fd_ota_chopped_full2_0/stage2_0/m1_32741_n15864# PGA_OUTP 3.405966e-17
C1720 eeg_afe_pga_0/eeg_fd_ota_chopped_full2_0/stage2_0/m1_33141_n8557# VSS 4.190540e-16
C1721 eeg_afe_pga_0/eeg_fd_ota_chopped_full2_0/stage2_0/m1_33141_n8557# eeg_afe_pga_0/eeg_fd_ota_chopped_full2_0/stage2_0/m1_33941_n8557# 6.789040e-17
C1722 eeg_afe_pga_0/eeg_fd_ota_chopped_full2_0/stage2_0/m1_33541_n15864# VSS 4.190540e-16
C1723 eeg_afe_pga_0/eeg_fd_ota_chopped_full2_0/stage2_0/m1_33541_n15864# eeg_afe_pga_0/eeg_fd_ota_chopped_full2_0/stage2_0/m1_34341_n15864# 6.789049e-17
C1724 eeg_afe_pga_0/eeg_fd_ota_chopped_full2_0/stage2_0/m1_33541_n15864# eeg_afe_pga_0/eeg_fd_ota_chopped_full2_0/stage2_0/m1_3966_n5928# 2.092590e-17
C1725 eeg_afe_pga_0/eeg_fd_ota_chopped_full2_0/stage2_0/m1_33541_n15864# PGA_OUTP 3.405966e-17
C1726 eeg_afe_pga_0/eeg_fd_ota_chopped_full2_0/stage2_0/m1_33941_n8557# VSS 4.190540e-16
C1727 eeg_afe_pga_0/eeg_fd_ota_chopped_full2_0/stage2_0/m1_33941_n8557# eeg_afe_pga_0/eeg_fd_ota_chopped_full2_0/stage2_0/m1_34741_n8557# 6.789044e-17
C1728 eeg_afe_pga_0/eeg_fd_ota_chopped_full2_0/stage2_0/m1_34341_n15864# VSS 4.190540e-16
C1729 eeg_afe_pga_0/eeg_fd_ota_chopped_full2_0/stage2_0/m1_34341_n15864# eeg_afe_pga_0/eeg_fd_ota_chopped_full2_0/stage2_0/m1_35141_n15864# 6.789049e-17
C1730 eeg_afe_pga_0/eeg_fd_ota_chopped_full2_0/stage2_0/m1_34341_n15864# eeg_afe_pga_0/eeg_fd_ota_chopped_full2_0/stage2_0/m1_3966_n5928# 2.092590e-17
C1731 eeg_afe_pga_0/eeg_fd_ota_chopped_full2_0/stage2_0/m1_34341_n15864# PGA_OUTP 3.405966e-17
C1732 eeg_afe_pga_0/eeg_fd_ota_chopped_full2_0/stage2_0/m1_34741_n8557# VSS 4.190540e-16
C1733 eeg_afe_pga_0/eeg_fd_ota_chopped_full2_0/stage2_0/m1_34741_n8557# eeg_afe_pga_0/eeg_fd_ota_chopped_full2_0/stage2_0/m1_35541_n8557# 6.789040e-17
C1734 eeg_afe_pga_0/eeg_fd_ota_chopped_full2_0/stage2_0/m1_35141_n15864# VSS 4.190540e-16
C1735 eeg_afe_pga_0/eeg_fd_ota_chopped_full2_0/stage2_0/m1_35141_n15864# eeg_afe_pga_0/eeg_fd_ota_chopped_full2_0/stage2_0/m1_35941_n15864# 6.789049e-17
C1736 eeg_afe_pga_0/eeg_fd_ota_chopped_full2_0/stage2_0/m1_35141_n15864# eeg_afe_pga_0/eeg_fd_ota_chopped_full2_0/stage2_0/m1_3966_n5928# 2.092590e-17
C1737 eeg_afe_pga_0/eeg_fd_ota_chopped_full2_0/stage2_0/m1_35141_n15864# PGA_OUTP 3.405966e-17
C1738 eeg_afe_pga_0/eeg_fd_ota_chopped_full2_0/stage2_0/m1_35541_n8557# VSS 4.190540e-16
C1739 eeg_afe_pga_0/eeg_fd_ota_chopped_full2_0/stage2_0/m1_35541_n8557# eeg_afe_pga_0/eeg_fd_ota_chopped_full2_0/stage2_0/m1_36341_n8557# 6.789040e-17
C1740 eeg_afe_pga_0/eeg_fd_ota_chopped_full2_0/stage2_0/m1_35941_n15864# VSS 4.190540e-16
C1741 eeg_afe_pga_0/eeg_fd_ota_chopped_full2_0/stage2_0/m1_35941_n15864# eeg_afe_pga_0/eeg_fd_ota_chopped_full2_0/stage2_0/m1_36741_n15864# 6.789049e-17
C1742 eeg_afe_pga_0/eeg_fd_ota_chopped_full2_0/stage2_0/m1_35941_n15864# eeg_afe_pga_0/eeg_fd_ota_chopped_full2_0/stage2_0/m1_3966_n5928# 2.092590e-17
C1743 eeg_afe_pga_0/eeg_fd_ota_chopped_full2_0/stage2_0/m1_35941_n15864# PGA_OUTP 3.405966e-17
C1744 eeg_afe_pga_0/eeg_fd_ota_chopped_full2_0/stage2_0/m1_36341_n8557# VSS 4.190540e-16
C1745 eeg_afe_pga_0/eeg_fd_ota_chopped_full2_0/stage2_0/m1_36341_n8557# eeg_afe_pga_0/eeg_fd_ota_chopped_full2_0/stage2_0/m1_37141_n8557# 6.789040e-17
C1746 eeg_afe_pga_0/eeg_fd_ota_chopped_full2_0/stage2_0/m1_36741_n15864# VSS 4.190540e-16
C1747 eeg_afe_pga_0/eeg_fd_ota_chopped_full2_0/stage2_0/m1_36741_n15864# eeg_afe_pga_0/eeg_fd_ota_chopped_full2_0/stage2_0/m1_37541_n15864# 6.789059e-17
C1748 eeg_afe_pga_0/eeg_fd_ota_chopped_full2_0/stage2_0/m1_36741_n15864# eeg_afe_pga_0/eeg_fd_ota_chopped_full2_0/stage2_0/m1_3966_n5928# 2.092590e-17
C1749 eeg_afe_pga_0/eeg_fd_ota_chopped_full2_0/stage2_0/m1_36741_n15864# PGA_OUTP 3.405966e-17
C1750 eeg_afe_pga_0/eeg_fd_ota_chopped_full2_0/stage2_0/m1_37141_n8557# VSS 4.190540e-16
C1751 eeg_afe_pga_0/eeg_fd_ota_chopped_full2_0/stage2_0/m1_37141_n8557# eeg_afe_pga_0/eeg_fd_ota_chopped_full2_0/stage2_0/m1_37941_n8557# 6.789040e-17
C1752 eeg_afe_pga_0/eeg_fd_ota_chopped_full2_0/stage2_0/m1_37541_n15864# VSS 4.190540e-16
C1753 eeg_afe_pga_0/eeg_fd_ota_chopped_full2_0/stage2_0/m1_37541_n15864# eeg_afe_pga_0/eeg_fd_ota_chopped_full2_0/stage2_0/m1_38341_n15864# 6.789049e-17
C1754 eeg_afe_pga_0/eeg_fd_ota_chopped_full2_0/stage2_0/m1_37541_n15864# eeg_afe_pga_0/eeg_fd_ota_chopped_full2_0/stage2_0/m1_3966_n5928# 2.092590e-17
C1755 eeg_afe_pga_0/eeg_fd_ota_chopped_full2_0/stage2_0/m1_37541_n15864# PGA_OUTP 3.405966e-17
C1756 eeg_afe_pga_0/eeg_fd_ota_chopped_full2_0/stage2_0/m1_37941_n8557# VSS 4.190540e-16
C1757 eeg_afe_pga_0/eeg_fd_ota_chopped_full2_0/stage2_0/m1_37941_n8557# eeg_afe_pga_0/eeg_fd_ota_chopped_full2_0/stage2_0/m1_38741_n8557# 6.789040e-17
C1758 eeg_afe_pga_0/eeg_fd_ota_chopped_full2_0/stage2_0/m1_38341_n15864# VSS 4.190540e-16
C1759 eeg_afe_pga_0/eeg_fd_ota_chopped_full2_0/stage2_0/m1_38341_n15864# eeg_afe_pga_0/eeg_fd_ota_chopped_full2_0/stage2_0/m1_39141_n15864# 6.789049e-17
C1760 eeg_afe_pga_0/eeg_fd_ota_chopped_full2_0/stage2_0/m1_38341_n15864# eeg_afe_pga_0/eeg_fd_ota_chopped_full2_0/stage2_0/m1_3966_n5928# 2.092590e-17
C1761 eeg_afe_pga_0/eeg_fd_ota_chopped_full2_0/stage2_0/m1_38341_n15864# PGA_OUTP 3.405966e-17
C1762 eeg_afe_pga_0/eeg_fd_ota_chopped_full2_0/stage2_0/m1_38741_n8557# VSS 4.623640e-16
C1763 eeg_afe_pga_0/eeg_fd_ota_chopped_full2_0/stage2_0/m1_39141_n15864# VSS 4.702790e-16
C1764 eeg_afe_pga_0/eeg_fd_ota_chopped_full2_0/stage2_0/m1_39141_n15864# eeg_afe_pga_0/eeg_fd_ota_chopped_full2_0/stage2_0/m1_3966_n5928# 2.092590e-17
C1765 eeg_afe_pga_0/eeg_fd_ota_chopped_full2_0/stage2_0/m1_39141_n15864# PGA_OUTP 3.405966e-17
C1766 eeg_afe_pga_0/eeg_fd_ota_chopped_full2_0/stage2_0/m1_3966_n5928# VSS 2.574590e-14
C1768 eeg_afe_pga_0/eeg_fd_ota_chopped_full2_0/stage2_0/m1_3966_n5928# PGA_OUTP 5.354613e-13
C1769 eeg_afe_pga_0/eeg_fd_ota_chopped_full2_0/stage2_0/m1_41941_n15864# VSS 4.702790e-16
C1770 eeg_afe_pga_0/eeg_fd_ota_chopped_full2_0/stage2_0/m1_41941_n15864# eeg_afe_pga_0/eeg_fd_ota_chopped_full2_0/stage2_0/m1_42741_n15864# 6.789049e-17
C1772 eeg_afe_pga_0/eeg_fd_ota_chopped_full2_0/stage2_0/m1_42341_n8557# VSS 4.623640e-16
C1773 eeg_afe_pga_0/eeg_fd_ota_chopped_full2_0/stage2_0/m1_42341_n8557# eeg_afe_pga_0/eeg_fd_ota_chopped_full2_0/stage2_0/m1_43141_n8557# 6.789044e-17
C1774 eeg_afe_pga_0/eeg_fd_ota_chopped_full2_0/stage2_0/m1_42341_n8557# PGA_OUTN 7.669250e-17
C1775 eeg_afe_pga_0/eeg_fd_ota_chopped_full2_0/stage2_0/m1_42741_n15864# VSS 4.190540e-16
C1776 eeg_afe_pga_0/eeg_fd_ota_chopped_full2_0/stage2_0/m1_42741_n15864# eeg_afe_pga_0/eeg_fd_ota_chopped_full2_0/stage2_0/m1_43541_n15864# 6.789049e-17
C1777 eeg_afe_pga_0/eeg_fd_ota_chopped_full2_0/stage2_0/m1_43141_n8557# VSS 4.190540e-16
C1778 eeg_afe_pga_0/eeg_fd_ota_chopped_full2_0/stage2_0/m1_43141_n8557# eeg_afe_pga_0/eeg_fd_ota_chopped_full2_0/stage2_0/m1_43941_n8557# 6.789040e-17
C1780 eeg_afe_pga_0/eeg_fd_ota_chopped_full2_0/stage2_0/m1_43541_n15864# VSS 4.190540e-16
C1781 eeg_afe_pga_0/eeg_fd_ota_chopped_full2_0/stage2_0/m1_43541_n15864# eeg_afe_pga_0/eeg_fd_ota_chopped_full2_0/stage2_0/m1_44341_n15864# 6.789049e-17
C1782 eeg_afe_pga_0/eeg_fd_ota_chopped_full2_0/stage2_0/m1_43941_n8557# VSS 4.190540e-16
C1783 eeg_afe_pga_0/eeg_fd_ota_chopped_full2_0/stage2_0/m1_43941_n8557# eeg_afe_pga_0/eeg_fd_ota_chopped_full2_0/stage2_0/m1_44741_n8557# 6.789040e-17
C1784 eeg_afe_pga_0/eeg_fd_ota_chopped_full2_0/stage2_0/m1_44341_n15864# VSS 4.190540e-16
C1785 eeg_afe_pga_0/eeg_fd_ota_chopped_full2_0/stage2_0/m1_44341_n15864# eeg_afe_pga_0/eeg_fd_ota_chopped_full2_0/stage2_0/m1_45141_n15864# 6.789049e-17
C1786 eeg_afe_pga_0/eeg_fd_ota_chopped_full2_0/stage2_0/m1_44741_n8557# VSS 4.190540e-16
C1787 eeg_afe_pga_0/eeg_fd_ota_chopped_full2_0/stage2_0/m1_44741_n8557# eeg_afe_pga_0/eeg_fd_ota_chopped_full2_0/stage2_0/m1_45541_n8557# 6.789040e-17
C1788 eeg_afe_pga_0/eeg_fd_ota_chopped_full2_0/stage2_0/m1_45141_n15864# VSS 4.190540e-16
C1789 eeg_afe_pga_0/eeg_fd_ota_chopped_full2_0/stage2_0/m1_45141_n15864# eeg_afe_pga_0/eeg_fd_ota_chopped_full2_0/stage2_0/m1_45941_n15864# 6.789059e-17
C1790 eeg_afe_pga_0/eeg_fd_ota_chopped_full2_0/stage2_0/m1_45541_n8557# VSS 4.190540e-16
C1791 eeg_afe_pga_0/eeg_fd_ota_chopped_full2_0/stage2_0/m1_45541_n8557# eeg_afe_pga_0/eeg_fd_ota_chopped_full2_0/stage2_0/m1_46341_n8557# 6.789040e-17
C1793 eeg_afe_pga_0/eeg_fd_ota_chopped_full2_0/stage2_0/m1_45941_n15864# VSS 4.190540e-16
C1794 eeg_afe_pga_0/eeg_fd_ota_chopped_full2_0/stage2_0/m1_45941_n15864# eeg_afe_pga_0/eeg_fd_ota_chopped_full2_0/stage2_0/m1_46741_n15864# 6.789049e-17
C1796 eeg_afe_pga_0/eeg_fd_ota_chopped_full2_0/stage2_0/m1_46341_n8557# VSS 4.190540e-16
C1797 eeg_afe_pga_0/eeg_fd_ota_chopped_full2_0/stage2_0/m1_46341_n8557# eeg_afe_pga_0/eeg_fd_ota_chopped_full2_0/stage2_0/m1_47141_n8557# 6.789040e-17
C1799 eeg_afe_pga_0/eeg_fd_ota_chopped_full2_0/stage2_0/m1_46741_n15864# VSS 4.190540e-16
C1800 eeg_afe_pga_0/eeg_fd_ota_chopped_full2_0/stage2_0/m1_46741_n15864# eeg_afe_pga_0/eeg_fd_ota_chopped_full2_0/stage2_0/m1_47541_n15864# 6.789049e-17
C1802 eeg_afe_pga_0/eeg_fd_ota_chopped_full2_0/stage2_0/m1_47141_n8557# VSS 4.190540e-16
C1803 eeg_afe_pga_0/eeg_fd_ota_chopped_full2_0/stage2_0/m1_47141_n8557# eeg_afe_pga_0/eeg_fd_ota_chopped_full2_0/stage2_0/m1_47941_n8557# 6.789040e-17
C1804 eeg_afe_pga_0/eeg_fd_ota_chopped_full2_0/stage2_0/m1_47141_n8557# PGA_OUTN 3.123278e-16
C1805 eeg_afe_pga_0/eeg_fd_ota_chopped_full2_0/stage2_0/m1_47541_n15864# VSS 4.190540e-16
C1806 eeg_afe_pga_0/eeg_fd_ota_chopped_full2_0/stage2_0/m1_47541_n15864# eeg_afe_pga_0/eeg_fd_ota_chopped_full2_0/stage2_0/m1_48341_n15864# 6.789049e-17
C1807 eeg_afe_pga_0/eeg_fd_ota_chopped_full2_0/stage2_0/m1_47541_n15864# PGA_OUTN 3.201824e-16
C1808 eeg_afe_pga_0/eeg_fd_ota_chopped_full2_0/stage2_0/m1_47941_n8557# VSS 4.190540e-16
C1809 eeg_afe_pga_0/eeg_fd_ota_chopped_full2_0/stage2_0/m1_47941_n8557# eeg_afe_pga_0/eeg_fd_ota_chopped_full2_0/stage2_0/m1_48741_n8557# 6.789044e-17
C1811 eeg_afe_pga_0/eeg_fd_ota_chopped_full2_0/stage2_0/m1_48341_n15864# VSS 4.190540e-16
C1812 eeg_afe_pga_0/eeg_fd_ota_chopped_full2_0/stage2_0/m1_48341_n15864# eeg_afe_pga_0/eeg_fd_ota_chopped_full2_0/stage2_0/m1_49141_n15864# 6.789049e-17
C1813 eeg_afe_pga_0/eeg_fd_ota_chopped_full2_0/stage2_0/m1_48341_n15864# PGA_OUTN 3.866493e-17
C1814 eeg_afe_pga_0/eeg_fd_ota_chopped_full2_0/stage2_0/m1_48741_n8557# VSS 4.190540e-16
C1815 eeg_afe_pga_0/eeg_fd_ota_chopped_full2_0/stage2_0/m1_48741_n8557# eeg_afe_pga_0/eeg_fd_ota_chopped_full2_0/stage2_0/m1_49541_n8557# 6.789040e-17
C1817 eeg_afe_pga_0/eeg_fd_ota_chopped_full2_0/stage2_0/m1_49141_n15864# VSS 4.190540e-16
C1818 eeg_afe_pga_0/eeg_fd_ota_chopped_full2_0/stage2_0/m1_49141_n15864# eeg_afe_pga_0/eeg_fd_ota_chopped_full2_0/stage2_0/m1_49941_n15864# 6.789049e-17
C1819 eeg_afe_pga_0/eeg_fd_ota_chopped_full2_0/stage2_0/m1_49141_n15864# PGA_OUTN 3.442668e-17
C1820 eeg_afe_pga_0/eeg_fd_ota_chopped_full2_0/stage2_0/m1_49541_n8557# VSS 4.190540e-16
C1821 eeg_afe_pga_0/eeg_fd_ota_chopped_full2_0/stage2_0/m1_49541_n8557# eeg_afe_pga_0/eeg_fd_ota_chopped_full2_0/stage2_0/m1_50341_n8557# 6.789040e-17
C1822 eeg_afe_pga_0/eeg_fd_ota_chopped_full2_0/stage2_0/m1_49941_n15864# VSS 4.190540e-16
C1823 eeg_afe_pga_0/eeg_fd_ota_chopped_full2_0/stage2_0/m1_49941_n15864# eeg_afe_pga_0/eeg_fd_ota_chopped_full2_0/stage2_0/m1_50741_n15864# 6.789049e-17
C1824 eeg_afe_pga_0/eeg_fd_ota_chopped_full2_0/stage2_0/m1_49941_n15864# PGA_OUTN 3.405966e-17
C1825 eeg_afe_pga_0/eeg_fd_ota_chopped_full2_0/stage2_0/m1_50341_n8557# VSS 4.190540e-16
C1826 eeg_afe_pga_0/eeg_fd_ota_chopped_full2_0/stage2_0/m1_50341_n8557# eeg_afe_pga_0/eeg_fd_ota_chopped_full2_0/stage2_0/m1_51141_n8557# 6.789040e-17
C1827 eeg_afe_pga_0/eeg_fd_ota_chopped_full2_0/stage2_0/m1_50741_n15864# VSS 4.190540e-16
C1828 eeg_afe_pga_0/eeg_fd_ota_chopped_full2_0/stage2_0/m1_50741_n15864# eeg_afe_pga_0/eeg_fd_ota_chopped_full2_0/stage2_0/m1_51541_n15864# 6.789059e-17
C1829 eeg_afe_pga_0/eeg_fd_ota_chopped_full2_0/stage2_0/m1_50741_n15864# PGA_OUTN 3.405966e-17
C1830 eeg_afe_pga_0/eeg_fd_ota_chopped_full2_0/stage2_0/m1_51141_n8557# VSS 4.190540e-16
C1831 eeg_afe_pga_0/eeg_fd_ota_chopped_full2_0/stage2_0/m1_51141_n8557# eeg_afe_pga_0/eeg_fd_ota_chopped_full2_0/stage2_0/m1_51941_n8557# 6.789040e-17
C1832 eeg_afe_pga_0/eeg_fd_ota_chopped_full2_0/stage2_0/m1_51541_n15864# VSS 4.190540e-16
C1833 eeg_afe_pga_0/eeg_fd_ota_chopped_full2_0/stage2_0/m1_51541_n15864# eeg_afe_pga_0/eeg_fd_ota_chopped_full2_0/stage2_0/m1_52341_n15864# 6.789049e-17
C1834 eeg_afe_pga_0/eeg_fd_ota_chopped_full2_0/stage2_0/m1_51541_n15864# PGA_OUTN 3.405966e-17
C1835 eeg_afe_pga_0/eeg_fd_ota_chopped_full2_0/stage2_0/m1_51941_n8557# VSS 4.190540e-16
C1836 eeg_afe_pga_0/eeg_fd_ota_chopped_full2_0/stage2_0/m1_51941_n8557# eeg_afe_pga_0/eeg_fd_ota_chopped_full2_0/stage2_0/m1_52741_n8557# 6.789040e-17
C1837 eeg_afe_pga_0/eeg_fd_ota_chopped_full2_0/stage2_0/m1_52341_n15864# VSS 4.190540e-16
C1838 eeg_afe_pga_0/eeg_fd_ota_chopped_full2_0/stage2_0/m1_52341_n15864# eeg_afe_pga_0/eeg_fd_ota_chopped_full2_0/stage2_0/m1_53141_n15864# 6.789049e-17
C1839 eeg_afe_pga_0/eeg_fd_ota_chopped_full2_0/stage2_0/m1_52341_n15864# PGA_OUTN 3.405966e-17
C1840 eeg_afe_pga_0/eeg_fd_ota_chopped_full2_0/stage2_0/m1_52741_n8557# VSS 4.190540e-16
C1841 eeg_afe_pga_0/eeg_fd_ota_chopped_full2_0/stage2_0/m1_52741_n8557# eeg_afe_pga_0/eeg_fd_ota_chopped_full2_0/stage2_0/m1_53541_n8557# 6.789040e-17
C1842 eeg_afe_pga_0/eeg_fd_ota_chopped_full2_0/stage2_0/m1_53141_n15864# VSS 4.190540e-16
C1843 eeg_afe_pga_0/eeg_fd_ota_chopped_full2_0/stage2_0/m1_53141_n15864# eeg_afe_pga_0/eeg_fd_ota_chopped_full2_0/stage2_0/m1_53941_n15864# 6.789049e-17
C1844 eeg_afe_pga_0/eeg_fd_ota_chopped_full2_0/stage2_0/m1_53141_n15864# PGA_OUTN 3.405966e-17
C1845 eeg_afe_pga_0/eeg_fd_ota_chopped_full2_0/stage2_0/m1_53541_n8557# VSS 4.190540e-16
C1846 eeg_afe_pga_0/eeg_fd_ota_chopped_full2_0/stage2_0/m1_53541_n8557# eeg_afe_pga_0/eeg_fd_ota_chopped_full2_0/stage2_0/m1_54341_n8557# 6.789044e-17
C1847 eeg_afe_pga_0/eeg_fd_ota_chopped_full2_0/stage2_0/m1_53941_n15864# VSS 4.190540e-16
C1848 eeg_afe_pga_0/eeg_fd_ota_chopped_full2_0/stage2_0/m1_53941_n15864# eeg_afe_pga_0/eeg_fd_ota_chopped_full2_0/stage2_0/m1_54741_n15864# 6.789049e-17
C1849 eeg_afe_pga_0/eeg_fd_ota_chopped_full2_0/stage2_0/m1_53941_n15864# PGA_OUTN 3.405966e-17
C1850 eeg_afe_pga_0/eeg_fd_ota_chopped_full2_0/stage2_0/m1_54341_n8557# VSS 4.190540e-16
C1851 eeg_afe_pga_0/eeg_fd_ota_chopped_full2_0/stage2_0/m1_54341_n8557# eeg_afe_pga_0/eeg_fd_ota_chopped_full2_0/stage2_0/m1_55141_n8557# 6.789040e-17
C1852 eeg_afe_pga_0/eeg_fd_ota_chopped_full2_0/stage2_0/m1_54741_n15864# VSS 4.190540e-16
C1853 eeg_afe_pga_0/eeg_fd_ota_chopped_full2_0/stage2_0/m1_54741_n15864# eeg_afe_pga_0/eeg_fd_ota_chopped_full2_0/stage2_0/m1_55541_n15864# 6.789049e-17
C1854 eeg_afe_pga_0/eeg_fd_ota_chopped_full2_0/stage2_0/m1_54741_n15864# PGA_OUTN 3.405966e-17
C1855 eeg_afe_pga_0/eeg_fd_ota_chopped_full2_0/stage2_0/m1_55141_n8557# VSS 4.190540e-16
C1856 eeg_afe_pga_0/eeg_fd_ota_chopped_full2_0/stage2_0/m1_55141_n8557# eeg_afe_pga_0/eeg_fd_ota_chopped_full2_0/stage2_0/m1_55941_n8557# 6.789040e-17
C1857 eeg_afe_pga_0/eeg_fd_ota_chopped_full2_0/stage2_0/m1_55541_n15864# VSS 4.190540e-16
C1858 eeg_afe_pga_0/eeg_fd_ota_chopped_full2_0/stage2_0/m1_55541_n15864# eeg_afe_pga_0/eeg_fd_ota_chopped_full2_0/stage2_0/m1_56341_n15864# 6.789049e-17
C1859 eeg_afe_pga_0/eeg_fd_ota_chopped_full2_0/stage2_0/m1_55541_n15864# PGA_OUTN 3.405966e-17
C1860 eeg_afe_pga_0/eeg_fd_ota_chopped_full2_0/stage2_0/m1_55941_n8557# VSS 4.190540e-16
C1861 eeg_afe_pga_0/eeg_fd_ota_chopped_full2_0/stage2_0/m1_55941_n8557# eeg_afe_pga_0/eeg_fd_ota_chopped_full2_0/stage2_0/m1_56741_n8557# 6.789040e-17
C1862 eeg_afe_pga_0/eeg_fd_ota_chopped_full2_0/stage2_0/m1_56341_n15864# VSS 4.190540e-16
C1863 eeg_afe_pga_0/eeg_fd_ota_chopped_full2_0/stage2_0/m1_56341_n15864# eeg_afe_pga_0/eeg_fd_ota_chopped_full2_0/stage2_0/m1_57141_n15864# 6.789059e-17
C1864 eeg_afe_pga_0/eeg_fd_ota_chopped_full2_0/stage2_0/m1_56341_n15864# PGA_OUTN 3.405966e-17
C1865 eeg_afe_pga_0/eeg_fd_ota_chopped_full2_0/stage2_0/m1_56741_n8557# VSS 4.190540e-16
C1866 eeg_afe_pga_0/eeg_fd_ota_chopped_full2_0/stage2_0/m1_56741_n8557# eeg_afe_pga_0/eeg_fd_ota_chopped_full2_0/stage2_0/m1_57541_n8557# 6.789040e-17
C1867 eeg_afe_pga_0/eeg_fd_ota_chopped_full2_0/stage2_0/m1_57141_n15864# VSS 4.190540e-16
C1868 eeg_afe_pga_0/eeg_fd_ota_chopped_full2_0/stage2_0/m1_57141_n15864# eeg_afe_pga_0/eeg_fd_ota_chopped_full2_0/stage2_0/m1_57941_n15864# 6.789049e-17
C1869 eeg_afe_pga_0/eeg_fd_ota_chopped_full2_0/stage2_0/m1_57141_n15864# PGA_OUTN 3.405966e-17
C1870 eeg_afe_pga_0/eeg_fd_ota_chopped_full2_0/stage2_0/m1_57541_n8557# VSS 4.190540e-16
C1871 eeg_afe_pga_0/eeg_fd_ota_chopped_full2_0/stage2_0/m1_57541_n8557# eeg_afe_pga_0/eeg_fd_ota_chopped_full2_0/stage2_0/m1_58341_n8557# 6.789040e-17
C1872 eeg_afe_pga_0/eeg_fd_ota_chopped_full2_0/stage2_0/m1_57941_n15864# VSS 4.190540e-16
C1873 eeg_afe_pga_0/eeg_fd_ota_chopped_full2_0/stage2_0/m1_57941_n15864# eeg_afe_pga_0/eeg_fd_ota_chopped_full2_0/stage2_0/m1_58741_n15864# 6.789049e-17
C1874 eeg_afe_pga_0/eeg_fd_ota_chopped_full2_0/stage2_0/m1_57941_n15864# PGA_OUTN 3.405966e-17
C1875 eeg_afe_pga_0/eeg_fd_ota_chopped_full2_0/stage2_0/m1_58341_n8557# VSS 4.190540e-16
C1876 eeg_afe_pga_0/eeg_fd_ota_chopped_full2_0/stage2_0/m1_58341_n8557# eeg_afe_pga_0/eeg_fd_ota_chopped_full2_0/stage2_0/m1_59141_n8557# 6.789040e-17
C1877 eeg_afe_pga_0/eeg_fd_ota_chopped_full2_0/stage2_0/m1_58741_n15864# VSS 4.190540e-16
C1878 eeg_afe_pga_0/eeg_fd_ota_chopped_full2_0/stage2_0/m1_58741_n15864# eeg_afe_pga_0/eeg_fd_ota_chopped_full2_0/stage2_0/m1_59541_n15864# 6.789049e-17
C1879 eeg_afe_pga_0/eeg_fd_ota_chopped_full2_0/stage2_0/m1_58741_n15864# PGA_OUTN 3.405966e-17
C1880 eeg_afe_pga_0/eeg_fd_ota_chopped_full2_0/stage2_0/m1_59141_n8557# VSS 4.190540e-16
C1881 eeg_afe_pga_0/eeg_fd_ota_chopped_full2_0/stage2_0/m1_59141_n8557# eeg_afe_pga_0/eeg_fd_ota_chopped_full2_0/stage2_0/m1_59941_n8557# 6.789044e-17
C1882 eeg_afe_pga_0/eeg_fd_ota_chopped_full2_0/stage2_0/m1_59541_n15864# VSS 4.190540e-16
C1883 eeg_afe_pga_0/eeg_fd_ota_chopped_full2_0/stage2_0/m1_59541_n15864# eeg_afe_pga_0/eeg_fd_ota_chopped_full2_0/stage2_0/m1_60341_n15864# 6.789049e-17
C1884 eeg_afe_pga_0/eeg_fd_ota_chopped_full2_0/stage2_0/m1_59541_n15864# PGA_OUTN 3.405966e-17
C1885 eeg_afe_pga_0/eeg_fd_ota_chopped_full2_0/stage2_0/m1_59941_n8557# VSS 4.190540e-16
C1886 eeg_afe_pga_0/eeg_fd_ota_chopped_full2_0/stage2_0/m1_59941_n8557# eeg_afe_pga_0/eeg_fd_ota_chopped_full2_0/stage2_0/m1_60741_n8557# 6.789040e-17
C1887 eeg_afe_pga_0/eeg_fd_ota_chopped_full2_0/stage2_0/m1_60341_n15864# VSS 4.190540e-16
C1888 eeg_afe_pga_0/eeg_fd_ota_chopped_full2_0/stage2_0/m1_60341_n15864# eeg_afe_pga_0/eeg_fd_ota_chopped_full2_0/stage2_0/m1_61141_n15864# 6.789049e-17
C1889 eeg_afe_pga_0/eeg_fd_ota_chopped_full2_0/stage2_0/m1_60341_n15864# PGA_OUTN 3.405966e-17
C1890 eeg_afe_pga_0/eeg_fd_ota_chopped_full2_0/stage2_0/m1_60741_n8557# VSS 4.623640e-16
C1891 eeg_afe_pga_0/eeg_fd_ota_chopped_full2_0/stage2_0/m1_61141_n15864# VSS 4.702790e-16
C1892 eeg_afe_pga_0/eeg_fd_ota_chopped_full2_0/stage2_0/m1_61141_n15864# PGA_OUTN 3.405966e-17
C1893 eeg_afe_pga_0/eeg_fd_ota_chopped_full2_0/stage2_0/m1_63941_n15864# VSS 4.702790e-16
C1894 eeg_afe_pga_0/eeg_fd_ota_chopped_full2_0/stage2_0/m1_63941_n15864# eeg_afe_pga_0/eeg_fd_ota_chopped_full2_0/stage2_0/m1_64741_n15864# 6.789049e-17
C1895 eeg_afe_pga_0/eeg_fd_ota_chopped_full2_0/stage2_0/m1_63941_n15864# PGA_OUTN 3.405966e-17
C1896 eeg_afe_pga_0/eeg_fd_ota_chopped_full2_0/stage2_0/m1_64341_n8557# VSS 4.623640e-16
C1897 eeg_afe_pga_0/eeg_fd_ota_chopped_full2_0/stage2_0/m1_64341_n8557# eeg_afe_pga_0/eeg_fd_ota_chopped_full2_0/stage2_0/m1_65141_n8557# 6.789040e-17
C1898 eeg_afe_pga_0/eeg_fd_ota_chopped_full2_0/stage2_0/m1_64341_n8557# PGA_OUTP 7.669250e-17
C1899 eeg_afe_pga_0/eeg_fd_ota_chopped_full2_0/stage2_0/m1_64741_n15864# VSS 4.190540e-16
C1900 eeg_afe_pga_0/eeg_fd_ota_chopped_full2_0/stage2_0/m1_64741_n15864# eeg_afe_pga_0/eeg_fd_ota_chopped_full2_0/stage2_0/m1_65541_n15864# 6.789059e-17
C1901 eeg_afe_pga_0/eeg_fd_ota_chopped_full2_0/stage2_0/m1_64741_n15864# PGA_OUTN 3.405966e-17
C1902 eeg_afe_pga_0/eeg_fd_ota_chopped_full2_0/stage2_0/m1_65141_n8557# VSS 4.190540e-16
C1903 eeg_afe_pga_0/eeg_fd_ota_chopped_full2_0/stage2_0/m1_65141_n8557# eeg_afe_pga_0/eeg_fd_ota_chopped_full2_0/stage2_0/m1_65941_n8557# 6.789040e-17
C1905 eeg_afe_pga_0/eeg_fd_ota_chopped_full2_0/stage2_0/m1_65541_n15864# VSS 4.190540e-16
C1906 eeg_afe_pga_0/eeg_fd_ota_chopped_full2_0/stage2_0/m1_65541_n15864# eeg_afe_pga_0/eeg_fd_ota_chopped_full2_0/stage2_0/m1_66341_n15864# 6.789049e-17
C1907 eeg_afe_pga_0/eeg_fd_ota_chopped_full2_0/stage2_0/m1_65541_n15864# PGA_OUTN 3.405966e-17
C1908 eeg_afe_pga_0/eeg_fd_ota_chopped_full2_0/stage2_0/m1_65941_n8557# VSS 4.190540e-16
C1909 eeg_afe_pga_0/eeg_fd_ota_chopped_full2_0/stage2_0/m1_65941_n8557# eeg_afe_pga_0/eeg_fd_ota_chopped_full2_0/stage2_0/m1_66741_n8557# 6.789040e-17
C1910 eeg_afe_pga_0/eeg_fd_ota_chopped_full2_0/stage2_0/m1_66341_n15864# VSS 4.190540e-16
C1911 eeg_afe_pga_0/eeg_fd_ota_chopped_full2_0/stage2_0/m1_66341_n15864# eeg_afe_pga_0/eeg_fd_ota_chopped_full2_0/stage2_0/m1_67141_n15864# 6.789049e-17
C1912 eeg_afe_pga_0/eeg_fd_ota_chopped_full2_0/stage2_0/m1_66341_n15864# PGA_OUTN 3.405966e-17
C1913 eeg_afe_pga_0/eeg_fd_ota_chopped_full2_0/stage2_0/m1_66741_n8557# VSS 4.190540e-16
C1914 eeg_afe_pga_0/eeg_fd_ota_chopped_full2_0/stage2_0/m1_66741_n8557# eeg_afe_pga_0/eeg_fd_ota_chopped_full2_0/stage2_0/m1_67541_n8557# 6.789040e-17
C1915 eeg_afe_pga_0/eeg_fd_ota_chopped_full2_0/stage2_0/m1_67141_n15864# VSS 4.190540e-16
C1916 eeg_afe_pga_0/eeg_fd_ota_chopped_full2_0/stage2_0/m1_67141_n15864# eeg_afe_pga_0/eeg_fd_ota_chopped_full2_0/stage2_0/m1_67941_n15864# 6.789049e-17
C1917 eeg_afe_pga_0/eeg_fd_ota_chopped_full2_0/stage2_0/m1_67141_n15864# PGA_OUTN 3.405966e-17
C1918 eeg_afe_pga_0/eeg_fd_ota_chopped_full2_0/stage2_0/m1_67541_n8557# VSS 4.190540e-16
C1919 eeg_afe_pga_0/eeg_fd_ota_chopped_full2_0/stage2_0/m1_67541_n8557# eeg_afe_pga_0/eeg_fd_ota_chopped_full2_0/stage2_0/m1_68341_n8557# 6.789044e-17
C1920 eeg_afe_pga_0/eeg_fd_ota_chopped_full2_0/stage2_0/m1_67941_n15864# VSS 4.190540e-16
C1921 eeg_afe_pga_0/eeg_fd_ota_chopped_full2_0/stage2_0/m1_67941_n15864# eeg_afe_pga_0/eeg_fd_ota_chopped_full2_0/stage2_0/m1_68741_n15864# 6.789049e-17
C1922 eeg_afe_pga_0/eeg_fd_ota_chopped_full2_0/stage2_0/m1_67941_n15864# PGA_OUTN 3.405966e-17
C1923 eeg_afe_pga_0/eeg_fd_ota_chopped_full2_0/stage2_0/m1_68341_n8557# VSS 4.190540e-16
C1924 eeg_afe_pga_0/eeg_fd_ota_chopped_full2_0/stage2_0/m1_68341_n8557# eeg_afe_pga_0/eeg_fd_ota_chopped_full2_0/stage2_0/m1_69141_n8557# 6.789040e-17
C1925 eeg_afe_pga_0/eeg_fd_ota_chopped_full2_0/stage2_0/m1_68741_n15864# VSS 4.190540e-16
C1926 eeg_afe_pga_0/eeg_fd_ota_chopped_full2_0/stage2_0/m1_68741_n15864# eeg_afe_pga_0/eeg_fd_ota_chopped_full2_0/stage2_0/m1_69541_n15864# 6.789049e-17
C1927 eeg_afe_pga_0/eeg_fd_ota_chopped_full2_0/stage2_0/m1_68741_n15864# PGA_OUTN 3.405966e-17
C1928 eeg_afe_pga_0/eeg_fd_ota_chopped_full2_0/stage2_0/m1_69141_n8557# VSS 4.190540e-16
C1929 eeg_afe_pga_0/eeg_fd_ota_chopped_full2_0/stage2_0/m1_69141_n8557# eeg_afe_pga_0/eeg_fd_ota_chopped_full2_0/stage2_0/m1_69941_n8557# 6.789040e-17
C1930 eeg_afe_pga_0/eeg_fd_ota_chopped_full2_0/stage2_0/m1_69541_n15864# VSS 4.190540e-16
C1931 eeg_afe_pga_0/eeg_fd_ota_chopped_full2_0/stage2_0/m1_69541_n15864# eeg_afe_pga_0/eeg_fd_ota_chopped_full2_0/stage2_0/m1_70341_n15864# 6.789049e-17
C1932 eeg_afe_pga_0/eeg_fd_ota_chopped_full2_0/stage2_0/m1_69541_n15864# PGA_OUTN 3.210496e-17
C1933 eeg_afe_pga_0/eeg_fd_ota_chopped_full2_0/stage2_0/m1_69941_n8557# VSS 4.190540e-16
C1934 eeg_afe_pga_0/eeg_fd_ota_chopped_full2_0/stage2_0/m1_69941_n8557# eeg_afe_pga_0/eeg_fd_ota_chopped_full2_0/stage2_0/m1_70741_n8557# 6.789040e-17
C1935 eeg_afe_pga_0/eeg_fd_ota_chopped_full2_0/stage2_0/m1_70341_n15864# VSS 4.190540e-16
C1936 eeg_afe_pga_0/eeg_fd_ota_chopped_full2_0/stage2_0/m1_70341_n15864# eeg_afe_pga_0/eeg_fd_ota_chopped_full2_0/stage2_0/m1_71141_n15864# 6.789059e-17
C1937 eeg_afe_pga_0/eeg_fd_ota_chopped_full2_0/stage2_0/m1_70741_n8557# VSS 4.623640e-16
C1938 eeg_afe_pga_0/eeg_fd_ota_chopped_full2_0/stage2_0/m1_71141_n15864# VSS 4.702790e-16
C1939 eeg_afe_pga_0/eeg_fd_ota_chopped_full2_0/stage2_0/m1_73941_n15864# VSS 4.702790e-16
C1940 eeg_afe_pga_0/eeg_fd_ota_chopped_full2_0/stage2_0/m1_73941_n15864# eeg_afe_pga_0/eeg_fd_ota_chopped_full2_0/stage2_0/m1_74741_n15864# 6.789049e-17
C1941 eeg_afe_pga_0/eeg_fd_ota_chopped_full2_0/stage2_0/m1_74341_n8557# VSS 4.623640e-16
C1942 eeg_afe_pga_0/eeg_fd_ota_chopped_full2_0/stage2_0/m1_74341_n8557# eeg_afe_pga_0/eeg_fd_ota_chopped_full2_0/stage2_0/m1_75141_n8557# 6.789040e-17
C1943 eeg_afe_pga_0/eeg_fd_ota_chopped_full2_0/stage2_0/m1_74341_n8557# PGA_OUTN 7.669250e-17
C1944 eeg_afe_pga_0/eeg_fd_ota_chopped_full2_0/stage2_0/m1_74741_n15864# VSS 4.190540e-16
C1945 eeg_afe_pga_0/eeg_fd_ota_chopped_full2_0/stage2_0/m1_74741_n15864# eeg_afe_pga_0/eeg_fd_ota_chopped_full2_0/stage2_0/m1_75541_n15864# 6.789049e-17
C1946 eeg_afe_pga_0/eeg_fd_ota_chopped_full2_0/stage2_0/m1_75141_n8557# VSS 4.190540e-16
C1947 eeg_afe_pga_0/eeg_fd_ota_chopped_full2_0/stage2_0/m1_75141_n8557# eeg_afe_pga_0/eeg_fd_ota_chopped_full2_0/stage2_0/m1_75941_n8557# 6.789040e-17
C1949 eeg_afe_pga_0/eeg_fd_ota_chopped_full2_0/stage2_0/m1_75541_n15864# VSS 4.190540e-16
C1950 eeg_afe_pga_0/eeg_fd_ota_chopped_full2_0/stage2_0/m1_75541_n15864# eeg_afe_pga_0/eeg_fd_ota_chopped_full2_0/stage2_0/m1_76341_n15864# 6.789049e-17
C1951 eeg_afe_pga_0/eeg_fd_ota_chopped_full2_0/stage2_0/m1_75941_n8557# VSS 4.190540e-16
C1952 eeg_afe_pga_0/eeg_fd_ota_chopped_full2_0/stage2_0/m1_75941_n8557# eeg_afe_pga_0/eeg_fd_ota_chopped_full2_0/stage2_0/m1_76741_n8557# 6.789044e-17
C1953 eeg_afe_pga_0/eeg_fd_ota_chopped_full2_0/stage2_0/m1_76341_n15864# VSS 4.190540e-16
C1954 eeg_afe_pga_0/eeg_fd_ota_chopped_full2_0/stage2_0/m1_76341_n15864# eeg_afe_pga_0/eeg_fd_ota_chopped_full2_0/stage2_0/m1_77141_n15864# 6.789049e-17
C1955 eeg_afe_pga_0/eeg_fd_ota_chopped_full2_0/stage2_0/m1_76741_n8557# VSS 4.190540e-16
C1956 eeg_afe_pga_0/eeg_fd_ota_chopped_full2_0/stage2_0/m1_76741_n8557# eeg_afe_pga_0/eeg_fd_ota_chopped_full2_0/stage2_0/m1_77541_n8557# 6.789040e-17
C1957 eeg_afe_pga_0/eeg_fd_ota_chopped_full2_0/stage2_0/m1_77141_n15864# VSS 4.190540e-16
C1958 eeg_afe_pga_0/eeg_fd_ota_chopped_full2_0/stage2_0/m1_77141_n15864# eeg_afe_pga_0/eeg_fd_ota_chopped_full2_0/stage2_0/m1_77941_n15864# 6.789049e-17
C1959 eeg_afe_pga_0/eeg_fd_ota_chopped_full2_0/stage2_0/m1_77541_n8557# VSS 4.190540e-16
C1960 eeg_afe_pga_0/eeg_fd_ota_chopped_full2_0/stage2_0/m1_77541_n8557# eeg_afe_pga_0/eeg_fd_ota_chopped_full2_0/stage2_0/m1_78341_n8557# 6.789040e-17
C1961 eeg_afe_pga_0/eeg_fd_ota_chopped_full2_0/stage2_0/m1_77941_n15864# VSS 4.190540e-16
C1962 eeg_afe_pga_0/eeg_fd_ota_chopped_full2_0/stage2_0/m1_77941_n15864# eeg_afe_pga_0/eeg_fd_ota_chopped_full2_0/stage2_0/m1_78741_n15864# 6.789049e-17
C1963 eeg_afe_pga_0/eeg_fd_ota_chopped_full2_0/stage2_0/m1_78341_n8557# VSS 4.190540e-16
C1964 eeg_afe_pga_0/eeg_fd_ota_chopped_full2_0/stage2_0/m1_78341_n8557# eeg_afe_pga_0/eeg_fd_ota_chopped_full2_0/stage2_0/m1_79141_n8557# 6.789040e-17
C1965 eeg_afe_pga_0/eeg_fd_ota_chopped_full2_0/stage2_0/m1_78741_n15864# VSS 4.190540e-16
C1966 eeg_afe_pga_0/eeg_fd_ota_chopped_full2_0/stage2_0/m1_78741_n15864# eeg_afe_pga_0/eeg_fd_ota_chopped_full2_0/stage2_0/m1_79541_n15864# 6.789059e-17
C1967 eeg_afe_pga_0/eeg_fd_ota_chopped_full2_0/stage2_0/m1_79141_n8557# VSS 4.190540e-16
C1968 eeg_afe_pga_0/eeg_fd_ota_chopped_full2_0/stage2_0/m1_79141_n8557# eeg_afe_pga_0/eeg_fd_ota_chopped_full2_0/stage2_0/m1_79941_n8557# 6.789040e-17
C1969 eeg_afe_pga_0/eeg_fd_ota_chopped_full2_0/stage2_0/m1_79541_n15864# VSS 4.190540e-16
C1970 eeg_afe_pga_0/eeg_fd_ota_chopped_full2_0/stage2_0/m1_79541_n15864# eeg_afe_pga_0/eeg_fd_ota_chopped_full2_0/stage2_0/m1_80341_n15864# 6.789049e-17
C1971 eeg_afe_pga_0/eeg_fd_ota_chopped_full2_0/stage2_0/m1_79941_n8557# VSS 4.190540e-16
C1972 eeg_afe_pga_0/eeg_fd_ota_chopped_full2_0/stage2_0/m1_79941_n8557# eeg_afe_pga_0/eeg_fd_ota_chopped_full2_0/stage2_0/m1_80741_n8557# 6.789040e-17
C1973 eeg_afe_pga_0/eeg_fd_ota_chopped_full2_0/stage2_0/m1_80341_n15864# VSS 4.190540e-16
C1974 eeg_afe_pga_0/eeg_fd_ota_chopped_full2_0/stage2_0/m1_80341_n15864# eeg_afe_pga_0/eeg_fd_ota_chopped_full2_0/stage2_0/m1_81141_n15864# 6.789049e-17
C1975 eeg_afe_pga_0/eeg_fd_ota_chopped_full2_0/stage2_0/m1_80741_n8557# VSS 4.623640e-16
C1976 eeg_afe_pga_0/eeg_fd_ota_chopped_full2_0/stage2_0/m1_81141_n15864# VSS 4.702790e-16
C1977 PGA_OUTN VSS 1.332930e-13
C1978 PGA_OUTN PGA_OUTP 1.250905e-14
C1979 PGA_OUTP VSS 1.254420e-13
C1980 eeg_afe_pga_0/eeg_fd_ota_chopped_full2_0/stage2_0/m1_58341_n8557# VSS 6.746650e-16
C1981 eeg_afe_pga_0/eeg_fd_ota_chopped_full2_0/stage2_0/m1_58741_n15864# VSS 6.746650e-16
C1982 eeg_afe_pga_0/eeg_fd_ota_chopped_full2_0/stage2_0/m1_24741_n15864# VSS 6.746650e-16
C1983 eeg_afe_pga_0/eeg_fd_ota_chopped_full2_0/stage2_0/m1_25141_n8557# VSS 6.746650e-16
C1984 eeg_afe_pga_0/eeg_fd_ota_chopped_full2_0/stage2_0/m1_20341_n8557# VSS 6.746650e-16
C1985 eeg_afe_pga_0/eeg_fd_ota_chopped_full2_0/stage2_0/m1_20741_n15864# VSS 6.746650e-16
C1986 eeg_afe_pga_0/eeg_fd_ota_chopped_full2_0/stage2_0/m1_35941_n15864# VSS 6.746650e-16
C1987 eeg_afe_pga_0/eeg_fd_ota_chopped_full2_0/stage2_0/m1_36341_n8557# VSS 6.746650e-16
C1988 eeg_afe_pga_0/eeg_fd_ota_chopped_full2_0/stage2_0/m1_79941_n8557# VSS 6.746650e-16
C1989 eeg_afe_pga_0/eeg_fd_ota_chopped_full2_0/stage2_0/m1_80341_n15864# VSS 6.746650e-16
C1990 eeg_afe_pga_0/eeg_fd_ota_chopped_full2_0/stage2_0/m1_75541_n15864# VSS 6.746650e-16
C1991 eeg_afe_pga_0/eeg_fd_ota_chopped_full2_0/stage2_0/m1_75941_n8557# VSS 6.746650e-16
C1992 eeg_afe_pga_0/eeg_fd_ota_chopped_full2_0/stage2_0/m1_69141_n8557# VSS 6.746650e-16
C1993 eeg_afe_pga_0/eeg_fd_ota_chopped_full2_0/stage2_0/m1_69541_n15864# VSS 6.746650e-16
C1994 eeg_afe_pga_0/eeg_fd_ota_chopped_full2_0/stage2_0/m1_64741_n15864# VSS 6.746650e-16
C1995 eeg_afe_pga_0/eeg_fd_ota_chopped_full2_0/stage2_0/m1_65141_n8557# VSS 6.746650e-16
C1996 eeg_afe_pga_0/eeg_fd_ota_chopped_full2_0/stage2_0/m1_57941_n15864# VSS 6.746650e-16
C1997 eeg_afe_pga_0/eeg_fd_ota_chopped_full2_0/stage2_0/m1_58341_n8557# VSS 6.746650e-16
C1998 eeg_afe_pga_0/eeg_fd_ota_chopped_full2_0/stage2_0/m1_28741_n15864# VSS 6.746650e-16
C1999 eeg_afe_pga_0/eeg_fd_ota_chopped_full2_0/stage2_0/m1_29141_n8557# VSS 6.746650e-16
C2000 eeg_afe_pga_0/eeg_fd_ota_chopped_full2_0/stage2_0/m1_24341_n8557# VSS 6.746650e-16
C2001 eeg_afe_pga_0/eeg_fd_ota_chopped_full2_0/stage2_0/m1_24741_n15864# VSS 6.746650e-16
C2002 eeg_afe_pga_0/eeg_fd_ota_chopped_full2_0/stage2_0/m1_19941_n15864# VSS 6.746650e-16
C2003 eeg_afe_pga_0/eeg_fd_ota_chopped_full2_0/stage2_0/m1_20341_n8557# VSS 6.746650e-16
C2004 eeg_afe_pga_0/eeg_fd_ota_chopped_full2_0/stage2_0/m1_35541_n8557# VSS 6.746650e-16
C2005 eeg_afe_pga_0/eeg_fd_ota_chopped_full2_0/stage2_0/m1_35941_n15864# VSS 6.746650e-16
C2006 eeg_afe_pga_0/eeg_fd_ota_chopped_full2_0/stage2_0/m1_79541_n15864# VSS 6.746650e-16
C2007 eeg_afe_pga_0/eeg_fd_ota_chopped_full2_0/stage2_0/m1_79941_n8557# VSS 6.746650e-16
C2008 eeg_afe_pga_0/eeg_fd_ota_chopped_full2_0/stage2_0/m1_75141_n8557# VSS 6.746650e-16
C2009 eeg_afe_pga_0/eeg_fd_ota_chopped_full2_0/stage2_0/m1_75541_n15864# VSS 6.746650e-16
C2010 eeg_afe_pga_0/eeg_fd_ota_chopped_full2_0/stage2_0/m1_68741_n15864# VSS 6.746650e-16
C2011 eeg_afe_pga_0/eeg_fd_ota_chopped_full2_0/stage2_0/m1_69141_n8557# VSS 6.746650e-16
C2012 eeg_afe_pga_0/eeg_fd_ota_chopped_full2_0/stage2_0/m1_64341_n8557# VSS 6.746650e-16
C2013 eeg_afe_pga_0/eeg_fd_ota_chopped_full2_0/stage2_0/m1_64741_n15864# VSS 6.746650e-16
C2014 eeg_afe_pga_0/eeg_fd_ota_chopped_full2_0/stage2_0/m1_57541_n8557# VSS 6.746650e-16
C2015 eeg_afe_pga_0/eeg_fd_ota_chopped_full2_0/stage2_0/m1_57941_n15864# VSS 6.746650e-16
C2016 eeg_afe_pga_0/eeg_fd_ota_chopped_full2_0/stage2_0/m1_28341_n8557# VSS 6.746650e-16
C2017 eeg_afe_pga_0/eeg_fd_ota_chopped_full2_0/stage2_0/m1_28741_n15864# VSS 6.746650e-16
C2018 eeg_afe_pga_0/eeg_fd_ota_chopped_full2_0/stage2_0/m1_23941_n15864# VSS 6.746650e-16
C2019 eeg_afe_pga_0/eeg_fd_ota_chopped_full2_0/stage2_0/m1_24341_n8557# VSS 6.746650e-16
C2020 eeg_afe_pga_0/eeg_fd_ota_chopped_full2_0/stage2_0/m1_19941_n15864# VSS 6.746650e-16
C2021 PGA_OUTP VSS 6.746650e-16
C2022 eeg_afe_pga_0/eeg_fd_ota_chopped_full2_0/stage2_0/m1_35141_n15864# VSS 6.746650e-16
C2023 eeg_afe_pga_0/eeg_fd_ota_chopped_full2_0/stage2_0/m1_35541_n8557# VSS 6.746650e-16
C2024 eeg_afe_pga_0/eeg_fd_ota_chopped_full2_0/stage2_0/m1_79141_n8557# VSS 6.746650e-16
C2025 eeg_afe_pga_0/eeg_fd_ota_chopped_full2_0/stage2_0/m1_79541_n15864# VSS 6.746650e-16
C2026 eeg_afe_pga_0/eeg_fd_ota_chopped_full2_0/stage2_0/m1_74741_n15864# VSS 6.746650e-16
C2027 eeg_afe_pga_0/eeg_fd_ota_chopped_full2_0/stage2_0/m1_75141_n8557# VSS 6.746650e-16
C2028 eeg_afe_pga_0/eeg_fd_ota_chopped_full2_0/stage2_0/m1_68341_n8557# VSS 6.746650e-16
C2029 eeg_afe_pga_0/eeg_fd_ota_chopped_full2_0/stage2_0/m1_68741_n15864# VSS 6.746650e-16
C2030 eeg_afe_pga_0/eeg_fd_ota_chopped_full2_0/stage2_0/m1_63941_n15864# VSS 6.746650e-16
C2031 eeg_afe_pga_0/eeg_fd_ota_chopped_full2_0/stage2_0/m1_64341_n8557# VSS 6.746650e-16
C2032 eeg_afe_pga_0/eeg_fd_ota_chopped_full2_0/stage2_0/m1_27941_n15864# VSS 6.746650e-16
C2033 eeg_afe_pga_0/eeg_fd_ota_chopped_full2_0/stage2_0/m1_28341_n8557# VSS 6.746650e-16
C2034 eeg_afe_pga_0/eeg_fd_ota_chopped_full2_0/stage2_0/m1_23541_n8557# VSS 6.746650e-16
C2035 eeg_afe_pga_0/eeg_fd_ota_chopped_full2_0/stage2_0/m1_23941_n15864# VSS 6.746650e-16
C2036 eeg_afe_pga_0/eeg_fd_ota_chopped_full2_0/stage2_0/VCM2 VSS 6.746650e-16
C2037 eeg_afe_pga_0/eeg_fd_ota_chopped_full2_0/stage2_0/m1_39141_n15864# VSS 6.746650e-16
C2038 eeg_afe_pga_0/eeg_fd_ota_chopped_full2_0/stage2_0/m1_34741_n8557# VSS 6.746650e-16
C2039 eeg_afe_pga_0/eeg_fd_ota_chopped_full2_0/stage2_0/m1_35141_n15864# VSS 6.746650e-16
C2040 eeg_afe_pga_0/eeg_fd_ota_chopped_full2_0/stage2_0/m1_78741_n15864# VSS 6.746650e-16
C2041 eeg_afe_pga_0/eeg_fd_ota_chopped_full2_0/stage2_0/m1_79141_n8557# VSS 6.746650e-16
C2042 eeg_afe_pga_0/eeg_fd_ota_chopped_full2_0/stage2_0/m1_74341_n8557# VSS 6.746650e-16
C2043 eeg_afe_pga_0/eeg_fd_ota_chopped_full2_0/stage2_0/m1_74741_n15864# VSS 6.746650e-16
C2044 eeg_afe_pga_0/eeg_fd_ota_chopped_full2_0/stage2_0/m1_67941_n15864# VSS 6.746650e-16
C2045 eeg_afe_pga_0/eeg_fd_ota_chopped_full2_0/stage2_0/m1_68341_n8557# VSS 6.746650e-16
C2046 eeg_afe_pga_0/eeg_fd_ota_chopped_full2_0/stage2_0/m1_63941_n15864# VSS 6.746650e-16
C2047 PGA_OUTP VSS 6.746650e-16
C2048 eeg_afe_pga_0/eeg_fd_ota_chopped_full2_0/stage2_0/m1_27541_n8557# VSS 6.746650e-16
C2049 eeg_afe_pga_0/eeg_fd_ota_chopped_full2_0/stage2_0/m1_27941_n15864# VSS 6.746650e-16
C2050 eeg_afe_pga_0/eeg_fd_ota_chopped_full2_0/stage2_0/m1_23141_n15864# VSS 6.746650e-16
C2051 eeg_afe_pga_0/eeg_fd_ota_chopped_full2_0/stage2_0/m1_23541_n8557# VSS 6.746650e-16
C2052 eeg_afe_pga_0/eeg_fd_ota_chopped_full2_0/stage2_0/m1_38741_n8557# VSS 6.746650e-16
C2053 eeg_afe_pga_0/eeg_fd_ota_chopped_full2_0/stage2_0/m1_39141_n15864# VSS 6.746650e-16
C2054 eeg_afe_pga_0/eeg_fd_ota_chopped_full2_0/stage2_0/m1_34341_n15864# VSS 6.746650e-16
C2055 eeg_afe_pga_0/eeg_fd_ota_chopped_full2_0/stage2_0/m1_34741_n8557# VSS 6.746650e-16
C2056 eeg_afe_pga_0/eeg_fd_ota_chopped_full2_0/stage2_0/m1_78341_n8557# VSS 6.746650e-16
C2057 eeg_afe_pga_0/eeg_fd_ota_chopped_full2_0/stage2_0/m1_78741_n15864# VSS 6.746650e-16
C2058 eeg_afe_pga_0/eeg_fd_ota_chopped_full2_0/stage2_0/m1_73941_n15864# VSS 6.746650e-16
C2059 eeg_afe_pga_0/eeg_fd_ota_chopped_full2_0/stage2_0/m1_74341_n8557# VSS 6.746650e-16
C2060 eeg_afe_pga_0/eeg_fd_ota_chopped_full2_0/stage2_0/m1_67541_n8557# VSS 6.746650e-16
C2061 eeg_afe_pga_0/eeg_fd_ota_chopped_full2_0/stage2_0/m1_67941_n15864# VSS 6.746650e-16
C2062 eeg_afe_pga_0/eeg_fd_ota_chopped_full2_0/stage2_0/m1_27141_n15864# VSS 6.746650e-16
C2063 eeg_afe_pga_0/eeg_fd_ota_chopped_full2_0/stage2_0/m1_27541_n8557# VSS 6.746650e-16
C2064 eeg_afe_pga_0/eeg_fd_ota_chopped_full2_0/stage2_0/m1_22741_n8557# VSS 6.746650e-16
C2065 eeg_afe_pga_0/eeg_fd_ota_chopped_full2_0/stage2_0/m1_23141_n15864# VSS 6.746650e-16
C2066 eeg_afe_pga_0/eeg_fd_ota_chopped_full2_0/stage2_0/m1_38341_n15864# VSS 6.746650e-16
C2067 eeg_afe_pga_0/eeg_fd_ota_chopped_full2_0/stage2_0/m1_38741_n8557# VSS 6.746650e-16
C2068 eeg_afe_pga_0/eeg_fd_ota_chopped_full2_0/stage2_0/m1_33941_n8557# VSS 6.746650e-16
C2069 eeg_afe_pga_0/eeg_fd_ota_chopped_full2_0/stage2_0/m1_34341_n15864# VSS 6.746650e-16
C2070 eeg_afe_pga_0/eeg_fd_ota_chopped_full2_0/stage2_0/m1_77941_n15864# VSS 6.746650e-16
C2071 eeg_afe_pga_0/eeg_fd_ota_chopped_full2_0/stage2_0/m1_78341_n8557# VSS 6.746650e-16
C2072 eeg_afe_pga_0/eeg_fd_ota_chopped_full2_0/stage2_0/m1_73941_n15864# VSS 6.746650e-16
C2073 PGA_OUTN VSS 6.746650e-16
C2074 eeg_afe_pga_0/eeg_fd_ota_chopped_full2_0/stage2_0/m1_26741_n8557# VSS 6.746650e-16
C2075 eeg_afe_pga_0/eeg_fd_ota_chopped_full2_0/stage2_0/m1_27141_n15864# VSS 6.746650e-16
C2076 eeg_afe_pga_0/eeg_fd_ota_chopped_full2_0/stage2_0/m1_22341_n15864# VSS 6.746650e-16
C2077 eeg_afe_pga_0/eeg_fd_ota_chopped_full2_0/stage2_0/m1_22741_n8557# VSS 6.746650e-16
C2078 eeg_afe_pga_0/eeg_fd_ota_chopped_full2_0/stage2_0/m1_37941_n8557# VSS 6.746650e-16
C2079 eeg_afe_pga_0/eeg_fd_ota_chopped_full2_0/stage2_0/m1_38341_n15864# VSS 6.746650e-16
C2080 eeg_afe_pga_0/eeg_fd_ota_chopped_full2_0/stage2_0/m1_33541_n15864# VSS 6.746650e-16
C2081 eeg_afe_pga_0/eeg_fd_ota_chopped_full2_0/stage2_0/m1_33941_n8557# VSS 6.746650e-16
C2082 eeg_afe_pga_0/eeg_fd_ota_chopped_full2_0/stage2_0/m1_77541_n8557# VSS 6.746650e-16
C2083 eeg_afe_pga_0/eeg_fd_ota_chopped_full2_0/stage2_0/m1_77941_n15864# VSS 6.746650e-16
C2084 eeg_afe_pga_0/eeg_fd_ota_chopped_full2_0/stage2_0/m1_26341_n15864# VSS 6.746650e-16
C2085 eeg_afe_pga_0/eeg_fd_ota_chopped_full2_0/stage2_0/m1_26741_n8557# VSS 6.746650e-16
C2086 eeg_afe_pga_0/eeg_fd_ota_chopped_full2_0/stage2_0/m1_21941_n8557# VSS 6.746650e-16
C2087 eeg_afe_pga_0/eeg_fd_ota_chopped_full2_0/stage2_0/m1_22341_n15864# VSS 6.746650e-16
C2088 eeg_afe_pga_0/eeg_fd_ota_chopped_full2_0/stage2_0/m1_37541_n15864# VSS 6.746650e-16
C2089 eeg_afe_pga_0/eeg_fd_ota_chopped_full2_0/stage2_0/m1_37941_n8557# VSS 6.746650e-16
C2090 eeg_afe_pga_0/eeg_fd_ota_chopped_full2_0/stage2_0/m1_33141_n8557# VSS 6.746650e-16
C2091 eeg_afe_pga_0/eeg_fd_ota_chopped_full2_0/stage2_0/m1_33541_n15864# VSS 6.746650e-16
C2092 eeg_afe_pga_0/eeg_fd_ota_chopped_full2_0/stage2_0/m1_25941_n8557# VSS 6.746650e-16
C2093 eeg_afe_pga_0/eeg_fd_ota_chopped_full2_0/stage2_0/m1_26341_n15864# VSS 6.746650e-16
C2094 eeg_afe_pga_0/eeg_fd_ota_chopped_full2_0/stage2_0/m1_21541_n15864# VSS 6.746650e-16
C2095 eeg_afe_pga_0/eeg_fd_ota_chopped_full2_0/stage2_0/m1_21941_n8557# VSS 6.746650e-16
C2096 eeg_afe_pga_0/eeg_fd_ota_chopped_full2_0/stage2_0/m1_37141_n8557# VSS 6.746650e-16
C2097 eeg_afe_pga_0/eeg_fd_ota_chopped_full2_0/stage2_0/m1_37541_n15864# VSS 6.746650e-16
C2098 eeg_afe_pga_0/eeg_fd_ota_chopped_full2_0/stage2_0/m1_25541_n15864# VSS 6.746650e-16
C2099 eeg_afe_pga_0/eeg_fd_ota_chopped_full2_0/stage2_0/m1_25941_n8557# VSS 6.746650e-16
C2100 eeg_afe_pga_0/eeg_fd_ota_chopped_full2_0/stage2_0/m1_21141_n8557# VSS 6.746650e-16
C2101 eeg_afe_pga_0/eeg_fd_ota_chopped_full2_0/stage2_0/m1_21541_n15864# VSS 6.746650e-16
C2102 eeg_afe_pga_0/eeg_fd_ota_chopped_full2_0/stage2_0/m1_25141_n8557# VSS 6.746650e-16
C2103 eeg_afe_pga_0/eeg_fd_ota_chopped_full2_0/stage2_0/m1_25541_n15864# VSS 6.746650e-16
C2104 VDD18 VSS 1.074004e-13
C2105 VDD18 eeg_afe_pga_0/eeg_fd_ota_chopped_full2_0/stage2_0/VBP2 2.903319e-14
C2106 VDD18 PGA_OUTN 9.216400e-16
C2107 eeg_afe_pga_0/eeg_fd_ota_chopped_full2_0/stage2_0/VBP2 VSS 7.027174e-15
C2108 eeg_afe_pga_0/eeg_fd_ota_chopped_full2_0/stage2_0/VBP2 PGA_OUTN 3.596600e-15
C2109 PGA_OUTN VSS 4.856640e-16
C2110 eeg_afe_pga_0/eeg_fd_ota_chopped_full2_0/stage2_0/m1_32741_n15864# VSS 6.746650e-16
C2111 eeg_afe_pga_0/eeg_fd_ota_chopped_full2_0/stage2_0/m1_33141_n8557# VSS 6.746650e-16
C2112 VSS eeg_afe_pga_0/eeg_fd_ota_chopped_full2_0/stage2_0/N2N 9.971760e-16
C2113 eeg_afe_pga_0/eeg_fd_ota_chopped_full2_0/stage2_0/N2N VSS 7.765320e-15
C2114 eeg_afe_pga_0/eeg_fd_ota_chopped_full2_0/stage2_0/N2N PGA_OUTN 8.991500e-16
C2115 PGA_OUTN VSS 1.639490e-16
C2116 eeg_afe_pga_0/eeg_fd_ota_chopped_full2_0/stage2_0/m1_32341_n8557# VSS 6.746650e-16
C2117 eeg_afe_pga_0/eeg_fd_ota_chopped_full2_0/stage2_0/m1_32741_n15864# VSS 6.746650e-16
C2118 eeg_afe_pga_0/eeg_fd_ota_chopped_full2_0/stage2_0/m1_31941_n15864# VSS 6.746650e-16
C2119 eeg_afe_pga_0/eeg_fd_ota_chopped_full2_0/stage2_0/m1_32341_n8557# VSS 6.746650e-16
C2120 eeg_afe_pga_0/eeg_fd_ota_chopped_full2_0/stage2_0/m1_31541_n8557# VSS 6.746650e-16
C2121 eeg_afe_pga_0/eeg_fd_ota_chopped_full2_0/stage2_0/m1_31941_n15864# VSS 6.746650e-16
C2122 eeg_afe_pga_0/eeg_fd_ota_chopped_full2_0/stage2_0/m1_31141_n15864# VSS 6.746650e-16
C2123 eeg_afe_pga_0/eeg_fd_ota_chopped_full2_0/stage2_0/m1_31541_n8557# VSS 6.746650e-16
C2124 eeg_afe_pga_0/eeg_fd_ota_chopped_full2_0/stage2_0/m1_30741_n8557# VSS 6.746650e-16
C2125 eeg_afe_pga_0/eeg_fd_ota_chopped_full2_0/stage2_0/m1_31141_n15864# VSS 6.746650e-16
C2126 eeg_afe_pga_0/eeg_fd_ota_chopped_full2_0/stage2_0/m1_30341_n15864# VSS 6.746650e-16
C2127 eeg_afe_pga_0/eeg_fd_ota_chopped_full2_0/stage2_0/m1_30741_n8557# VSS 6.746650e-16
C2128 eeg_afe_pga_0/eeg_fd_ota_chopped_full2_0/stage2_0/N2N VSS 6.668820e-16
C2130 eeg_afe_pga_0/eeg_fd_ota_chopped_full2_0/stage2_0/m1_12966_n5928# VSS 6.668820e-16
C2131 eeg_afe_pga_0/eeg_fd_ota_chopped_full2_0/stage2_0/m1_29941_n8557# VSS 6.746650e-16
C2132 eeg_afe_pga_0/eeg_fd_ota_chopped_full2_0/stage2_0/m1_30341_n15864# VSS 6.746650e-16
C2133 eeg_afe_pga_0/eeg_fd_ota_chopped_full2_0/stage2_0/m1_45141_n15864# VSS 6.746650e-16
C2134 eeg_afe_pga_0/eeg_fd_ota_chopped_full2_0/stage2_0/m1_45541_n8557# VSS 6.746650e-16
C2135 eeg_afe_pga_0/eeg_fd_ota_chopped_full2_0/stage2_0/N2P VSS 6.668820e-16
C2137 eeg_afe_pga_0/eeg_fd_ota_chopped_full2_0/stage2_0/m1_3966_n5928# VSS 6.668820e-16
C2138 eeg_afe_pga_0/eeg_fd_ota_chopped_full2_0/stage2_0/m1_29541_n15864# VSS 6.746650e-16
C2139 eeg_afe_pga_0/eeg_fd_ota_chopped_full2_0/stage2_0/m1_29941_n8557# VSS 6.746650e-16
C2140 eeg_afe_pga_0/eeg_fd_ota_chopped_full2_0/stage2_0/m1_44741_n8557# VSS 6.746650e-16
C2141 eeg_afe_pga_0/eeg_fd_ota_chopped_full2_0/stage2_0/m1_45141_n15864# VSS 6.746650e-16
C2142 eeg_afe_pga_0/eeg_fd_ota_chopped_full2_0/stage2_0/m1_49141_n15864# VSS 6.746650e-16
C2143 eeg_afe_pga_0/eeg_fd_ota_chopped_full2_0/stage2_0/m1_49541_n8557# VSS 6.746650e-16
C2144 eeg_afe_pga_0/eeg_fd_ota_chopped_full2_0/stage2_0/m1_29141_n8557# VSS 6.746650e-16
C2145 eeg_afe_pga_0/eeg_fd_ota_chopped_full2_0/stage2_0/m1_29541_n15864# VSS 6.746650e-16
C2146 eeg_afe_pga_0/eeg_fd_ota_chopped_full2_0/stage2_0/m1_44341_n15864# VSS 6.746650e-16
C2147 eeg_afe_pga_0/eeg_fd_ota_chopped_full2_0/stage2_0/m1_44741_n8557# VSS 6.746650e-16
C2148 eeg_afe_pga_0/eeg_fd_ota_chopped_full2_0/stage2_0/m1_48741_n8557# VSS 6.746650e-16
C2149 eeg_afe_pga_0/eeg_fd_ota_chopped_full2_0/stage2_0/m1_49141_n15864# VSS 6.746650e-16
C2150 eeg_afe_pga_0/eeg_fd_ota_chopped_full2_0/stage2_0/m1_53141_n15864# VSS 6.746650e-16
C2151 eeg_afe_pga_0/eeg_fd_ota_chopped_full2_0/stage2_0/m1_53541_n8557# VSS 6.746650e-16
C2152 eeg_afe_pga_0/eeg_fd_ota_chopped_full2_0/stage2_0/m1_43941_n8557# VSS 6.746650e-16
C2153 eeg_afe_pga_0/eeg_fd_ota_chopped_full2_0/stage2_0/m1_44341_n15864# VSS 6.746650e-16
C2154 eeg_afe_pga_0/eeg_fd_ota_chopped_full2_0/stage2_0/m1_48341_n15864# VSS 6.746650e-16
C2155 eeg_afe_pga_0/eeg_fd_ota_chopped_full2_0/stage2_0/m1_48741_n8557# VSS 6.746650e-16
C2156 eeg_afe_pga_0/eeg_fd_ota_chopped_full2_0/stage2_0/m1_52741_n8557# VSS 6.746650e-16
C2157 eeg_afe_pga_0/eeg_fd_ota_chopped_full2_0/stage2_0/m1_53141_n15864# VSS 6.746650e-16
C2158 eeg_afe_pga_0/eeg_fd_ota_chopped_full2_0/stage2_0/m1_57141_n15864# VSS 6.746650e-16
C2159 eeg_afe_pga_0/eeg_fd_ota_chopped_full2_0/stage2_0/m1_57541_n8557# VSS 6.746650e-16
C2160 eeg_afe_pga_0/eeg_fd_ota_chopped_full2_0/stage2_0/m1_43541_n15864# VSS 6.746650e-16
C2161 eeg_afe_pga_0/eeg_fd_ota_chopped_full2_0/stage2_0/m1_43941_n8557# VSS 6.746650e-16
C2162 eeg_afe_pga_0/eeg_fd_ota_chopped_full2_0/stage2_0/m1_47941_n8557# VSS 6.746650e-16
C2163 eeg_afe_pga_0/eeg_fd_ota_chopped_full2_0/stage2_0/m1_48341_n15864# VSS 6.746650e-16
C2164 eeg_afe_pga_0/eeg_fd_ota_chopped_full2_0/stage2_0/m1_52341_n15864# VSS 6.746650e-16
C2165 eeg_afe_pga_0/eeg_fd_ota_chopped_full2_0/stage2_0/m1_52741_n8557# VSS 6.746650e-16
C2166 eeg_afe_pga_0/eeg_fd_ota_chopped_full2_0/stage2_0/m1_56741_n8557# VSS 6.746650e-16
C2167 eeg_afe_pga_0/eeg_fd_ota_chopped_full2_0/stage2_0/m1_57141_n15864# VSS 6.746650e-16
C2168 eeg_afe_pga_0/eeg_fd_ota_chopped_full2_0/stage2_0/m1_43141_n8557# VSS 6.746650e-16
C2169 eeg_afe_pga_0/eeg_fd_ota_chopped_full2_0/stage2_0/m1_43541_n15864# VSS 6.746650e-16
C2170 eeg_afe_pga_0/eeg_fd_ota_chopped_full2_0/stage2_0/m1_47541_n15864# VSS 6.746650e-16
C2171 eeg_afe_pga_0/eeg_fd_ota_chopped_full2_0/stage2_0/m1_47941_n8557# VSS 6.746650e-16
C2172 eeg_afe_pga_0/eeg_fd_ota_chopped_full2_0/stage2_0/m1_51941_n8557# VSS 6.746650e-16
C2173 eeg_afe_pga_0/eeg_fd_ota_chopped_full2_0/stage2_0/m1_52341_n15864# VSS 6.746650e-16
C2174 eeg_afe_pga_0/eeg_fd_ota_chopped_full2_0/stage2_0/m1_56341_n15864# VSS 6.746650e-16
C2175 eeg_afe_pga_0/eeg_fd_ota_chopped_full2_0/stage2_0/m1_56741_n8557# VSS 6.746650e-16
C2176 eeg_afe_pga_0/eeg_fd_ota_chopped_full2_0/stage2_0/m1_42741_n15864# VSS 6.746650e-16
C2177 eeg_afe_pga_0/eeg_fd_ota_chopped_full2_0/stage2_0/m1_43141_n8557# VSS 6.746650e-16
C2178 eeg_afe_pga_0/eeg_fd_ota_chopped_full2_0/stage2_0/m1_47141_n8557# VSS 6.746650e-16
C2179 eeg_afe_pga_0/eeg_fd_ota_chopped_full2_0/stage2_0/m1_47541_n15864# VSS 6.746650e-16
C2180 eeg_afe_pga_0/eeg_fd_ota_chopped_full2_0/stage2_0/m1_51541_n15864# VSS 6.746650e-16
C2181 eeg_afe_pga_0/eeg_fd_ota_chopped_full2_0/stage2_0/m1_51941_n8557# VSS 6.746650e-16
C2182 eeg_afe_pga_0/eeg_fd_ota_chopped_full2_0/stage2_0/m1_55941_n8557# VSS 6.746650e-16
C2183 eeg_afe_pga_0/eeg_fd_ota_chopped_full2_0/stage2_0/m1_56341_n15864# VSS 6.746650e-16
C2184 eeg_afe_pga_0/eeg_fd_ota_chopped_full2_0/stage2_0/VCM2 VSS 6.746650e-16
C2185 eeg_afe_pga_0/eeg_fd_ota_chopped_full2_0/stage2_0/m1_61141_n15864# VSS 6.746650e-16
C2186 eeg_afe_pga_0/eeg_fd_ota_chopped_full2_0/stage2_0/m1_42341_n8557# VSS 6.746650e-16
C2187 eeg_afe_pga_0/eeg_fd_ota_chopped_full2_0/stage2_0/m1_42741_n15864# VSS 6.746650e-16
C2188 eeg_afe_pga_0/eeg_fd_ota_chopped_full2_0/stage2_0/m1_46741_n15864# VSS 6.746650e-16
C2189 eeg_afe_pga_0/eeg_fd_ota_chopped_full2_0/stage2_0/m1_47141_n8557# VSS 6.746650e-16
C2190 eeg_afe_pga_0/eeg_fd_ota_chopped_full2_0/stage2_0/m1_51141_n8557# VSS 6.746650e-16
C2191 eeg_afe_pga_0/eeg_fd_ota_chopped_full2_0/stage2_0/m1_51541_n15864# VSS 6.746650e-16
C2192 eeg_afe_pga_0/eeg_fd_ota_chopped_full2_0/stage2_0/m1_55541_n15864# VSS 6.746650e-16
C2193 eeg_afe_pga_0/eeg_fd_ota_chopped_full2_0/stage2_0/m1_55941_n8557# VSS 6.746650e-16
C2194 eeg_afe_pga_0/eeg_fd_ota_chopped_full2_0/stage2_0/m1_60741_n8557# VSS 6.746650e-16
C2195 eeg_afe_pga_0/eeg_fd_ota_chopped_full2_0/stage2_0/m1_61141_n15864# VSS 6.746650e-16
C2196 eeg_afe_pga_0/eeg_fd_ota_chopped_full2_0/stage2_0/m1_67141_n15864# VSS 6.746650e-16
C2197 eeg_afe_pga_0/eeg_fd_ota_chopped_full2_0/stage2_0/m1_67541_n8557# VSS 6.746650e-16
C2198 eeg_afe_pga_0/eeg_fd_ota_chopped_full2_0/stage2_0/m1_41941_n15864# VSS 6.746650e-16
C2199 eeg_afe_pga_0/eeg_fd_ota_chopped_full2_0/stage2_0/m1_42341_n8557# VSS 6.746650e-16
C2200 eeg_afe_pga_0/eeg_fd_ota_chopped_full2_0/stage2_0/m1_46341_n8557# VSS 6.746650e-16
C2201 eeg_afe_pga_0/eeg_fd_ota_chopped_full2_0/stage2_0/m1_46741_n15864# VSS 6.746650e-16
C2202 eeg_afe_pga_0/eeg_fd_ota_chopped_full2_0/stage2_0/m1_50741_n15864# VSS 6.746650e-16
C2203 eeg_afe_pga_0/eeg_fd_ota_chopped_full2_0/stage2_0/m1_51141_n8557# VSS 6.746650e-16
C2204 eeg_afe_pga_0/eeg_fd_ota_chopped_full2_0/stage2_0/m1_55141_n8557# VSS 6.746650e-16
C2205 eeg_afe_pga_0/eeg_fd_ota_chopped_full2_0/stage2_0/m1_55541_n15864# VSS 6.746650e-16
C2206 eeg_afe_pga_0/eeg_fd_ota_chopped_full2_0/stage2_0/m1_60341_n15864# VSS 6.746650e-16
C2207 eeg_afe_pga_0/eeg_fd_ota_chopped_full2_0/stage2_0/m1_60741_n8557# VSS 6.746650e-16
C2208 VCM_REF VSS 6.746650e-16
C2209 eeg_afe_pga_0/eeg_fd_ota_chopped_full2_0/stage2_0/m1_71141_n15864# VSS 6.746650e-16
C2210 eeg_afe_pga_0/eeg_fd_ota_chopped_full2_0/stage2_0/m1_66741_n8557# VSS 6.746650e-16
C2211 eeg_afe_pga_0/eeg_fd_ota_chopped_full2_0/stage2_0/m1_67141_n15864# VSS 6.746650e-16
C2212 eeg_afe_pga_0/eeg_fd_ota_chopped_full2_0/stage2_0/m1_41941_n15864# VSS 6.746650e-16
C2213 PGA_OUTN VSS 6.746650e-16
C2214 eeg_afe_pga_0/eeg_fd_ota_chopped_full2_0/stage2_0/m1_45941_n15864# VSS 6.746650e-16
C2215 eeg_afe_pga_0/eeg_fd_ota_chopped_full2_0/stage2_0/m1_46341_n8557# VSS 6.746650e-16
C2216 eeg_afe_pga_0/eeg_fd_ota_chopped_full2_0/stage2_0/m1_50341_n8557# VSS 6.746650e-16
C2217 eeg_afe_pga_0/eeg_fd_ota_chopped_full2_0/stage2_0/m1_50741_n15864# VSS 6.746650e-16
C2218 eeg_afe_pga_0/eeg_fd_ota_chopped_full2_0/stage2_0/m1_54741_n15864# VSS 6.746650e-16
C2219 eeg_afe_pga_0/eeg_fd_ota_chopped_full2_0/stage2_0/m1_55141_n8557# VSS 6.746650e-16
C2220 eeg_afe_pga_0/eeg_fd_ota_chopped_full2_0/stage2_0/m1_59941_n8557# VSS 6.746650e-16
C2221 eeg_afe_pga_0/eeg_fd_ota_chopped_full2_0/stage2_0/m1_60341_n15864# VSS 6.746650e-16
C2222 eeg_afe_pga_0/eeg_fd_ota_chopped_full2_0/stage2_0/m1_77141_n15864# VSS 6.746650e-16
C2223 eeg_afe_pga_0/eeg_fd_ota_chopped_full2_0/stage2_0/m1_77541_n8557# VSS 6.746650e-16
C2224 eeg_afe_pga_0/eeg_fd_ota_chopped_full2_0/stage2_0/m1_70741_n8557# VSS 6.746650e-16
C2225 eeg_afe_pga_0/eeg_fd_ota_chopped_full2_0/stage2_0/m1_71141_n15864# VSS 6.746650e-16
C2226 eeg_afe_pga_0/eeg_fd_ota_chopped_full2_0/stage2_0/m1_66341_n15864# VSS 6.746650e-16
C2227 eeg_afe_pga_0/eeg_fd_ota_chopped_full2_0/stage2_0/m1_66741_n8557# VSS 6.746650e-16
C2228 VDD18 VSS 1.074004e-13
C2229 VDD18 eeg_afe_pga_0/eeg_fd_ota_chopped_full2_0/stage2_0/VBP2 2.903319e-14
C2230 VDD18 PGA_OUTP 9.216400e-16
C2231 eeg_afe_pga_0/eeg_fd_ota_chopped_full2_0/stage2_0/VBP2 VSS 7.027174e-15
C2232 eeg_afe_pga_0/eeg_fd_ota_chopped_full2_0/stage2_0/VBP2 PGA_OUTP 3.596600e-15
C2233 PGA_OUTP VSS 4.856640e-16
C2234 eeg_afe_pga_0/eeg_fd_ota_chopped_full2_0/stage2_0/m1_45541_n8557# VSS 6.746650e-16
C2235 eeg_afe_pga_0/eeg_fd_ota_chopped_full2_0/stage2_0/m1_45941_n15864# VSS 6.746650e-16
C2236 eeg_afe_pga_0/eeg_fd_ota_chopped_full2_0/stage2_0/m1_49941_n15864# VSS 6.746650e-16
C2237 eeg_afe_pga_0/eeg_fd_ota_chopped_full2_0/stage2_0/m1_50341_n8557# VSS 6.746650e-16
C2238 eeg_afe_pga_0/eeg_fd_ota_chopped_full2_0/stage2_0/m1_54341_n8557# VSS 6.746650e-16
C2239 eeg_afe_pga_0/eeg_fd_ota_chopped_full2_0/stage2_0/m1_54741_n15864# VSS 6.746650e-16
C2240 eeg_afe_pga_0/eeg_fd_ota_chopped_full2_0/stage2_0/m1_59541_n15864# VSS 6.746650e-16
C2241 eeg_afe_pga_0/eeg_fd_ota_chopped_full2_0/stage2_0/m1_59941_n8557# VSS 6.746650e-16
C2242 VCM_REF VSS 6.746650e-16
C2243 eeg_afe_pga_0/eeg_fd_ota_chopped_full2_0/stage2_0/m1_81141_n15864# VSS 6.746650e-16
C2244 eeg_afe_pga_0/eeg_fd_ota_chopped_full2_0/stage2_0/m1_76741_n8557# VSS 6.746650e-16
C2245 eeg_afe_pga_0/eeg_fd_ota_chopped_full2_0/stage2_0/m1_77141_n15864# VSS 6.746650e-16
C2246 eeg_afe_pga_0/eeg_fd_ota_chopped_full2_0/stage2_0/m1_70341_n15864# VSS 6.746650e-16
C2247 eeg_afe_pga_0/eeg_fd_ota_chopped_full2_0/stage2_0/m1_70741_n8557# VSS 6.746650e-16
C2248 eeg_afe_pga_0/eeg_fd_ota_chopped_full2_0/stage2_0/m1_65941_n8557# VSS 6.746650e-16
C2249 eeg_afe_pga_0/eeg_fd_ota_chopped_full2_0/stage2_0/m1_66341_n15864# VSS 6.746650e-16
C2250 eeg_afe_pga_0/eeg_fd_ota_chopped_full2_0/stage2_0/m1_49541_n8557# VSS 6.746650e-16
C2251 eeg_afe_pga_0/eeg_fd_ota_chopped_full2_0/stage2_0/m1_49941_n15864# VSS 6.746650e-16
C2252 eeg_afe_pga_0/eeg_fd_ota_chopped_full2_0/stage2_0/m1_53941_n15864# VSS 6.746650e-16
C2253 eeg_afe_pga_0/eeg_fd_ota_chopped_full2_0/stage2_0/m1_54341_n8557# VSS 6.746650e-16
C2254 eeg_afe_pga_0/eeg_fd_ota_chopped_full2_0/stage2_0/m1_59141_n8557# VSS 6.746650e-16
C2255 eeg_afe_pga_0/eeg_fd_ota_chopped_full2_0/stage2_0/m1_59541_n15864# VSS 6.746650e-16
C2256 eeg_afe_pga_0/eeg_fd_ota_chopped_full2_0/stage2_0/m1_36741_n15864# VSS 6.746650e-16
C2257 eeg_afe_pga_0/eeg_fd_ota_chopped_full2_0/stage2_0/m1_37141_n8557# VSS 6.746650e-16
C2258 eeg_afe_pga_0/eeg_fd_ota_chopped_full2_0/stage2_0/m1_80741_n8557# VSS 6.746650e-16
C2259 eeg_afe_pga_0/eeg_fd_ota_chopped_full2_0/stage2_0/m1_81141_n15864# VSS 6.746650e-16
C2260 eeg_afe_pga_0/eeg_fd_ota_chopped_full2_0/stage2_0/m1_76341_n15864# VSS 6.746650e-16
C2261 eeg_afe_pga_0/eeg_fd_ota_chopped_full2_0/stage2_0/m1_76741_n8557# VSS 6.746650e-16
C2262 eeg_afe_pga_0/eeg_fd_ota_chopped_full2_0/stage2_0/m1_69941_n8557# VSS 6.746650e-16
C2263 eeg_afe_pga_0/eeg_fd_ota_chopped_full2_0/stage2_0/m1_70341_n15864# VSS 6.746650e-16
C2264 eeg_afe_pga_0/eeg_fd_ota_chopped_full2_0/stage2_0/m1_65541_n15864# VSS 6.746650e-16
C2265 eeg_afe_pga_0/eeg_fd_ota_chopped_full2_0/stage2_0/m1_65941_n8557# VSS 6.746650e-16
C2266 eeg_afe_pga_0/eeg_fd_ota_chopped_full2_0/stage2_0/m1_53541_n8557# VSS 6.746650e-16
C2267 eeg_afe_pga_0/eeg_fd_ota_chopped_full2_0/stage2_0/m1_53941_n15864# VSS 6.746650e-16
C2268 eeg_afe_pga_0/eeg_fd_ota_chopped_full2_0/stage2_0/m1_58741_n15864# VSS 6.746650e-16
C2269 eeg_afe_pga_0/eeg_fd_ota_chopped_full2_0/stage2_0/m1_59141_n8557# VSS 6.746650e-16
C2270 eeg_afe_pga_0/eeg_fd_ota_chopped_full2_0/stage2_0/m1_20741_n15864# VSS 6.746650e-16
C2271 eeg_afe_pga_0/eeg_fd_ota_chopped_full2_0/stage2_0/m1_21141_n8557# VSS 6.746650e-16
C2272 eeg_afe_pga_0/eeg_fd_ota_chopped_full2_0/stage2_0/m1_36341_n8557# VSS 6.746650e-16
C2273 eeg_afe_pga_0/eeg_fd_ota_chopped_full2_0/stage2_0/m1_36741_n15864# VSS 6.746650e-16
C2274 eeg_afe_pga_0/eeg_fd_ota_chopped_full2_0/stage2_0/m1_80341_n15864# VSS 6.746650e-16
C2275 eeg_afe_pga_0/eeg_fd_ota_chopped_full2_0/stage2_0/m1_80741_n8557# VSS 6.746650e-16
C2276 eeg_afe_pga_0/eeg_fd_ota_chopped_full2_0/stage2_0/m1_75941_n8557# VSS 6.746650e-16
C2277 eeg_afe_pga_0/eeg_fd_ota_chopped_full2_0/stage2_0/m1_76341_n15864# VSS 6.746650e-16
C2278 eeg_afe_pga_0/eeg_fd_ota_chopped_full2_0/stage2_0/m1_69541_n15864# VSS 6.746650e-16
C2279 eeg_afe_pga_0/eeg_fd_ota_chopped_full2_0/stage2_0/m1_69941_n8557# VSS 6.746650e-16
C2280 eeg_afe_pga_0/eeg_fd_ota_chopped_full2_0/stage2_0/m1_65141_n8557# VSS 6.746650e-16
C2281 eeg_afe_pga_0/eeg_fd_ota_chopped_full2_0/stage2_0/m1_65541_n15864# VSS 6.746650e-16
C2282 VSS eeg_afe_pga_0/eeg_fd_ota_chopped_full2_0/stage2_0/N2P 9.971760e-16
C2283 eeg_afe_pga_0/eeg_fd_ota_chopped_full2_0/stage2_0/N2P VSS 7.765320e-15
C2284 eeg_afe_pga_0/eeg_fd_ota_chopped_full2_0/stage2_0/N2P PGA_OUTP 8.991500e-16
C2285 PGA_OUTP VSS 1.639490e-16
C2286 NPHIBM NPHIM 7.901830e-17
C2287 NPHIBM PHIBM 5.228216e-15
C2288 NPHIBM PHIM 5.833740e-17
C2289 NPHIBM VDD18 1.030131e-16
C2290 NPHIBM VSS 7.512014e-15
C2291 NPHIBM eeg_afe_pga_0/eeg_fd_ota_chopped_full2_0/eeg_fd_ota_core_soft_0/OUTN 1.811041e-16
C2292 NPHIBM eeg_afe_pga_0/eeg_fd_ota_chopped_full2_0/eeg_fd_ota_core_soft_0/OUTP 1.783654e-16
C2293 NPHIBM eeg_afe_pga_0/eeg_fd_ota_chopped_full2_0/stage2_0/N2N 3.459312e-16
C2294 NPHIBM eeg_afe_pga_0/eeg_fd_ota_chopped_full2_0/stage2_0/N2P 3.587603e-16
C2295 NPHIM PHIBM 4.712490e-15
C2296 NPHIM PHIM 5.200586e-15
C2297 NPHIM VDD18 1.018586e-16
C2298 NPHIM VSS 3.887486e-15
C2299 NPHIM eeg_afe_pga_0/eeg_fd_ota_chopped_full2_0/eeg_fd_ota_core_soft_0/OUTN 1.853562e-16
C2300 NPHIM eeg_afe_pga_0/eeg_fd_ota_chopped_full2_0/eeg_fd_ota_core_soft_0/OUTP 1.806746e-16
C2301 NPHIM eeg_afe_pga_0/eeg_fd_ota_chopped_full2_0/stage2_0/N2N 3.472566e-16
C2302 NPHIM eeg_afe_pga_0/eeg_fd_ota_chopped_full2_0/stage2_0/N2P 3.595253e-16
C2303 PHIBM PHIM 1.062601e-16
C2304 PHIBM VDD18 1.685133e-16
C2305 PHIBM VSS 3.602799e-15
C2306 PHIBM eeg_afe_pga_0/eeg_fd_ota_chopped_full2_0/eeg_fd_ota_core_soft_0/OUTN 7.703784e-16
C2307 PHIBM eeg_afe_pga_0/eeg_fd_ota_chopped_full2_0/eeg_fd_ota_core_soft_0/OUTP 7.157421e-16
C2308 PHIBM eeg_afe_pga_0/eeg_fd_ota_chopped_full2_0/stage2_0/N2N 4.286349e-16
C2309 PHIBM eeg_afe_pga_0/eeg_fd_ota_chopped_full2_0/stage2_0/N2P 4.066731e-16
C2310 PHIM VDD18 1.607790e-16
C2311 PHIM VSS 3.328204e-15
C2312 PHIM eeg_afe_pga_0/eeg_fd_ota_chopped_full2_0/eeg_fd_ota_core_soft_0/OUTN 5.418324e-15
C2313 PHIM eeg_afe_pga_0/eeg_fd_ota_chopped_full2_0/eeg_fd_ota_core_soft_0/OUTP 7.203664e-16
C2314 PHIM eeg_afe_pga_0/eeg_fd_ota_chopped_full2_0/stage2_0/N2N 4.307666e-16
C2315 PHIM eeg_afe_pga_0/eeg_fd_ota_chopped_full2_0/stage2_0/N2P 4.077701e-16
C2316 VDD18 VSS 5.270369e-15
C2325 eeg_afe_pga_0/eeg_fd_ota_chopped_full2_0/eeg_fd_ota_core_soft_0/OUTN VSS 2.830580e-15
C2326 eeg_afe_pga_0/eeg_fd_ota_chopped_full2_0/eeg_fd_ota_core_soft_0/OUTN eeg_afe_pga_0/eeg_fd_ota_chopped_full2_0/eeg_fd_ota_core_soft_0/OUTP 4.996116e-15
C2327 eeg_afe_pga_0/eeg_fd_ota_chopped_full2_0/eeg_fd_ota_core_soft_0/OUTN eeg_afe_pga_0/eeg_fd_ota_chopped_full2_0/stage2_0/N2N 4.971801e-16
C2328 eeg_afe_pga_0/eeg_fd_ota_chopped_full2_0/eeg_fd_ota_core_soft_0/OUTN eeg_afe_pga_0/eeg_fd_ota_chopped_full2_0/stage2_0/N2P 5.233646e-16
C2329 eeg_afe_pga_0/eeg_fd_ota_chopped_full2_0/eeg_fd_ota_core_soft_0/OUTP VSS 2.659180e-15
C2330 eeg_afe_pga_0/eeg_fd_ota_chopped_full2_0/eeg_fd_ota_core_soft_0/OUTP eeg_afe_pga_0/eeg_fd_ota_chopped_full2_0/stage2_0/N2N 5.135942e-15
C2331 eeg_afe_pga_0/eeg_fd_ota_chopped_full2_0/eeg_fd_ota_core_soft_0/OUTP eeg_afe_pga_0/eeg_fd_ota_chopped_full2_0/stage2_0/N2P 5.252581e-16
C2332 eeg_afe_pga_0/eeg_fd_ota_chopped_full2_0/stage2_0/N2N VSS 1.709720e-15
C2333 eeg_afe_pga_0/eeg_fd_ota_chopped_full2_0/stage2_0/N2N eeg_afe_pga_0/eeg_fd_ota_chopped_full2_0/stage2_0/N2P 4.747254e-15
C2334 eeg_afe_pga_0/eeg_fd_ota_chopped_full2_0/stage2_0/N2P VSS 4.881870e-15
C2335 NPHIBM PHIBM 1.215812e-15
C2336 NPHIBM VDD18 5.262242e-16
C2337 NPHIBM VSS 2.537269e-15
C2338 NPHIBM eeg_afe_pga_0/eeg_fd_ota_chopped_full2_0/eeg_fd_ota_core_soft_0/OUTN 4.755154e-17
C2339 NPHIBM eeg_afe_pga_0/eeg_fd_ota_chopped_full2_0/stage2_0/N2P 1.076105e-16
C2340 PHIBM VDD18 6.588032e-16
C2341 PHIBM VSS 1.789951e-15
C2342 PHIBM eeg_afe_pga_0/eeg_fd_ota_chopped_full2_0/eeg_fd_ota_core_soft_0/OUTN 1.181323e-16
C2343 PHIBM eeg_afe_pga_0/eeg_fd_ota_chopped_full2_0/stage2_0/N2P 2.857784e-16
C2344 VDD18 VSS 3.714735e-15
C2345 VDD18 eeg_afe_pga_0/eeg_fd_ota_chopped_full2_0/eeg_fd_ota_core_soft_0/OUTN 1.484229e-16
C2346 VDD18 eeg_afe_pga_0/eeg_fd_ota_chopped_full2_0/stage2_0/N2P 3.128723e-16
C2347 VSS eeg_afe_pga_0/eeg_fd_ota_chopped_full2_0/eeg_fd_ota_core_soft_0/OUTN 7.819878e-17
C2348 VSS eeg_afe_pga_0/eeg_fd_ota_chopped_full2_0/stage2_0/N2P 1.097210e-16
C2349 eeg_afe_pga_0/eeg_fd_ota_chopped_full2_0/eeg_fd_ota_core_soft_0/OUTN VSS 2.430800e-15
C2350 eeg_afe_pga_0/eeg_fd_ota_chopped_full2_0/eeg_fd_ota_core_soft_0/OUTN eeg_afe_pga_0/eeg_fd_ota_chopped_full2_0/stage2_0/N2P 1.492117e-15
C2351 eeg_afe_pga_0/eeg_fd_ota_chopped_full2_0/stage2_0/N2P VSS 1.462840e-15
C2352 PHIBM VDD18 1.564350e-16
C2353 PHIBM VSS 4.901000e-17
C2354 PHIBM eeg_afe_pga_0/eeg_fd_ota_chopped_full2_0/stage2_0/N2P 2.862080e-17
C2355 VDD18 VSS 1.561810e-15
C2356 VDD18 eeg_afe_pga_0/eeg_fd_ota_chopped_full2_0/stage2_0/N2P 1.697704e-16
C2357 eeg_afe_pga_0/eeg_fd_ota_chopped_full2_0/stage2_0/N2P VSS 8.867300e-17
C2358 NPHIBM VSS 2.062020e-16
C2359 NPHIBM eeg_afe_pga_0/eeg_fd_ota_chopped_full2_0/eeg_fd_ota_core_soft_0/OUTN 2.084120e-17
C2360 eeg_afe_pga_0/eeg_fd_ota_chopped_full2_0/eeg_fd_ota_core_soft_0/OUTN VSS 1.088312e-16
C2361 NPHIBM VSS 2.062020e-16
C2362 NPHIBM eeg_afe_pga_0/eeg_fd_ota_chopped_full2_0/stage2_0/N2P 2.084120e-17
C2363 eeg_afe_pga_0/eeg_fd_ota_chopped_full2_0/stage2_0/N2P VSS 1.088312e-16
C2364 NPHIBM VDD18 1.594600e-16
C2365 NPHIBM VSS 4.382640e-17
C2366 NPHIBM eeg_afe_pga_0/eeg_fd_ota_chopped_full2_0/eeg_fd_ota_core_soft_0/OUTN 2.402360e-17
C2367 NPHIBM eeg_afe_pga_0/eeg_fd_ota_chopped_full2_0/stage2_0/N2P 2.402360e-17
C2368 VDD18 VSS 2.327590e-15
C2369 VDD18 eeg_afe_pga_0/eeg_fd_ota_chopped_full2_0/eeg_fd_ota_core_soft_0/OUTN 1.554040e-16
C2370 VDD18 eeg_afe_pga_0/eeg_fd_ota_chopped_full2_0/stage2_0/N2P 1.554040e-16
C2371 eeg_afe_pga_0/eeg_fd_ota_chopped_full2_0/eeg_fd_ota_core_soft_0/OUTN VSS 7.837880e-17
C2372 eeg_afe_pga_0/eeg_fd_ota_chopped_full2_0/eeg_fd_ota_core_soft_0/OUTN eeg_afe_pga_0/eeg_fd_ota_chopped_full2_0/stage2_0/N2P 1.170160e-16
C2373 eeg_afe_pga_0/eeg_fd_ota_chopped_full2_0/stage2_0/N2P VSS 7.837880e-17
C2374 PHIBM VDD18 1.564350e-16
C2375 PHIBM VSS 4.901000e-17
C2376 PHIBM eeg_afe_pga_0/eeg_fd_ota_chopped_full2_0/eeg_fd_ota_core_soft_0/OUTN 2.862080e-17
C2377 VDD18 VSS 1.561810e-15
C2378 VDD18 eeg_afe_pga_0/eeg_fd_ota_chopped_full2_0/eeg_fd_ota_core_soft_0/OUTN 1.697704e-16
C2379 eeg_afe_pga_0/eeg_fd_ota_chopped_full2_0/eeg_fd_ota_core_soft_0/OUTN VSS 8.867300e-17
C2380 PHIBM VSS 2.027230e-16
C2383 eeg_afe_pga_0/eeg_fd_ota_chopped_full2_0/eeg_fd_ota_core_soft_0/OUTN VSS 1.267930e-16
C2384 eeg_afe_pga_0/eeg_fd_ota_chopped_full2_0/eeg_fd_ota_core_soft_0/OUTN eeg_afe_pga_0/eeg_fd_ota_chopped_full2_0/stage2_0/N2P 5.623600e-17
C2385 eeg_afe_pga_0/eeg_fd_ota_chopped_full2_0/stage2_0/N2P VSS 1.267930e-16
C2386 NPHIBM PHIBM 1.215812e-15
C2387 NPHIBM VDD18 5.262242e-16
C2388 NPHIBM VSS 2.537269e-15
C2389 NPHIBM eeg_afe_pga_0/eeg_fd_ota_chopped_full2_0/eeg_fd_ota_core_soft_0/OUTP 4.755154e-17
C2390 NPHIBM eeg_afe_pga_0/eeg_fd_ota_chopped_full2_0/stage2_0/N2N 1.076105e-16
C2391 PHIBM VDD18 6.588032e-16
C2392 PHIBM VSS 1.789951e-15
C2393 PHIBM eeg_afe_pga_0/eeg_fd_ota_chopped_full2_0/eeg_fd_ota_core_soft_0/OUTP 1.181323e-16
C2394 PHIBM eeg_afe_pga_0/eeg_fd_ota_chopped_full2_0/stage2_0/N2N 2.857784e-16
C2395 VDD18 VSS 3.714735e-15
C2396 VDD18 eeg_afe_pga_0/eeg_fd_ota_chopped_full2_0/eeg_fd_ota_core_soft_0/OUTP 1.484229e-16
C2397 VDD18 eeg_afe_pga_0/eeg_fd_ota_chopped_full2_0/stage2_0/N2N 3.128723e-16
C2398 VSS eeg_afe_pga_0/eeg_fd_ota_chopped_full2_0/eeg_fd_ota_core_soft_0/OUTP 7.819878e-17
C2399 VSS eeg_afe_pga_0/eeg_fd_ota_chopped_full2_0/stage2_0/N2N 1.097210e-16
C2400 eeg_afe_pga_0/eeg_fd_ota_chopped_full2_0/eeg_fd_ota_core_soft_0/OUTP VSS 2.430800e-15
C2401 eeg_afe_pga_0/eeg_fd_ota_chopped_full2_0/eeg_fd_ota_core_soft_0/OUTP eeg_afe_pga_0/eeg_fd_ota_chopped_full2_0/stage2_0/N2N 1.492117e-15
C2402 eeg_afe_pga_0/eeg_fd_ota_chopped_full2_0/stage2_0/N2N VSS 1.462840e-15
C2403 PHIBM VDD18 1.564350e-16
C2404 PHIBM VSS 4.901000e-17
C2405 PHIBM eeg_afe_pga_0/eeg_fd_ota_chopped_full2_0/stage2_0/N2N 2.862080e-17
C2406 VDD18 VSS 1.561810e-15
C2407 VDD18 eeg_afe_pga_0/eeg_fd_ota_chopped_full2_0/stage2_0/N2N 1.697704e-16
C2408 eeg_afe_pga_0/eeg_fd_ota_chopped_full2_0/stage2_0/N2N VSS 8.867300e-17
C2409 NPHIBM VSS 2.062020e-16
C2410 NPHIBM eeg_afe_pga_0/eeg_fd_ota_chopped_full2_0/eeg_fd_ota_core_soft_0/OUTP 2.084120e-17
C2411 eeg_afe_pga_0/eeg_fd_ota_chopped_full2_0/eeg_fd_ota_core_soft_0/OUTP VSS 1.088312e-16
C2412 NPHIBM VSS 2.062020e-16
C2413 NPHIBM eeg_afe_pga_0/eeg_fd_ota_chopped_full2_0/stage2_0/N2N 2.084120e-17
C2414 eeg_afe_pga_0/eeg_fd_ota_chopped_full2_0/stage2_0/N2N VSS 1.088312e-16
C2415 NPHIBM VDD18 1.594600e-16
C2416 NPHIBM VSS 4.382640e-17
C2417 NPHIBM eeg_afe_pga_0/eeg_fd_ota_chopped_full2_0/eeg_fd_ota_core_soft_0/OUTP 2.402360e-17
C2418 NPHIBM eeg_afe_pga_0/eeg_fd_ota_chopped_full2_0/stage2_0/N2N 2.402360e-17
C2419 VDD18 VSS 2.327590e-15
C2420 VDD18 eeg_afe_pga_0/eeg_fd_ota_chopped_full2_0/eeg_fd_ota_core_soft_0/OUTP 1.554040e-16
C2421 VDD18 eeg_afe_pga_0/eeg_fd_ota_chopped_full2_0/stage2_0/N2N 1.554040e-16
C2422 eeg_afe_pga_0/eeg_fd_ota_chopped_full2_0/eeg_fd_ota_core_soft_0/OUTP VSS 7.837880e-17
C2423 eeg_afe_pga_0/eeg_fd_ota_chopped_full2_0/eeg_fd_ota_core_soft_0/OUTP eeg_afe_pga_0/eeg_fd_ota_chopped_full2_0/stage2_0/N2N 1.170160e-16
C2424 eeg_afe_pga_0/eeg_fd_ota_chopped_full2_0/stage2_0/N2N VSS 7.837880e-17
C2425 PHIBM VDD18 1.564350e-16
C2426 PHIBM VSS 4.901000e-17
C2427 PHIBM eeg_afe_pga_0/eeg_fd_ota_chopped_full2_0/eeg_fd_ota_core_soft_0/OUTP 2.862080e-17
C2428 VDD18 VSS 1.561810e-15
C2429 VDD18 eeg_afe_pga_0/eeg_fd_ota_chopped_full2_0/eeg_fd_ota_core_soft_0/OUTP 1.697704e-16
C2430 eeg_afe_pga_0/eeg_fd_ota_chopped_full2_0/eeg_fd_ota_core_soft_0/OUTP VSS 8.867300e-17
C2431 PHIBM VSS 2.027230e-16
C2434 eeg_afe_pga_0/eeg_fd_ota_chopped_full2_0/eeg_fd_ota_core_soft_0/OUTP VSS 1.267930e-16
C2435 eeg_afe_pga_0/eeg_fd_ota_chopped_full2_0/eeg_fd_ota_core_soft_0/OUTP eeg_afe_pga_0/eeg_fd_ota_chopped_full2_0/stage2_0/N2N 5.623600e-17
C2436 eeg_afe_pga_0/eeg_fd_ota_chopped_full2_0/stage2_0/N2N VSS 1.267930e-16
C2437 NPHIM PHIM 1.215812e-15
C2438 NPHIM VDD18 5.262242e-16
C2439 NPHIM VSS 2.537269e-15
C2440 NPHIM eeg_afe_pga_0/eeg_fd_ota_chopped_full2_0/eeg_fd_ota_core_soft_0/OUTN 4.755154e-17
C2441 NPHIM eeg_afe_pga_0/eeg_fd_ota_chopped_full2_0/stage2_0/N2N 1.076105e-16
C2442 PHIM VDD18 6.588032e-16
C2443 PHIM VSS 1.789951e-15
C2444 PHIM eeg_afe_pga_0/eeg_fd_ota_chopped_full2_0/eeg_fd_ota_core_soft_0/OUTN 1.181323e-16
C2445 PHIM eeg_afe_pga_0/eeg_fd_ota_chopped_full2_0/stage2_0/N2N 2.857784e-16
C2446 VDD18 VSS 3.714735e-15
C2447 VDD18 eeg_afe_pga_0/eeg_fd_ota_chopped_full2_0/eeg_fd_ota_core_soft_0/OUTN 1.484229e-16
C2448 VDD18 eeg_afe_pga_0/eeg_fd_ota_chopped_full2_0/stage2_0/N2N 3.128723e-16
C2449 VSS eeg_afe_pga_0/eeg_fd_ota_chopped_full2_0/eeg_fd_ota_core_soft_0/OUTN 7.819878e-17
C2450 VSS eeg_afe_pga_0/eeg_fd_ota_chopped_full2_0/stage2_0/N2N 1.097210e-16
C2451 eeg_afe_pga_0/eeg_fd_ota_chopped_full2_0/eeg_fd_ota_core_soft_0/OUTN VSS 2.430800e-15
C2452 eeg_afe_pga_0/eeg_fd_ota_chopped_full2_0/eeg_fd_ota_core_soft_0/OUTN eeg_afe_pga_0/eeg_fd_ota_chopped_full2_0/stage2_0/N2N 1.492117e-15
C2453 eeg_afe_pga_0/eeg_fd_ota_chopped_full2_0/stage2_0/N2N VSS 1.462840e-15
C2454 PHIM VDD18 1.564350e-16
C2455 PHIM VSS 4.901000e-17
C2456 PHIM eeg_afe_pga_0/eeg_fd_ota_chopped_full2_0/stage2_0/N2N 2.862080e-17
C2457 VDD18 VSS 1.561810e-15
C2458 VDD18 eeg_afe_pga_0/eeg_fd_ota_chopped_full2_0/stage2_0/N2N 1.697704e-16
C2459 eeg_afe_pga_0/eeg_fd_ota_chopped_full2_0/stage2_0/N2N VSS 8.867300e-17
C2460 NPHIM VSS 2.062020e-16
C2461 NPHIM eeg_afe_pga_0/eeg_fd_ota_chopped_full2_0/eeg_fd_ota_core_soft_0/OUTN 2.084120e-17
C2462 eeg_afe_pga_0/eeg_fd_ota_chopped_full2_0/eeg_fd_ota_core_soft_0/OUTN VSS 1.088312e-16
C2463 NPHIM VSS 2.062020e-16
C2464 NPHIM eeg_afe_pga_0/eeg_fd_ota_chopped_full2_0/stage2_0/N2N 2.084120e-17
C2465 eeg_afe_pga_0/eeg_fd_ota_chopped_full2_0/stage2_0/N2N VSS 1.088312e-16
C2466 NPHIM VDD18 1.594600e-16
C2467 NPHIM VSS 4.382640e-17
C2468 NPHIM eeg_afe_pga_0/eeg_fd_ota_chopped_full2_0/eeg_fd_ota_core_soft_0/OUTN 2.402360e-17
C2469 NPHIM eeg_afe_pga_0/eeg_fd_ota_chopped_full2_0/stage2_0/N2N 2.402360e-17
C2470 VDD18 VSS 2.327590e-15
C2471 VDD18 eeg_afe_pga_0/eeg_fd_ota_chopped_full2_0/eeg_fd_ota_core_soft_0/OUTN 1.554040e-16
C2472 VDD18 eeg_afe_pga_0/eeg_fd_ota_chopped_full2_0/stage2_0/N2N 1.554040e-16
C2473 eeg_afe_pga_0/eeg_fd_ota_chopped_full2_0/eeg_fd_ota_core_soft_0/OUTN VSS 7.837880e-17
C2474 eeg_afe_pga_0/eeg_fd_ota_chopped_full2_0/eeg_fd_ota_core_soft_0/OUTN eeg_afe_pga_0/eeg_fd_ota_chopped_full2_0/stage2_0/N2N 1.170160e-16
C2475 eeg_afe_pga_0/eeg_fd_ota_chopped_full2_0/stage2_0/N2N VSS 7.837880e-17
C2476 PHIM VDD18 1.564350e-16
C2477 PHIM VSS 4.901000e-17
C2478 PHIM eeg_afe_pga_0/eeg_fd_ota_chopped_full2_0/eeg_fd_ota_core_soft_0/OUTN 2.862080e-17
C2479 VDD18 VSS 1.561810e-15
C2480 VDD18 eeg_afe_pga_0/eeg_fd_ota_chopped_full2_0/eeg_fd_ota_core_soft_0/OUTN 1.697704e-16
C2481 eeg_afe_pga_0/eeg_fd_ota_chopped_full2_0/eeg_fd_ota_core_soft_0/OUTN VSS 8.867300e-17
C2482 PHIM VSS 2.027230e-16
C2485 eeg_afe_pga_0/eeg_fd_ota_chopped_full2_0/eeg_fd_ota_core_soft_0/OUTN VSS 1.267930e-16
C2486 eeg_afe_pga_0/eeg_fd_ota_chopped_full2_0/eeg_fd_ota_core_soft_0/OUTN eeg_afe_pga_0/eeg_fd_ota_chopped_full2_0/stage2_0/N2N 5.623600e-17
C2487 eeg_afe_pga_0/eeg_fd_ota_chopped_full2_0/stage2_0/N2N VSS 1.267930e-16
C2488 NPHIM PHIM 1.215812e-15
C2489 NPHIM VDD18 5.262242e-16
C2490 NPHIM VSS 2.537269e-15
C2491 NPHIM eeg_afe_pga_0/eeg_fd_ota_chopped_full2_0/eeg_fd_ota_core_soft_0/OUTP 4.755154e-17
C2492 NPHIM eeg_afe_pga_0/eeg_fd_ota_chopped_full2_0/stage2_0/N2P 1.076105e-16
C2493 PHIM VDD18 6.588032e-16
C2494 PHIM VSS 1.789951e-15
C2495 PHIM eeg_afe_pga_0/eeg_fd_ota_chopped_full2_0/eeg_fd_ota_core_soft_0/OUTP 1.181323e-16
C2496 PHIM eeg_afe_pga_0/eeg_fd_ota_chopped_full2_0/stage2_0/N2P 2.857784e-16
C2497 VDD18 VSS 3.714735e-15
C2498 VDD18 eeg_afe_pga_0/eeg_fd_ota_chopped_full2_0/eeg_fd_ota_core_soft_0/OUTP 1.484229e-16
C2499 VDD18 eeg_afe_pga_0/eeg_fd_ota_chopped_full2_0/stage2_0/N2P 3.128723e-16
C2500 VSS eeg_afe_pga_0/eeg_fd_ota_chopped_full2_0/eeg_fd_ota_core_soft_0/OUTP 7.819878e-17
C2501 VSS eeg_afe_pga_0/eeg_fd_ota_chopped_full2_0/stage2_0/N2P 1.097210e-16
C2502 eeg_afe_pga_0/eeg_fd_ota_chopped_full2_0/eeg_fd_ota_core_soft_0/OUTP VSS 2.430800e-15
C2503 eeg_afe_pga_0/eeg_fd_ota_chopped_full2_0/eeg_fd_ota_core_soft_0/OUTP eeg_afe_pga_0/eeg_fd_ota_chopped_full2_0/stage2_0/N2P 1.492117e-15
C2504 eeg_afe_pga_0/eeg_fd_ota_chopped_full2_0/stage2_0/N2P VSS 1.462840e-15
C2505 PHIM VDD18 1.564350e-16
C2506 PHIM VSS 4.901000e-17
C2507 PHIM eeg_afe_pga_0/eeg_fd_ota_chopped_full2_0/stage2_0/N2P 2.862080e-17
C2508 VDD18 VSS 1.561810e-15
C2509 VDD18 eeg_afe_pga_0/eeg_fd_ota_chopped_full2_0/stage2_0/N2P 1.697704e-16
C2510 eeg_afe_pga_0/eeg_fd_ota_chopped_full2_0/stage2_0/N2P VSS 8.867300e-17
C2511 NPHIM VSS 2.062020e-16
C2512 NPHIM eeg_afe_pga_0/eeg_fd_ota_chopped_full2_0/eeg_fd_ota_core_soft_0/OUTP 2.084120e-17
C2513 eeg_afe_pga_0/eeg_fd_ota_chopped_full2_0/eeg_fd_ota_core_soft_0/OUTP VSS 1.088312e-16
C2514 NPHIM VSS 2.062020e-16
C2515 NPHIM eeg_afe_pga_0/eeg_fd_ota_chopped_full2_0/stage2_0/N2P 2.084120e-17
C2516 eeg_afe_pga_0/eeg_fd_ota_chopped_full2_0/stage2_0/N2P VSS 1.088312e-16
C2517 NPHIM VDD18 1.594600e-16
C2518 NPHIM VSS 4.382640e-17
C2519 NPHIM eeg_afe_pga_0/eeg_fd_ota_chopped_full2_0/eeg_fd_ota_core_soft_0/OUTP 2.402360e-17
C2520 NPHIM eeg_afe_pga_0/eeg_fd_ota_chopped_full2_0/stage2_0/N2P 2.402360e-17
C2521 VDD18 VSS 2.327590e-15
C2522 VDD18 eeg_afe_pga_0/eeg_fd_ota_chopped_full2_0/eeg_fd_ota_core_soft_0/OUTP 1.554040e-16
C2523 VDD18 eeg_afe_pga_0/eeg_fd_ota_chopped_full2_0/stage2_0/N2P 1.554040e-16
C2524 eeg_afe_pga_0/eeg_fd_ota_chopped_full2_0/eeg_fd_ota_core_soft_0/OUTP VSS 7.837880e-17
C2525 eeg_afe_pga_0/eeg_fd_ota_chopped_full2_0/eeg_fd_ota_core_soft_0/OUTP eeg_afe_pga_0/eeg_fd_ota_chopped_full2_0/stage2_0/N2P 1.170160e-16
C2526 eeg_afe_pga_0/eeg_fd_ota_chopped_full2_0/stage2_0/N2P VSS 7.837880e-17
C2527 PHIM VDD18 1.564350e-16
C2528 PHIM VSS 4.901000e-17
C2529 PHIM eeg_afe_pga_0/eeg_fd_ota_chopped_full2_0/eeg_fd_ota_core_soft_0/OUTP 2.862080e-17
C2530 VDD18 VSS 1.561810e-15
C2531 VDD18 eeg_afe_pga_0/eeg_fd_ota_chopped_full2_0/eeg_fd_ota_core_soft_0/OUTP 1.697704e-16
C2532 eeg_afe_pga_0/eeg_fd_ota_chopped_full2_0/eeg_fd_ota_core_soft_0/OUTP VSS 8.867300e-17
C2533 PHIM VSS 2.027230e-16
C2536 eeg_afe_pga_0/eeg_fd_ota_chopped_full2_0/eeg_fd_ota_core_soft_0/OUTP VSS 1.267930e-16
C2537 eeg_afe_pga_0/eeg_fd_ota_chopped_full2_0/eeg_fd_ota_core_soft_0/OUTP eeg_afe_pga_0/eeg_fd_ota_chopped_full2_0/stage2_0/N2P 5.623600e-17
C2538 eeg_afe_pga_0/eeg_fd_ota_chopped_full2_0/stage2_0/N2P VSS 1.267930e-16
C2539 NPHIBI NPHII 7.901830e-17
C2540 NPHIBI PHIBI 5.228216e-15
C2541 NPHIBI PHII 5.833740e-17
C2542 NPHIBI VDD18 1.030131e-16
C2543 NPHIBI VSS 7.512014e-15
C2544 NPHIBI eeg_afe_pga_0/eeg_fd_ota_chopped_full2_0/eeg_fd_ota_core_soft_0/INN 3.459312e-16
C2545 NPHIBI eeg_afe_pga_0/eeg_fd_ota_chopped_full2_0/eeg_fd_ota_core_soft_0/INP 3.587603e-16
C2546 NPHIBI eeg_afe_pga_0/eeg_tg_lowq_3/B 1.811041e-16
C2547 NPHIBI eeg_afe_pga_0/eeg_tg_lowq_7/B 1.783654e-16
C2548 NPHII PHIBI 4.712490e-15
C2549 NPHII PHII 5.200586e-15
C2550 NPHII VDD18 1.018586e-16
C2551 NPHII VSS 3.887486e-15
C2552 NPHII eeg_afe_pga_0/eeg_fd_ota_chopped_full2_0/eeg_fd_ota_core_soft_0/INN 3.472566e-16
C2553 NPHII eeg_afe_pga_0/eeg_fd_ota_chopped_full2_0/eeg_fd_ota_core_soft_0/INP 3.595253e-16
C2554 NPHII eeg_afe_pga_0/eeg_tg_lowq_3/B 1.853562e-16
C2555 NPHII eeg_afe_pga_0/eeg_tg_lowq_7/B 1.806746e-16
C2556 PHIBI PHII 1.062601e-16
C2557 PHIBI VDD18 1.685133e-16
C2558 PHIBI VSS 3.602799e-15
C2559 PHIBI eeg_afe_pga_0/eeg_fd_ota_chopped_full2_0/eeg_fd_ota_core_soft_0/INN 4.286349e-16
C2560 PHIBI eeg_afe_pga_0/eeg_fd_ota_chopped_full2_0/eeg_fd_ota_core_soft_0/INP 4.066731e-16
C2561 PHIBI eeg_afe_pga_0/eeg_tg_lowq_3/B 7.703784e-16
C2562 PHIBI eeg_afe_pga_0/eeg_tg_lowq_7/B 7.157421e-16
C2563 PHII VDD18 1.607790e-16
C2564 PHII VSS 3.328204e-15
C2565 PHII eeg_afe_pga_0/eeg_fd_ota_chopped_full2_0/eeg_fd_ota_core_soft_0/INN 4.307666e-16
C2566 PHII eeg_afe_pga_0/eeg_fd_ota_chopped_full2_0/eeg_fd_ota_core_soft_0/INP 4.077701e-16
C2567 PHII eeg_afe_pga_0/eeg_tg_lowq_3/B 5.418324e-15
C2568 PHII eeg_afe_pga_0/eeg_tg_lowq_7/B 7.203664e-16
C2569 VDD18 VSS 5.270369e-15
C2578 eeg_afe_pga_0/eeg_fd_ota_chopped_full2_0/eeg_fd_ota_core_soft_0/INN VSS 1.709720e-15
C2579 eeg_afe_pga_0/eeg_fd_ota_chopped_full2_0/eeg_fd_ota_core_soft_0/INN eeg_afe_pga_0/eeg_fd_ota_chopped_full2_0/eeg_fd_ota_core_soft_0/INP 4.747254e-15
C2580 eeg_afe_pga_0/eeg_fd_ota_chopped_full2_0/eeg_fd_ota_core_soft_0/INN eeg_afe_pga_0/eeg_tg_lowq_3/B 4.971801e-16
C2581 eeg_afe_pga_0/eeg_fd_ota_chopped_full2_0/eeg_fd_ota_core_soft_0/INN eeg_afe_pga_0/eeg_tg_lowq_7/B 5.135942e-15
C2582 eeg_afe_pga_0/eeg_fd_ota_chopped_full2_0/eeg_fd_ota_core_soft_0/INP VSS 4.881870e-15
C2583 eeg_afe_pga_0/eeg_fd_ota_chopped_full2_0/eeg_fd_ota_core_soft_0/INP eeg_afe_pga_0/eeg_tg_lowq_3/B 5.233646e-16
C2584 eeg_afe_pga_0/eeg_fd_ota_chopped_full2_0/eeg_fd_ota_core_soft_0/INP eeg_afe_pga_0/eeg_tg_lowq_7/B 5.252581e-16
C2585 eeg_afe_pga_0/eeg_tg_lowq_3/B VSS 2.830580e-15
C2586 eeg_afe_pga_0/eeg_tg_lowq_3/B eeg_afe_pga_0/eeg_tg_lowq_7/B 4.996116e-15
C2587 eeg_afe_pga_0/eeg_tg_lowq_7/B VSS 2.659180e-15
C2588 NPHIBI PHIBI 1.215812e-15
C2589 NPHIBI VDD18 5.262242e-16
C2590 NPHIBI VSS 2.537269e-15
C2591 NPHIBI eeg_afe_pga_0/eeg_fd_ota_chopped_full2_0/eeg_fd_ota_core_soft_0/INP 1.076105e-16
C2592 NPHIBI eeg_afe_pga_0/eeg_tg_lowq_3/B 4.755154e-17
C2593 PHIBI VDD18 6.588032e-16
C2594 PHIBI VSS 1.789951e-15
C2595 PHIBI eeg_afe_pga_0/eeg_fd_ota_chopped_full2_0/eeg_fd_ota_core_soft_0/INP 2.857784e-16
C2596 PHIBI eeg_afe_pga_0/eeg_tg_lowq_3/B 1.181323e-16
C2597 VDD18 VSS 3.714735e-15
C2598 VDD18 eeg_afe_pga_0/eeg_fd_ota_chopped_full2_0/eeg_fd_ota_core_soft_0/INP 3.128723e-16
C2599 VDD18 eeg_afe_pga_0/eeg_tg_lowq_3/B 1.484229e-16
C2600 VSS eeg_afe_pga_0/eeg_fd_ota_chopped_full2_0/eeg_fd_ota_core_soft_0/INP 1.097210e-16
C2601 VSS eeg_afe_pga_0/eeg_tg_lowq_3/B 7.819878e-17
C2602 eeg_afe_pga_0/eeg_fd_ota_chopped_full2_0/eeg_fd_ota_core_soft_0/INP VSS 1.462840e-15
C2603 eeg_afe_pga_0/eeg_fd_ota_chopped_full2_0/eeg_fd_ota_core_soft_0/INP eeg_afe_pga_0/eeg_tg_lowq_3/B 1.492117e-15
C2604 eeg_afe_pga_0/eeg_tg_lowq_3/B VSS 2.430800e-15
C2605 PHIBI VDD18 1.564350e-16
C2606 PHIBI VSS 4.901000e-17
C2607 PHIBI eeg_afe_pga_0/eeg_fd_ota_chopped_full2_0/eeg_fd_ota_core_soft_0/INP 2.862080e-17
C2608 VDD18 VSS 1.561810e-15
C2609 VDD18 eeg_afe_pga_0/eeg_fd_ota_chopped_full2_0/eeg_fd_ota_core_soft_0/INP 1.697704e-16
C2610 eeg_afe_pga_0/eeg_fd_ota_chopped_full2_0/eeg_fd_ota_core_soft_0/INP VSS 8.867300e-17
C2611 NPHIBI VSS 2.062020e-16
C2612 NPHIBI eeg_afe_pga_0/eeg_tg_lowq_3/B 2.084120e-17
C2613 eeg_afe_pga_0/eeg_tg_lowq_3/B VSS 1.088312e-16
C2614 NPHIBI VSS 2.062020e-16
C2615 NPHIBI eeg_afe_pga_0/eeg_fd_ota_chopped_full2_0/eeg_fd_ota_core_soft_0/INP 2.084120e-17
C2616 eeg_afe_pga_0/eeg_fd_ota_chopped_full2_0/eeg_fd_ota_core_soft_0/INP VSS 1.088312e-16
C2617 NPHIBI VDD18 1.594600e-16
C2618 NPHIBI VSS 4.382640e-17
C2619 NPHIBI eeg_afe_pga_0/eeg_fd_ota_chopped_full2_0/eeg_fd_ota_core_soft_0/INP 2.402360e-17
C2620 NPHIBI eeg_afe_pga_0/eeg_tg_lowq_3/B 2.402360e-17
C2621 VDD18 VSS 2.327590e-15
C2622 VDD18 eeg_afe_pga_0/eeg_fd_ota_chopped_full2_0/eeg_fd_ota_core_soft_0/INP 1.554040e-16
C2623 VDD18 eeg_afe_pga_0/eeg_tg_lowq_3/B 1.554040e-16
C2624 eeg_afe_pga_0/eeg_fd_ota_chopped_full2_0/eeg_fd_ota_core_soft_0/INP VSS 7.837880e-17
C2625 eeg_afe_pga_0/eeg_fd_ota_chopped_full2_0/eeg_fd_ota_core_soft_0/INP eeg_afe_pga_0/eeg_tg_lowq_3/B 1.170160e-16
C2626 eeg_afe_pga_0/eeg_tg_lowq_3/B VSS 7.837880e-17
C2627 PHIBI VDD18 1.564350e-16
C2628 PHIBI VSS 4.901000e-17
C2629 PHIBI eeg_afe_pga_0/eeg_tg_lowq_3/B 2.862080e-17
C2630 VDD18 VSS 1.561810e-15
C2631 VDD18 eeg_afe_pga_0/eeg_tg_lowq_3/B 1.697704e-16
C2632 eeg_afe_pga_0/eeg_tg_lowq_3/B VSS 8.867300e-17
C2633 PHIBI VSS 2.027230e-16
C2636 eeg_afe_pga_0/eeg_fd_ota_chopped_full2_0/eeg_fd_ota_core_soft_0/INP VSS 1.267930e-16
C2637 eeg_afe_pga_0/eeg_fd_ota_chopped_full2_0/eeg_fd_ota_core_soft_0/INP eeg_afe_pga_0/eeg_tg_lowq_3/B 5.623600e-17
C2638 eeg_afe_pga_0/eeg_tg_lowq_3/B VSS 1.267930e-16
C2639 NPHIBI PHIBI 1.215812e-15
C2640 NPHIBI VDD18 5.262242e-16
C2641 NPHIBI VSS 2.537269e-15
C2642 NPHIBI eeg_afe_pga_0/eeg_fd_ota_chopped_full2_0/eeg_fd_ota_core_soft_0/INN 1.076105e-16
C2643 NPHIBI eeg_afe_pga_0/eeg_tg_lowq_7/B 4.755154e-17
C2644 PHIBI VDD18 6.588032e-16
C2645 PHIBI VSS 1.789951e-15
C2646 PHIBI eeg_afe_pga_0/eeg_fd_ota_chopped_full2_0/eeg_fd_ota_core_soft_0/INN 2.857784e-16
C2647 PHIBI eeg_afe_pga_0/eeg_tg_lowq_7/B 1.181323e-16
C2648 VDD18 VSS 3.714735e-15
C2649 VDD18 eeg_afe_pga_0/eeg_fd_ota_chopped_full2_0/eeg_fd_ota_core_soft_0/INN 3.128723e-16
C2650 VDD18 eeg_afe_pga_0/eeg_tg_lowq_7/B 1.484229e-16
C2651 VSS eeg_afe_pga_0/eeg_fd_ota_chopped_full2_0/eeg_fd_ota_core_soft_0/INN 1.097210e-16
C2652 VSS eeg_afe_pga_0/eeg_tg_lowq_7/B 7.819878e-17
C2653 eeg_afe_pga_0/eeg_fd_ota_chopped_full2_0/eeg_fd_ota_core_soft_0/INN VSS 1.462840e-15
C2654 eeg_afe_pga_0/eeg_fd_ota_chopped_full2_0/eeg_fd_ota_core_soft_0/INN eeg_afe_pga_0/eeg_tg_lowq_7/B 1.492117e-15
C2655 eeg_afe_pga_0/eeg_tg_lowq_7/B VSS 2.430800e-15
C2656 PHIBI VDD18 1.564350e-16
C2657 PHIBI VSS 4.901000e-17
C2658 PHIBI eeg_afe_pga_0/eeg_fd_ota_chopped_full2_0/eeg_fd_ota_core_soft_0/INN 2.862080e-17
C2659 VDD18 VSS 1.561810e-15
C2660 VDD18 eeg_afe_pga_0/eeg_fd_ota_chopped_full2_0/eeg_fd_ota_core_soft_0/INN 1.697704e-16
C2661 eeg_afe_pga_0/eeg_fd_ota_chopped_full2_0/eeg_fd_ota_core_soft_0/INN VSS 8.867300e-17
C2662 NPHIBI VSS 2.062020e-16
C2663 NPHIBI eeg_afe_pga_0/eeg_tg_lowq_7/B 2.084120e-17
C2664 eeg_afe_pga_0/eeg_tg_lowq_7/B VSS 1.088312e-16
C2665 NPHIBI VSS 2.062020e-16
C2666 NPHIBI eeg_afe_pga_0/eeg_fd_ota_chopped_full2_0/eeg_fd_ota_core_soft_0/INN 2.084120e-17
C2667 eeg_afe_pga_0/eeg_fd_ota_chopped_full2_0/eeg_fd_ota_core_soft_0/INN VSS 1.088312e-16
C2668 NPHIBI VDD18 1.594600e-16
C2669 NPHIBI VSS 4.382640e-17
C2670 NPHIBI eeg_afe_pga_0/eeg_fd_ota_chopped_full2_0/eeg_fd_ota_core_soft_0/INN 2.402360e-17
C2671 NPHIBI eeg_afe_pga_0/eeg_tg_lowq_7/B 2.402360e-17
C2672 VDD18 VSS 2.327590e-15
C2673 VDD18 eeg_afe_pga_0/eeg_fd_ota_chopped_full2_0/eeg_fd_ota_core_soft_0/INN 1.554040e-16
C2674 VDD18 eeg_afe_pga_0/eeg_tg_lowq_7/B 1.554040e-16
C2675 eeg_afe_pga_0/eeg_fd_ota_chopped_full2_0/eeg_fd_ota_core_soft_0/INN VSS 7.837880e-17
C2676 eeg_afe_pga_0/eeg_fd_ota_chopped_full2_0/eeg_fd_ota_core_soft_0/INN eeg_afe_pga_0/eeg_tg_lowq_7/B 1.170160e-16
C2677 eeg_afe_pga_0/eeg_tg_lowq_7/B VSS 7.837880e-17
C2678 PHIBI VDD18 1.564350e-16
C2679 PHIBI VSS 4.901000e-17
C2680 PHIBI eeg_afe_pga_0/eeg_tg_lowq_7/B 2.862080e-17
C2681 VDD18 VSS 1.561810e-15
C2682 VDD18 eeg_afe_pga_0/eeg_tg_lowq_7/B 1.697704e-16
C2683 eeg_afe_pga_0/eeg_tg_lowq_7/B VSS 8.867300e-17
C2684 PHIBI VSS 2.027230e-16
C2687 eeg_afe_pga_0/eeg_fd_ota_chopped_full2_0/eeg_fd_ota_core_soft_0/INN VSS 1.267930e-16
C2688 eeg_afe_pga_0/eeg_fd_ota_chopped_full2_0/eeg_fd_ota_core_soft_0/INN eeg_afe_pga_0/eeg_tg_lowq_7/B 5.623600e-17
C2689 eeg_afe_pga_0/eeg_tg_lowq_7/B VSS 1.267930e-16
C2690 NPHII PHII 1.215812e-15
C2691 NPHII VDD18 5.262242e-16
C2692 NPHII VSS 2.537269e-15
C2693 NPHII eeg_afe_pga_0/eeg_fd_ota_chopped_full2_0/eeg_fd_ota_core_soft_0/INN 1.076105e-16
C2694 NPHII eeg_afe_pga_0/eeg_tg_lowq_3/B 4.755154e-17
C2695 PHII VDD18 6.588032e-16
C2696 PHII VSS 1.789951e-15
C2697 PHII eeg_afe_pga_0/eeg_fd_ota_chopped_full2_0/eeg_fd_ota_core_soft_0/INN 2.857784e-16
C2698 PHII eeg_afe_pga_0/eeg_tg_lowq_3/B 1.181323e-16
C2699 VDD18 VSS 3.714735e-15
C2700 VDD18 eeg_afe_pga_0/eeg_fd_ota_chopped_full2_0/eeg_fd_ota_core_soft_0/INN 3.128723e-16
C2701 VDD18 eeg_afe_pga_0/eeg_tg_lowq_3/B 1.484229e-16
C2702 VSS eeg_afe_pga_0/eeg_fd_ota_chopped_full2_0/eeg_fd_ota_core_soft_0/INN 1.097210e-16
C2703 VSS eeg_afe_pga_0/eeg_tg_lowq_3/B 7.819878e-17
C2704 eeg_afe_pga_0/eeg_fd_ota_chopped_full2_0/eeg_fd_ota_core_soft_0/INN VSS 1.462840e-15
C2705 eeg_afe_pga_0/eeg_fd_ota_chopped_full2_0/eeg_fd_ota_core_soft_0/INN eeg_afe_pga_0/eeg_tg_lowq_3/B 1.492117e-15
C2706 eeg_afe_pga_0/eeg_tg_lowq_3/B VSS 2.430800e-15
C2707 PHII VDD18 1.564350e-16
C2708 PHII VSS 4.901000e-17
C2709 PHII eeg_afe_pga_0/eeg_fd_ota_chopped_full2_0/eeg_fd_ota_core_soft_0/INN 2.862080e-17
C2710 VDD18 VSS 1.561810e-15
C2711 VDD18 eeg_afe_pga_0/eeg_fd_ota_chopped_full2_0/eeg_fd_ota_core_soft_0/INN 1.697704e-16
C2712 eeg_afe_pga_0/eeg_fd_ota_chopped_full2_0/eeg_fd_ota_core_soft_0/INN VSS 8.867300e-17
C2713 NPHII VSS 2.062020e-16
C2714 NPHII eeg_afe_pga_0/eeg_tg_lowq_3/B 2.084120e-17
C2715 eeg_afe_pga_0/eeg_tg_lowq_3/B VSS 1.088312e-16
C2716 NPHII VSS 2.062020e-16
C2717 NPHII eeg_afe_pga_0/eeg_fd_ota_chopped_full2_0/eeg_fd_ota_core_soft_0/INN 2.084120e-17
C2718 eeg_afe_pga_0/eeg_fd_ota_chopped_full2_0/eeg_fd_ota_core_soft_0/INN VSS 1.088312e-16
C2719 NPHII VDD18 1.594600e-16
C2720 NPHII VSS 4.382640e-17
C2721 NPHII eeg_afe_pga_0/eeg_fd_ota_chopped_full2_0/eeg_fd_ota_core_soft_0/INN 2.402360e-17
C2722 NPHII eeg_afe_pga_0/eeg_tg_lowq_3/B 2.402360e-17
C2723 VDD18 VSS 2.327590e-15
C2724 VDD18 eeg_afe_pga_0/eeg_fd_ota_chopped_full2_0/eeg_fd_ota_core_soft_0/INN 1.554040e-16
C2725 VDD18 eeg_afe_pga_0/eeg_tg_lowq_3/B 1.554040e-16
C2726 eeg_afe_pga_0/eeg_fd_ota_chopped_full2_0/eeg_fd_ota_core_soft_0/INN VSS 7.837880e-17
C2727 eeg_afe_pga_0/eeg_fd_ota_chopped_full2_0/eeg_fd_ota_core_soft_0/INN eeg_afe_pga_0/eeg_tg_lowq_3/B 1.170160e-16
C2728 eeg_afe_pga_0/eeg_tg_lowq_3/B VSS 7.837880e-17
C2729 PHII VDD18 1.564350e-16
C2730 PHII VSS 4.901000e-17
C2731 PHII eeg_afe_pga_0/eeg_tg_lowq_3/B 2.862080e-17
C2732 VDD18 VSS 1.561810e-15
C2733 VDD18 eeg_afe_pga_0/eeg_tg_lowq_3/B 1.697704e-16
C2734 eeg_afe_pga_0/eeg_tg_lowq_3/B VSS 8.867300e-17
C2735 PHII VSS 2.027230e-16
C2738 eeg_afe_pga_0/eeg_fd_ota_chopped_full2_0/eeg_fd_ota_core_soft_0/INN VSS 1.267930e-16
C2739 eeg_afe_pga_0/eeg_fd_ota_chopped_full2_0/eeg_fd_ota_core_soft_0/INN eeg_afe_pga_0/eeg_tg_lowq_3/B 5.623600e-17
C2740 eeg_afe_pga_0/eeg_tg_lowq_3/B VSS 1.267930e-16
C2741 NPHII PHII 1.215812e-15
C2742 NPHII VDD18 5.262242e-16
C2743 NPHII VSS 2.537269e-15
C2744 NPHII eeg_afe_pga_0/eeg_fd_ota_chopped_full2_0/eeg_fd_ota_core_soft_0/INP 1.076105e-16
C2745 NPHII eeg_afe_pga_0/eeg_tg_lowq_7/B 4.755154e-17
C2746 PHII VDD18 6.588032e-16
C2747 PHII VSS 1.789951e-15
C2748 PHII eeg_afe_pga_0/eeg_fd_ota_chopped_full2_0/eeg_fd_ota_core_soft_0/INP 2.857784e-16
C2749 PHII eeg_afe_pga_0/eeg_tg_lowq_7/B 1.181323e-16
C2750 VDD18 VSS 3.714735e-15
C2751 VDD18 eeg_afe_pga_0/eeg_fd_ota_chopped_full2_0/eeg_fd_ota_core_soft_0/INP 3.128723e-16
C2752 VDD18 eeg_afe_pga_0/eeg_tg_lowq_7/B 1.484229e-16
C2753 VSS eeg_afe_pga_0/eeg_fd_ota_chopped_full2_0/eeg_fd_ota_core_soft_0/INP 1.097210e-16
C2754 VSS eeg_afe_pga_0/eeg_tg_lowq_7/B 7.819878e-17
C2755 eeg_afe_pga_0/eeg_fd_ota_chopped_full2_0/eeg_fd_ota_core_soft_0/INP VSS 1.462840e-15
C2756 eeg_afe_pga_0/eeg_fd_ota_chopped_full2_0/eeg_fd_ota_core_soft_0/INP eeg_afe_pga_0/eeg_tg_lowq_7/B 1.492117e-15
C2757 eeg_afe_pga_0/eeg_tg_lowq_7/B VSS 2.430800e-15
C2758 PHII VDD18 1.564350e-16
C2759 PHII VSS 4.901000e-17
C2760 PHII eeg_afe_pga_0/eeg_fd_ota_chopped_full2_0/eeg_fd_ota_core_soft_0/INP 2.862080e-17
C2761 VDD18 VSS 1.561810e-15
C2762 VDD18 eeg_afe_pga_0/eeg_fd_ota_chopped_full2_0/eeg_fd_ota_core_soft_0/INP 1.697704e-16
C2763 eeg_afe_pga_0/eeg_fd_ota_chopped_full2_0/eeg_fd_ota_core_soft_0/INP VSS 8.867300e-17
C2764 NPHII VSS 2.062020e-16
C2765 NPHII eeg_afe_pga_0/eeg_tg_lowq_7/B 2.084120e-17
C2766 eeg_afe_pga_0/eeg_tg_lowq_7/B VSS 1.088312e-16
C2767 NPHII VSS 2.062020e-16
C2768 NPHII eeg_afe_pga_0/eeg_fd_ota_chopped_full2_0/eeg_fd_ota_core_soft_0/INP 2.084120e-17
C2769 eeg_afe_pga_0/eeg_fd_ota_chopped_full2_0/eeg_fd_ota_core_soft_0/INP VSS 1.088312e-16
C2770 NPHII VDD18 1.594600e-16
C2771 NPHII VSS 4.382640e-17
C2772 NPHII eeg_afe_pga_0/eeg_fd_ota_chopped_full2_0/eeg_fd_ota_core_soft_0/INP 2.402360e-17
C2773 NPHII eeg_afe_pga_0/eeg_tg_lowq_7/B 2.402360e-17
C2774 VDD18 VSS 2.327590e-15
C2775 VDD18 eeg_afe_pga_0/eeg_fd_ota_chopped_full2_0/eeg_fd_ota_core_soft_0/INP 1.554040e-16
C2776 VDD18 eeg_afe_pga_0/eeg_tg_lowq_7/B 1.554040e-16
C2777 eeg_afe_pga_0/eeg_fd_ota_chopped_full2_0/eeg_fd_ota_core_soft_0/INP VSS 7.837880e-17
C2778 eeg_afe_pga_0/eeg_fd_ota_chopped_full2_0/eeg_fd_ota_core_soft_0/INP eeg_afe_pga_0/eeg_tg_lowq_7/B 1.170160e-16
C2779 eeg_afe_pga_0/eeg_tg_lowq_7/B VSS 7.837880e-17
C2780 PHII VDD18 1.564350e-16
C2781 PHII VSS 4.901000e-17
C2782 PHII eeg_afe_pga_0/eeg_tg_lowq_7/B 2.862080e-17
C2783 VDD18 VSS 1.561810e-15
C2784 VDD18 eeg_afe_pga_0/eeg_tg_lowq_7/B 1.697704e-16
C2785 eeg_afe_pga_0/eeg_tg_lowq_7/B VSS 8.867300e-17
C2786 PHII VSS 2.027230e-16
C2789 eeg_afe_pga_0/eeg_fd_ota_chopped_full2_0/eeg_fd_ota_core_soft_0/INP VSS 1.267930e-16
C2790 eeg_afe_pga_0/eeg_fd_ota_chopped_full2_0/eeg_fd_ota_core_soft_0/INP eeg_afe_pga_0/eeg_tg_lowq_7/B 5.623600e-17
C2791 eeg_afe_pga_0/eeg_tg_lowq_7/B VSS 1.267930e-16
C2792 VCM_REF VDD18 2.703258e-17
C2793 VCM_REF VSS 3.540900e-14
C2795 VCM_REF eeg_afe_pga_0/eeg_fd_ota_chopped_full2_0/eeg_cmfb_amp_dl2_0/VCM_SENSE 1.587590e-14
C2798 VCM_REF eeg_afe_pga_0/eeg_fd_ota_chopped_full2_0/eeg_fd_ota_core_soft_0/m1_51141_3443# 7.672760e-17
C2800 VCM_REF eeg_afe_pga_0/eeg_fd_ota_chopped_full2_0/eeg_fd_ota_core_soft_0/m1_n51659_3443# 7.672760e-17
C2802 VDD18 VSS 1.621650e-14
C2803 VDD18 eeg_afe_pga_0/eeg_fd_ota_chopped_full2_0/eeg_cmfb_amp_dl2_0/VBP 3.427693e-15
C2804 VDD18 eeg_afe_pga_0/eeg_fd_ota_chopped_full2_0/eeg_cmfb_amp_dl2_0/VCM_SENSE 4.825121e-15
C2805 VDD18 eeg_afe_pga_0/eeg_fd_ota_chopped_full2_0/eeg_fd_ota_core_soft_0/INN 2.563693e-17
C2806 VDD18 eeg_afe_pga_0/eeg_fd_ota_chopped_full2_0/eeg_fd_ota_core_soft_0/INP 2.022347e-16
C2807 VDD18 eeg_afe_pga_0/eeg_fd_ota_chopped_full2_0/eeg_fd_ota_core_soft_0/OUTN 2.666394e-16
C2808 VDD18 eeg_afe_pga_0/eeg_fd_ota_chopped_full2_0/eeg_fd_ota_core_soft_0/OUTP 2.827840e-16
C2809 VSS eeg_afe_pga_0/eeg_fd_ota_chopped_full2_0/eeg_bias_gen_0/VBNF 3.521512e-15
C2810 VSS eeg_afe_pga_0/eeg_fd_ota_chopped_full2_0/eeg_fd_ota_core_soft_0/INN 1.319906e-14
C2811 VSS eeg_afe_pga_0/eeg_fd_ota_chopped_full2_0/eeg_fd_ota_core_soft_0/INP 2.891675e-15
C2812 VSS eeg_afe_pga_0/eeg_fd_ota_chopped_full2_0/eeg_fd_ota_core_soft_0/OUTN 1.737419e-15
C2813 VSS eeg_afe_pga_0/eeg_fd_ota_chopped_full2_0/eeg_fd_ota_core_soft_0/OUTP 8.481620e-16
C2814 VSS eeg_afe_pga_0/eeg_fd_ota_chopped_full2_0/eeg_fd_ota_core_soft_0/m1_n22658_111# 2.612991e-14
C2815 eeg_afe_pga_0/eeg_fd_ota_chopped_full2_0/eeg_bias_gen_0/VBNF VSS 6.189670e-15
C2816 eeg_afe_pga_0/eeg_fd_ota_chopped_full2_0/eeg_bias_gen_0/VBNF eeg_afe_pga_0/eeg_fd_ota_chopped_full2_0/eeg_fd_ota_core_soft_0/INN 6.911931e-17
C2817 eeg_afe_pga_0/eeg_fd_ota_chopped_full2_0/eeg_bias_gen_0/VBNF eeg_afe_pga_0/eeg_fd_ota_chopped_full2_0/eeg_fd_ota_core_soft_0/INP 6.042561e-17
C2818 eeg_afe_pga_0/eeg_fd_ota_chopped_full2_0/eeg_bias_gen_0/VBNF eeg_afe_pga_0/eeg_fd_ota_chopped_full2_0/eeg_fd_ota_core_soft_0/m1_n22658_111# 6.839995e-16
C2819 eeg_afe_pga_0/eeg_fd_ota_chopped_full2_0/eeg_cmfb_amp_dl2_0/VBP VSS 1.400120e-14
C2821 eeg_afe_pga_0/eeg_fd_ota_chopped_full2_0/eeg_cmfb_amp_dl2_0/VBP eeg_afe_pga_0/eeg_fd_ota_chopped_full2_0/eeg_fd_ota_core_soft_0/INN 6.164535e-17
C2822 eeg_afe_pga_0/eeg_fd_ota_chopped_full2_0/eeg_cmfb_amp_dl2_0/VBP eeg_afe_pga_0/eeg_fd_ota_chopped_full2_0/eeg_fd_ota_core_soft_0/INP 6.844558e-16
C2823 eeg_afe_pga_0/eeg_fd_ota_chopped_full2_0/eeg_cmfb_amp_dl2_0/VBP eeg_afe_pga_0/eeg_fd_ota_chopped_full2_0/eeg_fd_ota_core_soft_0/OUTN 7.668368e-16
C2824 eeg_afe_pga_0/eeg_fd_ota_chopped_full2_0/eeg_cmfb_amp_dl2_0/VBP eeg_afe_pga_0/eeg_fd_ota_chopped_full2_0/eeg_fd_ota_core_soft_0/OUTP 7.875883e-16
C2825 eeg_afe_pga_0/eeg_fd_ota_chopped_full2_0/eeg_cmfb_amp_dl2_0/VCM_SENSE VSS 2.834530e-14
C2828 eeg_afe_pga_0/eeg_fd_ota_chopped_full2_0/eeg_cmfb_amp_dl2_0/VCM_SENSE eeg_afe_pga_0/eeg_fd_ota_chopped_full2_0/eeg_fd_ota_core_soft_0/m1_28741_3443# 7.672760e-17
C2830 eeg_afe_pga_0/eeg_fd_ota_chopped_full2_0/eeg_cmfb_amp_dl2_0/VCM_SENSE eeg_afe_pga_0/eeg_fd_ota_chopped_full2_0/eeg_fd_ota_core_soft_0/m1_n29259_3443# 7.672760e-17
C2832 eeg_afe_pga_0/eeg_fd_ota_chopped_full2_0/eeg_fd_ota_core_soft_0/INN VSS 1.448180e-14
C2833 eeg_afe_pga_0/eeg_fd_ota_chopped_full2_0/eeg_fd_ota_core_soft_0/INN eeg_afe_pga_0/eeg_fd_ota_chopped_full2_0/eeg_fd_ota_core_soft_0/INP 2.623505e-14
C2834 eeg_afe_pga_0/eeg_fd_ota_chopped_full2_0/eeg_fd_ota_core_soft_0/INN eeg_afe_pga_0/eeg_fd_ota_chopped_full2_0/eeg_fd_ota_core_soft_0/OUTN 7.379468e-15
C2835 eeg_afe_pga_0/eeg_fd_ota_chopped_full2_0/eeg_fd_ota_core_soft_0/INN eeg_afe_pga_0/eeg_fd_ota_chopped_full2_0/eeg_fd_ota_core_soft_0/OUTP 1.018187e-14
C2836 eeg_afe_pga_0/eeg_fd_ota_chopped_full2_0/eeg_fd_ota_core_soft_0/INN eeg_afe_pga_0/eeg_fd_ota_chopped_full2_0/eeg_fd_ota_core_soft_0/m1_n22658_111# 4.063561e-15
C2837 eeg_afe_pga_0/eeg_fd_ota_chopped_full2_0/eeg_fd_ota_core_soft_0/INP VSS 3.261730e-14
C2838 eeg_afe_pga_0/eeg_fd_ota_chopped_full2_0/eeg_fd_ota_core_soft_0/INP eeg_afe_pga_0/eeg_fd_ota_chopped_full2_0/eeg_fd_ota_core_soft_0/OUTN 6.641364e-15
C2839 eeg_afe_pga_0/eeg_fd_ota_chopped_full2_0/eeg_fd_ota_core_soft_0/INP eeg_afe_pga_0/eeg_fd_ota_chopped_full2_0/eeg_fd_ota_core_soft_0/OUTP 3.395166e-15
C2840 eeg_afe_pga_0/eeg_fd_ota_chopped_full2_0/eeg_fd_ota_core_soft_0/INP eeg_afe_pga_0/eeg_fd_ota_chopped_full2_0/eeg_fd_ota_core_soft_0/m1_n22658_111# 4.388117e-15
C2841 eeg_afe_pga_0/eeg_fd_ota_chopped_full2_0/eeg_fd_ota_core_soft_0/OUTN VSS 3.542310e-14
C2842 eeg_afe_pga_0/eeg_fd_ota_chopped_full2_0/eeg_fd_ota_core_soft_0/OUTN eeg_afe_pga_0/eeg_fd_ota_chopped_full2_0/eeg_fd_ota_core_soft_0/OUTP 9.928293e-15
C2866 eeg_afe_pga_0/eeg_fd_ota_chopped_full2_0/eeg_fd_ota_core_soft_0/OUTN eeg_afe_pga_0/eeg_fd_ota_chopped_full2_0/eeg_fd_ota_core_soft_0/m1_47141_3443# 9.923910e-17
C2875 eeg_afe_pga_0/eeg_fd_ota_chopped_full2_0/eeg_fd_ota_core_soft_0/OUTN eeg_afe_pga_0/eeg_fd_ota_chopped_full2_0/eeg_fd_ota_core_soft_0/m1_57541_3443# 9.923911e-17
C2876 eeg_afe_pga_0/eeg_fd_ota_chopped_full2_0/eeg_fd_ota_core_soft_0/OUTN eeg_afe_pga_0/eeg_fd_ota_chopped_full2_0/eeg_fd_ota_core_soft_0/m1_n22658_111# 3.475590e-16
C2877 eeg_afe_pga_0/eeg_fd_ota_chopped_full2_0/eeg_fd_ota_core_soft_0/OUTP VSS 2.763250e-14
C2878 eeg_afe_pga_0/eeg_fd_ota_chopped_full2_0/eeg_fd_ota_core_soft_0/OUTP eeg_afe_pga_0/eeg_fd_ota_chopped_full2_0/eeg_fd_ota_core_soft_0/m1_n22658_111# 5.910065e-17
C2902 eeg_afe_pga_0/eeg_fd_ota_chopped_full2_0/eeg_fd_ota_core_soft_0/OUTP eeg_afe_pga_0/eeg_fd_ota_chopped_full2_0/eeg_fd_ota_core_soft_0/m1_n47659_3443# 1.052830e-16
C2911 eeg_afe_pga_0/eeg_fd_ota_chopped_full2_0/eeg_fd_ota_core_soft_0/OUTP eeg_afe_pga_0/eeg_fd_ota_chopped_full2_0/eeg_fd_ota_core_soft_0/m1_n58059_3443# 1.052831e-16
C2912 eeg_afe_pga_0/eeg_fd_ota_chopped_full2_0/eeg_fd_ota_core_soft_0/m1_28341_n3864# VSS 4.702790e-16
C2913 eeg_afe_pga_0/eeg_fd_ota_chopped_full2_0/eeg_fd_ota_core_soft_0/m1_28341_n3864# eeg_afe_pga_0/eeg_fd_ota_chopped_full2_0/eeg_fd_ota_core_soft_0/m1_29141_n3864# 6.789050e-17
C2914 eeg_afe_pga_0/eeg_fd_ota_chopped_full2_0/eeg_fd_ota_core_soft_0/m1_28741_3443# VSS 4.622480e-16
C2915 eeg_afe_pga_0/eeg_fd_ota_chopped_full2_0/eeg_fd_ota_core_soft_0/m1_28741_3443# eeg_afe_pga_0/eeg_fd_ota_chopped_full2_0/eeg_fd_ota_core_soft_0/m1_29541_3443# 6.789050e-17
C2916 eeg_afe_pga_0/eeg_fd_ota_chopped_full2_0/eeg_fd_ota_core_soft_0/m1_29141_n3864# VSS 4.190540e-16
C2917 eeg_afe_pga_0/eeg_fd_ota_chopped_full2_0/eeg_fd_ota_core_soft_0/m1_29141_n3864# eeg_afe_pga_0/eeg_fd_ota_chopped_full2_0/eeg_fd_ota_core_soft_0/m1_29941_n3864# 6.789040e-17
C2918 eeg_afe_pga_0/eeg_fd_ota_chopped_full2_0/eeg_fd_ota_core_soft_0/m1_29541_3443# VSS 4.190540e-16
C2919 eeg_afe_pga_0/eeg_fd_ota_chopped_full2_0/eeg_fd_ota_core_soft_0/m1_29541_3443# eeg_afe_pga_0/eeg_fd_ota_chopped_full2_0/eeg_fd_ota_core_soft_0/m1_30341_3443# 6.789050e-17
C2920 eeg_afe_pga_0/eeg_fd_ota_chopped_full2_0/eeg_fd_ota_core_soft_0/m1_29941_n3864# VSS 4.190540e-16
C2921 eeg_afe_pga_0/eeg_fd_ota_chopped_full2_0/eeg_fd_ota_core_soft_0/m1_29941_n3864# eeg_afe_pga_0/eeg_fd_ota_chopped_full2_0/eeg_fd_ota_core_soft_0/m1_30741_n3864# 6.789050e-17
C2922 eeg_afe_pga_0/eeg_fd_ota_chopped_full2_0/eeg_fd_ota_core_soft_0/m1_30341_3443# VSS 4.190540e-16
C2923 eeg_afe_pga_0/eeg_fd_ota_chopped_full2_0/eeg_fd_ota_core_soft_0/m1_30341_3443# eeg_afe_pga_0/eeg_fd_ota_chopped_full2_0/eeg_fd_ota_core_soft_0/m1_31141_3443# 6.789050e-17
C2924 eeg_afe_pga_0/eeg_fd_ota_chopped_full2_0/eeg_fd_ota_core_soft_0/m1_30741_n3864# VSS 4.190540e-16
C2925 eeg_afe_pga_0/eeg_fd_ota_chopped_full2_0/eeg_fd_ota_core_soft_0/m1_30741_n3864# eeg_afe_pga_0/eeg_fd_ota_chopped_full2_0/eeg_fd_ota_core_soft_0/m1_31541_n3864# 6.789040e-17
C2926 eeg_afe_pga_0/eeg_fd_ota_chopped_full2_0/eeg_fd_ota_core_soft_0/m1_31141_3443# VSS 4.190540e-16
C2927 eeg_afe_pga_0/eeg_fd_ota_chopped_full2_0/eeg_fd_ota_core_soft_0/m1_31141_3443# eeg_afe_pga_0/eeg_fd_ota_chopped_full2_0/eeg_fd_ota_core_soft_0/m1_31941_3443# 6.789050e-17
C2928 eeg_afe_pga_0/eeg_fd_ota_chopped_full2_0/eeg_fd_ota_core_soft_0/m1_31541_n3864# VSS 4.190540e-16
C2929 eeg_afe_pga_0/eeg_fd_ota_chopped_full2_0/eeg_fd_ota_core_soft_0/m1_31541_n3864# eeg_afe_pga_0/eeg_fd_ota_chopped_full2_0/eeg_fd_ota_core_soft_0/m1_32341_n3864# 6.789050e-17
C2930 eeg_afe_pga_0/eeg_fd_ota_chopped_full2_0/eeg_fd_ota_core_soft_0/m1_31941_3443# VSS 4.190540e-16
C2931 eeg_afe_pga_0/eeg_fd_ota_chopped_full2_0/eeg_fd_ota_core_soft_0/m1_31941_3443# eeg_afe_pga_0/eeg_fd_ota_chopped_full2_0/eeg_fd_ota_core_soft_0/m1_32741_3443# 6.789040e-17
C2932 eeg_afe_pga_0/eeg_fd_ota_chopped_full2_0/eeg_fd_ota_core_soft_0/m1_32341_n3864# VSS 4.190540e-16
C2933 eeg_afe_pga_0/eeg_fd_ota_chopped_full2_0/eeg_fd_ota_core_soft_0/m1_32341_n3864# eeg_afe_pga_0/eeg_fd_ota_chopped_full2_0/eeg_fd_ota_core_soft_0/m1_33141_n3864# 6.789050e-17
C2934 eeg_afe_pga_0/eeg_fd_ota_chopped_full2_0/eeg_fd_ota_core_soft_0/m1_32741_3443# VSS 4.190540e-16
C2935 eeg_afe_pga_0/eeg_fd_ota_chopped_full2_0/eeg_fd_ota_core_soft_0/m1_32741_3443# eeg_afe_pga_0/eeg_fd_ota_chopped_full2_0/eeg_fd_ota_core_soft_0/m1_33541_3443# 6.789050e-17
C2936 eeg_afe_pga_0/eeg_fd_ota_chopped_full2_0/eeg_fd_ota_core_soft_0/m1_33141_n3864# VSS 4.190540e-16
C2937 eeg_afe_pga_0/eeg_fd_ota_chopped_full2_0/eeg_fd_ota_core_soft_0/m1_33141_n3864# eeg_afe_pga_0/eeg_fd_ota_chopped_full2_0/eeg_fd_ota_core_soft_0/m1_33941_n3864# 6.789050e-17
C2938 eeg_afe_pga_0/eeg_fd_ota_chopped_full2_0/eeg_fd_ota_core_soft_0/m1_33541_3443# VSS 4.190540e-16
C2939 eeg_afe_pga_0/eeg_fd_ota_chopped_full2_0/eeg_fd_ota_core_soft_0/m1_33541_3443# eeg_afe_pga_0/eeg_fd_ota_chopped_full2_0/eeg_fd_ota_core_soft_0/m1_34341_3443# 6.789040e-17
C2940 eeg_afe_pga_0/eeg_fd_ota_chopped_full2_0/eeg_fd_ota_core_soft_0/m1_33941_n3864# VSS 4.190540e-16
C2941 eeg_afe_pga_0/eeg_fd_ota_chopped_full2_0/eeg_fd_ota_core_soft_0/m1_33941_n3864# eeg_afe_pga_0/eeg_fd_ota_chopped_full2_0/eeg_fd_ota_core_soft_0/m1_34741_n3864# 6.789050e-17
C2942 eeg_afe_pga_0/eeg_fd_ota_chopped_full2_0/eeg_fd_ota_core_soft_0/m1_34341_3443# VSS 4.190540e-16
C2943 eeg_afe_pga_0/eeg_fd_ota_chopped_full2_0/eeg_fd_ota_core_soft_0/m1_34341_3443# eeg_afe_pga_0/eeg_fd_ota_chopped_full2_0/eeg_fd_ota_core_soft_0/m1_35141_3443# 6.789050e-17
C2944 eeg_afe_pga_0/eeg_fd_ota_chopped_full2_0/eeg_fd_ota_core_soft_0/m1_34741_n3864# VSS 4.190540e-16
C2945 eeg_afe_pga_0/eeg_fd_ota_chopped_full2_0/eeg_fd_ota_core_soft_0/m1_34741_n3864# eeg_afe_pga_0/eeg_fd_ota_chopped_full2_0/eeg_fd_ota_core_soft_0/m1_35541_n3864# 6.789040e-17
C2946 eeg_afe_pga_0/eeg_fd_ota_chopped_full2_0/eeg_fd_ota_core_soft_0/m1_35141_3443# VSS 4.190540e-16
C2947 eeg_afe_pga_0/eeg_fd_ota_chopped_full2_0/eeg_fd_ota_core_soft_0/m1_35141_3443# eeg_afe_pga_0/eeg_fd_ota_chopped_full2_0/eeg_fd_ota_core_soft_0/m1_35941_3443# 6.789050e-17
C2948 eeg_afe_pga_0/eeg_fd_ota_chopped_full2_0/eeg_fd_ota_core_soft_0/m1_35541_n3864# VSS 4.190540e-16
C2949 eeg_afe_pga_0/eeg_fd_ota_chopped_full2_0/eeg_fd_ota_core_soft_0/m1_35541_n3864# eeg_afe_pga_0/eeg_fd_ota_chopped_full2_0/eeg_fd_ota_core_soft_0/m1_36341_n3864# 6.789050e-17
C2950 eeg_afe_pga_0/eeg_fd_ota_chopped_full2_0/eeg_fd_ota_core_soft_0/m1_35941_3443# VSS 4.190540e-16
C2951 eeg_afe_pga_0/eeg_fd_ota_chopped_full2_0/eeg_fd_ota_core_soft_0/m1_35941_3443# eeg_afe_pga_0/eeg_fd_ota_chopped_full2_0/eeg_fd_ota_core_soft_0/m1_36741_3443# 6.789050e-17
C2952 eeg_afe_pga_0/eeg_fd_ota_chopped_full2_0/eeg_fd_ota_core_soft_0/m1_36341_n3864# VSS 4.190540e-16
C2953 eeg_afe_pga_0/eeg_fd_ota_chopped_full2_0/eeg_fd_ota_core_soft_0/m1_36341_n3864# eeg_afe_pga_0/eeg_fd_ota_chopped_full2_0/eeg_fd_ota_core_soft_0/m1_37141_n3864# 6.789040e-17
C2954 eeg_afe_pga_0/eeg_fd_ota_chopped_full2_0/eeg_fd_ota_core_soft_0/m1_36741_3443# VSS 4.190540e-16
C2955 eeg_afe_pga_0/eeg_fd_ota_chopped_full2_0/eeg_fd_ota_core_soft_0/m1_36741_3443# eeg_afe_pga_0/eeg_fd_ota_chopped_full2_0/eeg_fd_ota_core_soft_0/m1_37541_3443# 6.789050e-17
C2956 eeg_afe_pga_0/eeg_fd_ota_chopped_full2_0/eeg_fd_ota_core_soft_0/m1_37141_n3864# VSS 4.190540e-16
C2957 eeg_afe_pga_0/eeg_fd_ota_chopped_full2_0/eeg_fd_ota_core_soft_0/m1_37141_n3864# eeg_afe_pga_0/eeg_fd_ota_chopped_full2_0/eeg_fd_ota_core_soft_0/m1_37941_n3864# 6.789050e-17
C2958 eeg_afe_pga_0/eeg_fd_ota_chopped_full2_0/eeg_fd_ota_core_soft_0/m1_37541_3443# VSS 4.190540e-16
C2959 eeg_afe_pga_0/eeg_fd_ota_chopped_full2_0/eeg_fd_ota_core_soft_0/m1_37541_3443# eeg_afe_pga_0/eeg_fd_ota_chopped_full2_0/eeg_fd_ota_core_soft_0/m1_38341_3443# 6.789040e-17
C2960 eeg_afe_pga_0/eeg_fd_ota_chopped_full2_0/eeg_fd_ota_core_soft_0/m1_37941_n3864# VSS 4.190540e-16
C2961 eeg_afe_pga_0/eeg_fd_ota_chopped_full2_0/eeg_fd_ota_core_soft_0/m1_37941_n3864# eeg_afe_pga_0/eeg_fd_ota_chopped_full2_0/eeg_fd_ota_core_soft_0/m1_38741_n3864# 6.789050e-17
C2962 eeg_afe_pga_0/eeg_fd_ota_chopped_full2_0/eeg_fd_ota_core_soft_0/m1_38341_3443# VSS 4.190540e-16
C2963 eeg_afe_pga_0/eeg_fd_ota_chopped_full2_0/eeg_fd_ota_core_soft_0/m1_38341_3443# eeg_afe_pga_0/eeg_fd_ota_chopped_full2_0/eeg_fd_ota_core_soft_0/m1_39141_3443# 6.789050e-17
C2964 eeg_afe_pga_0/eeg_fd_ota_chopped_full2_0/eeg_fd_ota_core_soft_0/m1_38741_n3864# VSS 4.190540e-16
C2965 eeg_afe_pga_0/eeg_fd_ota_chopped_full2_0/eeg_fd_ota_core_soft_0/m1_38741_n3864# eeg_afe_pga_0/eeg_fd_ota_chopped_full2_0/eeg_fd_ota_core_soft_0/m1_39541_n3864# 6.789050e-17
C2966 eeg_afe_pga_0/eeg_fd_ota_chopped_full2_0/eeg_fd_ota_core_soft_0/m1_39141_3443# VSS 4.190540e-16
C2967 eeg_afe_pga_0/eeg_fd_ota_chopped_full2_0/eeg_fd_ota_core_soft_0/m1_39141_3443# eeg_afe_pga_0/eeg_fd_ota_chopped_full2_0/eeg_fd_ota_core_soft_0/m1_39941_3443# 6.789040e-17
C2968 eeg_afe_pga_0/eeg_fd_ota_chopped_full2_0/eeg_fd_ota_core_soft_0/m1_39541_n3864# VSS 4.190540e-16
C2969 eeg_afe_pga_0/eeg_fd_ota_chopped_full2_0/eeg_fd_ota_core_soft_0/m1_39541_n3864# eeg_afe_pga_0/eeg_fd_ota_chopped_full2_0/eeg_fd_ota_core_soft_0/m1_40341_n3864# 6.789050e-17
C2970 eeg_afe_pga_0/eeg_fd_ota_chopped_full2_0/eeg_fd_ota_core_soft_0/m1_39941_3443# VSS 4.190540e-16
C2971 eeg_afe_pga_0/eeg_fd_ota_chopped_full2_0/eeg_fd_ota_core_soft_0/m1_39941_3443# eeg_afe_pga_0/eeg_fd_ota_chopped_full2_0/eeg_fd_ota_core_soft_0/m1_40741_3443# 6.789050e-17
C2972 eeg_afe_pga_0/eeg_fd_ota_chopped_full2_0/eeg_fd_ota_core_soft_0/m1_40341_n3864# VSS 4.190540e-16
C2973 eeg_afe_pga_0/eeg_fd_ota_chopped_full2_0/eeg_fd_ota_core_soft_0/m1_40341_n3864# eeg_afe_pga_0/eeg_fd_ota_chopped_full2_0/eeg_fd_ota_core_soft_0/m1_41141_n3864# 6.789040e-17
C2974 eeg_afe_pga_0/eeg_fd_ota_chopped_full2_0/eeg_fd_ota_core_soft_0/m1_40741_3443# VSS 4.190540e-16
C2975 eeg_afe_pga_0/eeg_fd_ota_chopped_full2_0/eeg_fd_ota_core_soft_0/m1_40741_3443# eeg_afe_pga_0/eeg_fd_ota_chopped_full2_0/eeg_fd_ota_core_soft_0/m1_41541_3443# 6.789050e-17
C2976 eeg_afe_pga_0/eeg_fd_ota_chopped_full2_0/eeg_fd_ota_core_soft_0/m1_41141_n3864# VSS 4.190540e-16
C2977 eeg_afe_pga_0/eeg_fd_ota_chopped_full2_0/eeg_fd_ota_core_soft_0/m1_41141_n3864# eeg_afe_pga_0/eeg_fd_ota_chopped_full2_0/eeg_fd_ota_core_soft_0/m1_41941_n3864# 6.789050e-17
C2978 eeg_afe_pga_0/eeg_fd_ota_chopped_full2_0/eeg_fd_ota_core_soft_0/m1_41541_3443# VSS 4.190540e-16
C2979 eeg_afe_pga_0/eeg_fd_ota_chopped_full2_0/eeg_fd_ota_core_soft_0/m1_41541_3443# eeg_afe_pga_0/eeg_fd_ota_chopped_full2_0/eeg_fd_ota_core_soft_0/m1_42341_3443# 6.789050e-17
C2980 eeg_afe_pga_0/eeg_fd_ota_chopped_full2_0/eeg_fd_ota_core_soft_0/m1_41941_n3864# VSS 4.190540e-16
C2981 eeg_afe_pga_0/eeg_fd_ota_chopped_full2_0/eeg_fd_ota_core_soft_0/m1_41941_n3864# eeg_afe_pga_0/eeg_fd_ota_chopped_full2_0/eeg_fd_ota_core_soft_0/m1_42741_n3864# 6.789040e-17
C2982 eeg_afe_pga_0/eeg_fd_ota_chopped_full2_0/eeg_fd_ota_core_soft_0/m1_42341_3443# VSS 4.190540e-16
C2983 eeg_afe_pga_0/eeg_fd_ota_chopped_full2_0/eeg_fd_ota_core_soft_0/m1_42341_3443# eeg_afe_pga_0/eeg_fd_ota_chopped_full2_0/eeg_fd_ota_core_soft_0/m1_43141_3443# 6.789050e-17
C2984 eeg_afe_pga_0/eeg_fd_ota_chopped_full2_0/eeg_fd_ota_core_soft_0/m1_42741_n3864# VSS 4.190540e-16
C2985 eeg_afe_pga_0/eeg_fd_ota_chopped_full2_0/eeg_fd_ota_core_soft_0/m1_42741_n3864# eeg_afe_pga_0/eeg_fd_ota_chopped_full2_0/eeg_fd_ota_core_soft_0/m1_43541_n3864# 6.789050e-17
C2986 eeg_afe_pga_0/eeg_fd_ota_chopped_full2_0/eeg_fd_ota_core_soft_0/m1_43141_3443# VSS 4.190540e-16
C2987 eeg_afe_pga_0/eeg_fd_ota_chopped_full2_0/eeg_fd_ota_core_soft_0/m1_43141_3443# eeg_afe_pga_0/eeg_fd_ota_chopped_full2_0/eeg_fd_ota_core_soft_0/m1_43941_3443# 6.789040e-17
C2988 eeg_afe_pga_0/eeg_fd_ota_chopped_full2_0/eeg_fd_ota_core_soft_0/m1_43541_n3864# VSS 4.190540e-16
C2989 eeg_afe_pga_0/eeg_fd_ota_chopped_full2_0/eeg_fd_ota_core_soft_0/m1_43541_n3864# eeg_afe_pga_0/eeg_fd_ota_chopped_full2_0/eeg_fd_ota_core_soft_0/m1_44341_n3864# 6.789050e-17
C2990 eeg_afe_pga_0/eeg_fd_ota_chopped_full2_0/eeg_fd_ota_core_soft_0/m1_43941_3443# VSS 4.190540e-16
C2991 eeg_afe_pga_0/eeg_fd_ota_chopped_full2_0/eeg_fd_ota_core_soft_0/m1_43941_3443# eeg_afe_pga_0/eeg_fd_ota_chopped_full2_0/eeg_fd_ota_core_soft_0/m1_44741_3443# 6.789050e-17
C2992 eeg_afe_pga_0/eeg_fd_ota_chopped_full2_0/eeg_fd_ota_core_soft_0/m1_44341_n3864# VSS 4.190540e-16
C2993 eeg_afe_pga_0/eeg_fd_ota_chopped_full2_0/eeg_fd_ota_core_soft_0/m1_44341_n3864# eeg_afe_pga_0/eeg_fd_ota_chopped_full2_0/eeg_fd_ota_core_soft_0/m1_45141_n3864# 6.789050e-17
C2994 eeg_afe_pga_0/eeg_fd_ota_chopped_full2_0/eeg_fd_ota_core_soft_0/m1_44741_3443# VSS 4.190540e-16
C2995 eeg_afe_pga_0/eeg_fd_ota_chopped_full2_0/eeg_fd_ota_core_soft_0/m1_44741_3443# eeg_afe_pga_0/eeg_fd_ota_chopped_full2_0/eeg_fd_ota_core_soft_0/m1_45541_3443# 6.789040e-17
C2996 eeg_afe_pga_0/eeg_fd_ota_chopped_full2_0/eeg_fd_ota_core_soft_0/m1_45141_n3864# VSS 4.190540e-16
C2997 eeg_afe_pga_0/eeg_fd_ota_chopped_full2_0/eeg_fd_ota_core_soft_0/m1_45141_n3864# eeg_afe_pga_0/eeg_fd_ota_chopped_full2_0/eeg_fd_ota_core_soft_0/m1_45941_n3864# 6.789050e-17
C2998 eeg_afe_pga_0/eeg_fd_ota_chopped_full2_0/eeg_fd_ota_core_soft_0/m1_45541_3443# VSS 4.190540e-16
C2999 eeg_afe_pga_0/eeg_fd_ota_chopped_full2_0/eeg_fd_ota_core_soft_0/m1_45541_3443# eeg_afe_pga_0/eeg_fd_ota_chopped_full2_0/eeg_fd_ota_core_soft_0/m1_46341_3443# 6.789050e-17
C3000 eeg_afe_pga_0/eeg_fd_ota_chopped_full2_0/eeg_fd_ota_core_soft_0/m1_45941_n3864# VSS 4.190540e-16
C3001 eeg_afe_pga_0/eeg_fd_ota_chopped_full2_0/eeg_fd_ota_core_soft_0/m1_45941_n3864# eeg_afe_pga_0/eeg_fd_ota_chopped_full2_0/eeg_fd_ota_core_soft_0/m1_46741_n3864# 6.789040e-17
C3002 eeg_afe_pga_0/eeg_fd_ota_chopped_full2_0/eeg_fd_ota_core_soft_0/m1_46341_3443# VSS 4.190540e-16
C3003 eeg_afe_pga_0/eeg_fd_ota_chopped_full2_0/eeg_fd_ota_core_soft_0/m1_46341_3443# eeg_afe_pga_0/eeg_fd_ota_chopped_full2_0/eeg_fd_ota_core_soft_0/m1_47141_3443# 6.789050e-17
C3004 eeg_afe_pga_0/eeg_fd_ota_chopped_full2_0/eeg_fd_ota_core_soft_0/m1_46741_n3864# VSS 4.190540e-16
C3005 eeg_afe_pga_0/eeg_fd_ota_chopped_full2_0/eeg_fd_ota_core_soft_0/m1_46741_n3864# eeg_afe_pga_0/eeg_fd_ota_chopped_full2_0/eeg_fd_ota_core_soft_0/m1_47541_n3864# 6.789050e-17
C3006 eeg_afe_pga_0/eeg_fd_ota_chopped_full2_0/eeg_fd_ota_core_soft_0/m1_47141_3443# VSS 4.607340e-16
C3007 eeg_afe_pga_0/eeg_fd_ota_chopped_full2_0/eeg_fd_ota_core_soft_0/m1_47541_n3864# VSS 4.702790e-16
C3008 eeg_afe_pga_0/eeg_fd_ota_chopped_full2_0/eeg_fd_ota_core_soft_0/m1_50741_n3864# VSS 4.702790e-16
C3009 eeg_afe_pga_0/eeg_fd_ota_chopped_full2_0/eeg_fd_ota_core_soft_0/m1_50741_n3864# eeg_afe_pga_0/eeg_fd_ota_chopped_full2_0/eeg_fd_ota_core_soft_0/m1_51541_n3864# 6.789050e-17
C3010 eeg_afe_pga_0/eeg_fd_ota_chopped_full2_0/eeg_fd_ota_core_soft_0/m1_51141_3443# VSS 4.622480e-16
C3011 eeg_afe_pga_0/eeg_fd_ota_chopped_full2_0/eeg_fd_ota_core_soft_0/m1_51141_3443# eeg_afe_pga_0/eeg_fd_ota_chopped_full2_0/eeg_fd_ota_core_soft_0/m1_51941_3443# 6.789050e-17
C3012 eeg_afe_pga_0/eeg_fd_ota_chopped_full2_0/eeg_fd_ota_core_soft_0/m1_51541_n3864# VSS 4.190540e-16
C3013 eeg_afe_pga_0/eeg_fd_ota_chopped_full2_0/eeg_fd_ota_core_soft_0/m1_51541_n3864# eeg_afe_pga_0/eeg_fd_ota_chopped_full2_0/eeg_fd_ota_core_soft_0/m1_52341_n3864# 6.789040e-17
C3014 eeg_afe_pga_0/eeg_fd_ota_chopped_full2_0/eeg_fd_ota_core_soft_0/m1_51941_3443# VSS 4.190540e-16
C3015 eeg_afe_pga_0/eeg_fd_ota_chopped_full2_0/eeg_fd_ota_core_soft_0/m1_51941_3443# eeg_afe_pga_0/eeg_fd_ota_chopped_full2_0/eeg_fd_ota_core_soft_0/m1_52741_3443# 6.789050e-17
C3016 eeg_afe_pga_0/eeg_fd_ota_chopped_full2_0/eeg_fd_ota_core_soft_0/m1_52341_n3864# VSS 4.190540e-16
C3017 eeg_afe_pga_0/eeg_fd_ota_chopped_full2_0/eeg_fd_ota_core_soft_0/m1_52341_n3864# eeg_afe_pga_0/eeg_fd_ota_chopped_full2_0/eeg_fd_ota_core_soft_0/m1_53141_n3864# 6.789050e-17
C3018 eeg_afe_pga_0/eeg_fd_ota_chopped_full2_0/eeg_fd_ota_core_soft_0/m1_52741_3443# VSS 4.190540e-16
C3019 eeg_afe_pga_0/eeg_fd_ota_chopped_full2_0/eeg_fd_ota_core_soft_0/m1_52741_3443# eeg_afe_pga_0/eeg_fd_ota_chopped_full2_0/eeg_fd_ota_core_soft_0/m1_53541_3443# 6.789050e-17
C3020 eeg_afe_pga_0/eeg_fd_ota_chopped_full2_0/eeg_fd_ota_core_soft_0/m1_53141_n3864# VSS 4.190540e-16
C3021 eeg_afe_pga_0/eeg_fd_ota_chopped_full2_0/eeg_fd_ota_core_soft_0/m1_53141_n3864# eeg_afe_pga_0/eeg_fd_ota_chopped_full2_0/eeg_fd_ota_core_soft_0/m1_53941_n3864# 6.789040e-17
C3022 eeg_afe_pga_0/eeg_fd_ota_chopped_full2_0/eeg_fd_ota_core_soft_0/m1_53541_3443# VSS 4.190540e-16
C3023 eeg_afe_pga_0/eeg_fd_ota_chopped_full2_0/eeg_fd_ota_core_soft_0/m1_53541_3443# eeg_afe_pga_0/eeg_fd_ota_chopped_full2_0/eeg_fd_ota_core_soft_0/m1_54341_3443# 6.789050e-17
C3024 eeg_afe_pga_0/eeg_fd_ota_chopped_full2_0/eeg_fd_ota_core_soft_0/m1_53941_n3864# VSS 4.190540e-16
C3025 eeg_afe_pga_0/eeg_fd_ota_chopped_full2_0/eeg_fd_ota_core_soft_0/m1_53941_n3864# eeg_afe_pga_0/eeg_fd_ota_chopped_full2_0/eeg_fd_ota_core_soft_0/m1_54741_n3864# 6.789050e-17
C3026 eeg_afe_pga_0/eeg_fd_ota_chopped_full2_0/eeg_fd_ota_core_soft_0/m1_54341_3443# VSS 4.190540e-16
C3027 eeg_afe_pga_0/eeg_fd_ota_chopped_full2_0/eeg_fd_ota_core_soft_0/m1_54341_3443# eeg_afe_pga_0/eeg_fd_ota_chopped_full2_0/eeg_fd_ota_core_soft_0/m1_55141_3443# 6.789040e-17
C3028 eeg_afe_pga_0/eeg_fd_ota_chopped_full2_0/eeg_fd_ota_core_soft_0/m1_54741_n3864# VSS 4.190540e-16
C3029 eeg_afe_pga_0/eeg_fd_ota_chopped_full2_0/eeg_fd_ota_core_soft_0/m1_54741_n3864# eeg_afe_pga_0/eeg_fd_ota_chopped_full2_0/eeg_fd_ota_core_soft_0/m1_55541_n3864# 6.789050e-17
C3030 eeg_afe_pga_0/eeg_fd_ota_chopped_full2_0/eeg_fd_ota_core_soft_0/m1_55141_3443# VSS 4.190540e-16
C3031 eeg_afe_pga_0/eeg_fd_ota_chopped_full2_0/eeg_fd_ota_core_soft_0/m1_55141_3443# eeg_afe_pga_0/eeg_fd_ota_chopped_full2_0/eeg_fd_ota_core_soft_0/m1_55941_3443# 6.789050e-17
C3032 eeg_afe_pga_0/eeg_fd_ota_chopped_full2_0/eeg_fd_ota_core_soft_0/m1_55541_n3864# VSS 4.190540e-16
C3033 eeg_afe_pga_0/eeg_fd_ota_chopped_full2_0/eeg_fd_ota_core_soft_0/m1_55541_n3864# eeg_afe_pga_0/eeg_fd_ota_chopped_full2_0/eeg_fd_ota_core_soft_0/m1_56341_n3864# 6.789050e-17
C3034 eeg_afe_pga_0/eeg_fd_ota_chopped_full2_0/eeg_fd_ota_core_soft_0/m1_55941_3443# VSS 4.190540e-16
C3035 eeg_afe_pga_0/eeg_fd_ota_chopped_full2_0/eeg_fd_ota_core_soft_0/m1_55941_3443# eeg_afe_pga_0/eeg_fd_ota_chopped_full2_0/eeg_fd_ota_core_soft_0/m1_56741_3443# 6.789040e-17
C3036 eeg_afe_pga_0/eeg_fd_ota_chopped_full2_0/eeg_fd_ota_core_soft_0/m1_56341_n3864# VSS 4.190540e-16
C3037 eeg_afe_pga_0/eeg_fd_ota_chopped_full2_0/eeg_fd_ota_core_soft_0/m1_56341_n3864# eeg_afe_pga_0/eeg_fd_ota_chopped_full2_0/eeg_fd_ota_core_soft_0/m1_57141_n3864# 6.789050e-17
C3038 eeg_afe_pga_0/eeg_fd_ota_chopped_full2_0/eeg_fd_ota_core_soft_0/m1_56741_3443# VSS 4.190540e-16
C3039 eeg_afe_pga_0/eeg_fd_ota_chopped_full2_0/eeg_fd_ota_core_soft_0/m1_56741_3443# eeg_afe_pga_0/eeg_fd_ota_chopped_full2_0/eeg_fd_ota_core_soft_0/m1_57541_3443# 6.789050e-17
C3040 eeg_afe_pga_0/eeg_fd_ota_chopped_full2_0/eeg_fd_ota_core_soft_0/m1_57141_n3864# VSS 4.190540e-16
C3041 eeg_afe_pga_0/eeg_fd_ota_chopped_full2_0/eeg_fd_ota_core_soft_0/m1_57141_n3864# eeg_afe_pga_0/eeg_fd_ota_chopped_full2_0/eeg_fd_ota_core_soft_0/m1_57941_n3864# 6.789040e-17
C3042 eeg_afe_pga_0/eeg_fd_ota_chopped_full2_0/eeg_fd_ota_core_soft_0/m1_57541_3443# VSS 4.607340e-16
C3043 eeg_afe_pga_0/eeg_fd_ota_chopped_full2_0/eeg_fd_ota_core_soft_0/m1_57941_n3864# VSS 4.702790e-16
C3044 eeg_afe_pga_0/eeg_fd_ota_chopped_full2_0/eeg_fd_ota_core_soft_0/m1_n22658_111# VSS 1.794040e-14
C3045 eeg_afe_pga_0/eeg_fd_ota_chopped_full2_0/eeg_fd_ota_core_soft_0/m1_n28859_n3864# VSS 4.702790e-16
C3046 eeg_afe_pga_0/eeg_fd_ota_chopped_full2_0/eeg_fd_ota_core_soft_0/m1_n28859_n3864# eeg_afe_pga_0/eeg_fd_ota_chopped_full2_0/eeg_fd_ota_core_soft_0/m1_n29659_n3864# 6.789040e-17
C3047 eeg_afe_pga_0/eeg_fd_ota_chopped_full2_0/eeg_fd_ota_core_soft_0/m1_n29259_3443# VSS 4.622480e-16
C3048 eeg_afe_pga_0/eeg_fd_ota_chopped_full2_0/eeg_fd_ota_core_soft_0/m1_n29259_3443# eeg_afe_pga_0/eeg_fd_ota_chopped_full2_0/eeg_fd_ota_core_soft_0/m1_n30059_3443# 6.789050e-17
C3049 eeg_afe_pga_0/eeg_fd_ota_chopped_full2_0/eeg_fd_ota_core_soft_0/m1_n29659_n3864# VSS 4.190540e-16
C3050 eeg_afe_pga_0/eeg_fd_ota_chopped_full2_0/eeg_fd_ota_core_soft_0/m1_n29659_n3864# eeg_afe_pga_0/eeg_fd_ota_chopped_full2_0/eeg_fd_ota_core_soft_0/m1_n30459_n3864# 6.789050e-17
C3051 eeg_afe_pga_0/eeg_fd_ota_chopped_full2_0/eeg_fd_ota_core_soft_0/m1_n30059_3443# VSS 4.190540e-16
C3052 eeg_afe_pga_0/eeg_fd_ota_chopped_full2_0/eeg_fd_ota_core_soft_0/m1_n30059_3443# eeg_afe_pga_0/eeg_fd_ota_chopped_full2_0/eeg_fd_ota_core_soft_0/m1_n30859_3443# 6.789040e-17
C3053 eeg_afe_pga_0/eeg_fd_ota_chopped_full2_0/eeg_fd_ota_core_soft_0/m1_n30459_n3864# VSS 4.190540e-16
C3054 eeg_afe_pga_0/eeg_fd_ota_chopped_full2_0/eeg_fd_ota_core_soft_0/m1_n30459_n3864# eeg_afe_pga_0/eeg_fd_ota_chopped_full2_0/eeg_fd_ota_core_soft_0/m1_n31259_n3864# 6.789050e-17
C3055 eeg_afe_pga_0/eeg_fd_ota_chopped_full2_0/eeg_fd_ota_core_soft_0/m1_n30859_3443# VSS 4.190540e-16
C3056 eeg_afe_pga_0/eeg_fd_ota_chopped_full2_0/eeg_fd_ota_core_soft_0/m1_n30859_3443# eeg_afe_pga_0/eeg_fd_ota_chopped_full2_0/eeg_fd_ota_core_soft_0/m1_n31659_3443# 6.789050e-17
C3057 eeg_afe_pga_0/eeg_fd_ota_chopped_full2_0/eeg_fd_ota_core_soft_0/m1_n31259_n3864# VSS 4.190540e-16
C3058 eeg_afe_pga_0/eeg_fd_ota_chopped_full2_0/eeg_fd_ota_core_soft_0/m1_n31259_n3864# eeg_afe_pga_0/eeg_fd_ota_chopped_full2_0/eeg_fd_ota_core_soft_0/m1_n32059_n3864# 6.789050e-17
C3059 eeg_afe_pga_0/eeg_fd_ota_chopped_full2_0/eeg_fd_ota_core_soft_0/m1_n31659_3443# VSS 4.190540e-16
C3060 eeg_afe_pga_0/eeg_fd_ota_chopped_full2_0/eeg_fd_ota_core_soft_0/m1_n31659_3443# eeg_afe_pga_0/eeg_fd_ota_chopped_full2_0/eeg_fd_ota_core_soft_0/m1_n32459_3443# 6.789040e-17
C3061 eeg_afe_pga_0/eeg_fd_ota_chopped_full2_0/eeg_fd_ota_core_soft_0/m1_n32059_n3864# VSS 4.190540e-16
C3062 eeg_afe_pga_0/eeg_fd_ota_chopped_full2_0/eeg_fd_ota_core_soft_0/m1_n32059_n3864# eeg_afe_pga_0/eeg_fd_ota_chopped_full2_0/eeg_fd_ota_core_soft_0/m1_n32859_n3864# 6.789050e-17
C3063 eeg_afe_pga_0/eeg_fd_ota_chopped_full2_0/eeg_fd_ota_core_soft_0/m1_n32459_3443# VSS 4.190540e-16
C3064 eeg_afe_pga_0/eeg_fd_ota_chopped_full2_0/eeg_fd_ota_core_soft_0/m1_n32459_3443# eeg_afe_pga_0/eeg_fd_ota_chopped_full2_0/eeg_fd_ota_core_soft_0/m1_n33259_3443# 6.789050e-17
C3065 eeg_afe_pga_0/eeg_fd_ota_chopped_full2_0/eeg_fd_ota_core_soft_0/m1_n32859_n3864# VSS 4.190540e-16
C3066 eeg_afe_pga_0/eeg_fd_ota_chopped_full2_0/eeg_fd_ota_core_soft_0/m1_n32859_n3864# eeg_afe_pga_0/eeg_fd_ota_chopped_full2_0/eeg_fd_ota_core_soft_0/m1_n33659_n3864# 6.789040e-17
C3067 eeg_afe_pga_0/eeg_fd_ota_chopped_full2_0/eeg_fd_ota_core_soft_0/m1_n33259_3443# VSS 4.190540e-16
C3068 eeg_afe_pga_0/eeg_fd_ota_chopped_full2_0/eeg_fd_ota_core_soft_0/m1_n33259_3443# eeg_afe_pga_0/eeg_fd_ota_chopped_full2_0/eeg_fd_ota_core_soft_0/m1_n34059_3443# 6.789050e-17
C3069 eeg_afe_pga_0/eeg_fd_ota_chopped_full2_0/eeg_fd_ota_core_soft_0/m1_n33659_n3864# VSS 4.190540e-16
C3070 eeg_afe_pga_0/eeg_fd_ota_chopped_full2_0/eeg_fd_ota_core_soft_0/m1_n33659_n3864# eeg_afe_pga_0/eeg_fd_ota_chopped_full2_0/eeg_fd_ota_core_soft_0/m1_n34459_n3864# 6.789050e-17
C3071 eeg_afe_pga_0/eeg_fd_ota_chopped_full2_0/eeg_fd_ota_core_soft_0/m1_n34059_3443# VSS 4.190540e-16
C3072 eeg_afe_pga_0/eeg_fd_ota_chopped_full2_0/eeg_fd_ota_core_soft_0/m1_n34059_3443# eeg_afe_pga_0/eeg_fd_ota_chopped_full2_0/eeg_fd_ota_core_soft_0/m1_n34859_3443# 6.789050e-17
C3073 eeg_afe_pga_0/eeg_fd_ota_chopped_full2_0/eeg_fd_ota_core_soft_0/m1_n34459_n3864# VSS 4.190540e-16
C3074 eeg_afe_pga_0/eeg_fd_ota_chopped_full2_0/eeg_fd_ota_core_soft_0/m1_n34459_n3864# eeg_afe_pga_0/eeg_fd_ota_chopped_full2_0/eeg_fd_ota_core_soft_0/m1_n35259_n3864# 6.789040e-17
C3075 eeg_afe_pga_0/eeg_fd_ota_chopped_full2_0/eeg_fd_ota_core_soft_0/m1_n34859_3443# VSS 4.190540e-16
C3076 eeg_afe_pga_0/eeg_fd_ota_chopped_full2_0/eeg_fd_ota_core_soft_0/m1_n34859_3443# eeg_afe_pga_0/eeg_fd_ota_chopped_full2_0/eeg_fd_ota_core_soft_0/m1_n35659_3443# 6.789050e-17
C3077 eeg_afe_pga_0/eeg_fd_ota_chopped_full2_0/eeg_fd_ota_core_soft_0/m1_n35259_n3864# VSS 4.190540e-16
C3078 eeg_afe_pga_0/eeg_fd_ota_chopped_full2_0/eeg_fd_ota_core_soft_0/m1_n35259_n3864# eeg_afe_pga_0/eeg_fd_ota_chopped_full2_0/eeg_fd_ota_core_soft_0/m1_n36059_n3864# 6.789050e-17
C3079 eeg_afe_pga_0/eeg_fd_ota_chopped_full2_0/eeg_fd_ota_core_soft_0/m1_n35659_3443# VSS 4.190540e-16
C3080 eeg_afe_pga_0/eeg_fd_ota_chopped_full2_0/eeg_fd_ota_core_soft_0/m1_n35659_3443# eeg_afe_pga_0/eeg_fd_ota_chopped_full2_0/eeg_fd_ota_core_soft_0/m1_n36459_3443# 6.789040e-17
C3081 eeg_afe_pga_0/eeg_fd_ota_chopped_full2_0/eeg_fd_ota_core_soft_0/m1_n36059_n3864# VSS 4.190540e-16
C3082 eeg_afe_pga_0/eeg_fd_ota_chopped_full2_0/eeg_fd_ota_core_soft_0/m1_n36059_n3864# eeg_afe_pga_0/eeg_fd_ota_chopped_full2_0/eeg_fd_ota_core_soft_0/m1_n36859_n3864# 6.789050e-17
C3083 eeg_afe_pga_0/eeg_fd_ota_chopped_full2_0/eeg_fd_ota_core_soft_0/m1_n36459_3443# VSS 4.190540e-16
C3084 eeg_afe_pga_0/eeg_fd_ota_chopped_full2_0/eeg_fd_ota_core_soft_0/m1_n36459_3443# eeg_afe_pga_0/eeg_fd_ota_chopped_full2_0/eeg_fd_ota_core_soft_0/m1_n37259_3443# 6.789050e-17
C3085 eeg_afe_pga_0/eeg_fd_ota_chopped_full2_0/eeg_fd_ota_core_soft_0/m1_n36859_n3864# VSS 4.190540e-16
C3086 eeg_afe_pga_0/eeg_fd_ota_chopped_full2_0/eeg_fd_ota_core_soft_0/m1_n36859_n3864# eeg_afe_pga_0/eeg_fd_ota_chopped_full2_0/eeg_fd_ota_core_soft_0/m1_n37659_n3864# 6.789050e-17
C3087 eeg_afe_pga_0/eeg_fd_ota_chopped_full2_0/eeg_fd_ota_core_soft_0/m1_n37259_3443# VSS 4.190540e-16
C3088 eeg_afe_pga_0/eeg_fd_ota_chopped_full2_0/eeg_fd_ota_core_soft_0/m1_n37259_3443# eeg_afe_pga_0/eeg_fd_ota_chopped_full2_0/eeg_fd_ota_core_soft_0/m1_n38059_3443# 6.789040e-17
C3089 eeg_afe_pga_0/eeg_fd_ota_chopped_full2_0/eeg_fd_ota_core_soft_0/m1_n37659_n3864# VSS 4.190540e-16
C3090 eeg_afe_pga_0/eeg_fd_ota_chopped_full2_0/eeg_fd_ota_core_soft_0/m1_n37659_n3864# eeg_afe_pga_0/eeg_fd_ota_chopped_full2_0/eeg_fd_ota_core_soft_0/m1_n38459_n3864# 6.789050e-17
C3091 eeg_afe_pga_0/eeg_fd_ota_chopped_full2_0/eeg_fd_ota_core_soft_0/m1_n38059_3443# VSS 4.190540e-16
C3092 eeg_afe_pga_0/eeg_fd_ota_chopped_full2_0/eeg_fd_ota_core_soft_0/m1_n38059_3443# eeg_afe_pga_0/eeg_fd_ota_chopped_full2_0/eeg_fd_ota_core_soft_0/m1_n38859_3443# 6.789050e-17
C3093 eeg_afe_pga_0/eeg_fd_ota_chopped_full2_0/eeg_fd_ota_core_soft_0/m1_n38459_n3864# VSS 4.190540e-16
C3094 eeg_afe_pga_0/eeg_fd_ota_chopped_full2_0/eeg_fd_ota_core_soft_0/m1_n38459_n3864# eeg_afe_pga_0/eeg_fd_ota_chopped_full2_0/eeg_fd_ota_core_soft_0/m1_n39259_n3864# 6.789040e-17
C3095 eeg_afe_pga_0/eeg_fd_ota_chopped_full2_0/eeg_fd_ota_core_soft_0/m1_n38859_3443# VSS 4.190540e-16
C3096 eeg_afe_pga_0/eeg_fd_ota_chopped_full2_0/eeg_fd_ota_core_soft_0/m1_n38859_3443# eeg_afe_pga_0/eeg_fd_ota_chopped_full2_0/eeg_fd_ota_core_soft_0/m1_n39659_3443# 6.789050e-17
C3097 eeg_afe_pga_0/eeg_fd_ota_chopped_full2_0/eeg_fd_ota_core_soft_0/m1_n39259_n3864# VSS 4.190540e-16
C3098 eeg_afe_pga_0/eeg_fd_ota_chopped_full2_0/eeg_fd_ota_core_soft_0/m1_n39259_n3864# eeg_afe_pga_0/eeg_fd_ota_chopped_full2_0/eeg_fd_ota_core_soft_0/m1_n40059_n3864# 6.789050e-17
C3099 eeg_afe_pga_0/eeg_fd_ota_chopped_full2_0/eeg_fd_ota_core_soft_0/m1_n39659_3443# VSS 4.190540e-16
C3100 eeg_afe_pga_0/eeg_fd_ota_chopped_full2_0/eeg_fd_ota_core_soft_0/m1_n39659_3443# eeg_afe_pga_0/eeg_fd_ota_chopped_full2_0/eeg_fd_ota_core_soft_0/m1_n40459_3443# 6.789050e-17
C3101 eeg_afe_pga_0/eeg_fd_ota_chopped_full2_0/eeg_fd_ota_core_soft_0/m1_n40059_n3864# VSS 4.190540e-16
C3102 eeg_afe_pga_0/eeg_fd_ota_chopped_full2_0/eeg_fd_ota_core_soft_0/m1_n40059_n3864# eeg_afe_pga_0/eeg_fd_ota_chopped_full2_0/eeg_fd_ota_core_soft_0/m1_n40859_n3864# 6.789040e-17
C3103 eeg_afe_pga_0/eeg_fd_ota_chopped_full2_0/eeg_fd_ota_core_soft_0/m1_n40459_3443# VSS 4.190540e-16
C3104 eeg_afe_pga_0/eeg_fd_ota_chopped_full2_0/eeg_fd_ota_core_soft_0/m1_n40459_3443# eeg_afe_pga_0/eeg_fd_ota_chopped_full2_0/eeg_fd_ota_core_soft_0/m1_n41259_3443# 6.789050e-17
C3105 eeg_afe_pga_0/eeg_fd_ota_chopped_full2_0/eeg_fd_ota_core_soft_0/m1_n40859_n3864# VSS 4.190540e-16
C3106 eeg_afe_pga_0/eeg_fd_ota_chopped_full2_0/eeg_fd_ota_core_soft_0/m1_n40859_n3864# eeg_afe_pga_0/eeg_fd_ota_chopped_full2_0/eeg_fd_ota_core_soft_0/m1_n41659_n3864# 6.789050e-17
C3107 eeg_afe_pga_0/eeg_fd_ota_chopped_full2_0/eeg_fd_ota_core_soft_0/m1_n41259_3443# VSS 4.190540e-16
C3108 eeg_afe_pga_0/eeg_fd_ota_chopped_full2_0/eeg_fd_ota_core_soft_0/m1_n41259_3443# eeg_afe_pga_0/eeg_fd_ota_chopped_full2_0/eeg_fd_ota_core_soft_0/m1_n42059_3443# 6.789040e-17
C3109 eeg_afe_pga_0/eeg_fd_ota_chopped_full2_0/eeg_fd_ota_core_soft_0/m1_n41659_n3864# VSS 4.190540e-16
C3110 eeg_afe_pga_0/eeg_fd_ota_chopped_full2_0/eeg_fd_ota_core_soft_0/m1_n41659_n3864# eeg_afe_pga_0/eeg_fd_ota_chopped_full2_0/eeg_fd_ota_core_soft_0/m1_n42459_n3864# 6.789050e-17
C3111 eeg_afe_pga_0/eeg_fd_ota_chopped_full2_0/eeg_fd_ota_core_soft_0/m1_n42059_3443# VSS 4.190540e-16
C3112 eeg_afe_pga_0/eeg_fd_ota_chopped_full2_0/eeg_fd_ota_core_soft_0/m1_n42059_3443# eeg_afe_pga_0/eeg_fd_ota_chopped_full2_0/eeg_fd_ota_core_soft_0/m1_n42859_3443# 6.789050e-17
C3113 eeg_afe_pga_0/eeg_fd_ota_chopped_full2_0/eeg_fd_ota_core_soft_0/m1_n42459_n3864# VSS 4.190540e-16
C3114 eeg_afe_pga_0/eeg_fd_ota_chopped_full2_0/eeg_fd_ota_core_soft_0/m1_n42459_n3864# eeg_afe_pga_0/eeg_fd_ota_chopped_full2_0/eeg_fd_ota_core_soft_0/m1_n43259_n3864# 6.789050e-17
C3115 eeg_afe_pga_0/eeg_fd_ota_chopped_full2_0/eeg_fd_ota_core_soft_0/m1_n42859_3443# VSS 4.190540e-16
C3116 eeg_afe_pga_0/eeg_fd_ota_chopped_full2_0/eeg_fd_ota_core_soft_0/m1_n42859_3443# eeg_afe_pga_0/eeg_fd_ota_chopped_full2_0/eeg_fd_ota_core_soft_0/m1_n43659_3443# 6.789040e-17
C3117 eeg_afe_pga_0/eeg_fd_ota_chopped_full2_0/eeg_fd_ota_core_soft_0/m1_n43259_n3864# VSS 4.190540e-16
C3118 eeg_afe_pga_0/eeg_fd_ota_chopped_full2_0/eeg_fd_ota_core_soft_0/m1_n43259_n3864# eeg_afe_pga_0/eeg_fd_ota_chopped_full2_0/eeg_fd_ota_core_soft_0/m1_n44059_n3864# 6.789050e-17
C3119 eeg_afe_pga_0/eeg_fd_ota_chopped_full2_0/eeg_fd_ota_core_soft_0/m1_n43659_3443# VSS 4.190540e-16
C3120 eeg_afe_pga_0/eeg_fd_ota_chopped_full2_0/eeg_fd_ota_core_soft_0/m1_n43659_3443# eeg_afe_pga_0/eeg_fd_ota_chopped_full2_0/eeg_fd_ota_core_soft_0/m1_n44459_3443# 6.789050e-17
C3121 eeg_afe_pga_0/eeg_fd_ota_chopped_full2_0/eeg_fd_ota_core_soft_0/m1_n44059_n3864# VSS 4.190540e-16
C3122 eeg_afe_pga_0/eeg_fd_ota_chopped_full2_0/eeg_fd_ota_core_soft_0/m1_n44059_n3864# eeg_afe_pga_0/eeg_fd_ota_chopped_full2_0/eeg_fd_ota_core_soft_0/m1_n44859_n3864# 6.789040e-17
C3123 eeg_afe_pga_0/eeg_fd_ota_chopped_full2_0/eeg_fd_ota_core_soft_0/m1_n44459_3443# VSS 4.190540e-16
C3124 eeg_afe_pga_0/eeg_fd_ota_chopped_full2_0/eeg_fd_ota_core_soft_0/m1_n44459_3443# eeg_afe_pga_0/eeg_fd_ota_chopped_full2_0/eeg_fd_ota_core_soft_0/m1_n45259_3443# 6.789050e-17
C3125 eeg_afe_pga_0/eeg_fd_ota_chopped_full2_0/eeg_fd_ota_core_soft_0/m1_n44859_n3864# VSS 4.190540e-16
C3126 eeg_afe_pga_0/eeg_fd_ota_chopped_full2_0/eeg_fd_ota_core_soft_0/m1_n44859_n3864# eeg_afe_pga_0/eeg_fd_ota_chopped_full2_0/eeg_fd_ota_core_soft_0/m1_n45659_n3864# 6.789050e-17
C3127 eeg_afe_pga_0/eeg_fd_ota_chopped_full2_0/eeg_fd_ota_core_soft_0/m1_n45259_3443# VSS 4.190540e-16
C3128 eeg_afe_pga_0/eeg_fd_ota_chopped_full2_0/eeg_fd_ota_core_soft_0/m1_n45259_3443# eeg_afe_pga_0/eeg_fd_ota_chopped_full2_0/eeg_fd_ota_core_soft_0/m1_n46059_3443# 6.789050e-17
C3129 eeg_afe_pga_0/eeg_fd_ota_chopped_full2_0/eeg_fd_ota_core_soft_0/m1_n45659_n3864# VSS 4.190540e-16
C3130 eeg_afe_pga_0/eeg_fd_ota_chopped_full2_0/eeg_fd_ota_core_soft_0/m1_n45659_n3864# eeg_afe_pga_0/eeg_fd_ota_chopped_full2_0/eeg_fd_ota_core_soft_0/m1_n46459_n3864# 6.789040e-17
C3131 eeg_afe_pga_0/eeg_fd_ota_chopped_full2_0/eeg_fd_ota_core_soft_0/m1_n46059_3443# VSS 4.190540e-16
C3132 eeg_afe_pga_0/eeg_fd_ota_chopped_full2_0/eeg_fd_ota_core_soft_0/m1_n46059_3443# eeg_afe_pga_0/eeg_fd_ota_chopped_full2_0/eeg_fd_ota_core_soft_0/m1_n46859_3443# 6.789050e-17
C3133 eeg_afe_pga_0/eeg_fd_ota_chopped_full2_0/eeg_fd_ota_core_soft_0/m1_n46459_n3864# VSS 4.190540e-16
C3134 eeg_afe_pga_0/eeg_fd_ota_chopped_full2_0/eeg_fd_ota_core_soft_0/m1_n46459_n3864# eeg_afe_pga_0/eeg_fd_ota_chopped_full2_0/eeg_fd_ota_core_soft_0/m1_n47259_n3864# 6.789050e-17
C3135 eeg_afe_pga_0/eeg_fd_ota_chopped_full2_0/eeg_fd_ota_core_soft_0/m1_n46859_3443# VSS 4.190540e-16
C3136 eeg_afe_pga_0/eeg_fd_ota_chopped_full2_0/eeg_fd_ota_core_soft_0/m1_n46859_3443# eeg_afe_pga_0/eeg_fd_ota_chopped_full2_0/eeg_fd_ota_core_soft_0/m1_n47659_3443# 6.789040e-17
C3137 eeg_afe_pga_0/eeg_fd_ota_chopped_full2_0/eeg_fd_ota_core_soft_0/m1_n47259_n3864# VSS 4.190540e-16
C3138 eeg_afe_pga_0/eeg_fd_ota_chopped_full2_0/eeg_fd_ota_core_soft_0/m1_n47259_n3864# eeg_afe_pga_0/eeg_fd_ota_chopped_full2_0/eeg_fd_ota_core_soft_0/m1_n48059_n3864# 6.789050e-17
C3139 eeg_afe_pga_0/eeg_fd_ota_chopped_full2_0/eeg_fd_ota_core_soft_0/m1_n47659_3443# VSS 4.607340e-16
C3140 eeg_afe_pga_0/eeg_fd_ota_chopped_full2_0/eeg_fd_ota_core_soft_0/m1_n48059_n3864# VSS 4.702790e-16
C3141 eeg_afe_pga_0/eeg_fd_ota_chopped_full2_0/eeg_fd_ota_core_soft_0/m1_n51259_n3864# VSS 4.702790e-16
C3142 eeg_afe_pga_0/eeg_fd_ota_chopped_full2_0/eeg_fd_ota_core_soft_0/m1_n51259_n3864# eeg_afe_pga_0/eeg_fd_ota_chopped_full2_0/eeg_fd_ota_core_soft_0/m1_n52059_n3864# 6.789040e-17
C3143 eeg_afe_pga_0/eeg_fd_ota_chopped_full2_0/eeg_fd_ota_core_soft_0/m1_n51659_3443# VSS 4.622480e-16
C3144 eeg_afe_pga_0/eeg_fd_ota_chopped_full2_0/eeg_fd_ota_core_soft_0/m1_n51659_3443# eeg_afe_pga_0/eeg_fd_ota_chopped_full2_0/eeg_fd_ota_core_soft_0/m1_n52459_3443# 6.789050e-17
C3145 eeg_afe_pga_0/eeg_fd_ota_chopped_full2_0/eeg_fd_ota_core_soft_0/m1_n52059_n3864# VSS 4.190540e-16
C3146 eeg_afe_pga_0/eeg_fd_ota_chopped_full2_0/eeg_fd_ota_core_soft_0/m1_n52059_n3864# eeg_afe_pga_0/eeg_fd_ota_chopped_full2_0/eeg_fd_ota_core_soft_0/m1_n52859_n3864# 6.789050e-17
C3147 eeg_afe_pga_0/eeg_fd_ota_chopped_full2_0/eeg_fd_ota_core_soft_0/m1_n52459_3443# VSS 4.190540e-16
C3148 eeg_afe_pga_0/eeg_fd_ota_chopped_full2_0/eeg_fd_ota_core_soft_0/m1_n52459_3443# eeg_afe_pga_0/eeg_fd_ota_chopped_full2_0/eeg_fd_ota_core_soft_0/m1_n53259_3443# 6.789040e-17
C3149 eeg_afe_pga_0/eeg_fd_ota_chopped_full2_0/eeg_fd_ota_core_soft_0/m1_n52859_n3864# VSS 4.190540e-16
C3150 eeg_afe_pga_0/eeg_fd_ota_chopped_full2_0/eeg_fd_ota_core_soft_0/m1_n52859_n3864# eeg_afe_pga_0/eeg_fd_ota_chopped_full2_0/eeg_fd_ota_core_soft_0/m1_n53659_n3864# 6.789050e-17
C3151 eeg_afe_pga_0/eeg_fd_ota_chopped_full2_0/eeg_fd_ota_core_soft_0/m1_n53259_3443# VSS 4.190540e-16
C3152 eeg_afe_pga_0/eeg_fd_ota_chopped_full2_0/eeg_fd_ota_core_soft_0/m1_n53259_3443# eeg_afe_pga_0/eeg_fd_ota_chopped_full2_0/eeg_fd_ota_core_soft_0/m1_n54059_3443# 6.789050e-17
C3153 eeg_afe_pga_0/eeg_fd_ota_chopped_full2_0/eeg_fd_ota_core_soft_0/m1_n53659_n3864# VSS 4.190540e-16
C3154 eeg_afe_pga_0/eeg_fd_ota_chopped_full2_0/eeg_fd_ota_core_soft_0/m1_n53659_n3864# eeg_afe_pga_0/eeg_fd_ota_chopped_full2_0/eeg_fd_ota_core_soft_0/m1_n54459_n3864# 6.789050e-17
C3155 eeg_afe_pga_0/eeg_fd_ota_chopped_full2_0/eeg_fd_ota_core_soft_0/m1_n54059_3443# VSS 4.190540e-16
C3156 eeg_afe_pga_0/eeg_fd_ota_chopped_full2_0/eeg_fd_ota_core_soft_0/m1_n54059_3443# eeg_afe_pga_0/eeg_fd_ota_chopped_full2_0/eeg_fd_ota_core_soft_0/m1_n54859_3443# 6.789040e-17
C3157 eeg_afe_pga_0/eeg_fd_ota_chopped_full2_0/eeg_fd_ota_core_soft_0/m1_n54459_n3864# VSS 4.190540e-16
C3158 eeg_afe_pga_0/eeg_fd_ota_chopped_full2_0/eeg_fd_ota_core_soft_0/m1_n54459_n3864# eeg_afe_pga_0/eeg_fd_ota_chopped_full2_0/eeg_fd_ota_core_soft_0/m1_n55259_n3864# 6.789050e-17
C3159 eeg_afe_pga_0/eeg_fd_ota_chopped_full2_0/eeg_fd_ota_core_soft_0/m1_n54859_3443# VSS 4.190540e-16
C3160 eeg_afe_pga_0/eeg_fd_ota_chopped_full2_0/eeg_fd_ota_core_soft_0/m1_n54859_3443# eeg_afe_pga_0/eeg_fd_ota_chopped_full2_0/eeg_fd_ota_core_soft_0/m1_n55659_3443# 6.789050e-17
C3161 eeg_afe_pga_0/eeg_fd_ota_chopped_full2_0/eeg_fd_ota_core_soft_0/m1_n55259_n3864# VSS 4.190540e-16
C3162 eeg_afe_pga_0/eeg_fd_ota_chopped_full2_0/eeg_fd_ota_core_soft_0/m1_n55259_n3864# eeg_afe_pga_0/eeg_fd_ota_chopped_full2_0/eeg_fd_ota_core_soft_0/m1_n56059_n3864# 6.789040e-17
C3163 eeg_afe_pga_0/eeg_fd_ota_chopped_full2_0/eeg_fd_ota_core_soft_0/m1_n55659_3443# VSS 4.190540e-16
C3164 eeg_afe_pga_0/eeg_fd_ota_chopped_full2_0/eeg_fd_ota_core_soft_0/m1_n55659_3443# eeg_afe_pga_0/eeg_fd_ota_chopped_full2_0/eeg_fd_ota_core_soft_0/m1_n56459_3443# 6.789050e-17
C3165 eeg_afe_pga_0/eeg_fd_ota_chopped_full2_0/eeg_fd_ota_core_soft_0/m1_n56059_n3864# VSS 4.190540e-16
C3166 eeg_afe_pga_0/eeg_fd_ota_chopped_full2_0/eeg_fd_ota_core_soft_0/m1_n56059_n3864# eeg_afe_pga_0/eeg_fd_ota_chopped_full2_0/eeg_fd_ota_core_soft_0/m1_n56859_n3864# 6.789050e-17
C3167 eeg_afe_pga_0/eeg_fd_ota_chopped_full2_0/eeg_fd_ota_core_soft_0/m1_n56459_3443# VSS 4.190540e-16
C3168 eeg_afe_pga_0/eeg_fd_ota_chopped_full2_0/eeg_fd_ota_core_soft_0/m1_n56459_3443# eeg_afe_pga_0/eeg_fd_ota_chopped_full2_0/eeg_fd_ota_core_soft_0/m1_n57259_3443# 6.789050e-17
C3169 eeg_afe_pga_0/eeg_fd_ota_chopped_full2_0/eeg_fd_ota_core_soft_0/m1_n56859_n3864# VSS 4.190540e-16
C3170 eeg_afe_pga_0/eeg_fd_ota_chopped_full2_0/eeg_fd_ota_core_soft_0/m1_n56859_n3864# eeg_afe_pga_0/eeg_fd_ota_chopped_full2_0/eeg_fd_ota_core_soft_0/m1_n57659_n3864# 6.789040e-17
C3171 eeg_afe_pga_0/eeg_fd_ota_chopped_full2_0/eeg_fd_ota_core_soft_0/m1_n57259_3443# VSS 4.190540e-16
C3172 eeg_afe_pga_0/eeg_fd_ota_chopped_full2_0/eeg_fd_ota_core_soft_0/m1_n57259_3443# eeg_afe_pga_0/eeg_fd_ota_chopped_full2_0/eeg_fd_ota_core_soft_0/m1_n58059_3443# 6.789050e-17
C3173 eeg_afe_pga_0/eeg_fd_ota_chopped_full2_0/eeg_fd_ota_core_soft_0/m1_n57659_n3864# VSS 4.190540e-16
C3174 eeg_afe_pga_0/eeg_fd_ota_chopped_full2_0/eeg_fd_ota_core_soft_0/m1_n57659_n3864# eeg_afe_pga_0/eeg_fd_ota_chopped_full2_0/eeg_fd_ota_core_soft_0/m1_n58459_n3864# 6.789050e-17
C3175 eeg_afe_pga_0/eeg_fd_ota_chopped_full2_0/eeg_fd_ota_core_soft_0/m1_n58059_3443# VSS 4.607340e-16
C3176 eeg_afe_pga_0/eeg_fd_ota_chopped_full2_0/eeg_fd_ota_core_soft_0/m1_n58459_n3864# VSS 4.702790e-16
C3177 eeg_afe_pga_0/eeg_fd_ota_chopped_full2_0/eeg_fd_ota_core_soft_0/m1_n51259_n3864# VSS 6.746650e-16
C3178 eeg_afe_pga_0/eeg_fd_ota_chopped_full2_0/eeg_fd_ota_core_soft_0/m1_n51659_3443# VSS 6.746650e-16
C3179 eeg_afe_pga_0/eeg_fd_ota_chopped_full2_0/eeg_fd_ota_core_soft_0/m1_n51659_3443# VSS 6.746650e-16
C3180 eeg_afe_pga_0/eeg_fd_ota_chopped_full2_0/eeg_fd_ota_core_soft_0/m1_n52059_n3864# VSS 6.746650e-16
C3181 eeg_afe_pga_0/eeg_fd_ota_chopped_full2_0/eeg_fd_ota_core_soft_0/m1_n52059_n3864# VSS 6.746650e-16
C3182 eeg_afe_pga_0/eeg_fd_ota_chopped_full2_0/eeg_fd_ota_core_soft_0/m1_n52459_3443# VSS 6.746650e-16
C3183 eeg_afe_pga_0/eeg_fd_ota_chopped_full2_0/eeg_fd_ota_core_soft_0/m1_n52459_3443# VSS 6.746650e-16
C3184 eeg_afe_pga_0/eeg_fd_ota_chopped_full2_0/eeg_fd_ota_core_soft_0/m1_n52859_n3864# VSS 6.746650e-16
C3185 eeg_afe_pga_0/eeg_fd_ota_chopped_full2_0/eeg_fd_ota_core_soft_0/m1_n52859_n3864# VSS 6.746650e-16
C3186 eeg_afe_pga_0/eeg_fd_ota_chopped_full2_0/eeg_fd_ota_core_soft_0/m1_n53259_3443# VSS 6.746650e-16
C3187 VSS eeg_afe_pga_0/eeg_fd_ota_chopped_full2_0/eeg_bias_gen_0/VBNF 6.766352e-15
C3188 VSS eeg_afe_pga_0/eeg_fd_ota_chopped_full2_0/eeg_fd_ota_core_soft_0/m1_n22658_111# 7.972532e-16
C3189 eeg_afe_pga_0/eeg_fd_ota_chopped_full2_0/eeg_bias_gen_0/VBNF VSS 2.104804e-14
C3190 eeg_afe_pga_0/eeg_fd_ota_chopped_full2_0/eeg_bias_gen_0/VBNF eeg_afe_pga_0/eeg_fd_ota_chopped_full2_0/eeg_fd_ota_core_soft_0/m1_n22658_111# 6.671600e-15
C3191 eeg_afe_pga_0/eeg_fd_ota_chopped_full2_0/eeg_fd_ota_core_soft_0/m1_n22658_111# VSS 2.222918e-16
C3192 eeg_afe_pga_0/eeg_fd_ota_chopped_full2_0/eeg_fd_ota_core_soft_0/m1_n53259_3443# VSS 6.746650e-16
C3193 eeg_afe_pga_0/eeg_fd_ota_chopped_full2_0/eeg_fd_ota_core_soft_0/m1_n53659_n3864# VSS 6.746650e-16
C3194 eeg_afe_pga_0/eeg_fd_ota_chopped_full2_0/eeg_fd_ota_core_soft_0/m1_31541_n3864# VSS 6.746650e-16
C3195 eeg_afe_pga_0/eeg_fd_ota_chopped_full2_0/eeg_fd_ota_core_soft_0/m1_31941_3443# VSS 6.746650e-16
C3196 eeg_afe_pga_0/eeg_fd_ota_chopped_full2_0/eeg_fd_ota_core_soft_0/m1_n53659_n3864# VSS 6.746650e-16
C3197 eeg_afe_pga_0/eeg_fd_ota_chopped_full2_0/eeg_fd_ota_core_soft_0/m1_n54059_3443# VSS 6.746650e-16
C3198 eeg_afe_pga_0/eeg_fd_ota_chopped_full2_0/eeg_fd_ota_core_soft_0/m1_31141_3443# VSS 6.746650e-16
C3199 eeg_afe_pga_0/eeg_fd_ota_chopped_full2_0/eeg_fd_ota_core_soft_0/m1_31541_n3864# VSS 6.746650e-16
C3200 eeg_afe_pga_0/eeg_fd_ota_chopped_full2_0/eeg_fd_ota_core_soft_0/m1_35541_n3864# VSS 6.746650e-16
C3201 eeg_afe_pga_0/eeg_fd_ota_chopped_full2_0/eeg_fd_ota_core_soft_0/m1_35941_3443# VSS 6.746650e-16
C3202 eeg_afe_pga_0/eeg_fd_ota_chopped_full2_0/eeg_fd_ota_core_soft_0/m1_n54059_3443# VSS 6.746650e-16
C3203 eeg_afe_pga_0/eeg_fd_ota_chopped_full2_0/eeg_fd_ota_core_soft_0/m1_n54459_n3864# VSS 6.746650e-16
C3204 eeg_afe_pga_0/eeg_fd_ota_chopped_full2_0/eeg_fd_ota_core_soft_0/m1_39541_n3864# VSS 6.746650e-16
C3205 eeg_afe_pga_0/eeg_fd_ota_chopped_full2_0/eeg_fd_ota_core_soft_0/m1_39941_3443# VSS 6.746650e-16
C3206 eeg_afe_pga_0/eeg_fd_ota_chopped_full2_0/eeg_fd_ota_core_soft_0/m1_30741_n3864# VSS 6.746650e-16
C3207 eeg_afe_pga_0/eeg_fd_ota_chopped_full2_0/eeg_fd_ota_core_soft_0/m1_31141_3443# VSS 6.746650e-16
C3208 eeg_afe_pga_0/eeg_fd_ota_chopped_full2_0/eeg_fd_ota_core_soft_0/m1_35141_3443# VSS 6.746650e-16
C3209 eeg_afe_pga_0/eeg_fd_ota_chopped_full2_0/eeg_fd_ota_core_soft_0/m1_35541_n3864# VSS 6.746650e-16
C3210 eeg_afe_pga_0/eeg_fd_ota_chopped_full2_0/eeg_fd_ota_core_soft_0/m1_n54459_n3864# VSS 6.746650e-16
C3211 eeg_afe_pga_0/eeg_fd_ota_chopped_full2_0/eeg_fd_ota_core_soft_0/m1_n54859_3443# VSS 6.746650e-16
C3212 eeg_afe_pga_0/eeg_fd_ota_chopped_full2_0/eeg_fd_ota_core_soft_0/m1_43541_n3864# VSS 6.746650e-16
C3213 eeg_afe_pga_0/eeg_fd_ota_chopped_full2_0/eeg_fd_ota_core_soft_0/m1_43941_3443# VSS 6.746650e-16
C3214 eeg_afe_pga_0/eeg_fd_ota_chopped_full2_0/eeg_fd_ota_core_soft_0/m1_39141_3443# VSS 6.746650e-16
C3215 eeg_afe_pga_0/eeg_fd_ota_chopped_full2_0/eeg_fd_ota_core_soft_0/m1_39541_n3864# VSS 6.746650e-16
C3216 eeg_afe_pga_0/eeg_fd_ota_chopped_full2_0/eeg_fd_ota_core_soft_0/m1_30341_3443# VSS 6.746650e-16
C3217 eeg_afe_pga_0/eeg_fd_ota_chopped_full2_0/eeg_fd_ota_core_soft_0/m1_30741_n3864# VSS 6.746650e-16
C3218 eeg_afe_pga_0/eeg_fd_ota_chopped_full2_0/eeg_fd_ota_core_soft_0/m1_34741_n3864# VSS 6.746650e-16
C3219 eeg_afe_pga_0/eeg_fd_ota_chopped_full2_0/eeg_fd_ota_core_soft_0/m1_35141_3443# VSS 6.746650e-16
C3220 eeg_afe_pga_0/eeg_fd_ota_chopped_full2_0/eeg_fd_ota_core_soft_0/m1_n54859_3443# VSS 6.746650e-16
C3221 eeg_afe_pga_0/eeg_fd_ota_chopped_full2_0/eeg_fd_ota_core_soft_0/m1_n55259_n3864# VSS 6.746650e-16
C3222 eeg_afe_pga_0/eeg_fd_ota_chopped_full2_0/eeg_fd_ota_core_soft_0/m1_43141_3443# VSS 6.746650e-16
C3223 eeg_afe_pga_0/eeg_fd_ota_chopped_full2_0/eeg_fd_ota_core_soft_0/m1_43541_n3864# VSS 6.746650e-16
C3224 eeg_afe_pga_0/eeg_fd_ota_chopped_full2_0/eeg_fd_ota_core_soft_0/m1_38741_n3864# VSS 6.746650e-16
C3225 eeg_afe_pga_0/eeg_fd_ota_chopped_full2_0/eeg_fd_ota_core_soft_0/m1_39141_3443# VSS 6.746650e-16
C3226 eeg_afe_pga_0/eeg_fd_ota_chopped_full2_0/eeg_fd_ota_core_soft_0/m1_29941_n3864# VSS 6.746650e-16
C3227 eeg_afe_pga_0/eeg_fd_ota_chopped_full2_0/eeg_fd_ota_core_soft_0/m1_30341_3443# VSS 6.746650e-16
C3228 eeg_afe_pga_0/eeg_fd_ota_chopped_full2_0/eeg_fd_ota_core_soft_0/m1_34341_3443# VSS 6.746650e-16
C3229 eeg_afe_pga_0/eeg_fd_ota_chopped_full2_0/eeg_fd_ota_core_soft_0/m1_34741_n3864# VSS 6.746650e-16
C3230 eeg_afe_pga_0/eeg_fd_ota_chopped_full2_0/eeg_fd_ota_core_soft_0/m1_42741_n3864# VSS 6.746650e-16
C3231 eeg_afe_pga_0/eeg_fd_ota_chopped_full2_0/eeg_fd_ota_core_soft_0/m1_43141_3443# VSS 6.746650e-16
C3232 eeg_afe_pga_0/eeg_fd_ota_chopped_full2_0/eeg_fd_ota_core_soft_0/m1_38341_3443# VSS 6.746650e-16
C3233 eeg_afe_pga_0/eeg_fd_ota_chopped_full2_0/eeg_fd_ota_core_soft_0/m1_38741_n3864# VSS 6.746650e-16
C3234 eeg_afe_pga_0/eeg_fd_ota_chopped_full2_0/eeg_fd_ota_core_soft_0/m1_29541_3443# VSS 6.746650e-16
C3235 eeg_afe_pga_0/eeg_fd_ota_chopped_full2_0/eeg_fd_ota_core_soft_0/m1_29941_n3864# VSS 6.746650e-16
C3236 eeg_afe_pga_0/eeg_fd_ota_chopped_full2_0/eeg_fd_ota_core_soft_0/m1_33941_n3864# VSS 6.746650e-16
C3237 eeg_afe_pga_0/eeg_fd_ota_chopped_full2_0/eeg_fd_ota_core_soft_0/m1_34341_3443# VSS 6.746650e-16
C3240 VSS eeg_afe_pga_0/eeg_fd_ota_chopped_full2_0/eeg_fd_ota_core_soft_0/OUTP 1.412244e-15
C3241 VSS eeg_afe_pga_0/eeg_fd_ota_chopped_full2_0/eeg_fd_ota_core_soft_0/m1_n22658_111# 1.572616e-15
C3242 eeg_afe_pga_0/eeg_fd_ota_chopped_full2_0/eeg_fd_ota_core_soft_0/INN VSS 3.113808e-14
C3243 eeg_afe_pga_0/eeg_fd_ota_chopped_full2_0/eeg_fd_ota_core_soft_0/INN eeg_afe_pga_0/eeg_fd_ota_chopped_full2_0/eeg_fd_ota_core_soft_0/INP 2.420658e-16
C3244 eeg_afe_pga_0/eeg_fd_ota_chopped_full2_0/eeg_fd_ota_core_soft_0/INN eeg_afe_pga_0/eeg_fd_ota_chopped_full2_0/eeg_fd_ota_core_soft_0/OUTN 1.694693e-14
C3245 eeg_afe_pga_0/eeg_fd_ota_chopped_full2_0/eeg_fd_ota_core_soft_0/INN eeg_afe_pga_0/eeg_fd_ota_chopped_full2_0/eeg_fd_ota_core_soft_0/m1_n22658_111# 1.694693e-14
C3246 eeg_afe_pga_0/eeg_fd_ota_chopped_full2_0/eeg_fd_ota_core_soft_0/INP VSS 3.114656e-14
C3247 eeg_afe_pga_0/eeg_fd_ota_chopped_full2_0/eeg_fd_ota_core_soft_0/INP eeg_afe_pga_0/eeg_fd_ota_chopped_full2_0/eeg_fd_ota_core_soft_0/OUTP 1.694693e-14
C3248 eeg_afe_pga_0/eeg_fd_ota_chopped_full2_0/eeg_fd_ota_core_soft_0/INP eeg_afe_pga_0/eeg_fd_ota_chopped_full2_0/eeg_fd_ota_core_soft_0/m1_n22658_111# 1.694693e-14
C3249 eeg_afe_pga_0/eeg_fd_ota_chopped_full2_0/eeg_fd_ota_core_soft_0/OUTN VSS 1.622652e-16
C3250 eeg_afe_pga_0/eeg_fd_ota_chopped_full2_0/eeg_fd_ota_core_soft_0/OUTN eeg_afe_pga_0/eeg_fd_ota_chopped_full2_0/eeg_fd_ota_core_soft_0/m1_n22658_111# 2.029956e-15
C3251 eeg_afe_pga_0/eeg_fd_ota_chopped_full2_0/eeg_fd_ota_core_soft_0/OUTP VSS 1.754879e-16
C3252 eeg_afe_pga_0/eeg_fd_ota_chopped_full2_0/eeg_fd_ota_core_soft_0/OUTP eeg_afe_pga_0/eeg_fd_ota_chopped_full2_0/eeg_fd_ota_core_soft_0/m1_n22658_111# 2.196456e-15
C3253 eeg_afe_pga_0/eeg_fd_ota_chopped_full2_0/eeg_fd_ota_core_soft_0/m1_n22658_111# VSS 2.094330e-15
C3254 eeg_afe_pga_0/eeg_fd_ota_chopped_full2_0/eeg_fd_ota_core_soft_0/m1_42341_3443# VSS 6.746650e-16
C3255 eeg_afe_pga_0/eeg_fd_ota_chopped_full2_0/eeg_fd_ota_core_soft_0/m1_42741_n3864# VSS 6.746650e-16
C3256 eeg_afe_pga_0/eeg_fd_ota_chopped_full2_0/eeg_fd_ota_core_soft_0/m1_37941_n3864# VSS 6.746650e-16
C3257 eeg_afe_pga_0/eeg_fd_ota_chopped_full2_0/eeg_fd_ota_core_soft_0/m1_38341_3443# VSS 6.746650e-16
C3258 eeg_afe_pga_0/eeg_fd_ota_chopped_full2_0/eeg_fd_ota_core_soft_0/m1_29141_n3864# VSS 6.746650e-16
C3259 eeg_afe_pga_0/eeg_fd_ota_chopped_full2_0/eeg_fd_ota_core_soft_0/m1_29541_3443# VSS 6.746650e-16
C3260 eeg_afe_pga_0/eeg_fd_ota_chopped_full2_0/eeg_fd_ota_core_soft_0/m1_33541_3443# VSS 6.746650e-16
C3261 eeg_afe_pga_0/eeg_fd_ota_chopped_full2_0/eeg_fd_ota_core_soft_0/m1_33941_n3864# VSS 6.746650e-16
C3262 eeg_afe_pga_0/eeg_fd_ota_chopped_full2_0/eeg_fd_ota_core_soft_0/m1_41941_n3864# VSS 6.746650e-16
C3263 eeg_afe_pga_0/eeg_fd_ota_chopped_full2_0/eeg_fd_ota_core_soft_0/m1_42341_3443# VSS 6.746650e-16
C3264 eeg_afe_pga_0/eeg_fd_ota_chopped_full2_0/eeg_fd_ota_core_soft_0/m1_37541_3443# VSS 6.746650e-16
C3265 eeg_afe_pga_0/eeg_fd_ota_chopped_full2_0/eeg_fd_ota_core_soft_0/m1_37941_n3864# VSS 6.746650e-16
C3266 eeg_afe_pga_0/eeg_fd_ota_chopped_full2_0/eeg_fd_ota_core_soft_0/m1_28741_3443# VSS 6.746650e-16
C3267 eeg_afe_pga_0/eeg_fd_ota_chopped_full2_0/eeg_fd_ota_core_soft_0/m1_29141_n3864# VSS 6.746650e-16
C3268 eeg_afe_pga_0/eeg_fd_ota_chopped_full2_0/eeg_fd_ota_core_soft_0/m1_33141_n3864# VSS 6.746650e-16
C3269 eeg_afe_pga_0/eeg_fd_ota_chopped_full2_0/eeg_fd_ota_core_soft_0/m1_33541_3443# VSS 6.746650e-16
C3270 eeg_afe_pga_0/eeg_fd_ota_chopped_full2_0/eeg_fd_ota_core_soft_0/m1_41541_3443# VSS 6.746650e-16
C3271 eeg_afe_pga_0/eeg_fd_ota_chopped_full2_0/eeg_fd_ota_core_soft_0/m1_41941_n3864# VSS 6.746650e-16
C3272 eeg_afe_pga_0/eeg_fd_ota_chopped_full2_0/eeg_fd_ota_core_soft_0/m1_37141_n3864# VSS 6.746650e-16
C3273 eeg_afe_pga_0/eeg_fd_ota_chopped_full2_0/eeg_fd_ota_core_soft_0/m1_37541_3443# VSS 6.746650e-16
C3274 eeg_afe_pga_0/eeg_fd_ota_chopped_full2_0/eeg_fd_ota_core_soft_0/m1_28341_n3864# VSS 6.746650e-16
C3275 eeg_afe_pga_0/eeg_fd_ota_chopped_full2_0/eeg_fd_ota_core_soft_0/m1_28741_3443# VSS 6.746650e-16
C3276 eeg_afe_pga_0/eeg_fd_ota_chopped_full2_0/eeg_fd_ota_core_soft_0/m1_32741_3443# VSS 6.746650e-16
C3277 eeg_afe_pga_0/eeg_fd_ota_chopped_full2_0/eeg_fd_ota_core_soft_0/m1_33141_n3864# VSS 6.746650e-16
C3278 eeg_afe_pga_0/eeg_fd_ota_chopped_full2_0/eeg_fd_ota_core_soft_0/OUTN VSS 6.746650e-16
C3279 eeg_afe_pga_0/eeg_fd_ota_chopped_full2_0/eeg_fd_ota_core_soft_0/m1_47541_n3864# VSS 6.746650e-16
C3280 eeg_afe_pga_0/eeg_fd_ota_chopped_full2_0/eeg_fd_ota_core_soft_0/m1_41141_n3864# VSS 6.746650e-16
C3281 eeg_afe_pga_0/eeg_fd_ota_chopped_full2_0/eeg_fd_ota_core_soft_0/m1_41541_3443# VSS 6.746650e-16
C3282 eeg_afe_pga_0/eeg_fd_ota_chopped_full2_0/eeg_cmfb_amp_dl2_0/VCM_SENSE VSS 6.746650e-16
C3283 eeg_afe_pga_0/eeg_fd_ota_chopped_full2_0/eeg_fd_ota_core_soft_0/m1_28341_n3864# VSS 6.746650e-16
C3284 eeg_afe_pga_0/eeg_fd_ota_chopped_full2_0/eeg_fd_ota_core_soft_0/m1_32341_n3864# VSS 6.746650e-16
C3285 eeg_afe_pga_0/eeg_fd_ota_chopped_full2_0/eeg_fd_ota_core_soft_0/m1_32741_3443# VSS 6.746650e-16
C3286 eeg_afe_pga_0/eeg_fd_ota_chopped_full2_0/eeg_fd_ota_core_soft_0/m1_36741_3443# VSS 6.746650e-16
C3287 eeg_afe_pga_0/eeg_fd_ota_chopped_full2_0/eeg_fd_ota_core_soft_0/m1_37141_n3864# VSS 6.746650e-16
C3288 eeg_afe_pga_0/eeg_fd_ota_chopped_full2_0/eeg_fd_ota_core_soft_0/m1_53941_n3864# VSS 6.746650e-16
C3289 eeg_afe_pga_0/eeg_fd_ota_chopped_full2_0/eeg_fd_ota_core_soft_0/m1_54341_3443# VSS 6.746650e-16
C3290 eeg_afe_pga_0/eeg_fd_ota_chopped_full2_0/eeg_fd_ota_core_soft_0/m1_47141_3443# VSS 6.746650e-16
C3291 eeg_afe_pga_0/eeg_fd_ota_chopped_full2_0/eeg_fd_ota_core_soft_0/m1_47541_n3864# VSS 6.746650e-16
C3292 eeg_afe_pga_0/eeg_fd_ota_chopped_full2_0/eeg_fd_ota_core_soft_0/m1_40741_3443# VSS 6.746650e-16
C3293 eeg_afe_pga_0/eeg_fd_ota_chopped_full2_0/eeg_fd_ota_core_soft_0/m1_41141_n3864# VSS 6.746650e-16
C3294 eeg_afe_pga_0/eeg_fd_ota_chopped_full2_0/eeg_fd_ota_core_soft_0/m1_36341_n3864# VSS 6.746650e-16
C3295 eeg_afe_pga_0/eeg_fd_ota_chopped_full2_0/eeg_fd_ota_core_soft_0/m1_36741_3443# VSS 6.746650e-16
C3296 eeg_afe_pga_0/eeg_fd_ota_chopped_full2_0/eeg_fd_ota_core_soft_0/m1_31941_3443# VSS 6.746650e-16
C3297 eeg_afe_pga_0/eeg_fd_ota_chopped_full2_0/eeg_fd_ota_core_soft_0/m1_32341_n3864# VSS 6.746650e-16
C3298 eeg_afe_pga_0/eeg_fd_ota_chopped_full2_0/eeg_fd_ota_core_soft_0/OUTN VSS 6.746650e-16
C3299 eeg_afe_pga_0/eeg_fd_ota_chopped_full2_0/eeg_fd_ota_core_soft_0/m1_57941_n3864# VSS 6.746650e-16
C3300 eeg_afe_pga_0/eeg_fd_ota_chopped_full2_0/eeg_fd_ota_core_soft_0/m1_53541_3443# VSS 6.746650e-16
C3301 eeg_afe_pga_0/eeg_fd_ota_chopped_full2_0/eeg_fd_ota_core_soft_0/m1_53941_n3864# VSS 6.746650e-16
C3302 eeg_afe_pga_0/eeg_fd_ota_chopped_full2_0/eeg_fd_ota_core_soft_0/m1_46741_n3864# VSS 6.746650e-16
C3303 eeg_afe_pga_0/eeg_fd_ota_chopped_full2_0/eeg_fd_ota_core_soft_0/m1_47141_3443# VSS 6.746650e-16
C3304 eeg_afe_pga_0/eeg_fd_ota_chopped_full2_0/eeg_fd_ota_core_soft_0/m1_40341_n3864# VSS 6.746650e-16
C3305 eeg_afe_pga_0/eeg_fd_ota_chopped_full2_0/eeg_fd_ota_core_soft_0/m1_40741_3443# VSS 6.746650e-16
C3306 eeg_afe_pga_0/eeg_fd_ota_chopped_full2_0/eeg_fd_ota_core_soft_0/m1_35941_3443# VSS 6.746650e-16
C3307 eeg_afe_pga_0/eeg_fd_ota_chopped_full2_0/eeg_fd_ota_core_soft_0/m1_36341_n3864# VSS 6.746650e-16
C3308 eeg_afe_pga_0/eeg_fd_ota_chopped_full2_0/eeg_fd_ota_core_soft_0/m1_57541_3443# VSS 6.746650e-16
C3309 eeg_afe_pga_0/eeg_fd_ota_chopped_full2_0/eeg_fd_ota_core_soft_0/m1_57941_n3864# VSS 6.746650e-16
C3310 eeg_afe_pga_0/eeg_fd_ota_chopped_full2_0/eeg_fd_ota_core_soft_0/m1_53141_n3864# VSS 6.746650e-16
C3311 eeg_afe_pga_0/eeg_fd_ota_chopped_full2_0/eeg_fd_ota_core_soft_0/m1_53541_3443# VSS 6.746650e-16
C3312 eeg_afe_pga_0/eeg_fd_ota_chopped_full2_0/eeg_fd_ota_core_soft_0/m1_46341_3443# VSS 6.746650e-16
C3313 eeg_afe_pga_0/eeg_fd_ota_chopped_full2_0/eeg_fd_ota_core_soft_0/m1_46741_n3864# VSS 6.746650e-16
C3314 eeg_afe_pga_0/eeg_fd_ota_chopped_full2_0/eeg_fd_ota_core_soft_0/m1_n44859_n3864# VSS 6.746650e-16
C3315 eeg_afe_pga_0/eeg_fd_ota_chopped_full2_0/eeg_fd_ota_core_soft_0/m1_n45259_3443# VSS 6.746650e-16
C3316 eeg_afe_pga_0/eeg_fd_ota_chopped_full2_0/eeg_fd_ota_core_soft_0/m1_39941_3443# VSS 6.746650e-16
C3317 eeg_afe_pga_0/eeg_fd_ota_chopped_full2_0/eeg_fd_ota_core_soft_0/m1_40341_n3864# VSS 6.746650e-16
C3318 eeg_afe_pga_0/eeg_fd_ota_chopped_full2_0/eeg_fd_ota_core_soft_0/m1_57141_n3864# VSS 6.746650e-16
C3319 eeg_afe_pga_0/eeg_fd_ota_chopped_full2_0/eeg_fd_ota_core_soft_0/m1_57541_3443# VSS 6.746650e-16
C3320 eeg_afe_pga_0/eeg_fd_ota_chopped_full2_0/eeg_fd_ota_core_soft_0/m1_52741_3443# VSS 6.746650e-16
C3321 eeg_afe_pga_0/eeg_fd_ota_chopped_full2_0/eeg_fd_ota_core_soft_0/m1_53141_n3864# VSS 6.746650e-16
C3322 eeg_afe_pga_0/eeg_fd_ota_chopped_full2_0/eeg_fd_ota_core_soft_0/m1_45941_n3864# VSS 6.746650e-16
C3323 eeg_afe_pga_0/eeg_fd_ota_chopped_full2_0/eeg_fd_ota_core_soft_0/m1_46341_3443# VSS 6.746650e-16
C3324 eeg_afe_pga_0/eeg_fd_ota_chopped_full2_0/eeg_fd_ota_core_soft_0/m1_n45259_3443# VSS 6.746650e-16
C3325 eeg_afe_pga_0/eeg_fd_ota_chopped_full2_0/eeg_fd_ota_core_soft_0/m1_n45659_n3864# VSS 6.746650e-16
C3326 eeg_afe_pga_0/eeg_fd_ota_chopped_full2_0/eeg_fd_ota_core_soft_0/m1_n40859_n3864# VSS 6.746650e-16
C3327 eeg_afe_pga_0/eeg_fd_ota_chopped_full2_0/eeg_fd_ota_core_soft_0/m1_n41259_3443# VSS 6.746650e-16
C3328 eeg_afe_pga_0/eeg_fd_ota_chopped_full2_0/eeg_fd_ota_core_soft_0/m1_56741_3443# VSS 6.746650e-16
C3329 eeg_afe_pga_0/eeg_fd_ota_chopped_full2_0/eeg_fd_ota_core_soft_0/m1_57141_n3864# VSS 6.746650e-16
C3330 eeg_afe_pga_0/eeg_fd_ota_chopped_full2_0/eeg_fd_ota_core_soft_0/m1_52341_n3864# VSS 6.746650e-16
C3331 eeg_afe_pga_0/eeg_fd_ota_chopped_full2_0/eeg_fd_ota_core_soft_0/m1_52741_3443# VSS 6.746650e-16
C3332 eeg_afe_pga_0/eeg_fd_ota_chopped_full2_0/eeg_fd_ota_core_soft_0/m1_45541_3443# VSS 6.746650e-16
C3333 eeg_afe_pga_0/eeg_fd_ota_chopped_full2_0/eeg_fd_ota_core_soft_0/m1_45941_n3864# VSS 6.746650e-16
C3334 eeg_afe_pga_0/eeg_fd_ota_chopped_full2_0/eeg_fd_ota_core_soft_0/m1_n45659_n3864# VSS 6.746650e-16
C3335 eeg_afe_pga_0/eeg_fd_ota_chopped_full2_0/eeg_fd_ota_core_soft_0/m1_n46059_3443# VSS 6.746650e-16
C3336 eeg_afe_pga_0/eeg_fd_ota_chopped_full2_0/eeg_fd_ota_core_soft_0/m1_n41259_3443# VSS 6.746650e-16
C3337 eeg_afe_pga_0/eeg_fd_ota_chopped_full2_0/eeg_fd_ota_core_soft_0/m1_n41659_n3864# VSS 6.746650e-16
C3338 eeg_afe_pga_0/eeg_fd_ota_chopped_full2_0/eeg_fd_ota_core_soft_0/m1_n36859_n3864# VSS 6.746650e-16
C3339 eeg_afe_pga_0/eeg_fd_ota_chopped_full2_0/eeg_fd_ota_core_soft_0/m1_n37259_3443# VSS 6.746650e-16
C3340 eeg_afe_pga_0/eeg_fd_ota_chopped_full2_0/eeg_fd_ota_core_soft_0/m1_56341_n3864# VSS 6.746650e-16
C3341 eeg_afe_pga_0/eeg_fd_ota_chopped_full2_0/eeg_fd_ota_core_soft_0/m1_56741_3443# VSS 6.746650e-16
C3342 eeg_afe_pga_0/eeg_fd_ota_chopped_full2_0/eeg_fd_ota_core_soft_0/m1_51941_3443# VSS 6.746650e-16
C3343 eeg_afe_pga_0/eeg_fd_ota_chopped_full2_0/eeg_fd_ota_core_soft_0/m1_52341_n3864# VSS 6.746650e-16
C3344 eeg_afe_pga_0/eeg_fd_ota_chopped_full2_0/eeg_fd_ota_core_soft_0/m1_45141_n3864# VSS 6.746650e-16
C3345 eeg_afe_pga_0/eeg_fd_ota_chopped_full2_0/eeg_fd_ota_core_soft_0/m1_45541_3443# VSS 6.746650e-16
C3346 eeg_afe_pga_0/eeg_fd_ota_chopped_full2_0/eeg_fd_ota_core_soft_0/m1_n46059_3443# VSS 6.746650e-16
C3347 eeg_afe_pga_0/eeg_fd_ota_chopped_full2_0/eeg_fd_ota_core_soft_0/m1_n46459_n3864# VSS 6.746650e-16
C3348 eeg_afe_pga_0/eeg_fd_ota_chopped_full2_0/eeg_fd_ota_core_soft_0/m1_n41659_n3864# VSS 6.746650e-16
C3349 eeg_afe_pga_0/eeg_fd_ota_chopped_full2_0/eeg_fd_ota_core_soft_0/m1_n42059_3443# VSS 6.746650e-16
C3350 eeg_afe_pga_0/eeg_fd_ota_chopped_full2_0/eeg_fd_ota_core_soft_0/m1_n37259_3443# VSS 6.746650e-16
C3351 eeg_afe_pga_0/eeg_fd_ota_chopped_full2_0/eeg_fd_ota_core_soft_0/m1_n37659_n3864# VSS 6.746650e-16
C3352 eeg_afe_pga_0/eeg_fd_ota_chopped_full2_0/eeg_fd_ota_core_soft_0/m1_n32859_n3864# VSS 6.746650e-16
C3353 eeg_afe_pga_0/eeg_fd_ota_chopped_full2_0/eeg_fd_ota_core_soft_0/m1_n33259_3443# VSS 6.746650e-16
C3354 eeg_afe_pga_0/eeg_fd_ota_chopped_full2_0/eeg_fd_ota_core_soft_0/m1_55941_3443# VSS 6.746650e-16
C3355 eeg_afe_pga_0/eeg_fd_ota_chopped_full2_0/eeg_fd_ota_core_soft_0/m1_56341_n3864# VSS 6.746650e-16
C3356 eeg_afe_pga_0/eeg_fd_ota_chopped_full2_0/eeg_fd_ota_core_soft_0/m1_51541_n3864# VSS 6.746650e-16
C3357 eeg_afe_pga_0/eeg_fd_ota_chopped_full2_0/eeg_fd_ota_core_soft_0/m1_51941_3443# VSS 6.746650e-16
C3358 eeg_afe_pga_0/eeg_fd_ota_chopped_full2_0/eeg_fd_ota_core_soft_0/m1_44741_3443# VSS 6.746650e-16
C3359 eeg_afe_pga_0/eeg_fd_ota_chopped_full2_0/eeg_fd_ota_core_soft_0/m1_45141_n3864# VSS 6.746650e-16
C3360 eeg_afe_pga_0/eeg_fd_ota_chopped_full2_0/eeg_fd_ota_core_soft_0/m1_n46459_n3864# VSS 6.746650e-16
C3361 eeg_afe_pga_0/eeg_fd_ota_chopped_full2_0/eeg_fd_ota_core_soft_0/m1_n46859_3443# VSS 6.746650e-16
C3362 eeg_afe_pga_0/eeg_fd_ota_chopped_full2_0/eeg_fd_ota_core_soft_0/m1_n42059_3443# VSS 6.746650e-16
C3363 eeg_afe_pga_0/eeg_fd_ota_chopped_full2_0/eeg_fd_ota_core_soft_0/m1_n42459_n3864# VSS 6.746650e-16
C3364 eeg_afe_pga_0/eeg_fd_ota_chopped_full2_0/eeg_fd_ota_core_soft_0/m1_n37659_n3864# VSS 6.746650e-16
C3365 eeg_afe_pga_0/eeg_fd_ota_chopped_full2_0/eeg_fd_ota_core_soft_0/m1_n38059_3443# VSS 6.746650e-16
C3366 eeg_afe_pga_0/eeg_fd_ota_chopped_full2_0/eeg_fd_ota_core_soft_0/m1_n33259_3443# VSS 6.746650e-16
C3367 eeg_afe_pga_0/eeg_fd_ota_chopped_full2_0/eeg_fd_ota_core_soft_0/m1_n33659_n3864# VSS 6.746650e-16
C3368 eeg_afe_pga_0/eeg_fd_ota_chopped_full2_0/eeg_fd_ota_core_soft_0/m1_n28859_n3864# VSS 6.746650e-16
C3369 eeg_afe_pga_0/eeg_fd_ota_chopped_full2_0/eeg_fd_ota_core_soft_0/m1_n29259_3443# VSS 6.746650e-16
C3370 VDD18 VSS 4.124974e-14
C3371 VDD18 eeg_afe_pga_0/eeg_fd_ota_chopped_full2_0/eeg_cmfb_amp_dl2_0/VBP 1.216293e-14
C3372 VDD18 eeg_afe_pga_0/eeg_fd_ota_chopped_full2_0/eeg_fd_ota_core_soft_0/OUTP 1.242512e-15
C3373 eeg_afe_pga_0/eeg_fd_ota_chopped_full2_0/eeg_cmfb_amp_dl2_0/VBP VSS 2.342324e-15
C3374 eeg_afe_pga_0/eeg_fd_ota_chopped_full2_0/eeg_cmfb_amp_dl2_0/VBP eeg_afe_pga_0/eeg_fd_ota_chopped_full2_0/eeg_fd_ota_core_soft_0/OUTP 3.335800e-15
C3375 eeg_afe_pga_0/eeg_fd_ota_chopped_full2_0/eeg_fd_ota_core_soft_0/m1_55541_n3864# VSS 6.746650e-16
C3376 eeg_afe_pga_0/eeg_fd_ota_chopped_full2_0/eeg_fd_ota_core_soft_0/m1_55941_3443# VSS 6.746650e-16
C3377 eeg_afe_pga_0/eeg_fd_ota_chopped_full2_0/eeg_fd_ota_core_soft_0/m1_51141_3443# VSS 6.746650e-16
C3378 eeg_afe_pga_0/eeg_fd_ota_chopped_full2_0/eeg_fd_ota_core_soft_0/m1_51541_n3864# VSS 6.746650e-16
C3379 eeg_afe_pga_0/eeg_fd_ota_chopped_full2_0/eeg_fd_ota_core_soft_0/m1_44341_n3864# VSS 6.746650e-16
C3380 eeg_afe_pga_0/eeg_fd_ota_chopped_full2_0/eeg_fd_ota_core_soft_0/m1_44741_3443# VSS 6.746650e-16
C3381 eeg_afe_pga_0/eeg_fd_ota_chopped_full2_0/eeg_fd_ota_core_soft_0/m1_n55259_n3864# VSS 6.746650e-16
C3382 eeg_afe_pga_0/eeg_fd_ota_chopped_full2_0/eeg_fd_ota_core_soft_0/m1_n55659_3443# VSS 6.746650e-16
C3383 eeg_afe_pga_0/eeg_fd_ota_chopped_full2_0/eeg_fd_ota_core_soft_0/m1_n46859_3443# VSS 6.746650e-16
C3384 eeg_afe_pga_0/eeg_fd_ota_chopped_full2_0/eeg_fd_ota_core_soft_0/m1_n47259_n3864# VSS 6.746650e-16
C3385 eeg_afe_pga_0/eeg_fd_ota_chopped_full2_0/eeg_fd_ota_core_soft_0/m1_n42459_n3864# VSS 6.746650e-16
C3386 eeg_afe_pga_0/eeg_fd_ota_chopped_full2_0/eeg_fd_ota_core_soft_0/m1_n42859_3443# VSS 6.746650e-16
C3387 eeg_afe_pga_0/eeg_fd_ota_chopped_full2_0/eeg_fd_ota_core_soft_0/m1_n38059_3443# VSS 6.746650e-16
C3388 eeg_afe_pga_0/eeg_fd_ota_chopped_full2_0/eeg_fd_ota_core_soft_0/m1_n38459_n3864# VSS 6.746650e-16
C3389 eeg_afe_pga_0/eeg_fd_ota_chopped_full2_0/eeg_fd_ota_core_soft_0/m1_n33659_n3864# VSS 6.746650e-16
C3390 eeg_afe_pga_0/eeg_fd_ota_chopped_full2_0/eeg_fd_ota_core_soft_0/m1_n34059_3443# VSS 6.746650e-16
C3391 eeg_afe_pga_0/eeg_fd_ota_chopped_full2_0/eeg_fd_ota_core_soft_0/m1_n29259_3443# VSS 6.746650e-16
C3392 eeg_afe_pga_0/eeg_fd_ota_chopped_full2_0/eeg_fd_ota_core_soft_0/m1_n29659_n3864# VSS 6.746650e-16
C3393 eeg_afe_pga_0/eeg_fd_ota_chopped_full2_0/eeg_fd_ota_core_soft_0/m1_55141_3443# VSS 6.746650e-16
C3394 eeg_afe_pga_0/eeg_fd_ota_chopped_full2_0/eeg_fd_ota_core_soft_0/m1_55541_n3864# VSS 6.746650e-16
C3395 eeg_afe_pga_0/eeg_fd_ota_chopped_full2_0/eeg_fd_ota_core_soft_0/m1_50741_n3864# VSS 6.746650e-16
C3396 eeg_afe_pga_0/eeg_fd_ota_chopped_full2_0/eeg_fd_ota_core_soft_0/m1_51141_3443# VSS 6.746650e-16
C3397 eeg_afe_pga_0/eeg_fd_ota_chopped_full2_0/eeg_fd_ota_core_soft_0/m1_43941_3443# VSS 6.746650e-16
C3398 eeg_afe_pga_0/eeg_fd_ota_chopped_full2_0/eeg_fd_ota_core_soft_0/m1_44341_n3864# VSS 6.746650e-16
C3399 eeg_afe_pga_0/eeg_fd_ota_chopped_full2_0/eeg_fd_ota_core_soft_0/m1_n55659_3443# VSS 6.746650e-16
C3400 eeg_afe_pga_0/eeg_fd_ota_chopped_full2_0/eeg_fd_ota_core_soft_0/m1_n56059_n3864# VSS 6.746650e-16
C3401 eeg_afe_pga_0/eeg_fd_ota_chopped_full2_0/eeg_fd_ota_core_soft_0/m1_n47259_n3864# VSS 6.746650e-16
C3402 eeg_afe_pga_0/eeg_fd_ota_chopped_full2_0/eeg_fd_ota_core_soft_0/m1_n47659_3443# VSS 6.746650e-16
C3403 eeg_afe_pga_0/eeg_fd_ota_chopped_full2_0/eeg_fd_ota_core_soft_0/m1_n42859_3443# VSS 6.746650e-16
C3404 eeg_afe_pga_0/eeg_fd_ota_chopped_full2_0/eeg_fd_ota_core_soft_0/m1_n43259_n3864# VSS 6.746650e-16
C3405 eeg_afe_pga_0/eeg_fd_ota_chopped_full2_0/eeg_fd_ota_core_soft_0/m1_n38459_n3864# VSS 6.746650e-16
C3406 eeg_afe_pga_0/eeg_fd_ota_chopped_full2_0/eeg_fd_ota_core_soft_0/m1_n38859_3443# VSS 6.746650e-16
C3407 eeg_afe_pga_0/eeg_fd_ota_chopped_full2_0/eeg_fd_ota_core_soft_0/m1_n34059_3443# VSS 6.746650e-16
C3408 eeg_afe_pga_0/eeg_fd_ota_chopped_full2_0/eeg_fd_ota_core_soft_0/m1_n34459_n3864# VSS 6.746650e-16
C3409 eeg_afe_pga_0/eeg_fd_ota_chopped_full2_0/eeg_fd_ota_core_soft_0/m1_n29659_n3864# VSS 6.746650e-16
C3410 eeg_afe_pga_0/eeg_fd_ota_chopped_full2_0/eeg_fd_ota_core_soft_0/m1_n30059_3443# VSS 6.746650e-16
C3411 eeg_afe_pga_0/eeg_fd_ota_chopped_full2_0/eeg_fd_ota_core_soft_0/m1_54741_n3864# VSS 6.746650e-16
C3412 eeg_afe_pga_0/eeg_fd_ota_chopped_full2_0/eeg_fd_ota_core_soft_0/m1_55141_3443# VSS 6.746650e-16
C3413 VCM_REF VSS 6.746650e-16
C3414 eeg_afe_pga_0/eeg_fd_ota_chopped_full2_0/eeg_fd_ota_core_soft_0/m1_50741_n3864# VSS 6.746650e-16
C3415 eeg_afe_pga_0/eeg_fd_ota_chopped_full2_0/eeg_fd_ota_core_soft_0/m1_n56059_n3864# VSS 6.746650e-16
C3416 eeg_afe_pga_0/eeg_fd_ota_chopped_full2_0/eeg_fd_ota_core_soft_0/m1_n56459_3443# VSS 6.746650e-16
C3417 eeg_afe_pga_0/eeg_fd_ota_chopped_full2_0/eeg_fd_ota_core_soft_0/m1_n47659_3443# VSS 6.746650e-16
C3418 eeg_afe_pga_0/eeg_fd_ota_chopped_full2_0/eeg_fd_ota_core_soft_0/m1_n48059_n3864# VSS 6.746650e-16
C3419 eeg_afe_pga_0/eeg_fd_ota_chopped_full2_0/eeg_fd_ota_core_soft_0/m1_n43259_n3864# VSS 6.746650e-16
C3420 eeg_afe_pga_0/eeg_fd_ota_chopped_full2_0/eeg_fd_ota_core_soft_0/m1_n43659_3443# VSS 6.746650e-16
C3421 eeg_afe_pga_0/eeg_fd_ota_chopped_full2_0/eeg_fd_ota_core_soft_0/m1_n38859_3443# VSS 6.746650e-16
C3422 eeg_afe_pga_0/eeg_fd_ota_chopped_full2_0/eeg_fd_ota_core_soft_0/m1_n39259_n3864# VSS 6.746650e-16
C3423 eeg_afe_pga_0/eeg_fd_ota_chopped_full2_0/eeg_fd_ota_core_soft_0/m1_n34459_n3864# VSS 6.746650e-16
C3424 eeg_afe_pga_0/eeg_fd_ota_chopped_full2_0/eeg_fd_ota_core_soft_0/m1_n34859_3443# VSS 6.746650e-16
C3425 eeg_afe_pga_0/eeg_fd_ota_chopped_full2_0/eeg_fd_ota_core_soft_0/m1_n30059_3443# VSS 6.746650e-16
C3426 eeg_afe_pga_0/eeg_fd_ota_chopped_full2_0/eeg_fd_ota_core_soft_0/m1_n30459_n3864# VSS 6.746650e-16
C3427 eeg_afe_pga_0/eeg_fd_ota_chopped_full2_0/eeg_fd_ota_core_soft_0/m1_54341_3443# VSS 6.746650e-16
C3428 eeg_afe_pga_0/eeg_fd_ota_chopped_full2_0/eeg_fd_ota_core_soft_0/m1_54741_n3864# VSS 6.746650e-16
C3429 eeg_afe_pga_0/eeg_fd_ota_chopped_full2_0/eeg_fd_ota_core_soft_0/m1_n56459_3443# VSS 6.746650e-16
C3430 eeg_afe_pga_0/eeg_fd_ota_chopped_full2_0/eeg_fd_ota_core_soft_0/m1_n56859_n3864# VSS 6.746650e-16
C3431 eeg_afe_pga_0/eeg_fd_ota_chopped_full2_0/eeg_fd_ota_core_soft_0/OUTP VSS 6.746650e-16
C3432 eeg_afe_pga_0/eeg_fd_ota_chopped_full2_0/eeg_fd_ota_core_soft_0/m1_n48059_n3864# VSS 6.746650e-16
C3433 eeg_afe_pga_0/eeg_fd_ota_chopped_full2_0/eeg_fd_ota_core_soft_0/m1_n43659_3443# VSS 6.746650e-16
C3434 eeg_afe_pga_0/eeg_fd_ota_chopped_full2_0/eeg_fd_ota_core_soft_0/m1_n44059_n3864# VSS 6.746650e-16
C3435 eeg_afe_pga_0/eeg_fd_ota_chopped_full2_0/eeg_fd_ota_core_soft_0/m1_n39259_n3864# VSS 6.746650e-16
C3436 eeg_afe_pga_0/eeg_fd_ota_chopped_full2_0/eeg_fd_ota_core_soft_0/m1_n39659_3443# VSS 6.746650e-16
C3437 eeg_afe_pga_0/eeg_fd_ota_chopped_full2_0/eeg_fd_ota_core_soft_0/m1_n34859_3443# VSS 6.746650e-16
C3438 eeg_afe_pga_0/eeg_fd_ota_chopped_full2_0/eeg_fd_ota_core_soft_0/m1_n35259_n3864# VSS 6.746650e-16
C3439 eeg_afe_pga_0/eeg_fd_ota_chopped_full2_0/eeg_fd_ota_core_soft_0/m1_n30459_n3864# VSS 6.746650e-16
C3440 eeg_afe_pga_0/eeg_fd_ota_chopped_full2_0/eeg_fd_ota_core_soft_0/m1_n30859_3443# VSS 6.746650e-16
C3441 eeg_afe_pga_0/eeg_fd_ota_chopped_full2_0/eeg_fd_ota_core_soft_0/m1_n56859_n3864# VSS 6.746650e-16
C3442 eeg_afe_pga_0/eeg_fd_ota_chopped_full2_0/eeg_fd_ota_core_soft_0/m1_n57259_3443# VSS 6.746650e-16
C3443 VCM_REF VSS 6.746650e-16
C3444 eeg_afe_pga_0/eeg_fd_ota_chopped_full2_0/eeg_fd_ota_core_soft_0/m1_n51259_n3864# VSS 6.746650e-16
C3445 eeg_afe_pga_0/eeg_fd_ota_chopped_full2_0/eeg_fd_ota_core_soft_0/m1_n44059_n3864# VSS 6.746650e-16
C3446 eeg_afe_pga_0/eeg_fd_ota_chopped_full2_0/eeg_fd_ota_core_soft_0/m1_n44459_3443# VSS 6.746650e-16
C3447 eeg_afe_pga_0/eeg_fd_ota_chopped_full2_0/eeg_fd_ota_core_soft_0/m1_n39659_3443# VSS 6.746650e-16
C3448 eeg_afe_pga_0/eeg_fd_ota_chopped_full2_0/eeg_fd_ota_core_soft_0/m1_n40059_n3864# VSS 6.746650e-16
C3449 eeg_afe_pga_0/eeg_fd_ota_chopped_full2_0/eeg_fd_ota_core_soft_0/m1_n35259_n3864# VSS 6.746650e-16
C3450 eeg_afe_pga_0/eeg_fd_ota_chopped_full2_0/eeg_fd_ota_core_soft_0/m1_n35659_3443# VSS 6.746650e-16
C3451 eeg_afe_pga_0/eeg_fd_ota_chopped_full2_0/eeg_fd_ota_core_soft_0/m1_n30859_3443# VSS 6.746650e-16
C3452 eeg_afe_pga_0/eeg_fd_ota_chopped_full2_0/eeg_fd_ota_core_soft_0/m1_n31259_n3864# VSS 6.746650e-16
C3453 eeg_afe_pga_0/eeg_fd_ota_chopped_full2_0/eeg_fd_ota_core_soft_0/m1_n57259_3443# VSS 6.746650e-16
C3454 eeg_afe_pga_0/eeg_fd_ota_chopped_full2_0/eeg_fd_ota_core_soft_0/m1_n57659_n3864# VSS 6.746650e-16
C3455 eeg_afe_pga_0/eeg_fd_ota_chopped_full2_0/eeg_fd_ota_core_soft_0/m1_n44459_3443# VSS 6.746650e-16
C3456 eeg_afe_pga_0/eeg_fd_ota_chopped_full2_0/eeg_fd_ota_core_soft_0/m1_n44859_n3864# VSS 6.746650e-16
C3457 eeg_afe_pga_0/eeg_fd_ota_chopped_full2_0/eeg_fd_ota_core_soft_0/m1_n40059_n3864# VSS 6.746650e-16
C3458 eeg_afe_pga_0/eeg_fd_ota_chopped_full2_0/eeg_fd_ota_core_soft_0/m1_n40459_3443# VSS 6.746650e-16
C3459 eeg_afe_pga_0/eeg_fd_ota_chopped_full2_0/eeg_fd_ota_core_soft_0/m1_n35659_3443# VSS 6.746650e-16
C3460 eeg_afe_pga_0/eeg_fd_ota_chopped_full2_0/eeg_fd_ota_core_soft_0/m1_n36059_n3864# VSS 6.746650e-16
C3461 eeg_afe_pga_0/eeg_fd_ota_chopped_full2_0/eeg_fd_ota_core_soft_0/m1_n31259_n3864# VSS 6.746650e-16
C3462 eeg_afe_pga_0/eeg_fd_ota_chopped_full2_0/eeg_fd_ota_core_soft_0/m1_n31659_3443# VSS 6.746650e-16
C3463 VDD18 VSS 4.124974e-14
C3464 VDD18 eeg_afe_pga_0/eeg_fd_ota_chopped_full2_0/eeg_cmfb_amp_dl2_0/VBP 1.216293e-14
C3465 VDD18 eeg_afe_pga_0/eeg_fd_ota_chopped_full2_0/eeg_fd_ota_core_soft_0/OUTN 1.242512e-15
C3466 eeg_afe_pga_0/eeg_fd_ota_chopped_full2_0/eeg_cmfb_amp_dl2_0/VBP VSS 2.342324e-15
C3467 eeg_afe_pga_0/eeg_fd_ota_chopped_full2_0/eeg_cmfb_amp_dl2_0/VBP eeg_afe_pga_0/eeg_fd_ota_chopped_full2_0/eeg_fd_ota_core_soft_0/OUTN 3.335800e-15
C3468 eeg_afe_pga_0/eeg_fd_ota_chopped_full2_0/eeg_fd_ota_core_soft_0/m1_n57659_n3864# VSS 6.746650e-16
C3469 eeg_afe_pga_0/eeg_fd_ota_chopped_full2_0/eeg_fd_ota_core_soft_0/m1_n58059_3443# VSS 6.746650e-16
C3470 eeg_afe_pga_0/eeg_fd_ota_chopped_full2_0/eeg_fd_ota_core_soft_0/m1_n40459_3443# VSS 6.746650e-16
C3471 eeg_afe_pga_0/eeg_fd_ota_chopped_full2_0/eeg_fd_ota_core_soft_0/m1_n40859_n3864# VSS 6.746650e-16
C3472 eeg_afe_pga_0/eeg_fd_ota_chopped_full2_0/eeg_fd_ota_core_soft_0/m1_n36059_n3864# VSS 6.746650e-16
C3473 eeg_afe_pga_0/eeg_fd_ota_chopped_full2_0/eeg_fd_ota_core_soft_0/m1_n36459_3443# VSS 6.746650e-16
C3474 eeg_afe_pga_0/eeg_fd_ota_chopped_full2_0/eeg_fd_ota_core_soft_0/m1_n31659_3443# VSS 6.746650e-16
C3475 eeg_afe_pga_0/eeg_fd_ota_chopped_full2_0/eeg_fd_ota_core_soft_0/m1_n32059_n3864# VSS 6.746650e-16
C3476 eeg_afe_pga_0/eeg_fd_ota_chopped_full2_0/eeg_fd_ota_core_soft_0/m1_n58059_3443# VSS 6.746650e-16
C3477 eeg_afe_pga_0/eeg_fd_ota_chopped_full2_0/eeg_fd_ota_core_soft_0/m1_n58459_n3864# VSS 6.746650e-16
C3478 eeg_afe_pga_0/eeg_fd_ota_chopped_full2_0/eeg_fd_ota_core_soft_0/m1_n36459_3443# VSS 6.746650e-16
C3479 eeg_afe_pga_0/eeg_fd_ota_chopped_full2_0/eeg_fd_ota_core_soft_0/m1_n36859_n3864# VSS 6.746650e-16
C3480 eeg_afe_pga_0/eeg_fd_ota_chopped_full2_0/eeg_fd_ota_core_soft_0/m1_n32059_n3864# VSS 6.746650e-16
C3481 eeg_afe_pga_0/eeg_fd_ota_chopped_full2_0/eeg_fd_ota_core_soft_0/m1_n32459_3443# VSS 6.746650e-16
C3482 eeg_afe_pga_0/eeg_fd_ota_chopped_full2_0/eeg_fd_ota_core_soft_0/OUTP VSS 6.746650e-16
C3483 eeg_afe_pga_0/eeg_fd_ota_chopped_full2_0/eeg_fd_ota_core_soft_0/m1_n58459_n3864# VSS 6.746650e-16
C3484 eeg_afe_pga_0/eeg_fd_ota_chopped_full2_0/eeg_fd_ota_core_soft_0/m1_n32459_3443# VSS 6.746650e-16
C3485 eeg_afe_pga_0/eeg_fd_ota_chopped_full2_0/eeg_fd_ota_core_soft_0/m1_n32859_n3864# VSS 6.746650e-16
C3486 eeg_afe_pga_0/eeg_fd_ota_chopped_full2_0/eeg_cmfb_amp_dl2_0/VCM_SENSE VSS 6.746650e-16
C3487 eeg_afe_pga_0/eeg_fd_ota_chopped_full2_0/eeg_fd_ota_core_soft_0/m1_n28859_n3864# VSS 6.746650e-16
C3488 VCM_REF VSS 1.699680e-15
C3489 VCM_REF eeg_afe_pga_0/eeg_pseudo_res_0/m1_68_66# 5.017998e-16
C3490 VCM_REF eeg_afe_pga_0/eeg_tg_lowq_3/B 8.460309e-16
C3491 eeg_afe_pga_0/eeg_pseudo_res_0/m1_68_66# VSS 3.582030e-15
C3492 eeg_afe_pga_0/eeg_pseudo_res_0/m1_68_66# eeg_afe_pga_0/eeg_tg_lowq_3/B 1.314672e-15
C3493 eeg_afe_pga_0/eeg_tg_lowq_3/B VSS 8.414800e-16
C3494 VCM_REF VSS 3.678650e-15
C3495 VCM_REF eeg_afe_pga_0/eeg_pseudo_res_0/m1_68_66# 1.322042e-15
C3496 eeg_afe_pga_0/eeg_pseudo_res_0/m1_68_66# VSS 4.103261e-16
C3497 eeg_afe_pga_0/eeg_pseudo_res_0/m1_68_66# VSS 4.103261e-16
C3498 eeg_afe_pga_0/eeg_pseudo_res_0/m1_68_66# eeg_afe_pga_0/eeg_tg_lowq_3/B 1.322042e-15
C3499 eeg_afe_pga_0/eeg_tg_lowq_3/B VSS 3.678650e-15
C3500 VCM_REF VSS 1.699680e-15
C3501 VCM_REF eeg_afe_pga_0/eeg_pseudo_res_1/m1_68_66# 5.017998e-16
C3502 VCM_REF eeg_afe_pga_0/eeg_tg_lowq_7/B 8.460309e-16
C3503 eeg_afe_pga_0/eeg_pseudo_res_1/m1_68_66# VSS 3.582030e-15
C3504 eeg_afe_pga_0/eeg_pseudo_res_1/m1_68_66# eeg_afe_pga_0/eeg_tg_lowq_7/B 1.314672e-15
C3505 eeg_afe_pga_0/eeg_tg_lowq_7/B VSS 8.414800e-16
C3506 VCM_REF VSS 3.678650e-15
C3507 VCM_REF eeg_afe_pga_0/eeg_pseudo_res_1/m1_68_66# 1.322042e-15
C3508 eeg_afe_pga_0/eeg_pseudo_res_1/m1_68_66# VSS 4.103261e-16
C3509 eeg_afe_pga_0/eeg_pseudo_res_1/m1_68_66# VSS 4.103261e-16
C3510 eeg_afe_pga_0/eeg_pseudo_res_1/m1_68_66# eeg_afe_pga_0/eeg_tg_lowq_7/B 1.322042e-15
C3511 eeg_afe_pga_0/eeg_tg_lowq_7/B VSS 3.678650e-15
C3512 S16 VDD18 6.588032e-16
C3513 S16 VSS 1.789951e-15
C3514 S16 eeg_afe_pga_0/eeg_inv_2/Y 1.215812e-15
C3515 S16 eeg_afe_pga_0/eeg_tg_lowq_0/A 1.181323e-16
C3516 S16 eeg_afe_pga_0/eeg_tg_lowq_3/B 2.857784e-16
C3517 VDD18 VSS 3.714735e-15
C3518 VDD18 eeg_afe_pga_0/eeg_inv_2/Y 5.262242e-16
C3519 VDD18 eeg_afe_pga_0/eeg_tg_lowq_0/A 1.484229e-16
C3520 VDD18 eeg_afe_pga_0/eeg_tg_lowq_3/B 3.128723e-16
C3521 VSS eeg_afe_pga_0/eeg_inv_2/Y 1.446619e-15
C3522 VSS eeg_afe_pga_0/eeg_tg_lowq_0/A 7.819878e-17
C3523 VSS eeg_afe_pga_0/eeg_tg_lowq_3/B 1.097210e-16
C3524 eeg_afe_pga_0/eeg_inv_2/Y VSS 1.090650e-15
C3525 eeg_afe_pga_0/eeg_inv_2/Y eeg_afe_pga_0/eeg_tg_lowq_0/A 4.755154e-17
C3526 eeg_afe_pga_0/eeg_inv_2/Y eeg_afe_pga_0/eeg_tg_lowq_3/B 1.076105e-16
C3527 eeg_afe_pga_0/eeg_tg_lowq_0/A VSS 2.430800e-15
C3528 eeg_afe_pga_0/eeg_tg_lowq_0/A eeg_afe_pga_0/eeg_tg_lowq_3/B 1.492117e-15
C3529 eeg_afe_pga_0/eeg_tg_lowq_3/B VSS 1.462840e-15
C3530 S16 VDD18 1.564350e-16
C3531 S16 VSS 4.901000e-17
C3532 S16 eeg_afe_pga_0/eeg_tg_lowq_3/B 2.862080e-17
C3533 VDD18 VSS 1.561810e-15
C3534 VDD18 eeg_afe_pga_0/eeg_tg_lowq_3/B 1.697704e-16
C3535 eeg_afe_pga_0/eeg_tg_lowq_3/B VSS 8.867300e-17
C3536 eeg_afe_pga_0/eeg_inv_2/Y VSS 2.062020e-16
C3537 eeg_afe_pga_0/eeg_inv_2/Y eeg_afe_pga_0/eeg_tg_lowq_0/A 2.084120e-17
C3538 eeg_afe_pga_0/eeg_tg_lowq_0/A VSS 1.088312e-16
C3539 eeg_afe_pga_0/eeg_inv_2/Y VSS 2.062020e-16
C3540 eeg_afe_pga_0/eeg_inv_2/Y eeg_afe_pga_0/eeg_tg_lowq_3/B 2.084120e-17
C3541 eeg_afe_pga_0/eeg_tg_lowq_3/B VSS 1.088312e-16
C3542 VDD18 VSS 2.327590e-15
C3543 VDD18 eeg_afe_pga_0/eeg_inv_2/Y 1.594600e-16
C3544 VDD18 eeg_afe_pga_0/eeg_tg_lowq_0/A 1.554040e-16
C3545 VDD18 eeg_afe_pga_0/eeg_tg_lowq_3/B 1.554040e-16
C3546 eeg_afe_pga_0/eeg_inv_2/Y VSS 4.382640e-17
C3547 eeg_afe_pga_0/eeg_inv_2/Y eeg_afe_pga_0/eeg_tg_lowq_0/A 2.402360e-17
C3548 eeg_afe_pga_0/eeg_inv_2/Y eeg_afe_pga_0/eeg_tg_lowq_3/B 2.402360e-17
C3549 eeg_afe_pga_0/eeg_tg_lowq_0/A VSS 7.837880e-17
C3550 eeg_afe_pga_0/eeg_tg_lowq_0/A eeg_afe_pga_0/eeg_tg_lowq_3/B 1.170160e-16
C3551 eeg_afe_pga_0/eeg_tg_lowq_3/B VSS 7.837880e-17
C3552 S16 VDD18 1.564350e-16
C3553 S16 VSS 4.901000e-17
C3554 S16 eeg_afe_pga_0/eeg_tg_lowq_0/A 2.862080e-17
C3555 VDD18 VSS 1.561810e-15
C3556 VDD18 eeg_afe_pga_0/eeg_tg_lowq_0/A 1.697704e-16
C3557 eeg_afe_pga_0/eeg_tg_lowq_0/A VSS 8.867300e-17
C3558 S16 VSS 2.027230e-16
C3561 eeg_afe_pga_0/eeg_tg_lowq_0/A VSS 1.267930e-16
C3562 eeg_afe_pga_0/eeg_tg_lowq_0/A eeg_afe_pga_0/eeg_tg_lowq_3/B 5.623600e-17
C3563 eeg_afe_pga_0/eeg_tg_lowq_3/B VSS 1.267930e-16
C3564 S8 VDD18 6.588032e-16
C3565 S8 VSS 1.789951e-15
C3566 S8 eeg_afe_pga_0/eeg_inv_3/Y 1.215812e-15
C3567 S8 eeg_afe_pga_0/eeg_tg_lowq_1/A 1.181323e-16
C3568 S8 eeg_afe_pga_0/eeg_tg_lowq_3/B 2.857784e-16
C3569 VDD18 VSS 3.714735e-15
C3570 VDD18 eeg_afe_pga_0/eeg_inv_3/Y 5.262242e-16
C3571 VDD18 eeg_afe_pga_0/eeg_tg_lowq_1/A 1.484229e-16
C3572 VDD18 eeg_afe_pga_0/eeg_tg_lowq_3/B 3.128723e-16
C3573 VSS eeg_afe_pga_0/eeg_inv_3/Y 1.446619e-15
C3574 VSS eeg_afe_pga_0/eeg_tg_lowq_1/A 7.819878e-17
C3575 VSS eeg_afe_pga_0/eeg_tg_lowq_3/B 1.097210e-16
C3576 eeg_afe_pga_0/eeg_inv_3/Y VSS 1.090650e-15
C3577 eeg_afe_pga_0/eeg_inv_3/Y eeg_afe_pga_0/eeg_tg_lowq_1/A 4.755154e-17
C3578 eeg_afe_pga_0/eeg_inv_3/Y eeg_afe_pga_0/eeg_tg_lowq_3/B 1.076105e-16
C3579 eeg_afe_pga_0/eeg_tg_lowq_1/A VSS 2.430800e-15
C3580 eeg_afe_pga_0/eeg_tg_lowq_1/A eeg_afe_pga_0/eeg_tg_lowq_3/B 1.492117e-15
C3581 eeg_afe_pga_0/eeg_tg_lowq_3/B VSS 1.462840e-15
C3582 S8 VDD18 1.564350e-16
C3583 S8 VSS 4.901000e-17
C3584 S8 eeg_afe_pga_0/eeg_tg_lowq_3/B 2.862080e-17
C3585 VDD18 VSS 1.561810e-15
C3586 VDD18 eeg_afe_pga_0/eeg_tg_lowq_3/B 1.697704e-16
C3587 eeg_afe_pga_0/eeg_tg_lowq_3/B VSS 8.867300e-17
C3588 eeg_afe_pga_0/eeg_inv_3/Y VSS 2.062020e-16
C3589 eeg_afe_pga_0/eeg_inv_3/Y eeg_afe_pga_0/eeg_tg_lowq_1/A 2.084120e-17
C3590 eeg_afe_pga_0/eeg_tg_lowq_1/A VSS 1.088312e-16
C3591 eeg_afe_pga_0/eeg_inv_3/Y VSS 2.062020e-16
C3592 eeg_afe_pga_0/eeg_inv_3/Y eeg_afe_pga_0/eeg_tg_lowq_3/B 2.084120e-17
C3593 eeg_afe_pga_0/eeg_tg_lowq_3/B VSS 1.088312e-16
C3594 VDD18 VSS 2.327590e-15
C3595 VDD18 eeg_afe_pga_0/eeg_inv_3/Y 1.594600e-16
C3596 VDD18 eeg_afe_pga_0/eeg_tg_lowq_1/A 1.554040e-16
C3597 VDD18 eeg_afe_pga_0/eeg_tg_lowq_3/B 1.554040e-16
C3598 eeg_afe_pga_0/eeg_inv_3/Y VSS 4.382640e-17
C3599 eeg_afe_pga_0/eeg_inv_3/Y eeg_afe_pga_0/eeg_tg_lowq_1/A 2.402360e-17
C3600 eeg_afe_pga_0/eeg_inv_3/Y eeg_afe_pga_0/eeg_tg_lowq_3/B 2.402360e-17
C3601 eeg_afe_pga_0/eeg_tg_lowq_1/A VSS 7.837880e-17
C3602 eeg_afe_pga_0/eeg_tg_lowq_1/A eeg_afe_pga_0/eeg_tg_lowq_3/B 1.170160e-16
C3603 eeg_afe_pga_0/eeg_tg_lowq_3/B VSS 7.837880e-17
C3604 S8 VDD18 1.564350e-16
C3605 S8 VSS 4.901000e-17
C3606 S8 eeg_afe_pga_0/eeg_tg_lowq_1/A 2.862080e-17
C3607 VDD18 VSS 1.561810e-15
C3608 VDD18 eeg_afe_pga_0/eeg_tg_lowq_1/A 1.697704e-16
C3609 eeg_afe_pga_0/eeg_tg_lowq_1/A VSS 8.867300e-17
C3610 S8 VSS 2.027230e-16
C3613 eeg_afe_pga_0/eeg_tg_lowq_1/A VSS 1.267930e-16
C3614 eeg_afe_pga_0/eeg_tg_lowq_1/A eeg_afe_pga_0/eeg_tg_lowq_3/B 5.623600e-17
C3615 eeg_afe_pga_0/eeg_tg_lowq_3/B VSS 1.267930e-16
C3616 VCM_REF VDD18 3.128723e-16
C3617 VCM_REF VSS 1.858339e-15
C3618 VCM_REF eeg_afe_pga_0/eeg_inv_0/Y 1.076105e-16
C3619 VCM_REF eeg_afe_pga_0/eeg_tg_lowq_3/B 1.492117e-15
C3620 VDD18 VSS 4.373538e-15
C3621 VDD18 eeg_afe_pga_0/eeg_inv_0/Y 5.262242e-16
C3622 VDD18 eeg_afe_pga_0/eeg_tg_lowq_3/B 1.484229e-16
C3623 VSS eeg_afe_pga_0/eeg_inv_0/Y 2.662431e-15
C3624 VSS eeg_afe_pga_0/eeg_tg_lowq_3/B 1.963311e-16
C3625 eeg_afe_pga_0/eeg_inv_0/Y VSS 1.090650e-15
C3626 eeg_afe_pga_0/eeg_inv_0/Y eeg_afe_pga_0/eeg_tg_lowq_3/B 4.755154e-17
C3627 eeg_afe_pga_0/eeg_tg_lowq_3/B VSS 2.430800e-15
C3628 VCM_REF VDD18 1.697704e-16
C3629 VCM_REF VSS 1.172938e-16
C3630 VDD18 VSS 1.718245e-15
C3631 eeg_afe_pga_0/eeg_inv_0/Y VSS 2.062020e-16
C3632 eeg_afe_pga_0/eeg_inv_0/Y eeg_afe_pga_0/eeg_tg_lowq_3/B 2.084120e-17
C3633 eeg_afe_pga_0/eeg_tg_lowq_3/B VSS 1.088312e-16
C3634 VCM_REF VSS 1.088312e-16
C3635 VCM_REF eeg_afe_pga_0/eeg_inv_0/Y 2.084120e-17
C3636 eeg_afe_pga_0/eeg_inv_0/Y VSS 2.062020e-16
C3637 VCM_REF VDD18 1.554040e-16
C3638 VCM_REF VSS 7.837880e-17
C3639 VCM_REF eeg_afe_pga_0/eeg_inv_0/Y 2.402360e-17
C3640 VCM_REF eeg_afe_pga_0/eeg_tg_lowq_3/B 1.170160e-16
C3641 VDD18 VSS 2.327590e-15
C3642 VDD18 eeg_afe_pga_0/eeg_inv_0/Y 1.594600e-16
C3643 VDD18 eeg_afe_pga_0/eeg_tg_lowq_3/B 1.554040e-16
C3644 eeg_afe_pga_0/eeg_inv_0/Y VSS 4.382640e-17
C3645 eeg_afe_pga_0/eeg_inv_0/Y eeg_afe_pga_0/eeg_tg_lowq_3/B 2.402360e-17
C3646 eeg_afe_pga_0/eeg_tg_lowq_3/B VSS 7.837880e-17
C3647 VDD18 VSS 1.718245e-15
C3648 VDD18 eeg_afe_pga_0/eeg_tg_lowq_3/B 1.697704e-16
C3649 VSS eeg_afe_pga_0/eeg_tg_lowq_3/B 2.862080e-17
C3650 eeg_afe_pga_0/eeg_tg_lowq_3/B VSS 8.867300e-17
C3651 VCM_REF VSS 1.411034e-16
C3652 VCM_REF eeg_afe_pga_0/eeg_tg_lowq_3/B 5.623600e-17
C3654 eeg_afe_pga_0/eeg_tg_lowq_3/B VSS 1.267930e-16
C3655 S32 VDD18 6.588032e-16
C3656 S32 VSS 1.789951e-15
C3657 S32 eeg_afe_pga_0/eeg_inv_1/Y 1.215812e-15
C3658 S32 eeg_afe_pga_0/eeg_tg_lowq_3/A 1.181323e-16
C3659 S32 eeg_afe_pga_0/eeg_tg_lowq_3/B 2.857784e-16
C3660 VDD18 VSS 3.714735e-15
C3661 VDD18 eeg_afe_pga_0/eeg_inv_1/Y 5.262242e-16
C3662 VDD18 eeg_afe_pga_0/eeg_tg_lowq_3/A 1.484229e-16
C3663 VDD18 eeg_afe_pga_0/eeg_tg_lowq_3/B 3.128723e-16
C3664 VSS eeg_afe_pga_0/eeg_inv_1/Y 1.446619e-15
C3665 VSS eeg_afe_pga_0/eeg_tg_lowq_3/A 7.819878e-17
C3666 VSS eeg_afe_pga_0/eeg_tg_lowq_3/B 1.097210e-16
C3667 eeg_afe_pga_0/eeg_inv_1/Y VSS 1.090650e-15
C3668 eeg_afe_pga_0/eeg_inv_1/Y eeg_afe_pga_0/eeg_tg_lowq_3/A 4.755154e-17
C3669 eeg_afe_pga_0/eeg_inv_1/Y eeg_afe_pga_0/eeg_tg_lowq_3/B 1.076105e-16
C3670 eeg_afe_pga_0/eeg_tg_lowq_3/A VSS 2.430800e-15
C3671 eeg_afe_pga_0/eeg_tg_lowq_3/A eeg_afe_pga_0/eeg_tg_lowq_3/B 1.492117e-15
C3672 eeg_afe_pga_0/eeg_tg_lowq_3/B VSS 1.462840e-15
C3673 S32 VDD18 1.564350e-16
C3674 S32 VSS 4.901000e-17
C3675 S32 eeg_afe_pga_0/eeg_tg_lowq_3/B 2.862080e-17
C3676 VDD18 VSS 1.561810e-15
C3677 VDD18 eeg_afe_pga_0/eeg_tg_lowq_3/B 1.697704e-16
C3678 eeg_afe_pga_0/eeg_tg_lowq_3/B VSS 8.867300e-17
C3679 eeg_afe_pga_0/eeg_inv_1/Y VSS 2.062020e-16
C3680 eeg_afe_pga_0/eeg_inv_1/Y eeg_afe_pga_0/eeg_tg_lowq_3/A 2.084120e-17
C3681 eeg_afe_pga_0/eeg_tg_lowq_3/A VSS 1.088312e-16
C3682 eeg_afe_pga_0/eeg_inv_1/Y VSS 2.062020e-16
C3683 eeg_afe_pga_0/eeg_inv_1/Y eeg_afe_pga_0/eeg_tg_lowq_3/B 2.084120e-17
C3684 eeg_afe_pga_0/eeg_tg_lowq_3/B VSS 1.088312e-16
C3685 VDD18 VSS 2.327590e-15
C3686 VDD18 eeg_afe_pga_0/eeg_inv_1/Y 1.594600e-16
C3687 VDD18 eeg_afe_pga_0/eeg_tg_lowq_3/A 1.554040e-16
C3688 VDD18 eeg_afe_pga_0/eeg_tg_lowq_3/B 1.554040e-16
C3689 eeg_afe_pga_0/eeg_inv_1/Y VSS 4.382640e-17
C3690 eeg_afe_pga_0/eeg_inv_1/Y eeg_afe_pga_0/eeg_tg_lowq_3/A 2.402360e-17
C3691 eeg_afe_pga_0/eeg_inv_1/Y eeg_afe_pga_0/eeg_tg_lowq_3/B 2.402360e-17
C3692 eeg_afe_pga_0/eeg_tg_lowq_3/A VSS 7.837880e-17
C3693 eeg_afe_pga_0/eeg_tg_lowq_3/A eeg_afe_pga_0/eeg_tg_lowq_3/B 1.170160e-16
C3694 eeg_afe_pga_0/eeg_tg_lowq_3/B VSS 7.837880e-17
C3695 S32 VDD18 1.564350e-16
C3696 S32 VSS 4.901000e-17
C3697 S32 eeg_afe_pga_0/eeg_tg_lowq_3/A 2.862080e-17
C3698 VDD18 VSS 1.561810e-15
C3699 VDD18 eeg_afe_pga_0/eeg_tg_lowq_3/A 1.697704e-16
C3700 eeg_afe_pga_0/eeg_tg_lowq_3/A VSS 8.867300e-17
C3701 S32 VSS 2.027230e-16
C3704 eeg_afe_pga_0/eeg_tg_lowq_3/A VSS 1.267930e-16
C3705 eeg_afe_pga_0/eeg_tg_lowq_3/A eeg_afe_pga_0/eeg_tg_lowq_3/B 5.623600e-17
C3706 eeg_afe_pga_0/eeg_tg_lowq_3/B VSS 1.267930e-16
C3707 VCM_REF VDD18 3.128723e-16
C3708 VCM_REF VSS 1.858339e-15
C3709 VCM_REF eeg_afe_pga_0/eeg_inv_0/Y 1.076105e-16
C3710 VCM_REF eeg_afe_pga_0/eeg_tg_lowq_7/B 1.492117e-15
C3711 VDD18 VSS 4.373538e-15
C3712 VDD18 eeg_afe_pga_0/eeg_inv_0/Y 5.262242e-16
C3713 VDD18 eeg_afe_pga_0/eeg_tg_lowq_7/B 1.484229e-16
C3714 VSS eeg_afe_pga_0/eeg_inv_0/Y 2.662431e-15
C3715 VSS eeg_afe_pga_0/eeg_tg_lowq_7/B 1.963311e-16
C3716 eeg_afe_pga_0/eeg_inv_0/Y VSS 1.090650e-15
C3717 eeg_afe_pga_0/eeg_inv_0/Y eeg_afe_pga_0/eeg_tg_lowq_7/B 4.755154e-17
C3718 eeg_afe_pga_0/eeg_tg_lowq_7/B VSS 2.430800e-15
C3719 VCM_REF VDD18 1.697704e-16
C3720 VCM_REF VSS 1.172938e-16
C3721 VDD18 VSS 1.718245e-15
C3722 eeg_afe_pga_0/eeg_inv_0/Y VSS 2.062020e-16
C3723 eeg_afe_pga_0/eeg_inv_0/Y eeg_afe_pga_0/eeg_tg_lowq_7/B 2.084120e-17
C3724 eeg_afe_pga_0/eeg_tg_lowq_7/B VSS 1.088312e-16
C3725 VCM_REF VSS 1.088312e-16
C3726 VCM_REF eeg_afe_pga_0/eeg_inv_0/Y 2.084120e-17
C3727 eeg_afe_pga_0/eeg_inv_0/Y VSS 2.062020e-16
C3728 VCM_REF VDD18 1.554040e-16
C3729 VCM_REF VSS 7.837880e-17
C3730 VCM_REF eeg_afe_pga_0/eeg_inv_0/Y 2.402360e-17
C3731 VCM_REF eeg_afe_pga_0/eeg_tg_lowq_7/B 1.170160e-16
C3732 VDD18 VSS 2.327590e-15
C3733 VDD18 eeg_afe_pga_0/eeg_inv_0/Y 1.594600e-16
C3734 VDD18 eeg_afe_pga_0/eeg_tg_lowq_7/B 1.554040e-16
C3735 eeg_afe_pga_0/eeg_inv_0/Y VSS 4.382640e-17
C3736 eeg_afe_pga_0/eeg_inv_0/Y eeg_afe_pga_0/eeg_tg_lowq_7/B 2.402360e-17
C3737 eeg_afe_pga_0/eeg_tg_lowq_7/B VSS 7.837880e-17
C3738 VDD18 VSS 1.718245e-15
C3739 VDD18 eeg_afe_pga_0/eeg_tg_lowq_7/B 1.697704e-16
C3740 VSS eeg_afe_pga_0/eeg_tg_lowq_7/B 2.862080e-17
C3741 eeg_afe_pga_0/eeg_tg_lowq_7/B VSS 8.867300e-17
C3742 VCM_REF VSS 1.411034e-16
C3743 VCM_REF eeg_afe_pga_0/eeg_tg_lowq_7/B 5.623600e-17
C3745 eeg_afe_pga_0/eeg_tg_lowq_7/B VSS 1.267930e-16
C3746 S8 VDD18 6.588032e-16
C3747 S8 VSS 1.789951e-15
C3748 S8 eeg_afe_pga_0/eeg_inv_3/Y 1.215812e-15
C3749 S8 eeg_afe_pga_0/eeg_tg_lowq_5/A 1.181323e-16
C3750 S8 eeg_afe_pga_0/eeg_tg_lowq_7/B 2.857784e-16
C3751 VDD18 VSS 3.714735e-15
C3752 VDD18 eeg_afe_pga_0/eeg_inv_3/Y 5.262242e-16
C3753 VDD18 eeg_afe_pga_0/eeg_tg_lowq_5/A 1.484229e-16
C3754 VDD18 eeg_afe_pga_0/eeg_tg_lowq_7/B 3.128723e-16
C3755 VSS eeg_afe_pga_0/eeg_inv_3/Y 1.446619e-15
C3756 VSS eeg_afe_pga_0/eeg_tg_lowq_5/A 7.819878e-17
C3757 VSS eeg_afe_pga_0/eeg_tg_lowq_7/B 1.097210e-16
C3758 eeg_afe_pga_0/eeg_inv_3/Y VSS 1.090650e-15
C3759 eeg_afe_pga_0/eeg_inv_3/Y eeg_afe_pga_0/eeg_tg_lowq_5/A 4.755154e-17
C3760 eeg_afe_pga_0/eeg_inv_3/Y eeg_afe_pga_0/eeg_tg_lowq_7/B 1.076105e-16
C3761 eeg_afe_pga_0/eeg_tg_lowq_5/A VSS 2.430800e-15
C3762 eeg_afe_pga_0/eeg_tg_lowq_5/A eeg_afe_pga_0/eeg_tg_lowq_7/B 1.492117e-15
C3763 eeg_afe_pga_0/eeg_tg_lowq_7/B VSS 1.462840e-15
C3764 S8 VDD18 1.564350e-16
C3765 S8 VSS 4.901000e-17
C3766 S8 eeg_afe_pga_0/eeg_tg_lowq_7/B 2.862080e-17
C3767 VDD18 VSS 1.561810e-15
C3768 VDD18 eeg_afe_pga_0/eeg_tg_lowq_7/B 1.697704e-16
C3769 eeg_afe_pga_0/eeg_tg_lowq_7/B VSS 8.867300e-17
C3770 eeg_afe_pga_0/eeg_inv_3/Y VSS 2.062020e-16
C3771 eeg_afe_pga_0/eeg_inv_3/Y eeg_afe_pga_0/eeg_tg_lowq_5/A 2.084120e-17
C3772 eeg_afe_pga_0/eeg_tg_lowq_5/A VSS 1.088312e-16
C3773 eeg_afe_pga_0/eeg_inv_3/Y VSS 2.062020e-16
C3774 eeg_afe_pga_0/eeg_inv_3/Y eeg_afe_pga_0/eeg_tg_lowq_7/B 2.084120e-17
C3775 eeg_afe_pga_0/eeg_tg_lowq_7/B VSS 1.088312e-16
C3776 VDD18 VSS 2.327590e-15
C3777 VDD18 eeg_afe_pga_0/eeg_inv_3/Y 1.594600e-16
C3778 VDD18 eeg_afe_pga_0/eeg_tg_lowq_5/A 1.554040e-16
C3779 VDD18 eeg_afe_pga_0/eeg_tg_lowq_7/B 1.554040e-16
C3780 eeg_afe_pga_0/eeg_inv_3/Y VSS 4.382640e-17
C3781 eeg_afe_pga_0/eeg_inv_3/Y eeg_afe_pga_0/eeg_tg_lowq_5/A 2.402360e-17
C3782 eeg_afe_pga_0/eeg_inv_3/Y eeg_afe_pga_0/eeg_tg_lowq_7/B 2.402360e-17
C3783 eeg_afe_pga_0/eeg_tg_lowq_5/A VSS 7.837880e-17
C3784 eeg_afe_pga_0/eeg_tg_lowq_5/A eeg_afe_pga_0/eeg_tg_lowq_7/B 1.170160e-16
C3785 eeg_afe_pga_0/eeg_tg_lowq_7/B VSS 7.837880e-17
C3786 S8 VDD18 1.564350e-16
C3787 S8 VSS 4.901000e-17
C3788 S8 eeg_afe_pga_0/eeg_tg_lowq_5/A 2.862080e-17
C3789 VDD18 VSS 1.561810e-15
C3790 VDD18 eeg_afe_pga_0/eeg_tg_lowq_5/A 1.697704e-16
C3791 eeg_afe_pga_0/eeg_tg_lowq_5/A VSS 8.867300e-17
C3792 S8 VSS 2.027230e-16
C3795 eeg_afe_pga_0/eeg_tg_lowq_5/A VSS 1.267930e-16
C3796 eeg_afe_pga_0/eeg_tg_lowq_5/A eeg_afe_pga_0/eeg_tg_lowq_7/B 5.623600e-17
C3797 eeg_afe_pga_0/eeg_tg_lowq_7/B VSS 1.267930e-16
C3798 S16 VDD18 6.588032e-16
C3799 S16 VSS 1.789951e-15
C3800 S16 eeg_afe_pga_0/eeg_inv_2/Y 1.215812e-15
C3801 S16 eeg_afe_pga_0/eeg_tg_lowq_6/A 1.181323e-16
C3802 S16 eeg_afe_pga_0/eeg_tg_lowq_7/B 2.857784e-16
C3803 VDD18 VSS 3.714735e-15
C3804 VDD18 eeg_afe_pga_0/eeg_inv_2/Y 5.262242e-16
C3805 VDD18 eeg_afe_pga_0/eeg_tg_lowq_6/A 1.484229e-16
C3806 VDD18 eeg_afe_pga_0/eeg_tg_lowq_7/B 3.128723e-16
C3807 VSS eeg_afe_pga_0/eeg_inv_2/Y 1.446619e-15
C3808 VSS eeg_afe_pga_0/eeg_tg_lowq_6/A 7.819878e-17
C3809 VSS eeg_afe_pga_0/eeg_tg_lowq_7/B 1.097210e-16
C3810 eeg_afe_pga_0/eeg_inv_2/Y VSS 1.090650e-15
C3811 eeg_afe_pga_0/eeg_inv_2/Y eeg_afe_pga_0/eeg_tg_lowq_6/A 4.755154e-17
C3812 eeg_afe_pga_0/eeg_inv_2/Y eeg_afe_pga_0/eeg_tg_lowq_7/B 1.076105e-16
C3813 eeg_afe_pga_0/eeg_tg_lowq_6/A VSS 2.430800e-15
C3814 eeg_afe_pga_0/eeg_tg_lowq_6/A eeg_afe_pga_0/eeg_tg_lowq_7/B 1.492117e-15
C3815 eeg_afe_pga_0/eeg_tg_lowq_7/B VSS 1.462840e-15
C3816 S16 VDD18 1.564350e-16
C3817 S16 VSS 4.901000e-17
C3818 S16 eeg_afe_pga_0/eeg_tg_lowq_7/B 2.862080e-17
C3819 VDD18 VSS 1.561810e-15
C3820 VDD18 eeg_afe_pga_0/eeg_tg_lowq_7/B 1.697704e-16
C3821 eeg_afe_pga_0/eeg_tg_lowq_7/B VSS 8.867300e-17
C3822 eeg_afe_pga_0/eeg_inv_2/Y VSS 2.062020e-16
C3823 eeg_afe_pga_0/eeg_inv_2/Y eeg_afe_pga_0/eeg_tg_lowq_6/A 2.084120e-17
C3824 eeg_afe_pga_0/eeg_tg_lowq_6/A VSS 1.088312e-16
C3825 eeg_afe_pga_0/eeg_inv_2/Y VSS 2.062020e-16
C3826 eeg_afe_pga_0/eeg_inv_2/Y eeg_afe_pga_0/eeg_tg_lowq_7/B 2.084120e-17
C3827 eeg_afe_pga_0/eeg_tg_lowq_7/B VSS 1.088312e-16
C3828 VDD18 VSS 2.327590e-15
C3829 VDD18 eeg_afe_pga_0/eeg_inv_2/Y 1.594600e-16
C3830 VDD18 eeg_afe_pga_0/eeg_tg_lowq_6/A 1.554040e-16
C3831 VDD18 eeg_afe_pga_0/eeg_tg_lowq_7/B 1.554040e-16
C3832 eeg_afe_pga_0/eeg_inv_2/Y VSS 4.382640e-17
C3833 eeg_afe_pga_0/eeg_inv_2/Y eeg_afe_pga_0/eeg_tg_lowq_6/A 2.402360e-17
C3834 eeg_afe_pga_0/eeg_inv_2/Y eeg_afe_pga_0/eeg_tg_lowq_7/B 2.402360e-17
C3835 eeg_afe_pga_0/eeg_tg_lowq_6/A VSS 7.837880e-17
C3836 eeg_afe_pga_0/eeg_tg_lowq_6/A eeg_afe_pga_0/eeg_tg_lowq_7/B 1.170160e-16
C3837 eeg_afe_pga_0/eeg_tg_lowq_7/B VSS 7.837880e-17
C3838 S16 VDD18 1.564350e-16
C3839 S16 VSS 4.901000e-17
C3840 S16 eeg_afe_pga_0/eeg_tg_lowq_6/A 2.862080e-17
C3841 VDD18 VSS 1.561810e-15
C3842 VDD18 eeg_afe_pga_0/eeg_tg_lowq_6/A 1.697704e-16
C3843 eeg_afe_pga_0/eeg_tg_lowq_6/A VSS 8.867300e-17
C3844 S16 VSS 2.027230e-16
C3847 eeg_afe_pga_0/eeg_tg_lowq_6/A VSS 1.267930e-16
C3848 eeg_afe_pga_0/eeg_tg_lowq_6/A eeg_afe_pga_0/eeg_tg_lowq_7/B 5.623600e-17
C3849 eeg_afe_pga_0/eeg_tg_lowq_7/B VSS 1.267930e-16
C3850 S32 VDD18 6.588032e-16
C3851 S32 VSS 1.789951e-15
C3852 S32 eeg_afe_pga_0/eeg_inv_1/Y 1.215812e-15
C3853 S32 eeg_afe_pga_0/eeg_tg_lowq_7/A 1.181323e-16
C3854 S32 eeg_afe_pga_0/eeg_tg_lowq_7/B 2.857784e-16
C3855 VDD18 VSS 3.714735e-15
C3856 VDD18 eeg_afe_pga_0/eeg_inv_1/Y 5.262242e-16
C3857 VDD18 eeg_afe_pga_0/eeg_tg_lowq_7/A 1.484229e-16
C3858 VDD18 eeg_afe_pga_0/eeg_tg_lowq_7/B 3.128723e-16
C3859 VSS eeg_afe_pga_0/eeg_inv_1/Y 1.446619e-15
C3860 VSS eeg_afe_pga_0/eeg_tg_lowq_7/A 7.819878e-17
C3861 VSS eeg_afe_pga_0/eeg_tg_lowq_7/B 1.097210e-16
C3862 eeg_afe_pga_0/eeg_inv_1/Y VSS 1.090650e-15
C3863 eeg_afe_pga_0/eeg_inv_1/Y eeg_afe_pga_0/eeg_tg_lowq_7/A 4.755154e-17
C3864 eeg_afe_pga_0/eeg_inv_1/Y eeg_afe_pga_0/eeg_tg_lowq_7/B 1.076105e-16
C3865 eeg_afe_pga_0/eeg_tg_lowq_7/A VSS 2.430800e-15
C3866 eeg_afe_pga_0/eeg_tg_lowq_7/A eeg_afe_pga_0/eeg_tg_lowq_7/B 1.492117e-15
C3867 eeg_afe_pga_0/eeg_tg_lowq_7/B VSS 1.462840e-15
C3868 S32 VDD18 1.564350e-16
C3869 S32 VSS 4.901000e-17
C3870 S32 eeg_afe_pga_0/eeg_tg_lowq_7/B 2.862080e-17
C3871 VDD18 VSS 1.561810e-15
C3872 VDD18 eeg_afe_pga_0/eeg_tg_lowq_7/B 1.697704e-16
C3873 eeg_afe_pga_0/eeg_tg_lowq_7/B VSS 8.867300e-17
C3874 eeg_afe_pga_0/eeg_inv_1/Y VSS 2.062020e-16
C3875 eeg_afe_pga_0/eeg_inv_1/Y eeg_afe_pga_0/eeg_tg_lowq_7/A 2.084120e-17
C3876 eeg_afe_pga_0/eeg_tg_lowq_7/A VSS 1.088312e-16
C3877 eeg_afe_pga_0/eeg_inv_1/Y VSS 2.062020e-16
C3878 eeg_afe_pga_0/eeg_inv_1/Y eeg_afe_pga_0/eeg_tg_lowq_7/B 2.084120e-17
C3879 eeg_afe_pga_0/eeg_tg_lowq_7/B VSS 1.088312e-16
C3880 VDD18 VSS 2.327590e-15
C3881 VDD18 eeg_afe_pga_0/eeg_inv_1/Y 1.594600e-16
C3882 VDD18 eeg_afe_pga_0/eeg_tg_lowq_7/A 1.554040e-16
C3883 VDD18 eeg_afe_pga_0/eeg_tg_lowq_7/B 1.554040e-16
C3884 eeg_afe_pga_0/eeg_inv_1/Y VSS 4.382640e-17
C3885 eeg_afe_pga_0/eeg_inv_1/Y eeg_afe_pga_0/eeg_tg_lowq_7/A 2.402360e-17
C3886 eeg_afe_pga_0/eeg_inv_1/Y eeg_afe_pga_0/eeg_tg_lowq_7/B 2.402360e-17
C3887 eeg_afe_pga_0/eeg_tg_lowq_7/A VSS 7.837880e-17
C3888 eeg_afe_pga_0/eeg_tg_lowq_7/A eeg_afe_pga_0/eeg_tg_lowq_7/B 1.170160e-16
C3889 eeg_afe_pga_0/eeg_tg_lowq_7/B VSS 7.837880e-17
C3890 S32 VDD18 1.564350e-16
C3891 S32 VSS 4.901000e-17
C3892 S32 eeg_afe_pga_0/eeg_tg_lowq_7/A 2.862080e-17
C3893 VDD18 VSS 1.561810e-15
C3894 VDD18 eeg_afe_pga_0/eeg_tg_lowq_7/A 1.697704e-16
C3895 eeg_afe_pga_0/eeg_tg_lowq_7/A VSS 8.867300e-17
C3896 S32 VSS 2.027230e-16
C3899 eeg_afe_pga_0/eeg_tg_lowq_7/A VSS 1.267930e-16
C3900 eeg_afe_pga_0/eeg_tg_lowq_7/A eeg_afe_pga_0/eeg_tg_lowq_7/B 5.623600e-17
C3901 eeg_afe_pga_0/eeg_tg_lowq_7/B VSS 1.267930e-16
C3902 VDD18 VSS 1.497845e-15
C3903 VDD18 eeg_afe_pga_0/eeg_inv_0/Y 7.937490e-16
C3904 VSS eeg_afe_pga_0/eeg_inv_0/Y 2.540708e-16
C3905 eeg_afe_pga_0/eeg_inv_0/Y VSS 9.197480e-16
C3906 VDD18 VSS 2.781032e-15
C3907 VDD18 eeg_afe_pga_0/eeg_inv_0/Y 3.212380e-16
C3908 VSS eeg_afe_pga_0/eeg_inv_0/Y 2.887600e-17
C3909 eeg_afe_pga_0/eeg_inv_0/Y VSS 8.691660e-17
C3910 VSS eeg_afe_pga_0/eeg_inv_0/Y 7.038030e-17
C3911 eeg_afe_pga_0/eeg_inv_0/Y VSS 1.770690e-16
C3912 S32 VDD18 1.658314e-16
C3913 S32 VSS 1.620786e-15
C3914 S32 eeg_afe_pga_0/eeg_inv_1/Y 1.823050e-16
C3915 VDD18 VSS 1.332013e-15
C3916 VDD18 eeg_afe_pga_0/eeg_inv_1/Y 7.937490e-16
C3917 VSS eeg_afe_pga_0/eeg_inv_1/Y 7.176584e-17
C3918 eeg_afe_pga_0/eeg_inv_1/Y VSS 9.197480e-16
C3919 S32 VDD18 1.883250e-16
C3920 S32 VSS 4.355510e-17
C3921 S32 eeg_afe_pga_0/eeg_inv_1/Y 2.887600e-17
C3922 VDD18 VSS 2.592707e-15
C3923 VDD18 eeg_afe_pga_0/eeg_inv_1/Y 3.212380e-16
C3924 eeg_afe_pga_0/eeg_inv_1/Y VSS 8.691660e-17
C3925 S32 VSS 2.152613e-16
C3927 VSS eeg_afe_pga_0/eeg_inv_1/Y 5.623600e-17
C3928 eeg_afe_pga_0/eeg_inv_1/Y VSS 1.770690e-16
C3929 S16 VDD18 1.658314e-16
C3930 S16 VSS 1.620786e-15
C3931 S16 eeg_afe_pga_0/eeg_inv_2/Y 1.823050e-16
C3932 VDD18 VSS 1.332013e-15
C3933 VDD18 eeg_afe_pga_0/eeg_inv_2/Y 7.937490e-16
C3934 VSS eeg_afe_pga_0/eeg_inv_2/Y 7.176584e-17
C3935 eeg_afe_pga_0/eeg_inv_2/Y VSS 9.197480e-16
C3936 S16 VDD18 1.883250e-16
C3937 S16 VSS 4.355510e-17
C3938 S16 eeg_afe_pga_0/eeg_inv_2/Y 2.887600e-17
C3939 VDD18 VSS 2.592707e-15
C3940 VDD18 eeg_afe_pga_0/eeg_inv_2/Y 3.212380e-16
C3941 eeg_afe_pga_0/eeg_inv_2/Y VSS 8.691660e-17
C3942 S16 VSS 2.152613e-16
C3944 VSS eeg_afe_pga_0/eeg_inv_2/Y 5.623600e-17
C3945 eeg_afe_pga_0/eeg_inv_2/Y VSS 1.770690e-16
C3946 S8 VDD18 1.658314e-16
C3947 S8 VSS 1.620786e-15
C3948 S8 eeg_afe_pga_0/eeg_inv_3/Y 1.823050e-16
C3949 VDD18 VSS 1.332013e-15
C3950 VDD18 eeg_afe_pga_0/eeg_inv_3/Y 7.937490e-16
C3951 VSS eeg_afe_pga_0/eeg_inv_3/Y 7.176584e-17
C3952 eeg_afe_pga_0/eeg_inv_3/Y VSS 9.197480e-16
C3953 S8 VDD18 1.883250e-16
C3954 S8 VSS 4.355510e-17
C3955 S8 eeg_afe_pga_0/eeg_inv_3/Y 2.887600e-17
C3956 VDD18 VSS 2.592707e-15
C3957 VDD18 eeg_afe_pga_0/eeg_inv_3/Y 3.212380e-16
C3958 eeg_afe_pga_0/eeg_inv_3/Y VSS 8.691660e-17
C3959 S8 VSS 2.152613e-16
C3961 VSS eeg_afe_pga_0/eeg_inv_3/Y 5.623600e-17
C3962 eeg_afe_pga_0/eeg_inv_3/Y VSS 1.770690e-16
C3963 BIT NBIT 2.509713e-16
C3964 BIT VDD18 1.340696e-15
C3965 BIT VN 4.692243e-16
C3966 BIT VP 6.308619e-16
C3967 BIT VSS 9.414437e-14
C3968 BIT eeg_sdm1ct_0/OINTP 1.202550e-16
C3969 BIT eeg_sdm1ct_0/eeg_inv_0/Y 6.327567e-15
C3970 BIT eeg_sdm1ct_0/eeg_nand2_0/A 1.021312e-16
C3974 BIT eeg_sdm1ct_0/eeg_pseudo_res_0/B 1.234980e-16
C3975 BIT eeg_sdm1ct_0/eeg_pseudo_res_1/B 1.550740e-16
C3976 BIT eeg_sdm1ct_0/eeg_tg_lowq_1/A 2.931400e-16
C3977 BIT eeg_sdm1ct_0/eeg_tg_lowq_3/A 3.196065e-16
C3978 CLK16 NCLK16 4.395850e-17
C3980 CLK16 VSS 1.037626e-14
C3981 CLK16 eeg_sdm1ct_0/OINTN 1.006990e-16
C3982 CLK16 eeg_sdm1ct_0/OINTP 1.614110e-16
C3983 CLK16 eeg_sdm1ct_0/eeg_nand2_0/A 8.875192e-16
C3984 CLK16 eeg_sdm1ct_0/eeg_nand2_1/A 1.079367e-16
C3986 CLK16 eeg_sdm1ct_0/eeg_pseudo_res_1/B 1.223579e-16
C3987 NBIT VDD18 6.346682e-15
C3988 NBIT VSS 1.409500e-14
C3989 NBIT eeg_sdm1ct_0/OINTN 1.093840e-16
C3990 NBIT eeg_sdm1ct_0/OINTP 9.784730e-17
C3991 NBIT eeg_sdm1ct_0/eeg_nand2_0/A 1.039117e-16
C3993 NBIT eeg_sdm1ct_0/eeg_nand2_1/A 4.111633e-16
C3994 NBIT eeg_sdm1ct_0/eeg_nand2_1/m1_302_66# 1.144460e-16
C3995 NBIT eeg_sdm1ct_0/eeg_pseudo_res_0/B 3.691700e-17
C3996 NBIT eeg_sdm1ct_0/eeg_pseudo_res_1/B 1.429910e-16
C3998 NCLK16 VSS 5.677109e-16
C4001 NCLK16 eeg_sdm1ct_0/eeg_pseudo_res_1/B 8.417050e-17
C4007 VDD18 VN 2.168581e-15
C4008 VDD18 VP 1.011448e-16
C4009 VDD18 VSS 1.914124e-13
C4010 VDD18 eeg_sdm1ct_0/OINTN 4.401251e-16
C4011 VDD18 eeg_sdm1ct_0/OINTP 4.598390e-16
C4012 VDD18 eeg_sdm1ct_0/eeg_inv_0/Y 1.228193e-15
C4013 VDD18 eeg_sdm1ct_0/eeg_nand2_0/A 2.054854e-15
C4014 VDD18 eeg_sdm1ct_0/eeg_nand2_1/A 4.368980e-16
C4016 VDD18 eeg_sdm1ct_0/eeg_pseudo_res_0/B 9.892970e-15
C4017 VDD18 eeg_sdm1ct_0/eeg_pseudo_res_1/B 1.293195e-15
C4020 VN VP 9.593358e-17
C4021 VN VSS 5.887863e-15
C4022 VN eeg_sdm1ct_0/eeg_inv_0/Y 4.909950e-15
C4023 VN eeg_sdm1ct_0/eeg_tg_lowq_1/A 1.555021e-16
C4024 VN eeg_sdm1ct_0/eeg_tg_lowq_3/A 7.268920e-17
C4025 VP VSS 3.748362e-15
C4026 VP eeg_sdm1ct_0/eeg_inv_0/Y 2.428380e-17
C4027 VP eeg_sdm1ct_0/eeg_tg_lowq_1/A 3.423360e-16
C4028 VP eeg_sdm1ct_0/eeg_tg_lowq_3/A 1.024077e-16
C4029 VSS eeg_sdm1ct_0/OINTN 2.541418e-15
C4030 VSS eeg_sdm1ct_0/OINTP 2.811043e-15
C4031 VSS eeg_sdm1ct_0/eeg_fd_ota_full2_nc_0/eeg_bias_gen_0/VBNF 1.892084e-15
C4032 VSS eeg_sdm1ct_0/eeg_fd_ota_full2_nc_0/eeg_fd_ota_core_soft_0/m1_n22658_111# 3.986086e-16
C4069 VSS eeg_sdm1ct_0/eeg_inv_0/Y 5.177803e-16
C4070 VSS eeg_sdm1ct_0/eeg_nand2_0/A 5.511328e-14
C4071 VSS eeg_sdm1ct_0/eeg_nand2_0/m1_302_66# 1.310495e-16
C4072 VSS eeg_sdm1ct_0/eeg_nand2_1/A 4.810186e-14
C4074 VSS eeg_sdm1ct_0/eeg_pseudo_res_0/B 1.901368e-15
C4075 VSS eeg_sdm1ct_0/eeg_pseudo_res_1/B 4.851100e-16
C4077 VSS eeg_sdm1ct_0/eeg_tg_lowq_3/A 2.030524e-17
C4078 eeg_sdm1ct_0/OINTN VSS 2.840140e-13
C4079 eeg_sdm1ct_0/OINTN eeg_sdm1ct_0/OINTP 3.317660e-14
C4080 eeg_sdm1ct_0/OINTN eeg_sdm1ct_0/eeg_fd_ota_full2_nc_0/eeg_fd_ota_core_soft_0/m1_n22658_111# 3.600006e-15
C4082 eeg_sdm1ct_0/OINTN eeg_sdm1ct_0/eeg_fd_ota_full2_nc_0/eeg_fd_ota_core_soft_0/m1_n29659_n3864# 1.733650e-16
C4083 eeg_sdm1ct_0/OINTN eeg_sdm1ct_0/eeg_fd_ota_full2_nc_0/eeg_fd_ota_core_soft_0/m1_n30459_n3864# 2.039522e-17
C4085 eeg_sdm1ct_0/OINTN eeg_sdm1ct_0/eeg_fd_ota_full2_nc_0/stage2_0/N2N 6.910636e-16
C4086 eeg_sdm1ct_0/OINTN eeg_sdm1ct_0/eeg_fd_ota_full2_nc_0/stage2_0/N2P 7.154944e-16
C4088 eeg_sdm1ct_0/OINTN eeg_sdm1ct_0/eeg_nand2_0/A 1.419770e-15
C4089 eeg_sdm1ct_0/OINTN eeg_sdm1ct_0/eeg_nand2_1/A 4.901190e-17
C4090 eeg_sdm1ct_0/OINTN eeg_sdm1ct_0/eeg_pseudo_res_0/B 8.165229e-15
C4091 eeg_sdm1ct_0/OINTN eeg_sdm1ct_0/eeg_pseudo_res_1/B 1.029908e-12
C4093 eeg_sdm1ct_0/OINTP VSS 2.951920e-13
C4095 eeg_sdm1ct_0/OINTP eeg_sdm1ct_0/eeg_fd_ota_full2_nc_0/eeg_fd_ota_core_soft_0/m1_n22658_111# 2.356488e-15
C4096 eeg_sdm1ct_0/OINTP eeg_sdm1ct_0/eeg_fd_ota_full2_nc_0/eeg_fd_ota_core_soft_0/m1_n28859_n3864# 1.690782e-16
C4099 eeg_sdm1ct_0/OINTP eeg_sdm1ct_0/eeg_fd_ota_full2_nc_0/stage2_0/N2N 1.502409e-16
C4100 eeg_sdm1ct_0/OINTP eeg_sdm1ct_0/eeg_fd_ota_full2_nc_0/stage2_0/N2P 1.362988e-16
C4102 eeg_sdm1ct_0/OINTP eeg_sdm1ct_0/eeg_inv_0/Y 1.202550e-16
C4103 eeg_sdm1ct_0/OINTP eeg_sdm1ct_0/eeg_nand2_0/A 4.739020e-15
C4104 eeg_sdm1ct_0/OINTP eeg_sdm1ct_0/eeg_nand2_1/A 2.391850e-16
C4105 eeg_sdm1ct_0/OINTP eeg_sdm1ct_0/eeg_pseudo_res_0/B 1.023563e-12
C4107 eeg_sdm1ct_0/OINTP eeg_sdm1ct_0/eeg_pseudo_res_1/B 1.307526e-14
C4108 PGA_OUTN VSS 3.436900e-16
C4109 PGA_OUTN eeg_sdm1ct_0/eeg_pseudo_res_0/B 3.187697e-16
C4110 PGA_OUTN eeg_sdm1ct_0/m1_56341_39443# 7.177553e-17
C4112 PGA_OUTP VSS 3.436000e-16
C4113 PGA_OUTP eeg_sdm1ct_0/eeg_pseudo_res_1/B 3.198222e-16
C4114 PGA_OUTP eeg_sdm1ct_0/m1_56341_23443# 7.179582e-17
C4119 eeg_sdm1ct_0/eeg_fd_ota_full2_nc_0/eeg_fd_ota_core_soft_0/m1_n22658_111# eeg_sdm1ct_0/eeg_pseudo_res_0/B 3.009528e-17
C4120 eeg_sdm1ct_0/eeg_fd_ota_full2_nc_0/eeg_fd_ota_core_soft_0/m1_n22658_111# eeg_sdm1ct_0/eeg_pseudo_res_1/B 3.539512e-16
C4188 eeg_sdm1ct_0/eeg_fd_ota_full2_nc_0/stage2_0/N2N eeg_sdm1ct_0/eeg_pseudo_res_0/B 3.751993e-15
C4189 eeg_sdm1ct_0/eeg_fd_ota_full2_nc_0/stage2_0/N2N eeg_sdm1ct_0/eeg_pseudo_res_1/B 1.212278e-15
C4190 eeg_sdm1ct_0/eeg_fd_ota_full2_nc_0/stage2_0/N2P eeg_sdm1ct_0/eeg_pseudo_res_0/B 1.766998e-15
C4191 eeg_sdm1ct_0/eeg_fd_ota_full2_nc_0/stage2_0/N2P eeg_sdm1ct_0/eeg_pseudo_res_1/B 8.850098e-16
C4192 eeg_sdm1ct_0/eeg_inv_0/Y VSS 6.761550e-14
C4193 eeg_sdm1ct_0/eeg_inv_0/Y eeg_sdm1ct_0/eeg_tg_lowq_1/A 2.168647e-16
C4195 eeg_sdm1ct_0/eeg_nand2_0/A VSS 3.622970e-14
C4197 eeg_sdm1ct_0/eeg_nand2_0/A eeg_sdm1ct_0/eeg_nand2_1/A 7.726884e-15
C4199 eeg_sdm1ct_0/eeg_nand2_0/A eeg_sdm1ct_0/eeg_pseudo_res_1/B 8.492450e-17
C4200 eeg_sdm1ct_0/eeg_nand2_1/A VSS 3.775700e-14
C4202 eeg_sdm1ct_0/eeg_nand2_1/A eeg_sdm1ct_0/eeg_pseudo_res_0/B 8.467370e-17
C4203 eeg_sdm1ct_0/eeg_nand2_1/A eeg_sdm1ct_0/eeg_pseudo_res_1/B 3.156290e-16
C4204 eeg_sdm1ct_0/eeg_pseudo_res_0/B VSS 1.749880e-13
C4205 eeg_sdm1ct_0/eeg_pseudo_res_0/B eeg_sdm1ct_0/eeg_pseudo_res_1/B 5.060416e-14
C4208 eeg_sdm1ct_0/eeg_pseudo_res_0/B eeg_sdm1ct_0/m1_56341_39443# 4.524130e-16
C4209 eeg_sdm1ct_0/eeg_pseudo_res_0/B eeg_sdm1ct_0/m1_56341_71443# 7.091774e-17
C4210 eeg_sdm1ct_0/eeg_pseudo_res_0/B eeg_sdm1ct_0/m1_56741_32136# 7.704530e-17
C4211 eeg_sdm1ct_0/eeg_pseudo_res_0/B eeg_sdm1ct_0/m1_57141_39443# 5.329694e-16
C4213 eeg_sdm1ct_0/eeg_pseudo_res_1/B VSS 1.661170e-13
C4217 eeg_sdm1ct_0/eeg_pseudo_res_1/B eeg_sdm1ct_0/m1_56341_23443# 4.524130e-16
C4218 eeg_sdm1ct_0/eeg_pseudo_res_1/B eeg_sdm1ct_0/m1_56341_55443# 7.091774e-17
C4219 eeg_sdm1ct_0/eeg_pseudo_res_1/B eeg_sdm1ct_0/m1_56741_16136# 7.704530e-17
C4220 eeg_sdm1ct_0/eeg_pseudo_res_1/B eeg_sdm1ct_0/m1_57141_23443# 5.329694e-16
C4222 eeg_sdm1ct_0/eeg_tg_lowq_1/A VSS 1.325750e-14
C4223 eeg_sdm1ct_0/eeg_tg_lowq_1/A eeg_sdm1ct_0/eeg_tg_lowq_3/A 3.098350e-16
C4226 eeg_sdm1ct_0/eeg_tg_lowq_1/A eeg_sdm1ct_0/m1_56741_64136# 7.704530e-17
C4227 eeg_sdm1ct_0/eeg_tg_lowq_1/A eeg_sdm1ct_0/m1_57141_71443# 2.512575e-16
C4228 eeg_sdm1ct_0/eeg_tg_lowq_3/A VSS 2.432520e-14
C4231 eeg_sdm1ct_0/eeg_tg_lowq_3/A eeg_sdm1ct_0/m1_56741_48136# 7.704535e-17
C4232 eeg_sdm1ct_0/eeg_tg_lowq_3/A eeg_sdm1ct_0/m1_57141_55443# 2.512575e-16
C4233 eeg_sdm1ct_0/m1_55941_16136# VSS 4.702790e-16
C4234 eeg_sdm1ct_0/m1_55941_16136# eeg_sdm1ct_0/m1_56741_16136# 6.789050e-17
C4235 eeg_sdm1ct_0/m1_55941_32136# VSS 4.702790e-16
C4236 eeg_sdm1ct_0/m1_55941_32136# eeg_sdm1ct_0/m1_56741_32136# 6.789050e-17
C4237 eeg_sdm1ct_0/m1_55941_48136# VSS 4.702790e-16
C4238 eeg_sdm1ct_0/m1_55941_48136# eeg_sdm1ct_0/m1_56741_48136# 6.789050e-17
C4239 eeg_sdm1ct_0/m1_55941_64136# VSS 4.702790e-16
C4240 eeg_sdm1ct_0/m1_55941_64136# eeg_sdm1ct_0/m1_56741_64136# 6.789050e-17
C4241 eeg_sdm1ct_0/m1_56341_23443# VSS 4.643110e-16
C4242 eeg_sdm1ct_0/m1_56341_23443# eeg_sdm1ct_0/m1_57141_23443# 6.789050e-17
C4243 eeg_sdm1ct_0/m1_56341_39443# VSS 4.643110e-16
C4244 eeg_sdm1ct_0/m1_56341_39443# eeg_sdm1ct_0/m1_57141_39443# 6.789050e-17
C4245 eeg_sdm1ct_0/m1_56341_55443# VSS 4.643110e-16
C4246 eeg_sdm1ct_0/m1_56341_55443# eeg_sdm1ct_0/m1_57141_55443# 6.789050e-17
C4247 eeg_sdm1ct_0/m1_56341_71443# VSS 4.643110e-16
C4248 eeg_sdm1ct_0/m1_56341_71443# eeg_sdm1ct_0/m1_57141_71443# 6.789050e-17
C4249 eeg_sdm1ct_0/m1_56741_16136# VSS 4.643110e-16
C4250 eeg_sdm1ct_0/m1_56741_32136# VSS 4.643110e-16
C4251 eeg_sdm1ct_0/m1_56741_48136# VSS 4.643110e-16
C4252 eeg_sdm1ct_0/m1_56741_64136# VSS 4.643110e-16
C4253 eeg_sdm1ct_0/m1_57141_23443# VSS 4.702790e-16
C4254 eeg_sdm1ct_0/m1_57141_39443# VSS 4.702790e-16
C4255 eeg_sdm1ct_0/m1_57141_55443# VSS 4.702790e-16
C4256 eeg_sdm1ct_0/m1_57141_71443# VSS 4.702790e-16
C4257 eeg_sdm1ct_0/eeg_pseudo_res_0/B VSS 6.746650e-16
C4258 eeg_sdm1ct_0/m1_55941_64136# VSS 6.746650e-16
C4259 eeg_sdm1ct_0/eeg_tg_lowq_3/A VSS 6.746650e-16
C4260 eeg_sdm1ct_0/m1_57141_55443# VSS 6.746650e-16
C4261 eeg_sdm1ct_0/m1_56741_48136# VSS 6.746650e-16
C4262 eeg_sdm1ct_0/m1_57141_55443# VSS 6.746650e-16
C4263 eeg_sdm1ct_0/m1_56341_55443# VSS 6.746650e-16
C4264 eeg_sdm1ct_0/m1_56741_48136# VSS 6.746650e-16
C4265 eeg_sdm1ct_0/m1_55941_48136# VSS 6.746650e-16
C4266 eeg_sdm1ct_0/m1_56341_55443# VSS 6.746650e-16
C4267 eeg_sdm1ct_0/eeg_pseudo_res_1/B VSS 6.746650e-16
C4268 eeg_sdm1ct_0/m1_55941_48136# VSS 6.746650e-16
C4269 eeg_sdm1ct_0/eeg_pseudo_res_0/B VSS 6.746650e-16
C4270 eeg_sdm1ct_0/m1_57141_39443# VSS 6.746650e-16
C4271 eeg_sdm1ct_0/m1_56741_32136# VSS 6.746650e-16
C4272 eeg_sdm1ct_0/m1_57141_39443# VSS 6.746650e-16
C4273 eeg_sdm1ct_0/OINTP VSS 8.414800e-16
C4274 eeg_sdm1ct_0/OINTP eeg_sdm1ct_0/eeg_pseudo_res_0/B 8.460309e-16
C4275 eeg_sdm1ct_0/OINTP eeg_sdm1ct_0/eeg_pseudo_res_0/m1_68_66# 1.314672e-15
C4276 eeg_sdm1ct_0/eeg_pseudo_res_0/B VSS 1.699680e-15
C4277 eeg_sdm1ct_0/eeg_pseudo_res_0/B eeg_sdm1ct_0/eeg_pseudo_res_0/m1_68_66# 5.017998e-16
C4278 eeg_sdm1ct_0/eeg_pseudo_res_0/m1_68_66# VSS 3.582030e-15
C4279 eeg_sdm1ct_0/eeg_pseudo_res_0/B VSS 3.678650e-15
C4280 eeg_sdm1ct_0/eeg_pseudo_res_0/B eeg_sdm1ct_0/eeg_pseudo_res_0/m1_68_66# 1.322042e-15
C4281 eeg_sdm1ct_0/eeg_pseudo_res_0/m1_68_66# VSS 4.103261e-16
C4282 eeg_sdm1ct_0/OINTP VSS 3.678650e-15
C4283 eeg_sdm1ct_0/OINTP eeg_sdm1ct_0/eeg_pseudo_res_0/m1_68_66# 1.322042e-15
C4284 eeg_sdm1ct_0/eeg_pseudo_res_0/m1_68_66# VSS 4.103261e-16
C4285 eeg_sdm1ct_0/m1_56341_39443# VSS 6.746650e-16
C4286 eeg_sdm1ct_0/m1_56741_32136# VSS 6.746650e-16
C4287 eeg_sdm1ct_0/OINTN VSS 8.414800e-16
C4288 eeg_sdm1ct_0/OINTN eeg_sdm1ct_0/eeg_pseudo_res_1/B 8.460309e-16
C4289 eeg_sdm1ct_0/OINTN eeg_sdm1ct_0/eeg_pseudo_res_1/m1_68_66# 1.314672e-15
C4290 eeg_sdm1ct_0/eeg_pseudo_res_1/B VSS 1.699680e-15
C4291 eeg_sdm1ct_0/eeg_pseudo_res_1/B eeg_sdm1ct_0/eeg_pseudo_res_1/m1_68_66# 5.017998e-16
C4292 eeg_sdm1ct_0/eeg_pseudo_res_1/m1_68_66# VSS 3.582030e-15
C4293 eeg_sdm1ct_0/eeg_pseudo_res_1/B VSS 3.678650e-15
C4294 eeg_sdm1ct_0/eeg_pseudo_res_1/B eeg_sdm1ct_0/eeg_pseudo_res_1/m1_68_66# 1.322042e-15
C4295 eeg_sdm1ct_0/eeg_pseudo_res_1/m1_68_66# VSS 4.103261e-16
C4296 eeg_sdm1ct_0/OINTN VSS 3.678650e-15
C4297 eeg_sdm1ct_0/OINTN eeg_sdm1ct_0/eeg_pseudo_res_1/m1_68_66# 1.322042e-15
C4298 eeg_sdm1ct_0/eeg_pseudo_res_1/m1_68_66# VSS 4.103261e-16
C4299 eeg_sdm1ct_0/m1_55941_32136# VSS 6.746650e-16
C4300 eeg_sdm1ct_0/m1_56341_39443# VSS 6.746650e-16
C4301 PGA_OUTN VSS 6.746650e-16
C4302 eeg_sdm1ct_0/m1_55941_32136# VSS 6.746650e-16
C4303 eeg_sdm1ct_0/eeg_pseudo_res_1/B VSS 6.746650e-16
C4304 eeg_sdm1ct_0/m1_57141_23443# VSS 6.746650e-16
C4305 eeg_sdm1ct_0/m1_56741_16136# VSS 6.746650e-16
C4306 eeg_sdm1ct_0/m1_57141_23443# VSS 6.746650e-16
C4307 eeg_sdm1ct_0/m1_56341_23443# VSS 6.746650e-16
C4308 eeg_sdm1ct_0/m1_56741_16136# VSS 6.746650e-16
C4309 eeg_sdm1ct_0/m1_55941_16136# VSS 6.746650e-16
C4310 eeg_sdm1ct_0/m1_56341_23443# VSS 6.746650e-16
C4311 PGA_OUTP VSS 6.746650e-16
C4312 eeg_sdm1ct_0/m1_55941_16136# VSS 6.746650e-16
C4313 BIT VDD18 5.262242e-16
C4314 BIT VP 1.076105e-16
C4315 BIT VSS 2.537269e-15
C4316 BIT eeg_sdm1ct_0/eeg_inv_0/Y 1.215812e-15
C4317 BIT eeg_sdm1ct_0/eeg_tg_lowq_1/A 4.755154e-17
C4318 VDD18 VP 3.128723e-16
C4319 VDD18 VSS 3.714735e-15
C4320 VDD18 eeg_sdm1ct_0/eeg_inv_0/Y 6.588032e-16
C4321 VDD18 eeg_sdm1ct_0/eeg_tg_lowq_1/A 1.484229e-16
C4322 VP VSS 1.572561e-15
C4323 VP eeg_sdm1ct_0/eeg_inv_0/Y 2.857784e-16
C4324 VP eeg_sdm1ct_0/eeg_tg_lowq_1/A 1.492117e-15
C4325 VSS eeg_sdm1ct_0/eeg_inv_0/Y 4.062507e-16
C4326 VSS eeg_sdm1ct_0/eeg_tg_lowq_1/A 7.819878e-17
C4327 eeg_sdm1ct_0/eeg_inv_0/Y VSS 1.383700e-15
C4328 eeg_sdm1ct_0/eeg_inv_0/Y eeg_sdm1ct_0/eeg_tg_lowq_1/A 1.181323e-16
C4329 eeg_sdm1ct_0/eeg_tg_lowq_1/A VSS 2.430800e-15
C4330 VDD18 VP 1.697704e-16
C4331 VDD18 VSS 1.561810e-15
C4332 VDD18 eeg_sdm1ct_0/eeg_inv_0/Y 1.564350e-16
C4333 VP VSS 8.867300e-17
C4334 VP eeg_sdm1ct_0/eeg_inv_0/Y 2.862080e-17
C4335 eeg_sdm1ct_0/eeg_inv_0/Y VSS 4.901000e-17
C4336 BIT VSS 2.062020e-16
C4337 BIT eeg_sdm1ct_0/eeg_tg_lowq_1/A 2.084120e-17
C4338 eeg_sdm1ct_0/eeg_tg_lowq_1/A VSS 1.088312e-16
C4339 BIT VP 2.084120e-17
C4340 BIT VSS 2.062020e-16
C4341 VP VSS 1.088312e-16
C4342 BIT VDD18 1.594600e-16
C4343 BIT VP 2.402360e-17
C4344 BIT VSS 4.382640e-17
C4345 BIT eeg_sdm1ct_0/eeg_tg_lowq_1/A 2.402360e-17
C4346 VDD18 VP 1.554040e-16
C4347 VDD18 VSS 2.327590e-15
C4348 VDD18 eeg_sdm1ct_0/eeg_tg_lowq_1/A 1.554040e-16
C4349 VP VSS 7.837880e-17
C4350 VP eeg_sdm1ct_0/eeg_tg_lowq_1/A 1.170160e-16
C4351 eeg_sdm1ct_0/eeg_tg_lowq_1/A VSS 7.837880e-17
C4352 VDD18 VSS 1.561810e-15
C4353 VDD18 eeg_sdm1ct_0/eeg_inv_0/Y 1.564350e-16
C4354 VDD18 eeg_sdm1ct_0/eeg_tg_lowq_1/A 1.697704e-16
C4355 eeg_sdm1ct_0/eeg_inv_0/Y VSS 4.901000e-17
C4356 eeg_sdm1ct_0/eeg_inv_0/Y eeg_sdm1ct_0/eeg_tg_lowq_1/A 2.862080e-17
C4357 eeg_sdm1ct_0/eeg_tg_lowq_1/A VSS 8.867300e-17
C4358 VP VSS 1.267930e-16
C4360 VP eeg_sdm1ct_0/eeg_tg_lowq_1/A 5.623600e-17
C4361 eeg_sdm1ct_0/eeg_inv_0/Y VSS 2.027230e-16
C4363 eeg_sdm1ct_0/eeg_tg_lowq_1/A VSS 1.267930e-16
C4364 BIT NBIT 6.007324e-17
C4365 BIT VDD18 1.993747e-16
C4366 BIT VSS 2.007140e-15
C4367 BIT eeg_sdm1ct_0/eeg_nand2_0/A 8.744458e-16
C4368 BIT eeg_sdm1ct_0/eeg_nand2_0/m1_302_66# 6.599960e-17
C4369 NBIT VDD18 1.285656e-15
C4370 NBIT VSS 1.360775e-15
C4371 NBIT eeg_sdm1ct_0/eeg_nand2_0/A 2.235258e-16
C4372 NBIT eeg_sdm1ct_0/eeg_nand2_0/m1_302_66# 2.794282e-17
C4373 VDD18 VSS 1.746429e-15
C4374 VDD18 eeg_sdm1ct_0/eeg_nand2_0/A 2.781945e-16
C4376 VSS eeg_sdm1ct_0/eeg_nand2_0/A 4.546446e-16
C4377 VSS eeg_sdm1ct_0/eeg_nand2_0/m1_302_66# 6.937880e-17
C4378 eeg_sdm1ct_0/eeg_nand2_0/A VSS 1.163750e-15
C4380 eeg_sdm1ct_0/eeg_nand2_0/m1_302_66# VSS 1.926050e-16
C4381 NBIT VDD18 3.212380e-16
C4382 NBIT VSS 8.691660e-17
C4383 NBIT eeg_sdm1ct_0/eeg_nand2_0/A 2.887600e-17
C4384 VDD18 VSS 2.592707e-15
C4385 VDD18 eeg_sdm1ct_0/eeg_nand2_0/A 1.883250e-16
C4386 eeg_sdm1ct_0/eeg_nand2_0/A VSS 4.355510e-17
C4387 NBIT VSS 1.770690e-16
C4389 NBIT eeg_sdm1ct_0/eeg_nand2_0/m1_302_66# 5.623600e-17
C4390 eeg_sdm1ct_0/eeg_nand2_0/A VSS 2.011170e-16
C4392 eeg_sdm1ct_0/eeg_nand2_0/m1_302_66# VSS 1.770690e-16
C4393 BIT NBIT 2.887600e-17
C4394 BIT VDD18 1.883250e-16
C4395 BIT VSS 4.355510e-17
C4396 NBIT VDD18 3.212380e-16
C4397 NBIT VSS 8.691660e-17
C4398 VDD18 VSS 2.592707e-15
C4399 BIT VSS 2.152613e-16
C4401 VSS eeg_sdm1ct_0/eeg_nand2_0/m1_302_66# 5.623600e-17
C4402 eeg_sdm1ct_0/eeg_nand2_0/m1_302_66# VSS 1.770690e-16
C4403 BIT VDD18 6.588032e-16
C4404 BIT VN 2.857784e-16
C4405 BIT VSS 1.789951e-15
C4406 BIT eeg_sdm1ct_0/eeg_inv_0/Y 1.215812e-15
C4407 BIT eeg_sdm1ct_0/eeg_tg_lowq_1/A 1.181323e-16
C4408 VDD18 VN 3.128723e-16
C4409 VDD18 VSS 3.714735e-15
C4410 VDD18 eeg_sdm1ct_0/eeg_inv_0/Y 5.262242e-16
C4411 VDD18 eeg_sdm1ct_0/eeg_tg_lowq_1/A 1.484229e-16
C4412 VN VSS 1.572561e-15
C4413 VN eeg_sdm1ct_0/eeg_inv_0/Y 1.076105e-16
C4414 VN eeg_sdm1ct_0/eeg_tg_lowq_1/A 1.492117e-15
C4415 VSS eeg_sdm1ct_0/eeg_inv_0/Y 1.446619e-15
C4416 VSS eeg_sdm1ct_0/eeg_tg_lowq_1/A 7.819878e-17
C4417 eeg_sdm1ct_0/eeg_inv_0/Y VSS 1.090650e-15
C4418 eeg_sdm1ct_0/eeg_inv_0/Y eeg_sdm1ct_0/eeg_tg_lowq_1/A 4.755154e-17
C4419 eeg_sdm1ct_0/eeg_tg_lowq_1/A VSS 2.430800e-15
C4420 BIT VDD18 1.564350e-16
C4421 BIT VN 2.862080e-17
C4422 BIT VSS 4.901000e-17
C4423 VDD18 VN 1.697704e-16
C4424 VDD18 VSS 1.561810e-15
C4425 VN VSS 8.867300e-17
C4426 eeg_sdm1ct_0/eeg_inv_0/Y VSS 2.062020e-16
C4427 eeg_sdm1ct_0/eeg_inv_0/Y eeg_sdm1ct_0/eeg_tg_lowq_1/A 2.084120e-17
C4428 eeg_sdm1ct_0/eeg_tg_lowq_1/A VSS 1.088312e-16
C4429 VN VSS 1.088312e-16
C4430 VN eeg_sdm1ct_0/eeg_inv_0/Y 2.084120e-17
C4431 eeg_sdm1ct_0/eeg_inv_0/Y VSS 2.062020e-16
C4432 VDD18 VN 1.554040e-16
C4433 VDD18 VSS 2.327590e-15
C4434 VDD18 eeg_sdm1ct_0/eeg_inv_0/Y 1.594600e-16
C4435 VDD18 eeg_sdm1ct_0/eeg_tg_lowq_1/A 1.554040e-16
C4436 VN VSS 7.837880e-17
C4437 VN eeg_sdm1ct_0/eeg_inv_0/Y 2.402360e-17
C4438 VN eeg_sdm1ct_0/eeg_tg_lowq_1/A 1.170160e-16
C4439 eeg_sdm1ct_0/eeg_inv_0/Y VSS 4.382640e-17
C4440 eeg_sdm1ct_0/eeg_inv_0/Y eeg_sdm1ct_0/eeg_tg_lowq_1/A 2.402360e-17
C4441 eeg_sdm1ct_0/eeg_tg_lowq_1/A VSS 7.837880e-17
C4442 BIT VDD18 1.564350e-16
C4443 BIT VSS 4.901000e-17
C4444 BIT eeg_sdm1ct_0/eeg_tg_lowq_1/A 2.862080e-17
C4445 VDD18 VSS 1.561810e-15
C4446 VDD18 eeg_sdm1ct_0/eeg_tg_lowq_1/A 1.697704e-16
C4447 eeg_sdm1ct_0/eeg_tg_lowq_1/A VSS 8.867300e-17
C4449 BIT VSS 2.027230e-16
C4451 VN VSS 1.267930e-16
C4452 VN eeg_sdm1ct_0/eeg_tg_lowq_1/A 5.623600e-17
C4453 eeg_sdm1ct_0/eeg_tg_lowq_1/A VSS 1.267930e-16
C4454 BIT NBIT 6.007324e-17
C4455 BIT VDD18 1.285656e-15
C4456 BIT VSS 1.360775e-15
C4457 BIT eeg_sdm1ct_0/eeg_nand2_1/A 2.235258e-16
C4458 BIT eeg_sdm1ct_0/eeg_nand2_1/m1_302_66# 2.794282e-17
C4459 NBIT VDD18 1.993747e-16
C4460 NBIT VSS 2.007140e-15
C4461 NBIT eeg_sdm1ct_0/eeg_nand2_1/A 8.744458e-16
C4462 NBIT eeg_sdm1ct_0/eeg_nand2_1/m1_302_66# 6.599960e-17
C4463 VDD18 VSS 1.746429e-15
C4464 VDD18 eeg_sdm1ct_0/eeg_nand2_1/A 2.781945e-16
C4466 VSS eeg_sdm1ct_0/eeg_nand2_1/A 4.546446e-16
C4467 VSS eeg_sdm1ct_0/eeg_nand2_1/m1_302_66# 6.937880e-17
C4468 eeg_sdm1ct_0/eeg_nand2_1/A VSS 1.163750e-15
C4470 eeg_sdm1ct_0/eeg_nand2_1/m1_302_66# VSS 1.926050e-16
C4471 BIT VDD18 3.212380e-16
C4472 BIT VSS 8.691660e-17
C4473 BIT eeg_sdm1ct_0/eeg_nand2_1/A 2.887600e-17
C4474 VDD18 VSS 2.592707e-15
C4475 VDD18 eeg_sdm1ct_0/eeg_nand2_1/A 1.883250e-16
C4476 eeg_sdm1ct_0/eeg_nand2_1/A VSS 4.355510e-17
C4477 BIT VSS 1.770690e-16
C4479 BIT eeg_sdm1ct_0/eeg_nand2_1/m1_302_66# 5.623600e-17
C4480 eeg_sdm1ct_0/eeg_nand2_1/A VSS 2.011170e-16
C4482 eeg_sdm1ct_0/eeg_nand2_1/m1_302_66# VSS 1.770690e-16
C4483 BIT NBIT 2.887600e-17
C4484 BIT VDD18 3.212380e-16
C4485 BIT VSS 8.691660e-17
C4486 NBIT VDD18 1.883250e-16
C4487 NBIT VSS 4.355510e-17
C4488 VDD18 VSS 2.592707e-15
C4489 NBIT VSS 2.152613e-16
C4491 VSS eeg_sdm1ct_0/eeg_nand2_1/m1_302_66# 5.623600e-17
C4492 eeg_sdm1ct_0/eeg_nand2_1/m1_302_66# VSS 1.770690e-16
C4493 BIT VDD18 5.262242e-16
C4494 BIT VN 1.076105e-16
C4495 BIT VSS 2.537269e-15
C4496 BIT eeg_sdm1ct_0/eeg_inv_0/Y 1.215812e-15
C4497 BIT eeg_sdm1ct_0/eeg_tg_lowq_3/A 4.755154e-17
C4498 VDD18 VN 3.128723e-16
C4499 VDD18 VSS 3.714735e-15
C4500 VDD18 eeg_sdm1ct_0/eeg_inv_0/Y 6.588032e-16
C4501 VDD18 eeg_sdm1ct_0/eeg_tg_lowq_3/A 1.484229e-16
C4502 VN VSS 1.572561e-15
C4503 VN eeg_sdm1ct_0/eeg_inv_0/Y 2.857784e-16
C4504 VN eeg_sdm1ct_0/eeg_tg_lowq_3/A 1.492117e-15
C4505 VSS eeg_sdm1ct_0/eeg_inv_0/Y 4.062507e-16
C4506 VSS eeg_sdm1ct_0/eeg_tg_lowq_3/A 7.819878e-17
C4507 eeg_sdm1ct_0/eeg_inv_0/Y VSS 1.383700e-15
C4508 eeg_sdm1ct_0/eeg_inv_0/Y eeg_sdm1ct_0/eeg_tg_lowq_3/A 1.181323e-16
C4509 eeg_sdm1ct_0/eeg_tg_lowq_3/A VSS 2.430800e-15
C4510 VDD18 VN 1.697704e-16
C4511 VDD18 VSS 1.561810e-15
C4512 VDD18 eeg_sdm1ct_0/eeg_inv_0/Y 1.564350e-16
C4513 VN VSS 8.867300e-17
C4514 VN eeg_sdm1ct_0/eeg_inv_0/Y 2.862080e-17
C4515 eeg_sdm1ct_0/eeg_inv_0/Y VSS 4.901000e-17
C4516 BIT VSS 2.062020e-16
C4517 BIT eeg_sdm1ct_0/eeg_tg_lowq_3/A 2.084120e-17
C4518 eeg_sdm1ct_0/eeg_tg_lowq_3/A VSS 1.088312e-16
C4519 BIT VN 2.084120e-17
C4520 BIT VSS 2.062020e-16
C4521 VN VSS 1.088312e-16
C4522 BIT VDD18 1.594600e-16
C4523 BIT VN 2.402360e-17
C4524 BIT VSS 4.382640e-17
C4525 BIT eeg_sdm1ct_0/eeg_tg_lowq_3/A 2.402360e-17
C4526 VDD18 VN 1.554040e-16
C4527 VDD18 VSS 2.327590e-15
C4528 VDD18 eeg_sdm1ct_0/eeg_tg_lowq_3/A 1.554040e-16
C4529 VN VSS 7.837880e-17
C4530 VN eeg_sdm1ct_0/eeg_tg_lowq_3/A 1.170160e-16
C4531 eeg_sdm1ct_0/eeg_tg_lowq_3/A VSS 7.837880e-17
C4532 VDD18 VSS 1.561810e-15
C4533 VDD18 eeg_sdm1ct_0/eeg_inv_0/Y 1.564350e-16
C4534 VDD18 eeg_sdm1ct_0/eeg_tg_lowq_3/A 1.697704e-16
C4535 eeg_sdm1ct_0/eeg_inv_0/Y VSS 4.901000e-17
C4536 eeg_sdm1ct_0/eeg_inv_0/Y eeg_sdm1ct_0/eeg_tg_lowq_3/A 2.862080e-17
C4537 eeg_sdm1ct_0/eeg_tg_lowq_3/A VSS 8.867300e-17
C4538 VN VSS 1.267930e-16
C4540 VN eeg_sdm1ct_0/eeg_tg_lowq_3/A 5.623600e-17
C4541 eeg_sdm1ct_0/eeg_inv_0/Y VSS 2.027230e-16
C4543 eeg_sdm1ct_0/eeg_tg_lowq_3/A VSS 1.267930e-16
C4544 BIT VDD18 6.588032e-16
C4545 BIT VP 2.857784e-16
C4546 BIT VSS 1.789951e-15
C4547 BIT eeg_sdm1ct_0/eeg_inv_0/Y 1.215812e-15
C4548 BIT eeg_sdm1ct_0/eeg_tg_lowq_3/A 1.181323e-16
C4549 VDD18 VP 3.128723e-16
C4550 VDD18 VSS 3.714735e-15
C4551 VDD18 eeg_sdm1ct_0/eeg_inv_0/Y 5.262242e-16
C4552 VDD18 eeg_sdm1ct_0/eeg_tg_lowq_3/A 1.484229e-16
C4553 VP VSS 1.572561e-15
C4554 VP eeg_sdm1ct_0/eeg_inv_0/Y 1.076105e-16
C4555 VP eeg_sdm1ct_0/eeg_tg_lowq_3/A 1.492117e-15
C4556 VSS eeg_sdm1ct_0/eeg_inv_0/Y 1.446619e-15
C4557 VSS eeg_sdm1ct_0/eeg_tg_lowq_3/A 7.819878e-17
C4558 eeg_sdm1ct_0/eeg_inv_0/Y VSS 1.090650e-15
C4559 eeg_sdm1ct_0/eeg_inv_0/Y eeg_sdm1ct_0/eeg_tg_lowq_3/A 4.755154e-17
C4560 eeg_sdm1ct_0/eeg_tg_lowq_3/A VSS 2.430800e-15
C4561 BIT VDD18 1.564350e-16
C4562 BIT VP 2.862080e-17
C4563 BIT VSS 4.901000e-17
C4564 VDD18 VP 1.697704e-16
C4565 VDD18 VSS 1.561810e-15
C4566 VP VSS 8.867300e-17
C4567 eeg_sdm1ct_0/eeg_inv_0/Y VSS 2.062020e-16
C4568 eeg_sdm1ct_0/eeg_inv_0/Y eeg_sdm1ct_0/eeg_tg_lowq_3/A 2.084120e-17
C4569 eeg_sdm1ct_0/eeg_tg_lowq_3/A VSS 1.088312e-16
C4570 VP VSS 1.088312e-16
C4571 VP eeg_sdm1ct_0/eeg_inv_0/Y 2.084120e-17
C4572 eeg_sdm1ct_0/eeg_inv_0/Y VSS 2.062020e-16
C4573 VDD18 VP 1.554040e-16
C4574 VDD18 VSS 2.327590e-15
C4575 VDD18 eeg_sdm1ct_0/eeg_inv_0/Y 1.594600e-16
C4576 VDD18 eeg_sdm1ct_0/eeg_tg_lowq_3/A 1.554040e-16
C4577 VP VSS 7.837880e-17
C4578 VP eeg_sdm1ct_0/eeg_inv_0/Y 2.402360e-17
C4579 VP eeg_sdm1ct_0/eeg_tg_lowq_3/A 1.170160e-16
C4580 eeg_sdm1ct_0/eeg_inv_0/Y VSS 4.382640e-17
C4581 eeg_sdm1ct_0/eeg_inv_0/Y eeg_sdm1ct_0/eeg_tg_lowq_3/A 2.402360e-17
C4582 eeg_sdm1ct_0/eeg_tg_lowq_3/A VSS 7.837880e-17
C4583 BIT VDD18 1.564350e-16
C4584 BIT VSS 4.901000e-17
C4585 BIT eeg_sdm1ct_0/eeg_tg_lowq_3/A 2.862080e-17
C4586 VDD18 VSS 1.561810e-15
C4587 VDD18 eeg_sdm1ct_0/eeg_tg_lowq_3/A 1.697704e-16
C4588 eeg_sdm1ct_0/eeg_tg_lowq_3/A VSS 8.867300e-17
C4590 BIT VSS 2.027230e-16
C4592 VP VSS 1.267930e-16
C4593 VP eeg_sdm1ct_0/eeg_tg_lowq_3/A 5.623600e-17
C4594 eeg_sdm1ct_0/eeg_tg_lowq_3/A VSS 1.267930e-16
C4595 VCM_REF VDD18 2.925001e-15
C4596 VCM_REF VSS 4.754464e-14
C4597 VCM_REF eeg_sdm1ct_0/eeg_fd_ota_full2_nc_0/eeg_bias_gen_0/VBNF 1.760523e-14
C4598 VCM_REF eeg_sdm1ct_0/eeg_fd_ota_full2_nc_0/eeg_cmfb_amp_dl2_0/VBP 3.040320e-15
C4599 VCM_REF eeg_sdm1ct_0/eeg_fd_ota_full2_nc_0/eeg_cmfb_amp_dl2_0/VCM_SENSE 3.349959e-16
C4602 VCM_REF eeg_sdm1ct_0/eeg_fd_ota_full2_nc_0/stage2_0/N2N 1.978811e-16
C4603 VCM_REF eeg_sdm1ct_0/eeg_fd_ota_full2_nc_0/stage2_0/N2P 3.238353e-16
C4604 VCM_REF eeg_sdm1ct_0/eeg_fd_ota_full2_nc_0/stage2_0/VBP2 4.836588e-15
C4605 VCM_REF eeg_sdm1ct_0/eeg_fd_ota_full2_nc_0/stage2_0/VCM2 1.339766e-16
C4606 VDD18 VSS 6.340508e-14
C4610 VDD18 eeg_sdm1ct_0/eeg_fd_ota_full2_nc_0/eeg_bias_gen_0/VBNF 2.279913e-14
C4611 VDD18 eeg_sdm1ct_0/eeg_fd_ota_full2_nc_0/eeg_bias_gen_0/eeg_pseudo_res_0/m1_68_66# 9.173605e-17
C4612 VDD18 eeg_sdm1ct_0/eeg_fd_ota_full2_nc_0/eeg_cmfb_amp_dl2_0/VBP 5.412926e-16
C4613 VDD18 eeg_sdm1ct_0/eeg_fd_ota_full2_nc_0/eeg_cmfb_amp_dl2_0/VCM_SENSE 6.617475e-16
C4617 VDD18 eeg_sdm1ct_0/eeg_fd_ota_full2_nc_0/stage2_0/N2P 2.623749e-16
C4618 VDD18 eeg_sdm1ct_0/eeg_fd_ota_full2_nc_0/stage2_0/VBP2 2.653020e-16
C4620 VSS eeg_sdm1ct_0/OINTN 4.571667e-16
C4621 VSS eeg_sdm1ct_0/OINTP 3.752509e-16
C4622 VSS eeg_sdm1ct_0/eeg_fd_ota_full2_nc_0/eeg_bias_gen_0/VBN 6.624060e-17
C4623 VSS eeg_sdm1ct_0/eeg_fd_ota_full2_nc_0/eeg_bias_gen_0/VBNF 6.362273e-15
C4625 VSS eeg_sdm1ct_0/eeg_fd_ota_full2_nc_0/eeg_bias_gen_0/m1_3701_n11401# 5.414330e-17
C4626 VSS eeg_sdm1ct_0/eeg_fd_ota_full2_nc_0/eeg_bias_gen_0/m1_4341_n2557# 6.618650e-17
C4627 VSS eeg_sdm1ct_0/eeg_fd_ota_full2_nc_0/eeg_bias_gen_0/m1_5141_n2557# 6.618650e-17
C4628 VSS eeg_sdm1ct_0/eeg_fd_ota_full2_nc_0/eeg_bias_gen_0/m1_5941_n2557# 6.618650e-17
C4629 VSS eeg_sdm1ct_0/eeg_fd_ota_full2_nc_0/eeg_bias_gen_0/m1_6741_n2557# 6.618650e-17
C4630 VSS eeg_sdm1ct_0/eeg_fd_ota_full2_nc_0/eeg_bias_gen_0/m1_7541_n2557# 6.637850e-17
C4631 VSS eeg_sdm1ct_0/eeg_fd_ota_full2_nc_0/eeg_bias_gen_0/m1_8341_n2557# 7.296267e-17
C4632 VSS eeg_sdm1ct_0/eeg_fd_ota_full2_nc_0/eeg_bias_gen_0/m1_9141_n2557# 8.982070e-17
C4633 VSS eeg_sdm1ct_0/eeg_fd_ota_full2_nc_0/eeg_bias_gen_0/m1_9941_n2557# 3.857350e-17
C4634 VSS eeg_sdm1ct_0/eeg_fd_ota_full2_nc_0/eeg_cmfb_amp_dl2_0/VCM_SENSE 2.286714e-16
C4643 VSS eeg_sdm1ct_0/eeg_fd_ota_full2_nc_0/eeg_fd_ota_core_soft_0/m1_31941_3443# 5.111280e-17
C4645 VSS eeg_sdm1ct_0/eeg_fd_ota_full2_nc_0/eeg_fd_ota_core_soft_0/m1_32741_3443# 3.687719e-17
C4676 VSS eeg_sdm1ct_0/eeg_fd_ota_full2_nc_0/eeg_fd_ota_core_soft_0/m1_n22658_111# 2.315806e-16
C4677 VSS eeg_sdm1ct_0/eeg_fd_ota_full2_nc_0/stage2_0/N2N 8.321907e-16
C4678 VSS eeg_sdm1ct_0/eeg_fd_ota_full2_nc_0/stage2_0/N2P 5.585855e-16
C4679 VSS eeg_sdm1ct_0/eeg_fd_ota_full2_nc_0/stage2_0/VBP2 5.043658e-15
C4680 VSS eeg_sdm1ct_0/eeg_fd_ota_full2_nc_0/stage2_0/VCM2 6.769184e-16
C4683 eeg_sdm1ct_0/OINTN eeg_sdm1ct_0/eeg_fd_ota_full2_nc_0/eeg_bias_gen_0/VBNF 1.365910e-16
C4685 eeg_sdm1ct_0/OINTN eeg_sdm1ct_0/eeg_fd_ota_full2_nc_0/stage2_0/VBP2 6.053202e-15
C4686 eeg_sdm1ct_0/OINTN eeg_sdm1ct_0/eeg_fd_ota_full2_nc_0/stage2_0/VCM2 1.365910e-16
C4687 eeg_sdm1ct_0/OINTP eeg_sdm1ct_0/eeg_fd_ota_full2_nc_0/eeg_bias_gen_0/VBNF 2.070634e-16
C4690 eeg_sdm1ct_0/OINTP eeg_sdm1ct_0/eeg_fd_ota_full2_nc_0/stage2_0/VCM2 1.333710e-16
C4691 eeg_sdm1ct_0/eeg_fd_ota_full2_nc_0/eeg_bias_gen_0/VBN eeg_sdm1ct_0/eeg_fd_ota_full2_nc_0/eeg_bias_gen_0/VBNF 4.256316e-16
C4692 eeg_sdm1ct_0/eeg_fd_ota_full2_nc_0/eeg_bias_gen_0/VBNF VSS 6.371220e-14
C4694 eeg_sdm1ct_0/eeg_fd_ota_full2_nc_0/eeg_bias_gen_0/VBNF eeg_sdm1ct_0/eeg_fd_ota_full2_nc_0/eeg_bias_gen_0/eeg_pseudo_res_0/m1_68_66# 1.772766e-16
C4698 eeg_sdm1ct_0/eeg_fd_ota_full2_nc_0/eeg_bias_gen_0/VBNF eeg_sdm1ct_0/eeg_fd_ota_full2_nc_0/eeg_cmfb_amp_dl2_0/VBP 2.452104e-16
C4699 eeg_sdm1ct_0/eeg_fd_ota_full2_nc_0/eeg_bias_gen_0/VBNF eeg_sdm1ct_0/eeg_fd_ota_full2_nc_0/eeg_cmfb_amp_dl2_0/VCM_SENSE 2.222844e-16
C4700 eeg_sdm1ct_0/eeg_fd_ota_full2_nc_0/eeg_bias_gen_0/VBNF eeg_sdm1ct_0/eeg_fd_ota_full2_nc_0/eeg_cmfb_amp_dl2_0/m1_370_1493# 4.385371e-17
C4701 eeg_sdm1ct_0/eeg_fd_ota_full2_nc_0/eeg_bias_gen_0/VBNF eeg_sdm1ct_0/eeg_fd_ota_full2_nc_0/eeg_cmfb_amp_dl2_0/m1_68_166# 3.222660e-17
C4702 eeg_sdm1ct_0/eeg_fd_ota_full2_nc_0/eeg_bias_gen_0/VBNF eeg_sdm1ct_0/eeg_fd_ota_full2_nc_0/eeg_cmfb_amp_dl2_s2_0/m1_370_1493# 4.385371e-17
C4704 eeg_sdm1ct_0/eeg_fd_ota_full2_nc_0/eeg_bias_gen_0/VBNF eeg_sdm1ct_0/eeg_fd_ota_full2_nc_0/eeg_fd_ota_core_soft_0/m1_28341_n3864# 5.192510e-17
C4705 eeg_sdm1ct_0/eeg_fd_ota_full2_nc_0/eeg_bias_gen_0/VBNF eeg_sdm1ct_0/eeg_fd_ota_full2_nc_0/eeg_fd_ota_core_soft_0/m1_29141_n3864# 5.057930e-17
C4706 eeg_sdm1ct_0/eeg_fd_ota_full2_nc_0/eeg_bias_gen_0/VBNF eeg_sdm1ct_0/eeg_fd_ota_full2_nc_0/eeg_fd_ota_core_soft_0/m1_29941_n3864# 5.057930e-17
C4707 eeg_sdm1ct_0/eeg_fd_ota_full2_nc_0/eeg_bias_gen_0/VBNF eeg_sdm1ct_0/eeg_fd_ota_full2_nc_0/eeg_fd_ota_core_soft_0/m1_30741_n3864# 5.057930e-17
C4708 eeg_sdm1ct_0/eeg_fd_ota_full2_nc_0/eeg_bias_gen_0/VBNF eeg_sdm1ct_0/eeg_fd_ota_full2_nc_0/eeg_fd_ota_core_soft_0/m1_31541_n3864# 5.057930e-17
C4709 eeg_sdm1ct_0/eeg_fd_ota_full2_nc_0/eeg_bias_gen_0/VBNF eeg_sdm1ct_0/eeg_fd_ota_full2_nc_0/eeg_fd_ota_core_soft_0/m1_32341_n3864# 5.057930e-17
C4710 eeg_sdm1ct_0/eeg_fd_ota_full2_nc_0/eeg_bias_gen_0/VBNF eeg_sdm1ct_0/eeg_fd_ota_full2_nc_0/eeg_fd_ota_core_soft_0/m1_33141_n3864# 5.057930e-17
C4711 eeg_sdm1ct_0/eeg_fd_ota_full2_nc_0/eeg_bias_gen_0/VBNF eeg_sdm1ct_0/eeg_fd_ota_full2_nc_0/eeg_fd_ota_core_soft_0/m1_33941_n3864# 5.057930e-17
C4712 eeg_sdm1ct_0/eeg_fd_ota_full2_nc_0/eeg_bias_gen_0/VBNF eeg_sdm1ct_0/eeg_fd_ota_full2_nc_0/eeg_fd_ota_core_soft_0/m1_34741_n3864# 5.057930e-17
C4713 eeg_sdm1ct_0/eeg_fd_ota_full2_nc_0/eeg_bias_gen_0/VBNF eeg_sdm1ct_0/eeg_fd_ota_full2_nc_0/eeg_fd_ota_core_soft_0/m1_35541_n3864# 5.057930e-17
C4714 eeg_sdm1ct_0/eeg_fd_ota_full2_nc_0/eeg_bias_gen_0/VBNF eeg_sdm1ct_0/eeg_fd_ota_full2_nc_0/eeg_fd_ota_core_soft_0/m1_36341_n3864# 5.057930e-17
C4715 eeg_sdm1ct_0/eeg_fd_ota_full2_nc_0/eeg_bias_gen_0/VBNF eeg_sdm1ct_0/eeg_fd_ota_full2_nc_0/eeg_fd_ota_core_soft_0/m1_37141_n3864# 5.057930e-17
C4716 eeg_sdm1ct_0/eeg_fd_ota_full2_nc_0/eeg_bias_gen_0/VBNF eeg_sdm1ct_0/eeg_fd_ota_full2_nc_0/eeg_fd_ota_core_soft_0/m1_37941_n3864# 5.057930e-17
C4717 eeg_sdm1ct_0/eeg_fd_ota_full2_nc_0/eeg_bias_gen_0/VBNF eeg_sdm1ct_0/eeg_fd_ota_full2_nc_0/eeg_fd_ota_core_soft_0/m1_38741_n3864# 5.057930e-17
C4718 eeg_sdm1ct_0/eeg_fd_ota_full2_nc_0/eeg_bias_gen_0/VBNF eeg_sdm1ct_0/eeg_fd_ota_full2_nc_0/eeg_fd_ota_core_soft_0/m1_39541_n3864# 5.057930e-17
C4719 eeg_sdm1ct_0/eeg_fd_ota_full2_nc_0/eeg_bias_gen_0/VBNF eeg_sdm1ct_0/eeg_fd_ota_full2_nc_0/eeg_fd_ota_core_soft_0/m1_40341_n3864# 5.057930e-17
C4720 eeg_sdm1ct_0/eeg_fd_ota_full2_nc_0/eeg_bias_gen_0/VBNF eeg_sdm1ct_0/eeg_fd_ota_full2_nc_0/eeg_fd_ota_core_soft_0/m1_41141_n3864# 5.057930e-17
C4721 eeg_sdm1ct_0/eeg_fd_ota_full2_nc_0/eeg_bias_gen_0/VBNF eeg_sdm1ct_0/eeg_fd_ota_full2_nc_0/eeg_fd_ota_core_soft_0/m1_41941_n3864# 5.057930e-17
C4722 eeg_sdm1ct_0/eeg_fd_ota_full2_nc_0/eeg_bias_gen_0/VBNF eeg_sdm1ct_0/eeg_fd_ota_full2_nc_0/eeg_fd_ota_core_soft_0/m1_42741_n3864# 5.057930e-17
C4723 eeg_sdm1ct_0/eeg_fd_ota_full2_nc_0/eeg_bias_gen_0/VBNF eeg_sdm1ct_0/eeg_fd_ota_full2_nc_0/eeg_fd_ota_core_soft_0/m1_43541_n3864# 5.057930e-17
C4724 eeg_sdm1ct_0/eeg_fd_ota_full2_nc_0/eeg_bias_gen_0/VBNF eeg_sdm1ct_0/eeg_fd_ota_full2_nc_0/eeg_fd_ota_core_soft_0/m1_44341_n3864# 5.057930e-17
C4725 eeg_sdm1ct_0/eeg_fd_ota_full2_nc_0/eeg_bias_gen_0/VBNF eeg_sdm1ct_0/eeg_fd_ota_full2_nc_0/eeg_fd_ota_core_soft_0/m1_45141_n3864# 5.057930e-17
C4726 eeg_sdm1ct_0/eeg_fd_ota_full2_nc_0/eeg_bias_gen_0/VBNF eeg_sdm1ct_0/eeg_fd_ota_full2_nc_0/eeg_fd_ota_core_soft_0/m1_45941_n3864# 5.057930e-17
C4727 eeg_sdm1ct_0/eeg_fd_ota_full2_nc_0/eeg_bias_gen_0/VBNF eeg_sdm1ct_0/eeg_fd_ota_full2_nc_0/eeg_fd_ota_core_soft_0/m1_46741_n3864# 5.057930e-17
C4728 eeg_sdm1ct_0/eeg_fd_ota_full2_nc_0/eeg_bias_gen_0/VBNF eeg_sdm1ct_0/eeg_fd_ota_full2_nc_0/eeg_fd_ota_core_soft_0/m1_47541_n3864# 5.192510e-17
C4729 eeg_sdm1ct_0/eeg_fd_ota_full2_nc_0/eeg_bias_gen_0/VBNF eeg_sdm1ct_0/eeg_fd_ota_full2_nc_0/eeg_fd_ota_core_soft_0/m1_50741_n3864# 5.192510e-17
C4730 eeg_sdm1ct_0/eeg_fd_ota_full2_nc_0/eeg_bias_gen_0/VBNF eeg_sdm1ct_0/eeg_fd_ota_full2_nc_0/eeg_fd_ota_core_soft_0/m1_51541_n3864# 5.057930e-17
C4731 eeg_sdm1ct_0/eeg_fd_ota_full2_nc_0/eeg_bias_gen_0/VBNF eeg_sdm1ct_0/eeg_fd_ota_full2_nc_0/eeg_fd_ota_core_soft_0/m1_52341_n3864# 5.057930e-17
C4732 eeg_sdm1ct_0/eeg_fd_ota_full2_nc_0/eeg_bias_gen_0/VBNF eeg_sdm1ct_0/eeg_fd_ota_full2_nc_0/eeg_fd_ota_core_soft_0/m1_53141_n3864# 5.057930e-17
C4733 eeg_sdm1ct_0/eeg_fd_ota_full2_nc_0/eeg_bias_gen_0/VBNF eeg_sdm1ct_0/eeg_fd_ota_full2_nc_0/eeg_fd_ota_core_soft_0/m1_53941_n3864# 5.057930e-17
C4734 eeg_sdm1ct_0/eeg_fd_ota_full2_nc_0/eeg_bias_gen_0/VBNF eeg_sdm1ct_0/eeg_fd_ota_full2_nc_0/eeg_fd_ota_core_soft_0/m1_54741_n3864# 5.057930e-17
C4735 eeg_sdm1ct_0/eeg_fd_ota_full2_nc_0/eeg_bias_gen_0/VBNF eeg_sdm1ct_0/eeg_fd_ota_full2_nc_0/eeg_fd_ota_core_soft_0/m1_55541_n3864# 5.057930e-17
C4736 eeg_sdm1ct_0/eeg_fd_ota_full2_nc_0/eeg_bias_gen_0/VBNF eeg_sdm1ct_0/eeg_fd_ota_full2_nc_0/eeg_fd_ota_core_soft_0/m1_56341_n3864# 5.057930e-17
C4737 eeg_sdm1ct_0/eeg_fd_ota_full2_nc_0/eeg_bias_gen_0/VBNF eeg_sdm1ct_0/eeg_fd_ota_full2_nc_0/eeg_fd_ota_core_soft_0/m1_57141_n3864# 5.057930e-17
C4738 eeg_sdm1ct_0/eeg_fd_ota_full2_nc_0/eeg_bias_gen_0/VBNF eeg_sdm1ct_0/eeg_fd_ota_full2_nc_0/eeg_fd_ota_core_soft_0/m1_57941_n3864# 5.192510e-17
C4740 eeg_sdm1ct_0/eeg_fd_ota_full2_nc_0/eeg_bias_gen_0/VBNF eeg_sdm1ct_0/eeg_fd_ota_full2_nc_0/stage2_0/N2N 3.712090e-16
C4741 eeg_sdm1ct_0/eeg_fd_ota_full2_nc_0/eeg_bias_gen_0/VBNF eeg_sdm1ct_0/eeg_fd_ota_full2_nc_0/stage2_0/N2P 9.506756e-16
C4742 eeg_sdm1ct_0/eeg_fd_ota_full2_nc_0/eeg_bias_gen_0/VBNF eeg_sdm1ct_0/eeg_fd_ota_full2_nc_0/stage2_0/VBP2 1.125265e-15
C4743 eeg_sdm1ct_0/eeg_fd_ota_full2_nc_0/eeg_bias_gen_0/VBNF eeg_sdm1ct_0/eeg_fd_ota_full2_nc_0/stage2_0/VCM2 3.880655e-16
C4744 eeg_sdm1ct_0/eeg_fd_ota_full2_nc_0/eeg_cmfb_amp_dl2_0/VBP VSS 1.364910e-14
C4745 eeg_sdm1ct_0/eeg_fd_ota_full2_nc_0/eeg_cmfb_amp_dl2_0/VBP eeg_sdm1ct_0/eeg_fd_ota_full2_nc_0/eeg_cmfb_amp_dl2_0/VCM_SENSE 3.069697e-16
C4746 eeg_sdm1ct_0/eeg_fd_ota_full2_nc_0/eeg_cmfb_amp_dl2_0/VBP eeg_sdm1ct_0/eeg_fd_ota_full2_nc_0/stage2_0/N2P 1.614594e-16
C4748 eeg_sdm1ct_0/eeg_fd_ota_full2_nc_0/eeg_cmfb_amp_dl2_0/VBP eeg_sdm1ct_0/eeg_pseudo_res_1/B 3.185803e-17
C4749 eeg_sdm1ct_0/eeg_fd_ota_full2_nc_0/eeg_cmfb_amp_dl2_0/VCM_SENSE VSS 1.553050e-14
C4750 eeg_sdm1ct_0/eeg_fd_ota_full2_nc_0/eeg_cmfb_amp_dl2_0/VCM_SENSE eeg_sdm1ct_0/eeg_fd_ota_full2_nc_0/eeg_cmfb_amp_dl2_0/m1_370_1493# 9.450030e-17
C4751 eeg_sdm1ct_0/eeg_fd_ota_full2_nc_0/eeg_cmfb_amp_dl2_0/VCM_SENSE eeg_sdm1ct_0/eeg_fd_ota_full2_nc_0/eeg_cmfb_amp_dl2_0/m1_68_166# 1.874921e-16
C4752 eeg_sdm1ct_0/eeg_fd_ota_full2_nc_0/eeg_cmfb_amp_dl2_0/VCM_SENSE eeg_sdm1ct_0/eeg_fd_ota_full2_nc_0/stage2_0/N2N 1.526407e-16
C4753 eeg_sdm1ct_0/eeg_fd_ota_full2_nc_0/eeg_cmfb_amp_dl2_0/VCM_SENSE eeg_sdm1ct_0/eeg_fd_ota_full2_nc_0/stage2_0/N2P 3.196946e-16
C4755 eeg_sdm1ct_0/eeg_fd_ota_full2_nc_0/eeg_cmfb_amp_dl2_0/m1_68_166# eeg_sdm1ct_0/eeg_fd_ota_full2_nc_0/stage2_0/N2P 2.370177e-17
C4757 eeg_sdm1ct_0/eeg_fd_ota_full2_nc_0/eeg_cmfb_amp_dl2_s2_0/m1_68_166# eeg_sdm1ct_0/eeg_fd_ota_full2_nc_0/stage2_0/VCM2 3.437010e-17
C4759 eeg_sdm1ct_0/eeg_fd_ota_full2_nc_0/stage2_0/N2N VSS 2.096300e-14
C4760 eeg_sdm1ct_0/eeg_fd_ota_full2_nc_0/stage2_0/N2N eeg_sdm1ct_0/eeg_fd_ota_full2_nc_0/stage2_0/N2P 1.370712e-14
C4762 eeg_sdm1ct_0/eeg_fd_ota_full2_nc_0/stage2_0/N2N eeg_sdm1ct_0/eeg_pseudo_res_0/B 1.390907e-16
C4763 eeg_sdm1ct_0/eeg_fd_ota_full2_nc_0/stage2_0/N2N eeg_sdm1ct_0/eeg_pseudo_res_1/B 1.390910e-16
C4764 eeg_sdm1ct_0/eeg_fd_ota_full2_nc_0/stage2_0/N2P VSS 3.813280e-14
C4765 eeg_sdm1ct_0/eeg_fd_ota_full2_nc_0/stage2_0/N2P eeg_sdm1ct_0/eeg_fd_ota_full2_nc_0/stage2_0/VBP2 9.732428e-17
C4766 eeg_sdm1ct_0/eeg_fd_ota_full2_nc_0/stage2_0/N2P eeg_sdm1ct_0/eeg_pseudo_res_0/B 1.514485e-16
C4767 eeg_sdm1ct_0/eeg_fd_ota_full2_nc_0/stage2_0/N2P eeg_sdm1ct_0/eeg_pseudo_res_1/B 1.567700e-16
C4768 eeg_sdm1ct_0/eeg_fd_ota_full2_nc_0/stage2_0/VBP2 VSS 3.113330e-14
C4769 eeg_sdm1ct_0/eeg_fd_ota_full2_nc_0/stage2_0/VBP2 eeg_sdm1ct_0/eeg_fd_ota_full2_nc_0/stage2_0/VCM2 1.483105e-16
C4770 eeg_sdm1ct_0/eeg_fd_ota_full2_nc_0/stage2_0/VCM2 VSS 4.437230e-15
C4771 VDD18 VSS 1.072390e-14
C4772 VDD18 eeg_sdm1ct_0/eeg_fd_ota_full2_nc_0/eeg_bias_gen_0/VBN 1.083494e-15
C4773 VDD18 eeg_sdm1ct_0/eeg_fd_ota_full2_nc_0/eeg_bias_gen_0/VBNF 1.335704e-15
C4774 VDD18 eeg_sdm1ct_0/eeg_fd_ota_full2_nc_0/eeg_bias_gen_0/VBP 1.406448e-15
C4775 VDD18 eeg_sdm1ct_0/eeg_fd_ota_full2_nc_0/eeg_bias_gen_0/eeg_pseudo_res_0/m1_68_66# 4.622759e-16
C4776 VDD18 eeg_sdm1ct_0/eeg_fd_ota_full2_nc_0/eeg_bias_gen_0/m1_2524_466# 2.065494e-15
C4777 VSS eeg_sdm1ct_0/eeg_fd_ota_full2_nc_0/eeg_bias_gen_0/VBN 1.960641e-15
C4778 VSS eeg_sdm1ct_0/eeg_fd_ota_full2_nc_0/eeg_bias_gen_0/VBNF 5.192045e-12
C4779 VSS eeg_sdm1ct_0/eeg_fd_ota_full2_nc_0/eeg_bias_gen_0/VBP 5.474732e-16
C4780 VSS eeg_sdm1ct_0/eeg_fd_ota_full2_nc_0/eeg_bias_gen_0/m1_10341_n45240# 2.586160e-17
C4782 VSS eeg_sdm1ct_0/eeg_fd_ota_full2_nc_0/eeg_bias_gen_0/m1_11141_n45240# 2.586160e-17
C4784 VSS eeg_sdm1ct_0/eeg_fd_ota_full2_nc_0/eeg_bias_gen_0/m1_2524_466# 5.870937e-16
C4786 VSS eeg_sdm1ct_0/eeg_fd_ota_full2_nc_0/eeg_bias_gen_0/m1_3941_n45240# 2.586160e-17
C4788 VSS eeg_sdm1ct_0/eeg_fd_ota_full2_nc_0/eeg_bias_gen_0/m1_4741_n45240# 2.586160e-17
C4790 VSS eeg_sdm1ct_0/eeg_fd_ota_full2_nc_0/eeg_bias_gen_0/m1_5541_n45240# 2.586160e-17
C4792 VSS eeg_sdm1ct_0/eeg_fd_ota_full2_nc_0/eeg_bias_gen_0/m1_6341_n45240# 2.586160e-17
C4794 VSS eeg_sdm1ct_0/eeg_fd_ota_full2_nc_0/eeg_bias_gen_0/m1_7141_n45240# 2.586160e-17
C4796 VSS eeg_sdm1ct_0/eeg_fd_ota_full2_nc_0/eeg_bias_gen_0/m1_7941_n45240# 2.586160e-17
C4798 VSS eeg_sdm1ct_0/eeg_fd_ota_full2_nc_0/eeg_bias_gen_0/m1_8741_n45240# 2.586160e-17
C4800 VSS eeg_sdm1ct_0/eeg_fd_ota_full2_nc_0/eeg_bias_gen_0/m1_9541_n45240# 2.586160e-17
C4802 eeg_sdm1ct_0/eeg_fd_ota_full2_nc_0/eeg_bias_gen_0/VBN VSS 2.467770e-14
C4803 eeg_sdm1ct_0/eeg_fd_ota_full2_nc_0/eeg_bias_gen_0/VBN eeg_sdm1ct_0/eeg_fd_ota_full2_nc_0/eeg_bias_gen_0/VBNF 3.771753e-15
C4804 eeg_sdm1ct_0/eeg_fd_ota_full2_nc_0/eeg_bias_gen_0/VBN eeg_sdm1ct_0/eeg_fd_ota_full2_nc_0/eeg_bias_gen_0/VBP 4.597047e-15
C4805 eeg_sdm1ct_0/eeg_fd_ota_full2_nc_0/eeg_bias_gen_0/VBN eeg_sdm1ct_0/eeg_fd_ota_full2_nc_0/eeg_bias_gen_0/eeg_pseudo_res_0/m1_68_66# 4.676611e-16
C4806 eeg_sdm1ct_0/eeg_fd_ota_full2_nc_0/eeg_bias_gen_0/VBN eeg_sdm1ct_0/eeg_fd_ota_full2_nc_0/eeg_bias_gen_0/m1_2524_466# 1.449157e-15
C4807 eeg_sdm1ct_0/eeg_fd_ota_full2_nc_0/eeg_bias_gen_0/VBN eeg_sdm1ct_0/eeg_fd_ota_full2_nc_0/eeg_bias_gen_0/m1_3701_n11401# 9.237684e-16
C4808 eeg_sdm1ct_0/eeg_fd_ota_full2_nc_0/eeg_bias_gen_0/VBN eeg_sdm1ct_0/eeg_fd_ota_full2_nc_0/eeg_bias_gen_0/m1_3701_n29089# 9.231557e-16
C4809 eeg_sdm1ct_0/eeg_fd_ota_full2_nc_0/eeg_bias_gen_0/VBN eeg_sdm1ct_0/eeg_fd_ota_full2_nc_0/eeg_bias_gen_0/m1_3941_n27552# 3.117144e-16
C4810 eeg_sdm1ct_0/eeg_fd_ota_full2_nc_0/eeg_bias_gen_0/VBN eeg_sdm1ct_0/eeg_fd_ota_full2_nc_0/eeg_bias_gen_0/m1_3941_n9864# 3.117144e-16
C4811 eeg_sdm1ct_0/eeg_fd_ota_full2_nc_0/eeg_bias_gen_0/VBN eeg_sdm1ct_0/eeg_fd_ota_full2_nc_0/eeg_bias_gen_0/m1_4059_n18708# 3.117150e-16
C4812 eeg_sdm1ct_0/eeg_fd_ota_full2_nc_0/eeg_bias_gen_0/VBN eeg_sdm1ct_0/eeg_fd_ota_full2_nc_0/eeg_bias_gen_0/m1_4059_n36396# 3.171103e-16
C4815 eeg_sdm1ct_0/eeg_fd_ota_full2_nc_0/eeg_bias_gen_0/VBN eeg_sdm1ct_0/eeg_fd_ota_full2_nc_0/eeg_bias_gen_0/m1_4341_n37933# 7.669240e-17
C4831 eeg_sdm1ct_0/eeg_fd_ota_full2_nc_0/eeg_bias_gen_0/VBNF VSS 7.281980e-14
C4832 eeg_sdm1ct_0/eeg_fd_ota_full2_nc_0/eeg_bias_gen_0/VBNF eeg_sdm1ct_0/eeg_fd_ota_full2_nc_0/eeg_bias_gen_0/VBP 2.246044e-15
C4833 eeg_sdm1ct_0/eeg_fd_ota_full2_nc_0/eeg_bias_gen_0/VBNF eeg_sdm1ct_0/eeg_fd_ota_full2_nc_0/eeg_bias_gen_0/m1_10059_n11401# 3.343550e-17
C4834 eeg_sdm1ct_0/eeg_fd_ota_full2_nc_0/eeg_bias_gen_0/VBNF eeg_sdm1ct_0/eeg_fd_ota_full2_nc_0/eeg_bias_gen_0/m1_10059_n29089# 3.343556e-17
C4835 eeg_sdm1ct_0/eeg_fd_ota_full2_nc_0/eeg_bias_gen_0/VBNF eeg_sdm1ct_0/eeg_fd_ota_full2_nc_0/eeg_bias_gen_0/m1_10341_n27552# 1.024404e-16
C4836 eeg_sdm1ct_0/eeg_fd_ota_full2_nc_0/eeg_bias_gen_0/VBNF eeg_sdm1ct_0/eeg_fd_ota_full2_nc_0/eeg_bias_gen_0/m1_10341_n45240# 1.116124e-16
C4837 eeg_sdm1ct_0/eeg_fd_ota_full2_nc_0/eeg_bias_gen_0/VBNF eeg_sdm1ct_0/eeg_fd_ota_full2_nc_0/eeg_bias_gen_0/m1_10341_n9864# 1.024404e-16
C4838 eeg_sdm1ct_0/eeg_fd_ota_full2_nc_0/eeg_bias_gen_0/VBNF eeg_sdm1ct_0/eeg_fd_ota_full2_nc_0/eeg_bias_gen_0/m1_10459_n18708# 1.024404e-16
C4839 eeg_sdm1ct_0/eeg_fd_ota_full2_nc_0/eeg_bias_gen_0/VBNF eeg_sdm1ct_0/eeg_fd_ota_full2_nc_0/eeg_bias_gen_0/m1_10459_n36396# 1.024404e-16
C4840 eeg_sdm1ct_0/eeg_fd_ota_full2_nc_0/eeg_bias_gen_0/VBNF eeg_sdm1ct_0/eeg_fd_ota_full2_nc_0/eeg_bias_gen_0/m1_10741_n20245# 1.793252e-16
C4841 eeg_sdm1ct_0/eeg_fd_ota_full2_nc_0/eeg_bias_gen_0/VBNF eeg_sdm1ct_0/eeg_fd_ota_full2_nc_0/eeg_bias_gen_0/m1_10741_n2557# 2.584588e-16
C4842 eeg_sdm1ct_0/eeg_fd_ota_full2_nc_0/eeg_bias_gen_0/VBNF eeg_sdm1ct_0/eeg_fd_ota_full2_nc_0/eeg_bias_gen_0/m1_10741_n37933# 1.793251e-16
C4843 eeg_sdm1ct_0/eeg_fd_ota_full2_nc_0/eeg_bias_gen_0/VBNF eeg_sdm1ct_0/eeg_fd_ota_full2_nc_0/eeg_bias_gen_0/m1_10859_n11401# 1.793252e-16
C4844 eeg_sdm1ct_0/eeg_fd_ota_full2_nc_0/eeg_bias_gen_0/VBNF eeg_sdm1ct_0/eeg_fd_ota_full2_nc_0/eeg_bias_gen_0/m1_10859_n29089# 1.793253e-16
C4845 eeg_sdm1ct_0/eeg_fd_ota_full2_nc_0/eeg_bias_gen_0/VBNF eeg_sdm1ct_0/eeg_fd_ota_full2_nc_0/eeg_bias_gen_0/m1_11141_n27552# 1.024404e-16
C4846 eeg_sdm1ct_0/eeg_fd_ota_full2_nc_0/eeg_bias_gen_0/VBNF eeg_sdm1ct_0/eeg_fd_ota_full2_nc_0/eeg_bias_gen_0/m1_11141_n45240# 1.116125e-16
C4847 eeg_sdm1ct_0/eeg_fd_ota_full2_nc_0/eeg_bias_gen_0/VBNF eeg_sdm1ct_0/eeg_fd_ota_full2_nc_0/eeg_bias_gen_0/m1_11141_n9864# 1.024404e-16
C4848 eeg_sdm1ct_0/eeg_fd_ota_full2_nc_0/eeg_bias_gen_0/VBNF eeg_sdm1ct_0/eeg_fd_ota_full2_nc_0/eeg_bias_gen_0/m1_11259_n18708# 1.024404e-16
C4849 eeg_sdm1ct_0/eeg_fd_ota_full2_nc_0/eeg_bias_gen_0/VBNF eeg_sdm1ct_0/eeg_fd_ota_full2_nc_0/eeg_bias_gen_0/m1_11259_n36396# 1.024404e-16
C4850 eeg_sdm1ct_0/eeg_fd_ota_full2_nc_0/eeg_bias_gen_0/VBNF eeg_sdm1ct_0/eeg_fd_ota_full2_nc_0/eeg_bias_gen_0/m1_11541_n20245# 2.847116e-16
C4851 eeg_sdm1ct_0/eeg_fd_ota_full2_nc_0/eeg_bias_gen_0/VBNF eeg_sdm1ct_0/eeg_fd_ota_full2_nc_0/eeg_bias_gen_0/m1_11541_n37933# 2.847116e-16
C4852 eeg_sdm1ct_0/eeg_fd_ota_full2_nc_0/eeg_bias_gen_0/VBNF eeg_sdm1ct_0/eeg_fd_ota_full2_nc_0/eeg_bias_gen_0/m1_2524_466# 5.686547e-16
C4860 eeg_sdm1ct_0/eeg_fd_ota_full2_nc_0/eeg_bias_gen_0/VBNF eeg_sdm1ct_0/eeg_fd_ota_full2_nc_0/eeg_bias_gen_0/m1_8741_n45240# 2.017146e-17
C4870 eeg_sdm1ct_0/eeg_fd_ota_full2_nc_0/eeg_bias_gen_0/VBNF eeg_sdm1ct_0/eeg_fd_ota_full2_nc_0/eeg_bias_gen_0/m1_9541_n45240# 3.497385e-17
C4874 eeg_sdm1ct_0/eeg_fd_ota_full2_nc_0/eeg_bias_gen_0/VBNF eeg_sdm1ct_0/eeg_fd_ota_full2_nc_0/eeg_bias_gen_0/m1_9941_n20245# 3.343550e-17
C4875 eeg_sdm1ct_0/eeg_fd_ota_full2_nc_0/eeg_bias_gen_0/VBNF eeg_sdm1ct_0/eeg_fd_ota_full2_nc_0/eeg_bias_gen_0/m1_9941_n2557# 3.464034e-17
C4876 eeg_sdm1ct_0/eeg_fd_ota_full2_nc_0/eeg_bias_gen_0/VBNF eeg_sdm1ct_0/eeg_fd_ota_full2_nc_0/eeg_bias_gen_0/m1_9941_n37933# 3.343550e-17
C4877 eeg_sdm1ct_0/eeg_fd_ota_full2_nc_0/eeg_bias_gen_0/VBP VSS 5.243180e-15
C4878 eeg_sdm1ct_0/eeg_fd_ota_full2_nc_0/eeg_bias_gen_0/VBP eeg_sdm1ct_0/eeg_fd_ota_full2_nc_0/eeg_bias_gen_0/m1_2524_466# 4.554927e-15
C4879 eeg_sdm1ct_0/eeg_fd_ota_full2_nc_0/eeg_bias_gen_0/m1_10059_n11401# VSS 2.918310e-16
C4881 eeg_sdm1ct_0/eeg_fd_ota_full2_nc_0/eeg_bias_gen_0/m1_10059_n11401# eeg_sdm1ct_0/eeg_fd_ota_full2_nc_0/eeg_bias_gen_0/m1_10859_n11401# 6.789047e-17
C4883 eeg_sdm1ct_0/eeg_fd_ota_full2_nc_0/eeg_bias_gen_0/m1_10059_n11401# eeg_sdm1ct_0/eeg_fd_ota_full2_nc_0/eeg_bias_gen_0/m1_9259_n11401# 6.789047e-17
C4885 eeg_sdm1ct_0/eeg_fd_ota_full2_nc_0/eeg_bias_gen_0/m1_10059_n29089# VSS 2.918310e-16
C4887 eeg_sdm1ct_0/eeg_fd_ota_full2_nc_0/eeg_bias_gen_0/m1_10059_n29089# eeg_sdm1ct_0/eeg_fd_ota_full2_nc_0/eeg_bias_gen_0/m1_10859_n29089# 6.789043e-17
C4889 eeg_sdm1ct_0/eeg_fd_ota_full2_nc_0/eeg_bias_gen_0/m1_10059_n29089# eeg_sdm1ct_0/eeg_fd_ota_full2_nc_0/eeg_bias_gen_0/m1_9259_n29089# 6.789040e-17
C4891 eeg_sdm1ct_0/eeg_fd_ota_full2_nc_0/eeg_bias_gen_0/m1_10341_n27552# VSS 4.190540e-16
C4893 eeg_sdm1ct_0/eeg_fd_ota_full2_nc_0/eeg_bias_gen_0/m1_10341_n27552# eeg_sdm1ct_0/eeg_fd_ota_full2_nc_0/eeg_bias_gen_0/m1_11141_n27552# 6.789050e-17
C4894 eeg_sdm1ct_0/eeg_fd_ota_full2_nc_0/eeg_bias_gen_0/m1_10341_n27552# eeg_sdm1ct_0/eeg_fd_ota_full2_nc_0/eeg_bias_gen_0/m1_9541_n27552# 6.789050e-17
C4895 eeg_sdm1ct_0/eeg_fd_ota_full2_nc_0/eeg_bias_gen_0/m1_10341_n45240# VSS 4.190540e-16
C4896 eeg_sdm1ct_0/eeg_fd_ota_full2_nc_0/eeg_bias_gen_0/m1_10341_n45240# eeg_sdm1ct_0/eeg_fd_ota_full2_nc_0/eeg_bias_gen_0/m1_11141_n45240# 6.789050e-17
C4897 eeg_sdm1ct_0/eeg_fd_ota_full2_nc_0/eeg_bias_gen_0/m1_10341_n45240# eeg_sdm1ct_0/eeg_fd_ota_full2_nc_0/eeg_bias_gen_0/m1_9541_n45240# 6.789050e-17
C4898 eeg_sdm1ct_0/eeg_fd_ota_full2_nc_0/eeg_bias_gen_0/m1_10341_n9864# VSS 4.190540e-16
C4900 eeg_sdm1ct_0/eeg_fd_ota_full2_nc_0/eeg_bias_gen_0/m1_10341_n9864# eeg_sdm1ct_0/eeg_fd_ota_full2_nc_0/eeg_bias_gen_0/m1_11141_n9864# 6.789050e-17
C4901 eeg_sdm1ct_0/eeg_fd_ota_full2_nc_0/eeg_bias_gen_0/m1_10341_n9864# eeg_sdm1ct_0/eeg_fd_ota_full2_nc_0/eeg_bias_gen_0/m1_9541_n9864# 6.789050e-17
C4902 eeg_sdm1ct_0/eeg_fd_ota_full2_nc_0/eeg_bias_gen_0/m1_10459_n18708# VSS 2.918310e-16
C4904 eeg_sdm1ct_0/eeg_fd_ota_full2_nc_0/eeg_bias_gen_0/m1_10459_n18708# eeg_sdm1ct_0/eeg_fd_ota_full2_nc_0/eeg_bias_gen_0/m1_11259_n18708# 6.789040e-17
C4906 eeg_sdm1ct_0/eeg_fd_ota_full2_nc_0/eeg_bias_gen_0/m1_10459_n18708# eeg_sdm1ct_0/eeg_fd_ota_full2_nc_0/eeg_bias_gen_0/m1_9659_n18708# 6.789043e-17
C4908 eeg_sdm1ct_0/eeg_fd_ota_full2_nc_0/eeg_bias_gen_0/m1_10459_n36396# VSS 2.918310e-16
C4910 eeg_sdm1ct_0/eeg_fd_ota_full2_nc_0/eeg_bias_gen_0/m1_10459_n36396# eeg_sdm1ct_0/eeg_fd_ota_full2_nc_0/eeg_bias_gen_0/m1_11259_n36396# 6.789050e-17
C4912 eeg_sdm1ct_0/eeg_fd_ota_full2_nc_0/eeg_bias_gen_0/m1_10459_n36396# eeg_sdm1ct_0/eeg_fd_ota_full2_nc_0/eeg_bias_gen_0/m1_9659_n36396# 6.789043e-17
C4914 eeg_sdm1ct_0/eeg_fd_ota_full2_nc_0/eeg_bias_gen_0/m1_10741_n20245# VSS 4.190540e-16
C4916 eeg_sdm1ct_0/eeg_fd_ota_full2_nc_0/eeg_bias_gen_0/m1_10741_n20245# eeg_sdm1ct_0/eeg_fd_ota_full2_nc_0/eeg_bias_gen_0/m1_11541_n20245# 6.794053e-17
C4917 eeg_sdm1ct_0/eeg_fd_ota_full2_nc_0/eeg_bias_gen_0/m1_10741_n20245# eeg_sdm1ct_0/eeg_fd_ota_full2_nc_0/eeg_bias_gen_0/m1_9941_n20245# 6.789050e-17
C4918 eeg_sdm1ct_0/eeg_fd_ota_full2_nc_0/eeg_bias_gen_0/m1_10741_n2557# VSS 4.623640e-16
C4919 eeg_sdm1ct_0/eeg_fd_ota_full2_nc_0/eeg_bias_gen_0/m1_10741_n2557# eeg_sdm1ct_0/eeg_fd_ota_full2_nc_0/eeg_bias_gen_0/m1_9941_n2557# 6.789050e-17
C4920 eeg_sdm1ct_0/eeg_fd_ota_full2_nc_0/eeg_bias_gen_0/m1_10741_n37933# VSS 4.190540e-16
C4922 eeg_sdm1ct_0/eeg_fd_ota_full2_nc_0/eeg_bias_gen_0/m1_10741_n37933# eeg_sdm1ct_0/eeg_fd_ota_full2_nc_0/eeg_bias_gen_0/m1_11541_n37933# 6.794053e-17
C4923 eeg_sdm1ct_0/eeg_fd_ota_full2_nc_0/eeg_bias_gen_0/m1_10741_n37933# eeg_sdm1ct_0/eeg_fd_ota_full2_nc_0/eeg_bias_gen_0/m1_9941_n37933# 6.789050e-17
C4924 eeg_sdm1ct_0/eeg_fd_ota_full2_nc_0/eeg_bias_gen_0/m1_10859_n11401# VSS 2.849110e-16
C4926 eeg_sdm1ct_0/eeg_fd_ota_full2_nc_0/eeg_bias_gen_0/m1_10859_n11401# eeg_sdm1ct_0/eeg_fd_ota_full2_nc_0/eeg_bias_gen_0/m1_11541_n20245# 6.796552e-17
C4927 eeg_sdm1ct_0/eeg_fd_ota_full2_nc_0/eeg_bias_gen_0/m1_10859_n29089# VSS 2.849110e-16
C4929 eeg_sdm1ct_0/eeg_fd_ota_full2_nc_0/eeg_bias_gen_0/m1_10859_n29089# eeg_sdm1ct_0/eeg_fd_ota_full2_nc_0/eeg_bias_gen_0/m1_11541_n37933# 6.796554e-17
C4930 eeg_sdm1ct_0/eeg_fd_ota_full2_nc_0/eeg_bias_gen_0/m1_11141_n27552# VSS 4.651810e-16
C4932 eeg_sdm1ct_0/eeg_fd_ota_full2_nc_0/eeg_bias_gen_0/m1_11141_n45240# VSS 4.702790e-16
C4933 eeg_sdm1ct_0/eeg_fd_ota_full2_nc_0/eeg_bias_gen_0/m1_11141_n9864# VSS 4.651810e-16
C4935 eeg_sdm1ct_0/eeg_fd_ota_full2_nc_0/eeg_bias_gen_0/m1_11259_n18708# VSS 2.743410e-16
C4936 eeg_sdm1ct_0/eeg_fd_ota_full2_nc_0/eeg_bias_gen_0/m1_11259_n18708# eeg_sdm1ct_0/eeg_fd_ota_full2_nc_0/eeg_bias_gen_0/m1_11541_n20245# 6.171110e-17
C4937 eeg_sdm1ct_0/eeg_fd_ota_full2_nc_0/eeg_bias_gen_0/m1_11259_n36396# VSS 2.743410e-16
C4938 eeg_sdm1ct_0/eeg_fd_ota_full2_nc_0/eeg_bias_gen_0/m1_11259_n36396# eeg_sdm1ct_0/eeg_fd_ota_full2_nc_0/eeg_bias_gen_0/m1_11541_n37933# 6.171107e-17
C4939 eeg_sdm1ct_0/eeg_fd_ota_full2_nc_0/eeg_bias_gen_0/m1_11541_n20245# VSS 4.394320e-15
C4941 eeg_sdm1ct_0/eeg_fd_ota_full2_nc_0/eeg_bias_gen_0/m1_11541_n37933# VSS 4.394320e-15
C4943 eeg_sdm1ct_0/eeg_fd_ota_full2_nc_0/eeg_bias_gen_0/m1_2524_466# VSS 6.618010e-15
C4944 eeg_sdm1ct_0/eeg_fd_ota_full2_nc_0/eeg_bias_gen_0/m1_3701_n11401# VSS 4.381540e-15
C4945 eeg_sdm1ct_0/eeg_fd_ota_full2_nc_0/eeg_bias_gen_0/m1_3701_n11401# eeg_sdm1ct_0/eeg_fd_ota_full2_nc_0/eeg_bias_gen_0/m1_3941_n9864# 6.171105e-17
C4946 eeg_sdm1ct_0/eeg_fd_ota_full2_nc_0/eeg_bias_gen_0/m1_3701_n11401# eeg_sdm1ct_0/eeg_fd_ota_full2_nc_0/eeg_bias_gen_0/m1_4341_n2557# 6.796550e-17
C4947 eeg_sdm1ct_0/eeg_fd_ota_full2_nc_0/eeg_bias_gen_0/m1_3701_n11401# eeg_sdm1ct_0/eeg_fd_ota_full2_nc_0/eeg_bias_gen_0/m1_4459_n11401# 6.794051e-17
C4951 eeg_sdm1ct_0/eeg_fd_ota_full2_nc_0/eeg_bias_gen_0/m1_3701_n29089# VSS 4.381540e-15
C4952 eeg_sdm1ct_0/eeg_fd_ota_full2_nc_0/eeg_bias_gen_0/m1_3701_n29089# eeg_sdm1ct_0/eeg_fd_ota_full2_nc_0/eeg_bias_gen_0/m1_3941_n27552# 6.171109e-17
C4954 eeg_sdm1ct_0/eeg_fd_ota_full2_nc_0/eeg_bias_gen_0/m1_3701_n29089# eeg_sdm1ct_0/eeg_fd_ota_full2_nc_0/eeg_bias_gen_0/m1_4341_n20245# 6.796550e-17
C4955 eeg_sdm1ct_0/eeg_fd_ota_full2_nc_0/eeg_bias_gen_0/m1_3701_n29089# eeg_sdm1ct_0/eeg_fd_ota_full2_nc_0/eeg_bias_gen_0/m1_4459_n29089# 6.794050e-17
C4959 eeg_sdm1ct_0/eeg_fd_ota_full2_nc_0/eeg_bias_gen_0/m1_3941_n27552# VSS 3.999630e-16
C4961 eeg_sdm1ct_0/eeg_fd_ota_full2_nc_0/eeg_bias_gen_0/m1_3941_n27552# eeg_sdm1ct_0/eeg_fd_ota_full2_nc_0/eeg_bias_gen_0/m1_4741_n27552# 6.789050e-17
C4962 eeg_sdm1ct_0/eeg_fd_ota_full2_nc_0/eeg_bias_gen_0/m1_3941_n45240# VSS 4.702790e-16
C4963 eeg_sdm1ct_0/eeg_fd_ota_full2_nc_0/eeg_bias_gen_0/m1_3941_n45240# eeg_sdm1ct_0/eeg_fd_ota_full2_nc_0/eeg_bias_gen_0/m1_4741_n45240# 6.789050e-17
C4964 eeg_sdm1ct_0/eeg_fd_ota_full2_nc_0/eeg_bias_gen_0/m1_3941_n9864# VSS 3.999630e-16
C4966 eeg_sdm1ct_0/eeg_fd_ota_full2_nc_0/eeg_bias_gen_0/m1_3941_n9864# eeg_sdm1ct_0/eeg_fd_ota_full2_nc_0/eeg_bias_gen_0/m1_4741_n9864# 6.789050e-17
C4967 eeg_sdm1ct_0/eeg_fd_ota_full2_nc_0/eeg_bias_gen_0/m1_4059_n18708# VSS 3.267770e-16
C4969 eeg_sdm1ct_0/eeg_fd_ota_full2_nc_0/eeg_bias_gen_0/m1_4059_n18708# eeg_sdm1ct_0/eeg_fd_ota_full2_nc_0/eeg_bias_gen_0/m1_4859_n18708# 6.789043e-17
C4970 eeg_sdm1ct_0/eeg_fd_ota_full2_nc_0/eeg_bias_gen_0/m1_4059_n36396# VSS 3.267770e-16
C4972 eeg_sdm1ct_0/eeg_fd_ota_full2_nc_0/eeg_bias_gen_0/m1_4059_n36396# eeg_sdm1ct_0/eeg_fd_ota_full2_nc_0/eeg_bias_gen_0/m1_4859_n36396# 6.789043e-17
C4973 eeg_sdm1ct_0/eeg_fd_ota_full2_nc_0/eeg_bias_gen_0/m1_4341_n20245# VSS 4.190540e-16
C4975 eeg_sdm1ct_0/eeg_fd_ota_full2_nc_0/eeg_bias_gen_0/m1_4341_n20245# eeg_sdm1ct_0/eeg_fd_ota_full2_nc_0/eeg_bias_gen_0/m1_5141_n20245# 6.789050e-17
C4976 eeg_sdm1ct_0/eeg_fd_ota_full2_nc_0/eeg_bias_gen_0/m1_4341_n2557# VSS 4.190540e-16
C4977 eeg_sdm1ct_0/eeg_fd_ota_full2_nc_0/eeg_bias_gen_0/m1_4341_n2557# eeg_sdm1ct_0/eeg_fd_ota_full2_nc_0/eeg_bias_gen_0/m1_5141_n2557# 6.789050e-17
C4978 eeg_sdm1ct_0/eeg_fd_ota_full2_nc_0/eeg_bias_gen_0/m1_4341_n37933# VSS 4.624800e-16
C4980 eeg_sdm1ct_0/eeg_fd_ota_full2_nc_0/eeg_bias_gen_0/m1_4341_n37933# eeg_sdm1ct_0/eeg_fd_ota_full2_nc_0/eeg_bias_gen_0/m1_5141_n37933# 6.789050e-17
C4981 eeg_sdm1ct_0/eeg_fd_ota_full2_nc_0/eeg_bias_gen_0/m1_4459_n11401# VSS 2.849110e-16
C4983 eeg_sdm1ct_0/eeg_fd_ota_full2_nc_0/eeg_bias_gen_0/m1_4459_n11401# eeg_sdm1ct_0/eeg_fd_ota_full2_nc_0/eeg_bias_gen_0/m1_5259_n11401# 6.789047e-17
C4984 eeg_sdm1ct_0/eeg_fd_ota_full2_nc_0/eeg_bias_gen_0/m1_4459_n29089# VSS 2.849110e-16
C4986 eeg_sdm1ct_0/eeg_fd_ota_full2_nc_0/eeg_bias_gen_0/m1_4459_n29089# eeg_sdm1ct_0/eeg_fd_ota_full2_nc_0/eeg_bias_gen_0/m1_5259_n29089# 6.789043e-17
C4987 eeg_sdm1ct_0/eeg_fd_ota_full2_nc_0/eeg_bias_gen_0/m1_4741_n27552# VSS 4.190540e-16
C4989 eeg_sdm1ct_0/eeg_fd_ota_full2_nc_0/eeg_bias_gen_0/m1_4741_n27552# eeg_sdm1ct_0/eeg_fd_ota_full2_nc_0/eeg_bias_gen_0/m1_5541_n27552# 6.789050e-17
C4990 eeg_sdm1ct_0/eeg_fd_ota_full2_nc_0/eeg_bias_gen_0/m1_4741_n45240# VSS 4.190540e-16
C4991 eeg_sdm1ct_0/eeg_fd_ota_full2_nc_0/eeg_bias_gen_0/m1_4741_n45240# eeg_sdm1ct_0/eeg_fd_ota_full2_nc_0/eeg_bias_gen_0/m1_5541_n45240# 6.789050e-17
C4992 eeg_sdm1ct_0/eeg_fd_ota_full2_nc_0/eeg_bias_gen_0/m1_4741_n9864# VSS 4.190540e-16
C4994 eeg_sdm1ct_0/eeg_fd_ota_full2_nc_0/eeg_bias_gen_0/m1_4741_n9864# eeg_sdm1ct_0/eeg_fd_ota_full2_nc_0/eeg_bias_gen_0/m1_5541_n9864# 6.789050e-17
C4995 eeg_sdm1ct_0/eeg_fd_ota_full2_nc_0/eeg_bias_gen_0/m1_4859_n18708# VSS 2.918310e-16
C4997 eeg_sdm1ct_0/eeg_fd_ota_full2_nc_0/eeg_bias_gen_0/m1_4859_n18708# eeg_sdm1ct_0/eeg_fd_ota_full2_nc_0/eeg_bias_gen_0/m1_5659_n18708# 6.789040e-17
C4998 eeg_sdm1ct_0/eeg_fd_ota_full2_nc_0/eeg_bias_gen_0/m1_4859_n36396# VSS 2.918310e-16
C5000 eeg_sdm1ct_0/eeg_fd_ota_full2_nc_0/eeg_bias_gen_0/m1_4859_n36396# eeg_sdm1ct_0/eeg_fd_ota_full2_nc_0/eeg_bias_gen_0/m1_5659_n36396# 6.789050e-17
C5001 eeg_sdm1ct_0/eeg_fd_ota_full2_nc_0/eeg_bias_gen_0/m1_5141_n20245# VSS 4.190540e-16
C5003 eeg_sdm1ct_0/eeg_fd_ota_full2_nc_0/eeg_bias_gen_0/m1_5141_n20245# eeg_sdm1ct_0/eeg_fd_ota_full2_nc_0/eeg_bias_gen_0/m1_5941_n20245# 6.789050e-17
C5004 eeg_sdm1ct_0/eeg_fd_ota_full2_nc_0/eeg_bias_gen_0/m1_5141_n2557# VSS 4.190540e-16
C5005 eeg_sdm1ct_0/eeg_fd_ota_full2_nc_0/eeg_bias_gen_0/m1_5141_n2557# eeg_sdm1ct_0/eeg_fd_ota_full2_nc_0/eeg_bias_gen_0/m1_5941_n2557# 6.789050e-17
C5006 eeg_sdm1ct_0/eeg_fd_ota_full2_nc_0/eeg_bias_gen_0/m1_5141_n37933# VSS 4.190540e-16
C5008 eeg_sdm1ct_0/eeg_fd_ota_full2_nc_0/eeg_bias_gen_0/m1_5141_n37933# eeg_sdm1ct_0/eeg_fd_ota_full2_nc_0/eeg_bias_gen_0/m1_5941_n37933# 6.789050e-17
C5009 eeg_sdm1ct_0/eeg_fd_ota_full2_nc_0/eeg_bias_gen_0/m1_5259_n11401# VSS 2.918310e-16
C5011 eeg_sdm1ct_0/eeg_fd_ota_full2_nc_0/eeg_bias_gen_0/m1_5259_n11401# eeg_sdm1ct_0/eeg_fd_ota_full2_nc_0/eeg_bias_gen_0/m1_6059_n11401# 6.789047e-17
C5012 eeg_sdm1ct_0/eeg_fd_ota_full2_nc_0/eeg_bias_gen_0/m1_5259_n29089# VSS 2.918310e-16
C5014 eeg_sdm1ct_0/eeg_fd_ota_full2_nc_0/eeg_bias_gen_0/m1_5259_n29089# eeg_sdm1ct_0/eeg_fd_ota_full2_nc_0/eeg_bias_gen_0/m1_6059_n29089# 6.789040e-17
C5015 eeg_sdm1ct_0/eeg_fd_ota_full2_nc_0/eeg_bias_gen_0/m1_5541_n27552# VSS 4.190540e-16
C5017 eeg_sdm1ct_0/eeg_fd_ota_full2_nc_0/eeg_bias_gen_0/m1_5541_n27552# eeg_sdm1ct_0/eeg_fd_ota_full2_nc_0/eeg_bias_gen_0/m1_6341_n27552# 6.789040e-17
C5018 eeg_sdm1ct_0/eeg_fd_ota_full2_nc_0/eeg_bias_gen_0/m1_5541_n45240# VSS 4.190540e-16
C5019 eeg_sdm1ct_0/eeg_fd_ota_full2_nc_0/eeg_bias_gen_0/m1_5541_n45240# eeg_sdm1ct_0/eeg_fd_ota_full2_nc_0/eeg_bias_gen_0/m1_6341_n45240# 6.789040e-17
C5020 eeg_sdm1ct_0/eeg_fd_ota_full2_nc_0/eeg_bias_gen_0/m1_5541_n9864# VSS 4.190540e-16
C5022 eeg_sdm1ct_0/eeg_fd_ota_full2_nc_0/eeg_bias_gen_0/m1_5541_n9864# eeg_sdm1ct_0/eeg_fd_ota_full2_nc_0/eeg_bias_gen_0/m1_6341_n9864# 6.789040e-17
C5023 eeg_sdm1ct_0/eeg_fd_ota_full2_nc_0/eeg_bias_gen_0/m1_5659_n18708# VSS 2.918310e-16
C5025 eeg_sdm1ct_0/eeg_fd_ota_full2_nc_0/eeg_bias_gen_0/m1_5659_n18708# eeg_sdm1ct_0/eeg_fd_ota_full2_nc_0/eeg_bias_gen_0/m1_6459_n18708# 6.789050e-17
C5026 eeg_sdm1ct_0/eeg_fd_ota_full2_nc_0/eeg_bias_gen_0/m1_5659_n36396# VSS 2.918310e-16
C5028 eeg_sdm1ct_0/eeg_fd_ota_full2_nc_0/eeg_bias_gen_0/m1_5659_n36396# eeg_sdm1ct_0/eeg_fd_ota_full2_nc_0/eeg_bias_gen_0/m1_6459_n36396# 6.789046e-17
C5029 eeg_sdm1ct_0/eeg_fd_ota_full2_nc_0/eeg_bias_gen_0/m1_5941_n20245# VSS 4.190540e-16
C5031 eeg_sdm1ct_0/eeg_fd_ota_full2_nc_0/eeg_bias_gen_0/m1_5941_n20245# eeg_sdm1ct_0/eeg_fd_ota_full2_nc_0/eeg_bias_gen_0/m1_6741_n20245# 6.789050e-17
C5032 eeg_sdm1ct_0/eeg_fd_ota_full2_nc_0/eeg_bias_gen_0/m1_5941_n2557# VSS 4.190540e-16
C5033 eeg_sdm1ct_0/eeg_fd_ota_full2_nc_0/eeg_bias_gen_0/m1_5941_n2557# eeg_sdm1ct_0/eeg_fd_ota_full2_nc_0/eeg_bias_gen_0/m1_6741_n2557# 6.789050e-17
C5034 eeg_sdm1ct_0/eeg_fd_ota_full2_nc_0/eeg_bias_gen_0/m1_5941_n37933# VSS 4.190540e-16
C5036 eeg_sdm1ct_0/eeg_fd_ota_full2_nc_0/eeg_bias_gen_0/m1_5941_n37933# eeg_sdm1ct_0/eeg_fd_ota_full2_nc_0/eeg_bias_gen_0/m1_6741_n37933# 6.789050e-17
C5037 eeg_sdm1ct_0/eeg_fd_ota_full2_nc_0/eeg_bias_gen_0/m1_6059_n11401# VSS 2.918310e-16
C5039 eeg_sdm1ct_0/eeg_fd_ota_full2_nc_0/eeg_bias_gen_0/m1_6059_n11401# eeg_sdm1ct_0/eeg_fd_ota_full2_nc_0/eeg_bias_gen_0/m1_6859_n11401# 6.789047e-17
C5040 eeg_sdm1ct_0/eeg_fd_ota_full2_nc_0/eeg_bias_gen_0/m1_6059_n29089# VSS 2.918310e-16
C5042 eeg_sdm1ct_0/eeg_fd_ota_full2_nc_0/eeg_bias_gen_0/m1_6059_n29089# eeg_sdm1ct_0/eeg_fd_ota_full2_nc_0/eeg_bias_gen_0/m1_6859_n29089# 6.789040e-17
C5043 eeg_sdm1ct_0/eeg_fd_ota_full2_nc_0/eeg_bias_gen_0/m1_6341_n27552# VSS 4.190540e-16
C5045 eeg_sdm1ct_0/eeg_fd_ota_full2_nc_0/eeg_bias_gen_0/m1_6341_n27552# eeg_sdm1ct_0/eeg_fd_ota_full2_nc_0/eeg_bias_gen_0/m1_7141_n27552# 6.789050e-17
C5046 eeg_sdm1ct_0/eeg_fd_ota_full2_nc_0/eeg_bias_gen_0/m1_6341_n45240# VSS 4.190540e-16
C5047 eeg_sdm1ct_0/eeg_fd_ota_full2_nc_0/eeg_bias_gen_0/m1_6341_n45240# eeg_sdm1ct_0/eeg_fd_ota_full2_nc_0/eeg_bias_gen_0/m1_7141_n45240# 6.789050e-17
C5048 eeg_sdm1ct_0/eeg_fd_ota_full2_nc_0/eeg_bias_gen_0/m1_6341_n9864# VSS 4.190540e-16
C5050 eeg_sdm1ct_0/eeg_fd_ota_full2_nc_0/eeg_bias_gen_0/m1_6341_n9864# eeg_sdm1ct_0/eeg_fd_ota_full2_nc_0/eeg_bias_gen_0/m1_7141_n9864# 6.789050e-17
C5051 eeg_sdm1ct_0/eeg_fd_ota_full2_nc_0/eeg_bias_gen_0/m1_6459_n18708# VSS 2.918310e-16
C5053 eeg_sdm1ct_0/eeg_fd_ota_full2_nc_0/eeg_bias_gen_0/m1_6459_n18708# eeg_sdm1ct_0/eeg_fd_ota_full2_nc_0/eeg_bias_gen_0/m1_7259_n18708# 6.789040e-17
C5054 eeg_sdm1ct_0/eeg_fd_ota_full2_nc_0/eeg_bias_gen_0/m1_6459_n36396# VSS 2.918310e-16
C5056 eeg_sdm1ct_0/eeg_fd_ota_full2_nc_0/eeg_bias_gen_0/m1_6459_n36396# eeg_sdm1ct_0/eeg_fd_ota_full2_nc_0/eeg_bias_gen_0/m1_7259_n36396# 6.789050e-17
C5057 eeg_sdm1ct_0/eeg_fd_ota_full2_nc_0/eeg_bias_gen_0/m1_6741_n20245# VSS 4.190540e-16
C5059 eeg_sdm1ct_0/eeg_fd_ota_full2_nc_0/eeg_bias_gen_0/m1_6741_n20245# eeg_sdm1ct_0/eeg_fd_ota_full2_nc_0/eeg_bias_gen_0/m1_7541_n20245# 6.789050e-17
C5060 eeg_sdm1ct_0/eeg_fd_ota_full2_nc_0/eeg_bias_gen_0/m1_6741_n2557# VSS 4.190540e-16
C5061 eeg_sdm1ct_0/eeg_fd_ota_full2_nc_0/eeg_bias_gen_0/m1_6741_n2557# eeg_sdm1ct_0/eeg_fd_ota_full2_nc_0/eeg_bias_gen_0/m1_7541_n2557# 6.789050e-17
C5062 eeg_sdm1ct_0/eeg_fd_ota_full2_nc_0/eeg_bias_gen_0/m1_6741_n37933# VSS 4.190540e-16
C5064 eeg_sdm1ct_0/eeg_fd_ota_full2_nc_0/eeg_bias_gen_0/m1_6741_n37933# eeg_sdm1ct_0/eeg_fd_ota_full2_nc_0/eeg_bias_gen_0/m1_7541_n37933# 6.789050e-17
C5065 eeg_sdm1ct_0/eeg_fd_ota_full2_nc_0/eeg_bias_gen_0/m1_6859_n11401# VSS 2.918310e-16
C5067 eeg_sdm1ct_0/eeg_fd_ota_full2_nc_0/eeg_bias_gen_0/m1_6859_n11401# eeg_sdm1ct_0/eeg_fd_ota_full2_nc_0/eeg_bias_gen_0/m1_7659_n11401# 6.789047e-17
C5068 eeg_sdm1ct_0/eeg_fd_ota_full2_nc_0/eeg_bias_gen_0/m1_6859_n29089# VSS 2.918310e-16
C5070 eeg_sdm1ct_0/eeg_fd_ota_full2_nc_0/eeg_bias_gen_0/m1_6859_n29089# eeg_sdm1ct_0/eeg_fd_ota_full2_nc_0/eeg_bias_gen_0/m1_7659_n29089# 6.789043e-17
C5071 eeg_sdm1ct_0/eeg_fd_ota_full2_nc_0/eeg_bias_gen_0/m1_7141_n27552# VSS 4.190540e-16
C5073 eeg_sdm1ct_0/eeg_fd_ota_full2_nc_0/eeg_bias_gen_0/m1_7141_n27552# eeg_sdm1ct_0/eeg_fd_ota_full2_nc_0/eeg_bias_gen_0/m1_7941_n27552# 6.789050e-17
C5074 eeg_sdm1ct_0/eeg_fd_ota_full2_nc_0/eeg_bias_gen_0/m1_7141_n45240# VSS 4.190540e-16
C5075 eeg_sdm1ct_0/eeg_fd_ota_full2_nc_0/eeg_bias_gen_0/m1_7141_n45240# eeg_sdm1ct_0/eeg_fd_ota_full2_nc_0/eeg_bias_gen_0/m1_7941_n45240# 6.789050e-17
C5076 eeg_sdm1ct_0/eeg_fd_ota_full2_nc_0/eeg_bias_gen_0/m1_7141_n9864# VSS 4.190540e-16
C5078 eeg_sdm1ct_0/eeg_fd_ota_full2_nc_0/eeg_bias_gen_0/m1_7141_n9864# eeg_sdm1ct_0/eeg_fd_ota_full2_nc_0/eeg_bias_gen_0/m1_7941_n9864# 6.789050e-17
C5079 eeg_sdm1ct_0/eeg_fd_ota_full2_nc_0/eeg_bias_gen_0/m1_7259_n18708# VSS 2.918310e-16
C5081 eeg_sdm1ct_0/eeg_fd_ota_full2_nc_0/eeg_bias_gen_0/m1_7259_n18708# eeg_sdm1ct_0/eeg_fd_ota_full2_nc_0/eeg_bias_gen_0/m1_8059_n18708# 6.789043e-17
C5082 eeg_sdm1ct_0/eeg_fd_ota_full2_nc_0/eeg_bias_gen_0/m1_7259_n36396# VSS 2.918310e-16
C5084 eeg_sdm1ct_0/eeg_fd_ota_full2_nc_0/eeg_bias_gen_0/m1_7259_n36396# eeg_sdm1ct_0/eeg_fd_ota_full2_nc_0/eeg_bias_gen_0/m1_8059_n36396# 6.789043e-17
C5085 eeg_sdm1ct_0/eeg_fd_ota_full2_nc_0/eeg_bias_gen_0/m1_7541_n20245# VSS 4.190540e-16
C5087 eeg_sdm1ct_0/eeg_fd_ota_full2_nc_0/eeg_bias_gen_0/m1_7541_n20245# eeg_sdm1ct_0/eeg_fd_ota_full2_nc_0/eeg_bias_gen_0/m1_8341_n20245# 6.789050e-17
C5088 eeg_sdm1ct_0/eeg_fd_ota_full2_nc_0/eeg_bias_gen_0/m1_7541_n2557# VSS 4.190540e-16
C5089 eeg_sdm1ct_0/eeg_fd_ota_full2_nc_0/eeg_bias_gen_0/m1_7541_n2557# eeg_sdm1ct_0/eeg_fd_ota_full2_nc_0/eeg_bias_gen_0/m1_8341_n2557# 6.789050e-17
C5090 eeg_sdm1ct_0/eeg_fd_ota_full2_nc_0/eeg_bias_gen_0/m1_7541_n37933# VSS 4.190540e-16
C5092 eeg_sdm1ct_0/eeg_fd_ota_full2_nc_0/eeg_bias_gen_0/m1_7541_n37933# eeg_sdm1ct_0/eeg_fd_ota_full2_nc_0/eeg_bias_gen_0/m1_8341_n37933# 6.789050e-17
C5093 eeg_sdm1ct_0/eeg_fd_ota_full2_nc_0/eeg_bias_gen_0/m1_7659_n11401# VSS 2.918310e-16
C5095 eeg_sdm1ct_0/eeg_fd_ota_full2_nc_0/eeg_bias_gen_0/m1_7659_n11401# eeg_sdm1ct_0/eeg_fd_ota_full2_nc_0/eeg_bias_gen_0/m1_8459_n11401# 6.789047e-17
C5096 eeg_sdm1ct_0/eeg_fd_ota_full2_nc_0/eeg_bias_gen_0/m1_7659_n29089# VSS 2.918310e-16
C5098 eeg_sdm1ct_0/eeg_fd_ota_full2_nc_0/eeg_bias_gen_0/m1_7659_n29089# eeg_sdm1ct_0/eeg_fd_ota_full2_nc_0/eeg_bias_gen_0/m1_8459_n29089# 6.789040e-17
C5099 eeg_sdm1ct_0/eeg_fd_ota_full2_nc_0/eeg_bias_gen_0/m1_7941_n27552# VSS 4.190540e-16
C5101 eeg_sdm1ct_0/eeg_fd_ota_full2_nc_0/eeg_bias_gen_0/m1_7941_n27552# eeg_sdm1ct_0/eeg_fd_ota_full2_nc_0/eeg_bias_gen_0/m1_8741_n27552# 6.789050e-17
C5102 eeg_sdm1ct_0/eeg_fd_ota_full2_nc_0/eeg_bias_gen_0/m1_7941_n45240# VSS 4.190540e-16
C5103 eeg_sdm1ct_0/eeg_fd_ota_full2_nc_0/eeg_bias_gen_0/m1_7941_n45240# eeg_sdm1ct_0/eeg_fd_ota_full2_nc_0/eeg_bias_gen_0/m1_8741_n45240# 6.789050e-17
C5104 eeg_sdm1ct_0/eeg_fd_ota_full2_nc_0/eeg_bias_gen_0/m1_7941_n9864# VSS 4.190540e-16
C5106 eeg_sdm1ct_0/eeg_fd_ota_full2_nc_0/eeg_bias_gen_0/m1_7941_n9864# eeg_sdm1ct_0/eeg_fd_ota_full2_nc_0/eeg_bias_gen_0/m1_8741_n9864# 6.789050e-17
C5107 eeg_sdm1ct_0/eeg_fd_ota_full2_nc_0/eeg_bias_gen_0/m1_8059_n18708# VSS 2.918310e-16
C5109 eeg_sdm1ct_0/eeg_fd_ota_full2_nc_0/eeg_bias_gen_0/m1_8059_n18708# eeg_sdm1ct_0/eeg_fd_ota_full2_nc_0/eeg_bias_gen_0/m1_8859_n18708# 6.789040e-17
C5110 eeg_sdm1ct_0/eeg_fd_ota_full2_nc_0/eeg_bias_gen_0/m1_8059_n36396# VSS 2.918310e-16
C5112 eeg_sdm1ct_0/eeg_fd_ota_full2_nc_0/eeg_bias_gen_0/m1_8059_n36396# eeg_sdm1ct_0/eeg_fd_ota_full2_nc_0/eeg_bias_gen_0/m1_8859_n36396# 6.789050e-17
C5113 eeg_sdm1ct_0/eeg_fd_ota_full2_nc_0/eeg_bias_gen_0/m1_8341_n20245# VSS 4.190540e-16
C5115 eeg_sdm1ct_0/eeg_fd_ota_full2_nc_0/eeg_bias_gen_0/m1_8341_n20245# eeg_sdm1ct_0/eeg_fd_ota_full2_nc_0/eeg_bias_gen_0/m1_9141_n20245# 6.789040e-17
C5116 eeg_sdm1ct_0/eeg_fd_ota_full2_nc_0/eeg_bias_gen_0/m1_8341_n2557# VSS 4.190540e-16
C5117 eeg_sdm1ct_0/eeg_fd_ota_full2_nc_0/eeg_bias_gen_0/m1_8341_n2557# eeg_sdm1ct_0/eeg_fd_ota_full2_nc_0/eeg_bias_gen_0/m1_9141_n2557# 6.789040e-17
C5118 eeg_sdm1ct_0/eeg_fd_ota_full2_nc_0/eeg_bias_gen_0/m1_8341_n37933# VSS 4.190540e-16
C5120 eeg_sdm1ct_0/eeg_fd_ota_full2_nc_0/eeg_bias_gen_0/m1_8341_n37933# eeg_sdm1ct_0/eeg_fd_ota_full2_nc_0/eeg_bias_gen_0/m1_9141_n37933# 6.789052e-17
C5121 eeg_sdm1ct_0/eeg_fd_ota_full2_nc_0/eeg_bias_gen_0/m1_8459_n11401# VSS 2.918310e-16
C5123 eeg_sdm1ct_0/eeg_fd_ota_full2_nc_0/eeg_bias_gen_0/m1_8459_n11401# eeg_sdm1ct_0/eeg_fd_ota_full2_nc_0/eeg_bias_gen_0/m1_9259_n11401# 6.789036e-17
C5124 eeg_sdm1ct_0/eeg_fd_ota_full2_nc_0/eeg_bias_gen_0/m1_8459_n29089# VSS 2.918310e-16
C5126 eeg_sdm1ct_0/eeg_fd_ota_full2_nc_0/eeg_bias_gen_0/m1_8459_n29089# eeg_sdm1ct_0/eeg_fd_ota_full2_nc_0/eeg_bias_gen_0/m1_9259_n29089# 6.789050e-17
C5127 eeg_sdm1ct_0/eeg_fd_ota_full2_nc_0/eeg_bias_gen_0/m1_8741_n27552# VSS 4.190540e-16
C5129 eeg_sdm1ct_0/eeg_fd_ota_full2_nc_0/eeg_bias_gen_0/m1_8741_n27552# eeg_sdm1ct_0/eeg_fd_ota_full2_nc_0/eeg_bias_gen_0/m1_9541_n27552# 6.789050e-17
C5130 eeg_sdm1ct_0/eeg_fd_ota_full2_nc_0/eeg_bias_gen_0/m1_8741_n45240# VSS 4.190540e-16
C5131 eeg_sdm1ct_0/eeg_fd_ota_full2_nc_0/eeg_bias_gen_0/m1_8741_n45240# eeg_sdm1ct_0/eeg_fd_ota_full2_nc_0/eeg_bias_gen_0/m1_9541_n45240# 6.789050e-17
C5132 eeg_sdm1ct_0/eeg_fd_ota_full2_nc_0/eeg_bias_gen_0/m1_8741_n9864# VSS 4.190540e-16
C5134 eeg_sdm1ct_0/eeg_fd_ota_full2_nc_0/eeg_bias_gen_0/m1_8741_n9864# eeg_sdm1ct_0/eeg_fd_ota_full2_nc_0/eeg_bias_gen_0/m1_9541_n9864# 6.789050e-17
C5135 eeg_sdm1ct_0/eeg_fd_ota_full2_nc_0/eeg_bias_gen_0/m1_8859_n18708# VSS 2.918310e-16
C5137 eeg_sdm1ct_0/eeg_fd_ota_full2_nc_0/eeg_bias_gen_0/m1_8859_n18708# eeg_sdm1ct_0/eeg_fd_ota_full2_nc_0/eeg_bias_gen_0/m1_9659_n18708# 6.789040e-17
C5138 eeg_sdm1ct_0/eeg_fd_ota_full2_nc_0/eeg_bias_gen_0/m1_8859_n36396# VSS 2.918310e-16
C5140 eeg_sdm1ct_0/eeg_fd_ota_full2_nc_0/eeg_bias_gen_0/m1_8859_n36396# eeg_sdm1ct_0/eeg_fd_ota_full2_nc_0/eeg_bias_gen_0/m1_9659_n36396# 6.789050e-17
C5141 eeg_sdm1ct_0/eeg_fd_ota_full2_nc_0/eeg_bias_gen_0/m1_9141_n20245# VSS 4.190540e-16
C5143 eeg_sdm1ct_0/eeg_fd_ota_full2_nc_0/eeg_bias_gen_0/m1_9141_n20245# eeg_sdm1ct_0/eeg_fd_ota_full2_nc_0/eeg_bias_gen_0/m1_9941_n20245# 6.789050e-17
C5144 eeg_sdm1ct_0/eeg_fd_ota_full2_nc_0/eeg_bias_gen_0/m1_9141_n2557# VSS 4.190540e-16
C5145 eeg_sdm1ct_0/eeg_fd_ota_full2_nc_0/eeg_bias_gen_0/m1_9141_n2557# eeg_sdm1ct_0/eeg_fd_ota_full2_nc_0/eeg_bias_gen_0/m1_9941_n2557# 6.789050e-17
C5146 eeg_sdm1ct_0/eeg_fd_ota_full2_nc_0/eeg_bias_gen_0/m1_9141_n37933# VSS 4.190540e-16
C5148 eeg_sdm1ct_0/eeg_fd_ota_full2_nc_0/eeg_bias_gen_0/m1_9141_n37933# eeg_sdm1ct_0/eeg_fd_ota_full2_nc_0/eeg_bias_gen_0/m1_9941_n37933# 6.789050e-17
C5149 eeg_sdm1ct_0/eeg_fd_ota_full2_nc_0/eeg_bias_gen_0/m1_9259_n11401# VSS 2.918310e-16
C5151 eeg_sdm1ct_0/eeg_fd_ota_full2_nc_0/eeg_bias_gen_0/m1_9259_n29089# VSS 2.918310e-16
C5153 eeg_sdm1ct_0/eeg_fd_ota_full2_nc_0/eeg_bias_gen_0/m1_9541_n27552# VSS 4.190540e-16
C5154 eeg_sdm1ct_0/eeg_fd_ota_full2_nc_0/eeg_bias_gen_0/m1_9541_n45240# VSS 4.190540e-16
C5155 eeg_sdm1ct_0/eeg_fd_ota_full2_nc_0/eeg_bias_gen_0/m1_9541_n9864# VSS 4.190540e-16
C5156 eeg_sdm1ct_0/eeg_fd_ota_full2_nc_0/eeg_bias_gen_0/m1_9659_n18708# VSS 2.918310e-16
C5158 eeg_sdm1ct_0/eeg_fd_ota_full2_nc_0/eeg_bias_gen_0/m1_9659_n36396# VSS 2.918310e-16
C5160 eeg_sdm1ct_0/eeg_fd_ota_full2_nc_0/eeg_bias_gen_0/m1_9941_n20245# VSS 4.190540e-16
C5161 eeg_sdm1ct_0/eeg_fd_ota_full2_nc_0/eeg_bias_gen_0/m1_9941_n2557# VSS 4.190540e-16
C5162 eeg_sdm1ct_0/eeg_fd_ota_full2_nc_0/eeg_bias_gen_0/m1_9941_n37933# VSS 4.190540e-16
C5163 VDD18 VSS 1.198063e-14
C5164 VDD18 eeg_sdm1ct_0/eeg_fd_ota_full2_nc_0/eeg_bias_gen_0/VBN 2.562736e-16
C5165 VDD18 eeg_sdm1ct_0/eeg_fd_ota_full2_nc_0/eeg_bias_gen_0/VBP 2.977050e-15
C5166 eeg_sdm1ct_0/eeg_fd_ota_full2_nc_0/eeg_bias_gen_0/VBN eeg_sdm1ct_0/eeg_fd_ota_full2_nc_0/eeg_bias_gen_0/VBP 6.762340e-16
C5167 eeg_sdm1ct_0/eeg_fd_ota_full2_nc_0/eeg_bias_gen_0/VBP VSS 6.072420e-16
C5168 eeg_sdm1ct_0/eeg_fd_ota_full2_nc_0/eeg_bias_gen_0/m1_6341_n27552# VSS 6.746650e-16
C5169 eeg_sdm1ct_0/eeg_fd_ota_full2_nc_0/eeg_bias_gen_0/m1_6741_n20245# VSS 6.746650e-16
C5170 VDD18 VSS 8.414800e-16
C5171 VDD18 eeg_sdm1ct_0/eeg_fd_ota_full2_nc_0/eeg_bias_gen_0/VBN 8.460309e-16
C5172 VDD18 eeg_sdm1ct_0/eeg_fd_ota_full2_nc_0/eeg_bias_gen_0/eeg_pseudo_res_0/m1_68_66# 1.314672e-15
C5173 eeg_sdm1ct_0/eeg_fd_ota_full2_nc_0/eeg_bias_gen_0/VBN VSS 1.699680e-15
C5174 eeg_sdm1ct_0/eeg_fd_ota_full2_nc_0/eeg_bias_gen_0/VBN eeg_sdm1ct_0/eeg_fd_ota_full2_nc_0/eeg_bias_gen_0/eeg_pseudo_res_0/m1_68_66# 5.017998e-16
C5175 eeg_sdm1ct_0/eeg_fd_ota_full2_nc_0/eeg_bias_gen_0/eeg_pseudo_res_0/m1_68_66# VSS 3.582030e-15
C5176 eeg_sdm1ct_0/eeg_fd_ota_full2_nc_0/eeg_bias_gen_0/VBN VSS 3.678650e-15
C5177 eeg_sdm1ct_0/eeg_fd_ota_full2_nc_0/eeg_bias_gen_0/VBN eeg_sdm1ct_0/eeg_fd_ota_full2_nc_0/eeg_bias_gen_0/eeg_pseudo_res_0/m1_68_66# 1.322042e-15
C5178 eeg_sdm1ct_0/eeg_fd_ota_full2_nc_0/eeg_bias_gen_0/eeg_pseudo_res_0/m1_68_66# VSS 4.103261e-16
C5179 VDD18 VSS 3.678650e-15
C5180 VDD18 eeg_sdm1ct_0/eeg_fd_ota_full2_nc_0/eeg_bias_gen_0/eeg_pseudo_res_0/m1_68_66# 1.322042e-15
C5181 eeg_sdm1ct_0/eeg_fd_ota_full2_nc_0/eeg_bias_gen_0/eeg_pseudo_res_0/m1_68_66# VSS 4.103261e-16
C5182 eeg_sdm1ct_0/eeg_fd_ota_full2_nc_0/eeg_bias_gen_0/m1_10459_n36396# VSS 6.746650e-16
C5183 eeg_sdm1ct_0/eeg_fd_ota_full2_nc_0/eeg_bias_gen_0/m1_10859_n29089# VSS 6.746650e-16
C5184 VSS eeg_sdm1ct_0/eeg_fd_ota_full2_nc_0/eeg_bias_gen_0/VBN 8.327656e-16
C5185 eeg_sdm1ct_0/eeg_fd_ota_full2_nc_0/eeg_bias_gen_0/VBN VSS 2.737979e-15
C5186 eeg_sdm1ct_0/eeg_fd_ota_full2_nc_0/eeg_bias_gen_0/m1_5941_n20245# VSS 6.746650e-16
C5187 eeg_sdm1ct_0/eeg_fd_ota_full2_nc_0/eeg_bias_gen_0/m1_6341_n27552# VSS 6.746650e-16
C5188 eeg_sdm1ct_0/eeg_fd_ota_full2_nc_0/eeg_bias_gen_0/m1_10341_n27552# VSS 6.746650e-16
C5189 eeg_sdm1ct_0/eeg_fd_ota_full2_nc_0/eeg_bias_gen_0/m1_10741_n20245# VSS 6.746650e-16
C5190 eeg_sdm1ct_0/eeg_fd_ota_full2_nc_0/eeg_bias_gen_0/m1_2524_466# VSS 6.747650e-16
C5191 eeg_sdm1ct_0/eeg_fd_ota_full2_nc_0/eeg_bias_gen_0/m1_10859_n29089# VSS 6.746650e-16
C5192 eeg_sdm1ct_0/eeg_fd_ota_full2_nc_0/eeg_bias_gen_0/m1_11259_n36396# VSS 6.746650e-16
C5193 eeg_sdm1ct_0/eeg_fd_ota_full2_nc_0/eeg_bias_gen_0/VBNF VSS 6.746650e-16
C5194 eeg_sdm1ct_0/eeg_fd_ota_full2_nc_0/eeg_bias_gen_0/m1_11141_n9864# VSS 6.746650e-16
C5195 eeg_sdm1ct_0/eeg_fd_ota_full2_nc_0/eeg_bias_gen_0/m1_11259_n36396# VSS 6.746650e-16
C5196 eeg_sdm1ct_0/eeg_fd_ota_full2_nc_0/eeg_bias_gen_0/m1_11541_n37933# VSS 6.746650e-16
C5197 eeg_sdm1ct_0/eeg_fd_ota_full2_nc_0/eeg_bias_gen_0/m1_5541_n27552# VSS 6.746650e-16
C5198 eeg_sdm1ct_0/eeg_fd_ota_full2_nc_0/eeg_bias_gen_0/m1_5941_n20245# VSS 6.746650e-16
C5199 eeg_sdm1ct_0/eeg_fd_ota_full2_nc_0/eeg_bias_gen_0/m1_10341_n27552# VSS 6.746650e-16
C5200 eeg_sdm1ct_0/eeg_fd_ota_full2_nc_0/eeg_bias_gen_0/m1_9941_n20245# VSS 6.746650e-16
C5201 eeg_sdm1ct_0/eeg_fd_ota_full2_nc_0/eeg_bias_gen_0/m1_10741_n2557# VSS 6.746650e-16
C5202 eeg_sdm1ct_0/eeg_fd_ota_full2_nc_0/eeg_bias_gen_0/m1_11141_n9864# VSS 6.746650e-16
C5203 eeg_sdm1ct_0/eeg_fd_ota_full2_nc_0/eeg_bias_gen_0/m1_5141_n20245# VSS 6.746650e-16
C5204 eeg_sdm1ct_0/eeg_fd_ota_full2_nc_0/eeg_bias_gen_0/m1_5541_n27552# VSS 6.746650e-16
C5205 eeg_sdm1ct_0/eeg_fd_ota_full2_nc_0/eeg_bias_gen_0/m1_9541_n27552# VSS 6.746650e-16
C5206 eeg_sdm1ct_0/eeg_fd_ota_full2_nc_0/eeg_bias_gen_0/m1_9941_n20245# VSS 6.746650e-16
C5207 eeg_sdm1ct_0/eeg_fd_ota_full2_nc_0/eeg_bias_gen_0/m1_4859_n18708# VSS 6.746650e-16
C5208 eeg_sdm1ct_0/eeg_fd_ota_full2_nc_0/eeg_bias_gen_0/m1_5259_n11401# VSS 6.746650e-16
C5209 eeg_sdm1ct_0/eeg_fd_ota_full2_nc_0/eeg_bias_gen_0/m1_11141_n45240# VSS 6.746650e-16
C5210 eeg_sdm1ct_0/eeg_fd_ota_full2_nc_0/eeg_bias_gen_0/m1_11541_n37933# VSS 6.746650e-16
C5211 eeg_sdm1ct_0/eeg_fd_ota_full2_nc_0/eeg_bias_gen_0/m1_10341_n9864# VSS 6.746650e-16
C5212 eeg_sdm1ct_0/eeg_fd_ota_full2_nc_0/eeg_bias_gen_0/m1_10741_n2557# VSS 6.746650e-16
C5213 eeg_sdm1ct_0/eeg_fd_ota_full2_nc_0/eeg_bias_gen_0/m1_4741_n27552# VSS 6.746650e-16
C5214 eeg_sdm1ct_0/eeg_fd_ota_full2_nc_0/eeg_bias_gen_0/m1_5141_n20245# VSS 6.746650e-16
C5215 eeg_sdm1ct_0/eeg_fd_ota_full2_nc_0/eeg_bias_gen_0/m1_9141_n20245# VSS 6.746650e-16
C5216 eeg_sdm1ct_0/eeg_fd_ota_full2_nc_0/eeg_bias_gen_0/m1_9541_n27552# VSS 6.746650e-16
C5217 eeg_sdm1ct_0/eeg_fd_ota_full2_nc_0/eeg_bias_gen_0/m1_5259_n11401# VSS 6.746650e-16
C5218 eeg_sdm1ct_0/eeg_fd_ota_full2_nc_0/eeg_bias_gen_0/m1_5659_n18708# VSS 6.746650e-16
C5219 eeg_sdm1ct_0/eeg_fd_ota_full2_nc_0/eeg_bias_gen_0/m1_5941_n2557# VSS 6.746650e-16
C5220 eeg_sdm1ct_0/eeg_fd_ota_full2_nc_0/eeg_bias_gen_0/m1_6341_n9864# VSS 6.746650e-16
C5221 eeg_sdm1ct_0/eeg_fd_ota_full2_nc_0/eeg_bias_gen_0/m1_10741_n37933# VSS 6.746650e-16
C5222 eeg_sdm1ct_0/eeg_fd_ota_full2_nc_0/eeg_bias_gen_0/m1_11141_n45240# VSS 6.746650e-16
C5223 eeg_sdm1ct_0/eeg_fd_ota_full2_nc_0/eeg_bias_gen_0/m1_4341_n20245# VSS 6.746650e-16
C5224 eeg_sdm1ct_0/eeg_fd_ota_full2_nc_0/eeg_bias_gen_0/m1_4741_n27552# VSS 6.746650e-16
C5225 eeg_sdm1ct_0/eeg_fd_ota_full2_nc_0/eeg_bias_gen_0/m1_8741_n27552# VSS 6.746650e-16
C5226 eeg_sdm1ct_0/eeg_fd_ota_full2_nc_0/eeg_bias_gen_0/m1_9141_n20245# VSS 6.746650e-16
C5227 eeg_sdm1ct_0/eeg_fd_ota_full2_nc_0/eeg_bias_gen_0/m1_5659_n18708# VSS 6.746650e-16
C5228 eeg_sdm1ct_0/eeg_fd_ota_full2_nc_0/eeg_bias_gen_0/m1_6059_n11401# VSS 6.746650e-16
C5229 eeg_sdm1ct_0/eeg_fd_ota_full2_nc_0/eeg_bias_gen_0/m1_10059_n11401# VSS 6.746650e-16
C5230 eeg_sdm1ct_0/eeg_fd_ota_full2_nc_0/eeg_bias_gen_0/m1_9659_n18708# VSS 6.746650e-16
C5231 eeg_sdm1ct_0/eeg_fd_ota_full2_nc_0/eeg_bias_gen_0/m1_10459_n18708# VSS 6.746650e-16
C5232 eeg_sdm1ct_0/eeg_fd_ota_full2_nc_0/eeg_bias_gen_0/m1_10859_n11401# VSS 6.746650e-16
C5233 eeg_sdm1ct_0/eeg_fd_ota_full2_nc_0/eeg_bias_gen_0/m1_5541_n9864# VSS 6.746650e-16
C5234 eeg_sdm1ct_0/eeg_fd_ota_full2_nc_0/eeg_bias_gen_0/m1_5941_n2557# VSS 6.746650e-16
C5235 eeg_sdm1ct_0/eeg_fd_ota_full2_nc_0/eeg_bias_gen_0/m1_10341_n45240# VSS 6.746650e-16
C5236 eeg_sdm1ct_0/eeg_fd_ota_full2_nc_0/eeg_bias_gen_0/m1_10741_n37933# VSS 6.746650e-16
C5237 VDD18 VSS 1.198063e-14
C5238 VDD18 eeg_sdm1ct_0/eeg_fd_ota_full2_nc_0/eeg_bias_gen_0/VBP 3.233324e-15
C5239 eeg_sdm1ct_0/eeg_fd_ota_full2_nc_0/eeg_bias_gen_0/VBP VSS 6.072420e-16
C5240 eeg_sdm1ct_0/eeg_fd_ota_full2_nc_0/eeg_bias_gen_0/m1_5941_n37933# VSS 6.746650e-16
C5241 eeg_sdm1ct_0/eeg_fd_ota_full2_nc_0/eeg_bias_gen_0/m1_6341_n45240# VSS 6.746650e-16
C5242 eeg_sdm1ct_0/eeg_fd_ota_full2_nc_0/eeg_bias_gen_0/m1_3941_n27552# VSS 6.746650e-16
C5243 eeg_sdm1ct_0/eeg_fd_ota_full2_nc_0/eeg_bias_gen_0/m1_4341_n20245# VSS 6.746650e-16
C5244 eeg_sdm1ct_0/eeg_fd_ota_full2_nc_0/eeg_bias_gen_0/m1_8341_n20245# VSS 6.746650e-16
C5245 eeg_sdm1ct_0/eeg_fd_ota_full2_nc_0/eeg_bias_gen_0/m1_8741_n27552# VSS 6.746650e-16
C5246 eeg_sdm1ct_0/eeg_fd_ota_full2_nc_0/eeg_bias_gen_0/m1_6059_n11401# VSS 6.746650e-16
C5247 eeg_sdm1ct_0/eeg_fd_ota_full2_nc_0/eeg_bias_gen_0/m1_6459_n18708# VSS 6.746650e-16
C5248 eeg_sdm1ct_0/eeg_fd_ota_full2_nc_0/eeg_bias_gen_0/m1_10859_n11401# VSS 6.746650e-16
C5249 eeg_sdm1ct_0/eeg_fd_ota_full2_nc_0/eeg_bias_gen_0/m1_11259_n18708# VSS 6.746650e-16
C5250 eeg_sdm1ct_0/eeg_fd_ota_full2_nc_0/eeg_bias_gen_0/m1_5141_n2557# VSS 6.746650e-16
C5251 eeg_sdm1ct_0/eeg_fd_ota_full2_nc_0/eeg_bias_gen_0/m1_5541_n9864# VSS 6.746650e-16
C5252 eeg_sdm1ct_0/eeg_fd_ota_full2_nc_0/eeg_bias_gen_0/m1_9541_n9864# VSS 6.746650e-16
C5253 eeg_sdm1ct_0/eeg_fd_ota_full2_nc_0/eeg_bias_gen_0/m1_9941_n2557# VSS 6.746650e-16
C5254 eeg_sdm1ct_0/eeg_fd_ota_full2_nc_0/eeg_bias_gen_0/m1_4859_n36396# VSS 6.746650e-16
C5255 eeg_sdm1ct_0/eeg_fd_ota_full2_nc_0/eeg_bias_gen_0/m1_5259_n29089# VSS 6.746650e-16
C5256 eeg_sdm1ct_0/eeg_fd_ota_full2_nc_0/eeg_bias_gen_0/VBN VSS 6.746650e-16
C5257 eeg_sdm1ct_0/eeg_fd_ota_full2_nc_0/eeg_bias_gen_0/m1_3941_n45240# VSS 6.746650e-16
C5258 eeg_sdm1ct_0/eeg_fd_ota_full2_nc_0/eeg_bias_gen_0/m1_5541_n45240# VSS 6.746650e-16
C5259 eeg_sdm1ct_0/eeg_fd_ota_full2_nc_0/eeg_bias_gen_0/m1_5941_n37933# VSS 6.746650e-16
C5260 eeg_sdm1ct_0/eeg_fd_ota_full2_nc_0/eeg_bias_gen_0/m1_3701_n29089# VSS 6.746650e-16
C5261 eeg_sdm1ct_0/eeg_fd_ota_full2_nc_0/eeg_bias_gen_0/m1_3941_n27552# VSS 6.746650e-16
C5262 eeg_sdm1ct_0/eeg_fd_ota_full2_nc_0/eeg_bias_gen_0/m1_7941_n27552# VSS 6.746650e-16
C5263 eeg_sdm1ct_0/eeg_fd_ota_full2_nc_0/eeg_bias_gen_0/m1_8341_n20245# VSS 6.746650e-16
C5264 eeg_sdm1ct_0/eeg_fd_ota_full2_nc_0/eeg_bias_gen_0/m1_6459_n18708# VSS 6.746650e-16
C5265 eeg_sdm1ct_0/eeg_fd_ota_full2_nc_0/eeg_bias_gen_0/m1_6859_n11401# VSS 6.746650e-16
C5266 eeg_sdm1ct_0/eeg_fd_ota_full2_nc_0/eeg_bias_gen_0/m1_11259_n18708# VSS 6.746650e-16
C5267 eeg_sdm1ct_0/eeg_fd_ota_full2_nc_0/eeg_bias_gen_0/m1_11541_n20245# VSS 6.746650e-16
C5268 eeg_sdm1ct_0/eeg_fd_ota_full2_nc_0/eeg_bias_gen_0/m1_4741_n9864# VSS 6.746650e-16
C5269 eeg_sdm1ct_0/eeg_fd_ota_full2_nc_0/eeg_bias_gen_0/m1_5141_n2557# VSS 6.746650e-16
C5270 eeg_sdm1ct_0/eeg_fd_ota_full2_nc_0/eeg_bias_gen_0/m1_9141_n2557# VSS 6.746650e-16
C5271 eeg_sdm1ct_0/eeg_fd_ota_full2_nc_0/eeg_bias_gen_0/m1_9541_n9864# VSS 6.746650e-16
C5272 eeg_sdm1ct_0/eeg_fd_ota_full2_nc_0/eeg_bias_gen_0/m1_5259_n29089# VSS 6.746650e-16
C5273 eeg_sdm1ct_0/eeg_fd_ota_full2_nc_0/eeg_bias_gen_0/m1_5659_n36396# VSS 6.746650e-16
C5274 eeg_sdm1ct_0/eeg_fd_ota_full2_nc_0/eeg_bias_gen_0/m1_10341_n9864# VSS 6.746650e-16
C5275 eeg_sdm1ct_0/eeg_fd_ota_full2_nc_0/eeg_bias_gen_0/m1_9941_n2557# VSS 6.746650e-16
C5276 eeg_sdm1ct_0/eeg_fd_ota_full2_nc_0/eeg_bias_gen_0/m1_5141_n37933# VSS 6.746650e-16
C5277 eeg_sdm1ct_0/eeg_fd_ota_full2_nc_0/eeg_bias_gen_0/m1_5541_n45240# VSS 6.746650e-16
C5278 eeg_sdm1ct_0/eeg_fd_ota_full2_nc_0/eeg_bias_gen_0/m1_9541_n45240# VSS 6.746650e-16
C5279 eeg_sdm1ct_0/eeg_fd_ota_full2_nc_0/eeg_bias_gen_0/m1_9941_n37933# VSS 6.746650e-16
C5280 eeg_sdm1ct_0/eeg_fd_ota_full2_nc_0/eeg_bias_gen_0/m1_6459_n36396# VSS 6.746650e-16
C5281 eeg_sdm1ct_0/eeg_fd_ota_full2_nc_0/eeg_bias_gen_0/m1_6859_n29089# VSS 6.746650e-16
C5282 eeg_sdm1ct_0/eeg_fd_ota_full2_nc_0/eeg_bias_gen_0/m1_10059_n29089# VSS 6.746650e-16
C5283 eeg_sdm1ct_0/eeg_fd_ota_full2_nc_0/eeg_bias_gen_0/m1_10459_n36396# VSS 6.746650e-16
C5284 eeg_sdm1ct_0/eeg_fd_ota_full2_nc_0/eeg_bias_gen_0/m1_7541_n20245# VSS 6.746650e-16
C5285 eeg_sdm1ct_0/eeg_fd_ota_full2_nc_0/eeg_bias_gen_0/m1_7941_n27552# VSS 6.746650e-16
C5286 eeg_sdm1ct_0/eeg_fd_ota_full2_nc_0/eeg_bias_gen_0/m1_6859_n11401# VSS 6.746650e-16
C5287 eeg_sdm1ct_0/eeg_fd_ota_full2_nc_0/eeg_bias_gen_0/m1_7259_n18708# VSS 6.746650e-16
C5288 eeg_sdm1ct_0/eeg_fd_ota_full2_nc_0/eeg_bias_gen_0/m1_4341_n2557# VSS 6.746650e-16
C5289 eeg_sdm1ct_0/eeg_fd_ota_full2_nc_0/eeg_bias_gen_0/m1_4741_n9864# VSS 6.746650e-16
C5290 eeg_sdm1ct_0/eeg_fd_ota_full2_nc_0/eeg_bias_gen_0/m1_8741_n9864# VSS 6.746650e-16
C5291 eeg_sdm1ct_0/eeg_fd_ota_full2_nc_0/eeg_bias_gen_0/m1_9141_n2557# VSS 6.746650e-16
C5292 eeg_sdm1ct_0/eeg_fd_ota_full2_nc_0/eeg_bias_gen_0/m1_5659_n36396# VSS 6.746650e-16
C5293 eeg_sdm1ct_0/eeg_fd_ota_full2_nc_0/eeg_bias_gen_0/m1_6059_n29089# VSS 6.746650e-16
C5294 eeg_sdm1ct_0/eeg_fd_ota_full2_nc_0/eeg_bias_gen_0/m1_4741_n45240# VSS 6.746650e-16
C5295 eeg_sdm1ct_0/eeg_fd_ota_full2_nc_0/eeg_bias_gen_0/m1_5141_n37933# VSS 6.746650e-16
C5296 eeg_sdm1ct_0/eeg_fd_ota_full2_nc_0/eeg_bias_gen_0/m1_9141_n37933# VSS 6.746650e-16
C5297 eeg_sdm1ct_0/eeg_fd_ota_full2_nc_0/eeg_bias_gen_0/m1_9541_n45240# VSS 6.746650e-16
C5298 eeg_sdm1ct_0/eeg_fd_ota_full2_nc_0/eeg_bias_gen_0/m1_10341_n45240# VSS 6.746650e-16
C5299 eeg_sdm1ct_0/eeg_fd_ota_full2_nc_0/eeg_bias_gen_0/m1_9941_n37933# VSS 6.746650e-16
C5300 eeg_sdm1ct_0/eeg_fd_ota_full2_nc_0/eeg_bias_gen_0/m1_6859_n29089# VSS 6.746650e-16
C5301 eeg_sdm1ct_0/eeg_fd_ota_full2_nc_0/eeg_bias_gen_0/m1_7259_n36396# VSS 6.746650e-16
C5302 eeg_sdm1ct_0/eeg_fd_ota_full2_nc_0/eeg_bias_gen_0/m1_7141_n27552# VSS 6.746650e-16
C5303 eeg_sdm1ct_0/eeg_fd_ota_full2_nc_0/eeg_bias_gen_0/m1_7541_n20245# VSS 6.746650e-16
C5304 eeg_sdm1ct_0/eeg_fd_ota_full2_nc_0/eeg_bias_gen_0/m1_7259_n18708# VSS 6.746650e-16
C5305 eeg_sdm1ct_0/eeg_fd_ota_full2_nc_0/eeg_bias_gen_0/m1_7659_n11401# VSS 6.746650e-16
C5306 eeg_sdm1ct_0/eeg_fd_ota_full2_nc_0/eeg_bias_gen_0/m1_10059_n11401# VSS 6.746650e-16
C5307 eeg_sdm1ct_0/eeg_fd_ota_full2_nc_0/eeg_bias_gen_0/m1_10459_n18708# VSS 6.746650e-16
C5308 eeg_sdm1ct_0/eeg_fd_ota_full2_nc_0/eeg_bias_gen_0/m1_3941_n9864# VSS 6.746650e-16
C5309 eeg_sdm1ct_0/eeg_fd_ota_full2_nc_0/eeg_bias_gen_0/m1_4341_n2557# VSS 6.746650e-16
C5310 eeg_sdm1ct_0/eeg_fd_ota_full2_nc_0/eeg_bias_gen_0/m1_8341_n2557# VSS 6.746650e-16
C5311 eeg_sdm1ct_0/eeg_fd_ota_full2_nc_0/eeg_bias_gen_0/m1_8741_n9864# VSS 6.746650e-16
C5312 eeg_sdm1ct_0/eeg_fd_ota_full2_nc_0/eeg_bias_gen_0/m1_6059_n29089# VSS 6.746650e-16
C5313 eeg_sdm1ct_0/eeg_fd_ota_full2_nc_0/eeg_bias_gen_0/m1_6459_n36396# VSS 6.746650e-16
C5314 eeg_sdm1ct_0/eeg_fd_ota_full2_nc_0/eeg_bias_gen_0/m1_4341_n37933# VSS 6.746650e-16
C5315 eeg_sdm1ct_0/eeg_fd_ota_full2_nc_0/eeg_bias_gen_0/m1_4741_n45240# VSS 6.746650e-16
C5316 eeg_sdm1ct_0/eeg_fd_ota_full2_nc_0/eeg_bias_gen_0/m1_8741_n45240# VSS 6.746650e-16
C5317 eeg_sdm1ct_0/eeg_fd_ota_full2_nc_0/eeg_bias_gen_0/m1_9141_n37933# VSS 6.746650e-16
C5318 eeg_sdm1ct_0/eeg_fd_ota_full2_nc_0/eeg_bias_gen_0/m1_7259_n36396# VSS 6.746650e-16
C5319 eeg_sdm1ct_0/eeg_fd_ota_full2_nc_0/eeg_bias_gen_0/m1_7659_n29089# VSS 6.746650e-16
C5320 eeg_sdm1ct_0/eeg_fd_ota_full2_nc_0/eeg_bias_gen_0/m1_6741_n20245# VSS 6.746650e-16
C5321 eeg_sdm1ct_0/eeg_fd_ota_full2_nc_0/eeg_bias_gen_0/m1_7141_n27552# VSS 6.746650e-16
C5322 eeg_sdm1ct_0/eeg_fd_ota_full2_nc_0/eeg_bias_gen_0/m1_11141_n27552# VSS 6.746650e-16
C5323 eeg_sdm1ct_0/eeg_fd_ota_full2_nc_0/eeg_bias_gen_0/m1_11541_n20245# VSS 6.746650e-16
C5324 eeg_sdm1ct_0/eeg_fd_ota_full2_nc_0/eeg_bias_gen_0/m1_7659_n11401# VSS 6.746650e-16
C5325 eeg_sdm1ct_0/eeg_fd_ota_full2_nc_0/eeg_bias_gen_0/m1_8059_n18708# VSS 6.746650e-16
C5326 eeg_sdm1ct_0/eeg_fd_ota_full2_nc_0/eeg_bias_gen_0/m1_3701_n11401# VSS 6.746650e-16
C5327 eeg_sdm1ct_0/eeg_fd_ota_full2_nc_0/eeg_bias_gen_0/m1_3941_n9864# VSS 6.746650e-16
C5328 eeg_sdm1ct_0/eeg_fd_ota_full2_nc_0/eeg_bias_gen_0/m1_7941_n9864# VSS 6.746650e-16
C5329 eeg_sdm1ct_0/eeg_fd_ota_full2_nc_0/eeg_bias_gen_0/m1_8341_n2557# VSS 6.746650e-16
C5330 eeg_sdm1ct_0/eeg_fd_ota_full2_nc_0/eeg_bias_gen_0/m1_8341_n37933# VSS 6.746650e-16
C5331 eeg_sdm1ct_0/eeg_fd_ota_full2_nc_0/eeg_bias_gen_0/m1_8741_n45240# VSS 6.746650e-16
C5332 eeg_sdm1ct_0/eeg_fd_ota_full2_nc_0/eeg_bias_gen_0/m1_3701_n29089# VSS 6.746650e-16
C5333 eeg_sdm1ct_0/eeg_fd_ota_full2_nc_0/eeg_bias_gen_0/m1_4059_n36396# VSS 6.746650e-16
C5334 eeg_sdm1ct_0/eeg_fd_ota_full2_nc_0/eeg_bias_gen_0/m1_7659_n29089# VSS 6.746650e-16
C5335 eeg_sdm1ct_0/eeg_fd_ota_full2_nc_0/eeg_bias_gen_0/m1_8059_n36396# VSS 6.746650e-16
C5336 eeg_sdm1ct_0/eeg_fd_ota_full2_nc_0/eeg_bias_gen_0/m1_10741_n20245# VSS 6.746650e-16
C5337 eeg_sdm1ct_0/eeg_fd_ota_full2_nc_0/eeg_bias_gen_0/m1_11141_n27552# VSS 6.746650e-16
C5338 eeg_sdm1ct_0/eeg_fd_ota_full2_nc_0/eeg_bias_gen_0/m1_3701_n11401# VSS 6.746650e-16
C5339 eeg_sdm1ct_0/eeg_fd_ota_full2_nc_0/eeg_bias_gen_0/m1_4059_n18708# VSS 6.746650e-16
C5340 eeg_sdm1ct_0/eeg_fd_ota_full2_nc_0/eeg_bias_gen_0/m1_8059_n18708# VSS 6.746650e-16
C5341 eeg_sdm1ct_0/eeg_fd_ota_full2_nc_0/eeg_bias_gen_0/m1_8459_n11401# VSS 6.746650e-16
C5342 eeg_sdm1ct_0/eeg_fd_ota_full2_nc_0/eeg_bias_gen_0/m1_7541_n2557# VSS 6.746650e-16
C5343 eeg_sdm1ct_0/eeg_fd_ota_full2_nc_0/eeg_bias_gen_0/m1_7941_n9864# VSS 6.746650e-16
C5344 eeg_sdm1ct_0/eeg_fd_ota_full2_nc_0/eeg_bias_gen_0/m1_7941_n45240# VSS 6.746650e-16
C5345 eeg_sdm1ct_0/eeg_fd_ota_full2_nc_0/eeg_bias_gen_0/m1_8341_n37933# VSS 6.746650e-16
C5346 eeg_sdm1ct_0/eeg_fd_ota_full2_nc_0/eeg_bias_gen_0/m1_4059_n36396# VSS 6.746650e-16
C5347 eeg_sdm1ct_0/eeg_fd_ota_full2_nc_0/eeg_bias_gen_0/m1_4459_n29089# VSS 6.746650e-16
C5348 eeg_sdm1ct_0/eeg_fd_ota_full2_nc_0/eeg_bias_gen_0/m1_8059_n36396# VSS 6.746650e-16
C5349 eeg_sdm1ct_0/eeg_fd_ota_full2_nc_0/eeg_bias_gen_0/m1_8459_n29089# VSS 6.746650e-16
C5350 eeg_sdm1ct_0/eeg_fd_ota_full2_nc_0/eeg_bias_gen_0/m1_4059_n18708# VSS 6.746650e-16
C5351 eeg_sdm1ct_0/eeg_fd_ota_full2_nc_0/eeg_bias_gen_0/m1_4459_n11401# VSS 6.746650e-16
C5352 eeg_sdm1ct_0/eeg_fd_ota_full2_nc_0/eeg_bias_gen_0/m1_8459_n11401# VSS 6.746650e-16
C5353 eeg_sdm1ct_0/eeg_fd_ota_full2_nc_0/eeg_bias_gen_0/m1_8859_n18708# VSS 6.746650e-16
C5354 eeg_sdm1ct_0/eeg_fd_ota_full2_nc_0/eeg_bias_gen_0/m1_7141_n9864# VSS 6.746650e-16
C5355 eeg_sdm1ct_0/eeg_fd_ota_full2_nc_0/eeg_bias_gen_0/m1_7541_n2557# VSS 6.746650e-16
C5356 eeg_sdm1ct_0/eeg_fd_ota_full2_nc_0/eeg_bias_gen_0/m1_7541_n37933# VSS 6.746650e-16
C5357 eeg_sdm1ct_0/eeg_fd_ota_full2_nc_0/eeg_bias_gen_0/m1_7941_n45240# VSS 6.746650e-16
C5358 eeg_sdm1ct_0/eeg_fd_ota_full2_nc_0/eeg_bias_gen_0/m1_4459_n29089# VSS 6.746650e-16
C5359 eeg_sdm1ct_0/eeg_fd_ota_full2_nc_0/eeg_bias_gen_0/m1_4859_n36396# VSS 6.746650e-16
C5360 eeg_sdm1ct_0/eeg_fd_ota_full2_nc_0/eeg_bias_gen_0/m1_8459_n29089# VSS 6.746650e-16
C5361 eeg_sdm1ct_0/eeg_fd_ota_full2_nc_0/eeg_bias_gen_0/m1_8859_n36396# VSS 6.746650e-16
C5362 eeg_sdm1ct_0/eeg_fd_ota_full2_nc_0/eeg_bias_gen_0/m1_4459_n11401# VSS 6.746650e-16
C5363 eeg_sdm1ct_0/eeg_fd_ota_full2_nc_0/eeg_bias_gen_0/m1_4859_n18708# VSS 6.746650e-16
C5364 eeg_sdm1ct_0/eeg_fd_ota_full2_nc_0/eeg_bias_gen_0/m1_6741_n2557# VSS 6.746650e-16
C5365 eeg_sdm1ct_0/eeg_fd_ota_full2_nc_0/eeg_bias_gen_0/m1_7141_n9864# VSS 6.746650e-16
C5366 eeg_sdm1ct_0/eeg_fd_ota_full2_nc_0/eeg_bias_gen_0/m1_7141_n45240# VSS 6.746650e-16
C5367 eeg_sdm1ct_0/eeg_fd_ota_full2_nc_0/eeg_bias_gen_0/m1_7541_n37933# VSS 6.746650e-16
C5368 eeg_sdm1ct_0/eeg_fd_ota_full2_nc_0/eeg_bias_gen_0/m1_8859_n36396# VSS 6.746650e-16
C5369 eeg_sdm1ct_0/eeg_fd_ota_full2_nc_0/eeg_bias_gen_0/m1_9259_n29089# VSS 6.746650e-16
C5370 eeg_sdm1ct_0/eeg_fd_ota_full2_nc_0/eeg_bias_gen_0/m1_8859_n18708# VSS 6.746650e-16
C5371 eeg_sdm1ct_0/eeg_fd_ota_full2_nc_0/eeg_bias_gen_0/m1_9259_n11401# VSS 6.746650e-16
C5372 eeg_sdm1ct_0/eeg_fd_ota_full2_nc_0/eeg_bias_gen_0/m1_6341_n9864# VSS 6.746650e-16
C5373 eeg_sdm1ct_0/eeg_fd_ota_full2_nc_0/eeg_bias_gen_0/m1_6741_n2557# VSS 6.746650e-16
C5374 eeg_sdm1ct_0/eeg_fd_ota_full2_nc_0/eeg_bias_gen_0/m1_6741_n37933# VSS 6.746650e-16
C5375 eeg_sdm1ct_0/eeg_fd_ota_full2_nc_0/eeg_bias_gen_0/m1_7141_n45240# VSS 6.746650e-16
C5376 eeg_sdm1ct_0/eeg_fd_ota_full2_nc_0/eeg_bias_gen_0/m1_9259_n29089# VSS 6.746650e-16
C5377 eeg_sdm1ct_0/eeg_fd_ota_full2_nc_0/eeg_bias_gen_0/m1_9659_n36396# VSS 6.746650e-16
C5378 eeg_sdm1ct_0/eeg_fd_ota_full2_nc_0/eeg_bias_gen_0/m1_9259_n11401# VSS 6.746650e-16
C5379 eeg_sdm1ct_0/eeg_fd_ota_full2_nc_0/eeg_bias_gen_0/m1_9659_n18708# VSS 6.746650e-16
C5380 eeg_sdm1ct_0/eeg_fd_ota_full2_nc_0/eeg_bias_gen_0/m1_6341_n45240# VSS 6.746650e-16
C5381 eeg_sdm1ct_0/eeg_fd_ota_full2_nc_0/eeg_bias_gen_0/m1_6741_n37933# VSS 6.746650e-16
C5382 eeg_sdm1ct_0/eeg_fd_ota_full2_nc_0/eeg_bias_gen_0/m1_10059_n29089# VSS 6.746650e-16
C5383 eeg_sdm1ct_0/eeg_fd_ota_full2_nc_0/eeg_bias_gen_0/m1_9659_n36396# VSS 6.746650e-16
C5384 eeg_sdm1ct_0/eeg_fd_ota_full2_nc_0/eeg_bias_gen_0/m1_3941_n45240# VSS 6.746650e-16
C5385 eeg_sdm1ct_0/eeg_fd_ota_full2_nc_0/eeg_bias_gen_0/m1_4341_n37933# VSS 6.746650e-16
C5386 eeg_sdm1ct_0/eeg_fd_ota_full2_nc_0/eeg_bias_gen_0/VBN VSS 1.059610e-14
C5387 eeg_sdm1ct_0/eeg_fd_ota_full2_nc_0/eeg_bias_gen_0/VBN eeg_sdm1ct_0/eeg_fd_ota_full2_nc_0/eeg_bias_gen_0/VBP 2.704936e-15
C5388 eeg_sdm1ct_0/eeg_fd_ota_full2_nc_0/eeg_bias_gen_0/VBN eeg_sdm1ct_0/eeg_fd_ota_full2_nc_0/eeg_bias_gen_0/m1_2524_466# 2.781792e-15
C5389 eeg_sdm1ct_0/eeg_fd_ota_full2_nc_0/eeg_bias_gen_0/VBP VSS 1.199796e-16
C5390 eeg_sdm1ct_0/eeg_fd_ota_full2_nc_0/eeg_bias_gen_0/VBP eeg_sdm1ct_0/eeg_fd_ota_full2_nc_0/eeg_bias_gen_0/m1_2524_466# 3.225268e-16
C5391 eeg_sdm1ct_0/eeg_fd_ota_full2_nc_0/eeg_bias_gen_0/m1_2524_466# VSS 9.907064e-16
C5393 VCM_REF VSS 6.240538e-16
C5394 VCM_REF eeg_sdm1ct_0/eeg_fd_ota_full2_nc_0/eeg_bias_gen_0/VBNF 2.510694e-16
C5396 VCM_REF eeg_sdm1ct_0/eeg_fd_ota_full2_nc_0/eeg_cmfb_amp_dl2_s2_0/m1_68_166# 2.427824e-16
C5397 VCM_REF eeg_sdm1ct_0/eeg_fd_ota_full2_nc_0/stage2_0/VBP2 4.094696e-17
C5399 VDD18 VSS 2.668463e-15
C5400 VDD18 eeg_sdm1ct_0/eeg_fd_ota_full2_nc_0/eeg_cmfb_amp_dl2_s2_0/m1_370_1493# 2.840876e-16
C5402 VDD18 eeg_sdm1ct_0/eeg_fd_ota_full2_nc_0/stage2_0/VBP2 7.519594e-16
C5404 VSS eeg_sdm1ct_0/eeg_fd_ota_full2_nc_0/eeg_bias_gen_0/VBNF 2.369513e-15
C5405 VSS eeg_sdm1ct_0/eeg_fd_ota_full2_nc_0/eeg_cmfb_amp_dl2_s2_0/m1_370_1493# 5.700428e-17
C5406 VSS eeg_sdm1ct_0/eeg_fd_ota_full2_nc_0/eeg_cmfb_amp_dl2_s2_0/m1_68_166# 5.221927e-16
C5407 VSS eeg_sdm1ct_0/eeg_fd_ota_full2_nc_0/stage2_0/VBP2 3.413030e-17
C5408 VSS eeg_sdm1ct_0/eeg_fd_ota_full2_nc_0/stage2_0/VCM2 2.749285e-16
C5409 eeg_sdm1ct_0/eeg_fd_ota_full2_nc_0/eeg_bias_gen_0/VBNF VSS 1.604850e-15
C5411 eeg_sdm1ct_0/eeg_fd_ota_full2_nc_0/eeg_bias_gen_0/VBNF eeg_sdm1ct_0/eeg_fd_ota_full2_nc_0/eeg_cmfb_amp_dl2_s2_0/m1_68_166# 3.152511e-16
C5413 eeg_sdm1ct_0/eeg_fd_ota_full2_nc_0/eeg_bias_gen_0/VBNF eeg_sdm1ct_0/eeg_fd_ota_full2_nc_0/stage2_0/VCM2 3.744583e-17
C5414 eeg_sdm1ct_0/eeg_fd_ota_full2_nc_0/eeg_cmfb_amp_dl2_s2_0/m1_370_1493# VSS 9.817690e-16
C5415 eeg_sdm1ct_0/eeg_fd_ota_full2_nc_0/eeg_cmfb_amp_dl2_s2_0/m1_370_1493# eeg_sdm1ct_0/eeg_fd_ota_full2_nc_0/eeg_cmfb_amp_dl2_s2_0/m1_68_166# 4.867321e-17
C5416 eeg_sdm1ct_0/eeg_fd_ota_full2_nc_0/eeg_cmfb_amp_dl2_s2_0/m1_370_1493# eeg_sdm1ct_0/eeg_fd_ota_full2_nc_0/stage2_0/VBP2 4.354865e-17
C5417 eeg_sdm1ct_0/eeg_fd_ota_full2_nc_0/eeg_cmfb_amp_dl2_s2_0/m1_370_1493# eeg_sdm1ct_0/eeg_fd_ota_full2_nc_0/stage2_0/VCM2 3.677346e-17
C5418 eeg_sdm1ct_0/eeg_fd_ota_full2_nc_0/eeg_cmfb_amp_dl2_s2_0/m1_68_166# VSS 1.236880e-15
C5420 eeg_sdm1ct_0/eeg_fd_ota_full2_nc_0/eeg_cmfb_amp_dl2_s2_0/m1_68_166# eeg_sdm1ct_0/eeg_fd_ota_full2_nc_0/stage2_0/VCM2 3.012335e-16
C5421 eeg_sdm1ct_0/eeg_fd_ota_full2_nc_0/stage2_0/VBP2 VSS 1.787320e-15
C5422 eeg_sdm1ct_0/eeg_fd_ota_full2_nc_0/stage2_0/VCM2 VSS 3.299460e-16
C5423 VDD18 VSS 3.587888e-15
C5424 VDD18 eeg_sdm1ct_0/eeg_fd_ota_full2_nc_0/eeg_cmfb_amp_dl2_s2_0/m1_370_1493# 9.654664e-16
C5425 eeg_sdm1ct_0/eeg_fd_ota_full2_nc_0/eeg_cmfb_amp_dl2_s2_0/m1_370_1493# VSS 2.472537e-16
C5426 eeg_sdm1ct_0/eeg_fd_ota_full2_nc_0/eeg_cmfb_amp_dl2_s2_0/m1_370_1493# VSS 2.522110e-16
C5427 eeg_sdm1ct_0/eeg_fd_ota_full2_nc_0/eeg_cmfb_amp_dl2_s2_0/m1_370_1493# eeg_sdm1ct_0/eeg_fd_ota_full2_nc_0/eeg_cmfb_amp_dl2_s2_0/m1_68_166# 2.845540e-17
C5428 eeg_sdm1ct_0/eeg_fd_ota_full2_nc_0/eeg_cmfb_amp_dl2_s2_0/m1_370_1493# eeg_sdm1ct_0/eeg_fd_ota_full2_nc_0/stage2_0/VCM2 1.233540e-16
C5429 eeg_sdm1ct_0/eeg_fd_ota_full2_nc_0/eeg_cmfb_amp_dl2_s2_0/m1_68_166# VSS 2.522110e-16
C5430 eeg_sdm1ct_0/eeg_fd_ota_full2_nc_0/eeg_cmfb_amp_dl2_s2_0/m1_68_166# eeg_sdm1ct_0/eeg_fd_ota_full2_nc_0/stage2_0/VCM2 1.233540e-16
C5431 eeg_sdm1ct_0/eeg_fd_ota_full2_nc_0/stage2_0/VCM2 VSS 7.517030e-16
C5432 VSS eeg_sdm1ct_0/eeg_fd_ota_full2_nc_0/eeg_bias_gen_0/VBNF 9.287020e-16
C5433 VSS eeg_sdm1ct_0/eeg_fd_ota_full2_nc_0/eeg_cmfb_amp_dl2_s2_0/m1_68_166# 9.828080e-17
C5434 eeg_sdm1ct_0/eeg_fd_ota_full2_nc_0/eeg_bias_gen_0/VBNF VSS 2.698520e-15
C5435 eeg_sdm1ct_0/eeg_fd_ota_full2_nc_0/eeg_bias_gen_0/VBNF eeg_sdm1ct_0/eeg_fd_ota_full2_nc_0/eeg_cmfb_amp_dl2_s2_0/m1_68_166# 8.339500e-16
C5436 eeg_sdm1ct_0/eeg_fd_ota_full2_nc_0/eeg_cmfb_amp_dl2_s2_0/m1_68_166# VSS 2.771420e-17
C5437 VDD18 VSS 2.586521e-15
C5438 VDD18 eeg_sdm1ct_0/eeg_fd_ota_full2_nc_0/stage2_0/VBP2 1.198369e-15
C5439 eeg_sdm1ct_0/eeg_fd_ota_full2_nc_0/stage2_0/VBP2 VSS 3.939952e-16
C5440 VCM_REF VSS 7.517030e-16
C5441 VCM_REF eeg_sdm1ct_0/eeg_fd_ota_full2_nc_0/eeg_cmfb_amp_dl2_s2_0/m1_68_166# 1.233540e-16
C5442 VCM_REF eeg_sdm1ct_0/eeg_fd_ota_full2_nc_0/stage2_0/VBP2 1.233540e-16
C5443 eeg_sdm1ct_0/eeg_fd_ota_full2_nc_0/eeg_cmfb_amp_dl2_s2_0/m1_68_166# VSS 2.522110e-16
C5444 eeg_sdm1ct_0/eeg_fd_ota_full2_nc_0/eeg_cmfb_amp_dl2_s2_0/m1_68_166# eeg_sdm1ct_0/eeg_fd_ota_full2_nc_0/stage2_0/VBP2 2.845540e-17
C5445 eeg_sdm1ct_0/eeg_fd_ota_full2_nc_0/stage2_0/VBP2 VSS 2.522110e-16
C5447 VCM_REF VSS 6.276408e-16
C5448 VCM_REF eeg_sdm1ct_0/eeg_fd_ota_full2_nc_0/eeg_bias_gen_0/VBNF 2.510694e-16
C5449 VCM_REF eeg_sdm1ct_0/eeg_fd_ota_full2_nc_0/eeg_cmfb_amp_dl2_0/VBP 4.083846e-17
C5452 VCM_REF eeg_sdm1ct_0/eeg_fd_ota_full2_nc_0/eeg_cmfb_amp_dl2_0/m1_68_166# 2.427824e-16
C5453 VDD18 VSS 2.546487e-15
C5454 VDD18 eeg_sdm1ct_0/eeg_fd_ota_full2_nc_0/eeg_cmfb_amp_dl2_0/VBP 8.003207e-16
C5456 VDD18 eeg_sdm1ct_0/eeg_fd_ota_full2_nc_0/eeg_cmfb_amp_dl2_0/m1_370_1493# 2.821268e-16
C5458 VSS eeg_sdm1ct_0/eeg_fd_ota_full2_nc_0/eeg_bias_gen_0/VBNF 2.369513e-15
C5459 VSS eeg_sdm1ct_0/eeg_fd_ota_full2_nc_0/eeg_cmfb_amp_dl2_0/VBP 3.379078e-17
C5460 VSS eeg_sdm1ct_0/eeg_fd_ota_full2_nc_0/eeg_cmfb_amp_dl2_0/VCM_SENSE 2.749285e-16
C5461 VSS eeg_sdm1ct_0/eeg_fd_ota_full2_nc_0/eeg_cmfb_amp_dl2_0/m1_370_1493# 5.700428e-17
C5462 VSS eeg_sdm1ct_0/eeg_fd_ota_full2_nc_0/eeg_cmfb_amp_dl2_0/m1_68_166# 5.221927e-16
C5463 eeg_sdm1ct_0/eeg_fd_ota_full2_nc_0/eeg_bias_gen_0/VBNF VSS 1.604850e-15
C5465 eeg_sdm1ct_0/eeg_fd_ota_full2_nc_0/eeg_bias_gen_0/VBNF eeg_sdm1ct_0/eeg_fd_ota_full2_nc_0/eeg_cmfb_amp_dl2_0/VCM_SENSE 3.744583e-17
C5467 eeg_sdm1ct_0/eeg_fd_ota_full2_nc_0/eeg_bias_gen_0/VBNF eeg_sdm1ct_0/eeg_fd_ota_full2_nc_0/eeg_cmfb_amp_dl2_0/m1_68_166# 3.152511e-16
C5468 eeg_sdm1ct_0/eeg_fd_ota_full2_nc_0/eeg_cmfb_amp_dl2_0/VBP VSS 2.231260e-15
C5469 eeg_sdm1ct_0/eeg_fd_ota_full2_nc_0/eeg_cmfb_amp_dl2_0/VBP eeg_sdm1ct_0/eeg_fd_ota_full2_nc_0/eeg_cmfb_amp_dl2_0/m1_370_1493# 4.937477e-17
C5471 eeg_sdm1ct_0/eeg_fd_ota_full2_nc_0/eeg_cmfb_amp_dl2_0/VCM_SENSE VSS 3.299460e-16
C5472 eeg_sdm1ct_0/eeg_fd_ota_full2_nc_0/eeg_cmfb_amp_dl2_0/VCM_SENSE eeg_sdm1ct_0/eeg_fd_ota_full2_nc_0/eeg_cmfb_amp_dl2_0/m1_370_1493# 3.677346e-17
C5473 eeg_sdm1ct_0/eeg_fd_ota_full2_nc_0/eeg_cmfb_amp_dl2_0/VCM_SENSE eeg_sdm1ct_0/eeg_fd_ota_full2_nc_0/eeg_cmfb_amp_dl2_0/m1_68_166# 3.012335e-16
C5474 eeg_sdm1ct_0/eeg_fd_ota_full2_nc_0/eeg_cmfb_amp_dl2_0/m1_370_1493# VSS 9.932130e-16
C5475 eeg_sdm1ct_0/eeg_fd_ota_full2_nc_0/eeg_cmfb_amp_dl2_0/m1_370_1493# eeg_sdm1ct_0/eeg_fd_ota_full2_nc_0/eeg_cmfb_amp_dl2_0/m1_68_166# 4.867321e-17
C5476 eeg_sdm1ct_0/eeg_fd_ota_full2_nc_0/eeg_cmfb_amp_dl2_0/m1_68_166# VSS 1.237070e-15
C5477 VDD18 VSS 6.757137e-15
C5478 VDD18 eeg_sdm1ct_0/eeg_fd_ota_full2_nc_0/eeg_cmfb_amp_dl2_0/VBP 1.873828e-15
C5479 eeg_sdm1ct_0/eeg_fd_ota_full2_nc_0/eeg_cmfb_amp_dl2_0/VBP VSS 4.451080e-16
C5480 VCM_REF VSS 7.517030e-16
C5481 VCM_REF eeg_sdm1ct_0/eeg_fd_ota_full2_nc_0/eeg_cmfb_amp_dl2_0/VBP 1.233540e-16
C5482 VCM_REF eeg_sdm1ct_0/eeg_fd_ota_full2_nc_0/eeg_cmfb_amp_dl2_0/m1_68_166# 1.233540e-16
C5483 eeg_sdm1ct_0/eeg_fd_ota_full2_nc_0/eeg_cmfb_amp_dl2_0/VBP VSS 2.522110e-16
C5484 eeg_sdm1ct_0/eeg_fd_ota_full2_nc_0/eeg_cmfb_amp_dl2_0/VBP eeg_sdm1ct_0/eeg_fd_ota_full2_nc_0/eeg_cmfb_amp_dl2_0/m1_68_166# 2.845540e-17
C5485 eeg_sdm1ct_0/eeg_fd_ota_full2_nc_0/eeg_cmfb_amp_dl2_0/m1_68_166# VSS 2.522110e-16
C5486 VSS eeg_sdm1ct_0/eeg_fd_ota_full2_nc_0/eeg_bias_gen_0/VBNF 9.287020e-16
C5487 VSS eeg_sdm1ct_0/eeg_fd_ota_full2_nc_0/eeg_cmfb_amp_dl2_0/m1_68_166# 9.828080e-17
C5488 eeg_sdm1ct_0/eeg_fd_ota_full2_nc_0/eeg_bias_gen_0/VBNF VSS 2.698520e-15
C5489 eeg_sdm1ct_0/eeg_fd_ota_full2_nc_0/eeg_bias_gen_0/VBNF eeg_sdm1ct_0/eeg_fd_ota_full2_nc_0/eeg_cmfb_amp_dl2_0/m1_68_166# 8.339500e-16
C5490 eeg_sdm1ct_0/eeg_fd_ota_full2_nc_0/eeg_cmfb_amp_dl2_0/m1_68_166# VSS 2.771420e-17
C5491 VDD18 VSS 3.587888e-15
C5492 VDD18 eeg_sdm1ct_0/eeg_fd_ota_full2_nc_0/eeg_cmfb_amp_dl2_0/m1_370_1493# 9.654664e-16
C5493 eeg_sdm1ct_0/eeg_fd_ota_full2_nc_0/eeg_cmfb_amp_dl2_0/m1_370_1493# VSS 2.472537e-16
C5494 eeg_sdm1ct_0/eeg_fd_ota_full2_nc_0/eeg_cmfb_amp_dl2_0/VCM_SENSE VSS 7.517030e-16
C5495 eeg_sdm1ct_0/eeg_fd_ota_full2_nc_0/eeg_cmfb_amp_dl2_0/VCM_SENSE eeg_sdm1ct_0/eeg_fd_ota_full2_nc_0/eeg_cmfb_amp_dl2_0/m1_370_1493# 1.233540e-16
C5496 eeg_sdm1ct_0/eeg_fd_ota_full2_nc_0/eeg_cmfb_amp_dl2_0/VCM_SENSE eeg_sdm1ct_0/eeg_fd_ota_full2_nc_0/eeg_cmfb_amp_dl2_0/m1_68_166# 1.233540e-16
C5497 eeg_sdm1ct_0/eeg_fd_ota_full2_nc_0/eeg_cmfb_amp_dl2_0/m1_370_1493# VSS 2.522110e-16
C5498 eeg_sdm1ct_0/eeg_fd_ota_full2_nc_0/eeg_cmfb_amp_dl2_0/m1_370_1493# eeg_sdm1ct_0/eeg_fd_ota_full2_nc_0/eeg_cmfb_amp_dl2_0/m1_68_166# 2.845540e-17
C5499 eeg_sdm1ct_0/eeg_fd_ota_full2_nc_0/eeg_cmfb_amp_dl2_0/m1_68_166# VSS 2.522110e-16
C5500 VCM_REF VDD18 7.328797e-16
C5501 VCM_REF VSS 1.680760e-14
C5502 VCM_REF eeg_sdm1ct_0/OINTN 1.571540e-15
C5503 VCM_REF eeg_sdm1ct_0/OINTP 1.032390e-14
C5504 VCM_REF eeg_sdm1ct_0/eeg_fd_ota_full2_nc_0/stage2_0/VBP2 1.491687e-16
C5505 VCM_REF eeg_sdm1ct_0/eeg_fd_ota_full2_nc_0/stage2_0/VCM2 1.478800e-14
C5507 VCM_REF eeg_sdm1ct_0/eeg_fd_ota_full2_nc_0/stage2_0/m1_70741_n8557# 7.669250e-17
C5509 VCM_REF eeg_sdm1ct_0/eeg_fd_ota_full2_nc_0/stage2_0/m1_80741_n8557# 7.669250e-17
C5510 VDD18 VSS 2.038645e-14
C5511 VDD18 eeg_sdm1ct_0/OINTN 1.639622e-15
C5512 VDD18 eeg_sdm1ct_0/OINTP 2.589536e-15
C5515 VDD18 eeg_sdm1ct_0/eeg_fd_ota_full2_nc_0/stage2_0/VBP2 1.191804e-14
C5516 VDD18 eeg_sdm1ct_0/eeg_fd_ota_full2_nc_0/stage2_0/VCM2 1.675041e-15
C5517 VSS eeg_sdm1ct_0/OINTN 3.033735e-17
C5518 VSS eeg_sdm1ct_0/OINTP 3.186307e-16
C5519 VSS eeg_sdm1ct_0/eeg_fd_ota_full2_nc_0/stage2_0/N2N 8.833751e-15
C5520 VSS eeg_sdm1ct_0/eeg_fd_ota_full2_nc_0/stage2_0/N2P 1.288700e-15
C5522 VSS eeg_sdm1ct_0/eeg_fd_ota_full2_nc_0/stage2_0/VCM2 1.093840e-16
C5523 eeg_sdm1ct_0/OINTN VSS 1.332930e-13
C5524 eeg_sdm1ct_0/OINTN eeg_sdm1ct_0/OINTP 1.250905e-14
C5525 eeg_sdm1ct_0/OINTN eeg_sdm1ct_0/eeg_fd_ota_full2_nc_0/stage2_0/N2N 2.525290e-16
C5527 eeg_sdm1ct_0/OINTN eeg_sdm1ct_0/eeg_fd_ota_full2_nc_0/stage2_0/VBP2 9.326616e-15
C5528 eeg_sdm1ct_0/OINTN eeg_sdm1ct_0/eeg_fd_ota_full2_nc_0/stage2_0/VCM2 7.778653e-16
C5529 eeg_sdm1ct_0/OINTN eeg_sdm1ct_0/eeg_fd_ota_full2_nc_0/stage2_0/m1_12966_n5928# 5.354807e-13
C5530 eeg_sdm1ct_0/OINTN eeg_sdm1ct_0/eeg_fd_ota_full2_nc_0/stage2_0/m1_42341_n8557# 7.669250e-17
C5536 eeg_sdm1ct_0/OINTN eeg_sdm1ct_0/eeg_fd_ota_full2_nc_0/stage2_0/m1_47141_n8557# 3.123278e-16
C5537 eeg_sdm1ct_0/OINTN eeg_sdm1ct_0/eeg_fd_ota_full2_nc_0/stage2_0/m1_47541_n15864# 3.201824e-16
C5539 eeg_sdm1ct_0/OINTN eeg_sdm1ct_0/eeg_fd_ota_full2_nc_0/stage2_0/m1_48341_n15864# 3.866493e-17
C5541 eeg_sdm1ct_0/OINTN eeg_sdm1ct_0/eeg_fd_ota_full2_nc_0/stage2_0/m1_49141_n15864# 3.442668e-17
C5542 eeg_sdm1ct_0/OINTN eeg_sdm1ct_0/eeg_fd_ota_full2_nc_0/stage2_0/m1_49941_n15864# 3.405966e-17
C5543 eeg_sdm1ct_0/OINTN eeg_sdm1ct_0/eeg_fd_ota_full2_nc_0/stage2_0/m1_50741_n15864# 3.405966e-17
C5544 eeg_sdm1ct_0/OINTN eeg_sdm1ct_0/eeg_fd_ota_full2_nc_0/stage2_0/m1_51541_n15864# 3.405966e-17
C5545 eeg_sdm1ct_0/OINTN eeg_sdm1ct_0/eeg_fd_ota_full2_nc_0/stage2_0/m1_52341_n15864# 3.405966e-17
C5546 eeg_sdm1ct_0/OINTN eeg_sdm1ct_0/eeg_fd_ota_full2_nc_0/stage2_0/m1_53141_n15864# 3.405966e-17
C5547 eeg_sdm1ct_0/OINTN eeg_sdm1ct_0/eeg_fd_ota_full2_nc_0/stage2_0/m1_53941_n15864# 3.405966e-17
C5548 eeg_sdm1ct_0/OINTN eeg_sdm1ct_0/eeg_fd_ota_full2_nc_0/stage2_0/m1_54741_n15864# 3.405966e-17
C5549 eeg_sdm1ct_0/OINTN eeg_sdm1ct_0/eeg_fd_ota_full2_nc_0/stage2_0/m1_55541_n15864# 3.405966e-17
C5550 eeg_sdm1ct_0/OINTN eeg_sdm1ct_0/eeg_fd_ota_full2_nc_0/stage2_0/m1_56341_n15864# 3.405966e-17
C5551 eeg_sdm1ct_0/OINTN eeg_sdm1ct_0/eeg_fd_ota_full2_nc_0/stage2_0/m1_57141_n15864# 3.405966e-17
C5552 eeg_sdm1ct_0/OINTN eeg_sdm1ct_0/eeg_fd_ota_full2_nc_0/stage2_0/m1_57941_n15864# 3.405966e-17
C5553 eeg_sdm1ct_0/OINTN eeg_sdm1ct_0/eeg_fd_ota_full2_nc_0/stage2_0/m1_58741_n15864# 3.405966e-17
C5554 eeg_sdm1ct_0/OINTN eeg_sdm1ct_0/eeg_fd_ota_full2_nc_0/stage2_0/m1_59541_n15864# 3.405966e-17
C5555 eeg_sdm1ct_0/OINTN eeg_sdm1ct_0/eeg_fd_ota_full2_nc_0/stage2_0/m1_60341_n15864# 3.405966e-17
C5556 eeg_sdm1ct_0/OINTN eeg_sdm1ct_0/eeg_fd_ota_full2_nc_0/stage2_0/m1_61141_n15864# 3.405966e-17
C5557 eeg_sdm1ct_0/OINTN eeg_sdm1ct_0/eeg_fd_ota_full2_nc_0/stage2_0/m1_63941_n15864# 3.405966e-17
C5558 eeg_sdm1ct_0/OINTN eeg_sdm1ct_0/eeg_fd_ota_full2_nc_0/stage2_0/m1_64741_n15864# 3.405966e-17
C5559 eeg_sdm1ct_0/OINTN eeg_sdm1ct_0/eeg_fd_ota_full2_nc_0/stage2_0/m1_65541_n15864# 3.405966e-17
C5560 eeg_sdm1ct_0/OINTN eeg_sdm1ct_0/eeg_fd_ota_full2_nc_0/stage2_0/m1_66341_n15864# 3.405966e-17
C5561 eeg_sdm1ct_0/OINTN eeg_sdm1ct_0/eeg_fd_ota_full2_nc_0/stage2_0/m1_67141_n15864# 3.405966e-17
C5562 eeg_sdm1ct_0/OINTN eeg_sdm1ct_0/eeg_fd_ota_full2_nc_0/stage2_0/m1_67941_n15864# 3.405966e-17
C5563 eeg_sdm1ct_0/OINTN eeg_sdm1ct_0/eeg_fd_ota_full2_nc_0/stage2_0/m1_68741_n15864# 3.405966e-17
C5564 eeg_sdm1ct_0/OINTN eeg_sdm1ct_0/eeg_fd_ota_full2_nc_0/stage2_0/m1_69541_n15864# 3.210496e-17
C5565 eeg_sdm1ct_0/OINTN eeg_sdm1ct_0/eeg_fd_ota_full2_nc_0/stage2_0/m1_74341_n8557# 7.669250e-17
C5567 eeg_sdm1ct_0/OINTP VSS 1.254420e-13
C5568 eeg_sdm1ct_0/OINTP eeg_sdm1ct_0/eeg_fd_ota_full2_nc_0/stage2_0/N2N 2.003715e-16
C5569 eeg_sdm1ct_0/OINTP eeg_sdm1ct_0/eeg_fd_ota_full2_nc_0/stage2_0/N2P 4.623865e-16
C5570 eeg_sdm1ct_0/OINTP eeg_sdm1ct_0/eeg_fd_ota_full2_nc_0/stage2_0/VBP2 4.266178e-15
C5571 eeg_sdm1ct_0/OINTP eeg_sdm1ct_0/eeg_fd_ota_full2_nc_0/stage2_0/VCM2 1.597490e-16
C5572 eeg_sdm1ct_0/OINTP eeg_sdm1ct_0/eeg_fd_ota_full2_nc_0/stage2_0/m1_12966_n5928# 2.275473e-16
C5573 eeg_sdm1ct_0/OINTP eeg_sdm1ct_0/eeg_fd_ota_full2_nc_0/stage2_0/m1_19941_n15864# 5.389540e-17
C5574 eeg_sdm1ct_0/OINTP eeg_sdm1ct_0/eeg_fd_ota_full2_nc_0/stage2_0/m1_20341_n8557# 7.866144e-17
C5575 eeg_sdm1ct_0/OINTP eeg_sdm1ct_0/eeg_fd_ota_full2_nc_0/stage2_0/m1_20741_n15864# 3.615601e-17
C5577 eeg_sdm1ct_0/OINTP eeg_sdm1ct_0/eeg_fd_ota_full2_nc_0/stage2_0/m1_21541_n15864# 3.405966e-17
C5578 eeg_sdm1ct_0/OINTP eeg_sdm1ct_0/eeg_fd_ota_full2_nc_0/stage2_0/m1_22341_n15864# 3.405966e-17
C5579 eeg_sdm1ct_0/OINTP eeg_sdm1ct_0/eeg_fd_ota_full2_nc_0/stage2_0/m1_23141_n15864# 3.405966e-17
C5580 eeg_sdm1ct_0/OINTP eeg_sdm1ct_0/eeg_fd_ota_full2_nc_0/stage2_0/m1_23941_n15864# 3.405966e-17
C5581 eeg_sdm1ct_0/OINTP eeg_sdm1ct_0/eeg_fd_ota_full2_nc_0/stage2_0/m1_24741_n15864# 3.405966e-17
C5582 eeg_sdm1ct_0/OINTP eeg_sdm1ct_0/eeg_fd_ota_full2_nc_0/stage2_0/m1_25541_n15864# 3.405966e-17
C5583 eeg_sdm1ct_0/OINTP eeg_sdm1ct_0/eeg_fd_ota_full2_nc_0/stage2_0/m1_26341_n15864# 3.405966e-17
C5584 eeg_sdm1ct_0/OINTP eeg_sdm1ct_0/eeg_fd_ota_full2_nc_0/stage2_0/m1_27141_n15864# 3.405966e-17
C5585 eeg_sdm1ct_0/OINTP eeg_sdm1ct_0/eeg_fd_ota_full2_nc_0/stage2_0/m1_27941_n15864# 3.405966e-17
C5586 eeg_sdm1ct_0/OINTP eeg_sdm1ct_0/eeg_fd_ota_full2_nc_0/stage2_0/m1_28741_n15864# 3.405966e-17
C5587 eeg_sdm1ct_0/OINTP eeg_sdm1ct_0/eeg_fd_ota_full2_nc_0/stage2_0/m1_29541_n15864# 3.405966e-17
C5588 eeg_sdm1ct_0/OINTP eeg_sdm1ct_0/eeg_fd_ota_full2_nc_0/stage2_0/m1_30341_n15864# 3.405966e-17
C5589 eeg_sdm1ct_0/OINTP eeg_sdm1ct_0/eeg_fd_ota_full2_nc_0/stage2_0/m1_31141_n15864# 3.405966e-17
C5590 eeg_sdm1ct_0/OINTP eeg_sdm1ct_0/eeg_fd_ota_full2_nc_0/stage2_0/m1_31941_n15864# 3.405966e-17
C5591 eeg_sdm1ct_0/OINTP eeg_sdm1ct_0/eeg_fd_ota_full2_nc_0/stage2_0/m1_32741_n15864# 3.405966e-17
C5592 eeg_sdm1ct_0/OINTP eeg_sdm1ct_0/eeg_fd_ota_full2_nc_0/stage2_0/m1_33541_n15864# 3.405966e-17
C5593 eeg_sdm1ct_0/OINTP eeg_sdm1ct_0/eeg_fd_ota_full2_nc_0/stage2_0/m1_34341_n15864# 3.405966e-17
C5594 eeg_sdm1ct_0/OINTP eeg_sdm1ct_0/eeg_fd_ota_full2_nc_0/stage2_0/m1_35141_n15864# 3.405966e-17
C5595 eeg_sdm1ct_0/OINTP eeg_sdm1ct_0/eeg_fd_ota_full2_nc_0/stage2_0/m1_35941_n15864# 3.405966e-17
C5596 eeg_sdm1ct_0/OINTP eeg_sdm1ct_0/eeg_fd_ota_full2_nc_0/stage2_0/m1_36741_n15864# 3.405966e-17
C5597 eeg_sdm1ct_0/OINTP eeg_sdm1ct_0/eeg_fd_ota_full2_nc_0/stage2_0/m1_37541_n15864# 3.405966e-17
C5598 eeg_sdm1ct_0/OINTP eeg_sdm1ct_0/eeg_fd_ota_full2_nc_0/stage2_0/m1_38341_n15864# 3.405966e-17
C5599 eeg_sdm1ct_0/OINTP eeg_sdm1ct_0/eeg_fd_ota_full2_nc_0/stage2_0/m1_39141_n15864# 3.405966e-17
C5600 eeg_sdm1ct_0/OINTP eeg_sdm1ct_0/eeg_fd_ota_full2_nc_0/stage2_0/m1_3966_n5928# 5.354613e-13
C5602 eeg_sdm1ct_0/OINTP eeg_sdm1ct_0/eeg_fd_ota_full2_nc_0/stage2_0/m1_64341_n8557# 7.669250e-17
C5604 eeg_sdm1ct_0/eeg_fd_ota_full2_nc_0/stage2_0/N2N VSS 6.392800e-15
C5605 eeg_sdm1ct_0/eeg_fd_ota_full2_nc_0/stage2_0/N2N eeg_sdm1ct_0/eeg_fd_ota_full2_nc_0/stage2_0/N2P 8.621393e-15
C5606 eeg_sdm1ct_0/eeg_fd_ota_full2_nc_0/stage2_0/N2N eeg_sdm1ct_0/eeg_fd_ota_full2_nc_0/stage2_0/VBP2 3.636257e-17
C5607 eeg_sdm1ct_0/eeg_fd_ota_full2_nc_0/stage2_0/N2N eeg_sdm1ct_0/eeg_fd_ota_full2_nc_0/stage2_0/VCM2 9.762040e-17
C5609 eeg_sdm1ct_0/eeg_fd_ota_full2_nc_0/stage2_0/N2P VSS 1.400660e-14
C5610 eeg_sdm1ct_0/eeg_fd_ota_full2_nc_0/stage2_0/N2P eeg_sdm1ct_0/eeg_fd_ota_full2_nc_0/stage2_0/VBP2 3.636256e-17
C5611 eeg_sdm1ct_0/eeg_fd_ota_full2_nc_0/stage2_0/N2P eeg_sdm1ct_0/eeg_fd_ota_full2_nc_0/stage2_0/VCM2 1.093840e-16
C5613 eeg_sdm1ct_0/eeg_fd_ota_full2_nc_0/stage2_0/VBP2 VSS 2.125980e-14
C5614 eeg_sdm1ct_0/eeg_fd_ota_full2_nc_0/stage2_0/VBP2 eeg_sdm1ct_0/eeg_fd_ota_full2_nc_0/stage2_0/VCM2 4.555847e-15
C5615 eeg_sdm1ct_0/eeg_fd_ota_full2_nc_0/stage2_0/VCM2 VSS 2.633740e-14
C5616 eeg_sdm1ct_0/eeg_fd_ota_full2_nc_0/stage2_0/VCM2 eeg_sdm1ct_0/eeg_fd_ota_full2_nc_0/stage2_0/m1_12966_n5928# 1.237053e-16
C5618 eeg_sdm1ct_0/eeg_fd_ota_full2_nc_0/stage2_0/VCM2 eeg_sdm1ct_0/eeg_fd_ota_full2_nc_0/stage2_0/m1_38741_n8557# 7.669250e-17
C5620 eeg_sdm1ct_0/eeg_fd_ota_full2_nc_0/stage2_0/VCM2 eeg_sdm1ct_0/eeg_fd_ota_full2_nc_0/stage2_0/m1_60741_n8557# 7.669250e-17
C5621 eeg_sdm1ct_0/eeg_fd_ota_full2_nc_0/stage2_0/m1_12966_n5928# VSS 3.339850e-14
C5622 eeg_sdm1ct_0/eeg_fd_ota_full2_nc_0/stage2_0/m1_12966_n5928# eeg_sdm1ct_0/eeg_fd_ota_full2_nc_0/stage2_0/m1_20341_n8557# 2.101150e-17
C5623 eeg_sdm1ct_0/eeg_fd_ota_full2_nc_0/stage2_0/m1_12966_n5928# eeg_sdm1ct_0/eeg_fd_ota_full2_nc_0/stage2_0/m1_21141_n8557# 2.101150e-17
C5624 eeg_sdm1ct_0/eeg_fd_ota_full2_nc_0/stage2_0/m1_12966_n5928# eeg_sdm1ct_0/eeg_fd_ota_full2_nc_0/stage2_0/m1_21941_n8557# 2.101150e-17
C5625 eeg_sdm1ct_0/eeg_fd_ota_full2_nc_0/stage2_0/m1_12966_n5928# eeg_sdm1ct_0/eeg_fd_ota_full2_nc_0/stage2_0/m1_22741_n8557# 2.101150e-17
C5626 eeg_sdm1ct_0/eeg_fd_ota_full2_nc_0/stage2_0/m1_12966_n5928# eeg_sdm1ct_0/eeg_fd_ota_full2_nc_0/stage2_0/m1_23541_n8557# 2.101150e-17
C5627 eeg_sdm1ct_0/eeg_fd_ota_full2_nc_0/stage2_0/m1_12966_n5928# eeg_sdm1ct_0/eeg_fd_ota_full2_nc_0/stage2_0/m1_24341_n8557# 2.101150e-17
C5628 eeg_sdm1ct_0/eeg_fd_ota_full2_nc_0/stage2_0/m1_12966_n5928# eeg_sdm1ct_0/eeg_fd_ota_full2_nc_0/stage2_0/m1_25141_n8557# 2.101150e-17
C5629 eeg_sdm1ct_0/eeg_fd_ota_full2_nc_0/stage2_0/m1_12966_n5928# eeg_sdm1ct_0/eeg_fd_ota_full2_nc_0/stage2_0/m1_25941_n8557# 2.101150e-17
C5630 eeg_sdm1ct_0/eeg_fd_ota_full2_nc_0/stage2_0/m1_12966_n5928# eeg_sdm1ct_0/eeg_fd_ota_full2_nc_0/stage2_0/m1_26741_n8557# 2.101150e-17
C5631 eeg_sdm1ct_0/eeg_fd_ota_full2_nc_0/stage2_0/m1_12966_n5928# eeg_sdm1ct_0/eeg_fd_ota_full2_nc_0/stage2_0/m1_27541_n8557# 2.101150e-17
C5632 eeg_sdm1ct_0/eeg_fd_ota_full2_nc_0/stage2_0/m1_12966_n5928# eeg_sdm1ct_0/eeg_fd_ota_full2_nc_0/stage2_0/m1_28341_n8557# 2.101150e-17
C5633 eeg_sdm1ct_0/eeg_fd_ota_full2_nc_0/stage2_0/m1_12966_n5928# eeg_sdm1ct_0/eeg_fd_ota_full2_nc_0/stage2_0/m1_29141_n8557# 2.101150e-17
C5634 eeg_sdm1ct_0/eeg_fd_ota_full2_nc_0/stage2_0/m1_12966_n5928# eeg_sdm1ct_0/eeg_fd_ota_full2_nc_0/stage2_0/m1_29941_n8557# 2.101150e-17
C5635 eeg_sdm1ct_0/eeg_fd_ota_full2_nc_0/stage2_0/m1_12966_n5928# eeg_sdm1ct_0/eeg_fd_ota_full2_nc_0/stage2_0/m1_30741_n8557# 2.101150e-17
C5636 eeg_sdm1ct_0/eeg_fd_ota_full2_nc_0/stage2_0/m1_12966_n5928# eeg_sdm1ct_0/eeg_fd_ota_full2_nc_0/stage2_0/m1_31541_n8557# 2.101150e-17
C5637 eeg_sdm1ct_0/eeg_fd_ota_full2_nc_0/stage2_0/m1_12966_n5928# eeg_sdm1ct_0/eeg_fd_ota_full2_nc_0/stage2_0/m1_32341_n8557# 2.101150e-17
C5638 eeg_sdm1ct_0/eeg_fd_ota_full2_nc_0/stage2_0/m1_12966_n5928# eeg_sdm1ct_0/eeg_fd_ota_full2_nc_0/stage2_0/m1_33141_n8557# 2.101150e-17
C5639 eeg_sdm1ct_0/eeg_fd_ota_full2_nc_0/stage2_0/m1_12966_n5928# eeg_sdm1ct_0/eeg_fd_ota_full2_nc_0/stage2_0/m1_33941_n8557# 2.101150e-17
C5640 eeg_sdm1ct_0/eeg_fd_ota_full2_nc_0/stage2_0/m1_12966_n5928# eeg_sdm1ct_0/eeg_fd_ota_full2_nc_0/stage2_0/m1_34741_n8557# 2.101150e-17
C5641 eeg_sdm1ct_0/eeg_fd_ota_full2_nc_0/stage2_0/m1_12966_n5928# eeg_sdm1ct_0/eeg_fd_ota_full2_nc_0/stage2_0/m1_35541_n8557# 2.101150e-17
C5642 eeg_sdm1ct_0/eeg_fd_ota_full2_nc_0/stage2_0/m1_12966_n5928# eeg_sdm1ct_0/eeg_fd_ota_full2_nc_0/stage2_0/m1_36341_n8557# 2.101150e-17
C5643 eeg_sdm1ct_0/eeg_fd_ota_full2_nc_0/stage2_0/m1_12966_n5928# eeg_sdm1ct_0/eeg_fd_ota_full2_nc_0/stage2_0/m1_37141_n8557# 2.101150e-17
C5644 eeg_sdm1ct_0/eeg_fd_ota_full2_nc_0/stage2_0/m1_12966_n5928# eeg_sdm1ct_0/eeg_fd_ota_full2_nc_0/stage2_0/m1_37941_n8557# 2.101150e-17
C5645 eeg_sdm1ct_0/eeg_fd_ota_full2_nc_0/stage2_0/m1_12966_n5928# eeg_sdm1ct_0/eeg_fd_ota_full2_nc_0/stage2_0/m1_38741_n8557# 2.101150e-17
C5646 eeg_sdm1ct_0/eeg_fd_ota_full2_nc_0/stage2_0/m1_12966_n5928# eeg_sdm1ct_0/eeg_fd_ota_full2_nc_0/stage2_0/m1_3966_n5928# 2.125553e-15
C5647 eeg_sdm1ct_0/eeg_fd_ota_full2_nc_0/stage2_0/m1_12966_n5928# eeg_sdm1ct_0/eeg_fd_ota_full2_nc_0/stage2_0/m1_42341_n8557# 2.101150e-17
C5648 eeg_sdm1ct_0/eeg_fd_ota_full2_nc_0/stage2_0/m1_12966_n5928# eeg_sdm1ct_0/eeg_fd_ota_full2_nc_0/stage2_0/m1_43141_n8557# 2.101150e-17
C5649 eeg_sdm1ct_0/eeg_fd_ota_full2_nc_0/stage2_0/m1_12966_n5928# eeg_sdm1ct_0/eeg_fd_ota_full2_nc_0/stage2_0/m1_43941_n8557# 2.101150e-17
C5650 eeg_sdm1ct_0/eeg_fd_ota_full2_nc_0/stage2_0/m1_12966_n5928# eeg_sdm1ct_0/eeg_fd_ota_full2_nc_0/stage2_0/m1_44741_n8557# 2.101150e-17
C5651 eeg_sdm1ct_0/eeg_fd_ota_full2_nc_0/stage2_0/m1_12966_n5928# eeg_sdm1ct_0/eeg_fd_ota_full2_nc_0/stage2_0/m1_45541_n8557# 2.101150e-17
C5652 eeg_sdm1ct_0/eeg_fd_ota_full2_nc_0/stage2_0/m1_12966_n5928# eeg_sdm1ct_0/eeg_fd_ota_full2_nc_0/stage2_0/m1_46341_n8557# 2.101150e-17
C5655 eeg_sdm1ct_0/eeg_fd_ota_full2_nc_0/stage2_0/m1_12966_n5928# eeg_sdm1ct_0/eeg_fd_ota_full2_nc_0/stage2_0/m1_47941_n8557# 2.101150e-17
C5656 eeg_sdm1ct_0/eeg_fd_ota_full2_nc_0/stage2_0/m1_12966_n5928# eeg_sdm1ct_0/eeg_fd_ota_full2_nc_0/stage2_0/m1_48341_n15864# 2.092590e-17
C5657 eeg_sdm1ct_0/eeg_fd_ota_full2_nc_0/stage2_0/m1_12966_n5928# eeg_sdm1ct_0/eeg_fd_ota_full2_nc_0/stage2_0/m1_48741_n8557# 2.101150e-17
C5658 eeg_sdm1ct_0/eeg_fd_ota_full2_nc_0/stage2_0/m1_12966_n5928# eeg_sdm1ct_0/eeg_fd_ota_full2_nc_0/stage2_0/m1_49141_n15864# 2.092590e-17
C5659 eeg_sdm1ct_0/eeg_fd_ota_full2_nc_0/stage2_0/m1_12966_n5928# eeg_sdm1ct_0/eeg_fd_ota_full2_nc_0/stage2_0/m1_49541_n8557# 2.101150e-17
C5660 eeg_sdm1ct_0/eeg_fd_ota_full2_nc_0/stage2_0/m1_12966_n5928# eeg_sdm1ct_0/eeg_fd_ota_full2_nc_0/stage2_0/m1_49941_n15864# 2.092590e-17
C5661 eeg_sdm1ct_0/eeg_fd_ota_full2_nc_0/stage2_0/m1_12966_n5928# eeg_sdm1ct_0/eeg_fd_ota_full2_nc_0/stage2_0/m1_50341_n8557# 2.101150e-17
C5662 eeg_sdm1ct_0/eeg_fd_ota_full2_nc_0/stage2_0/m1_12966_n5928# eeg_sdm1ct_0/eeg_fd_ota_full2_nc_0/stage2_0/m1_50741_n15864# 2.092590e-17
C5663 eeg_sdm1ct_0/eeg_fd_ota_full2_nc_0/stage2_0/m1_12966_n5928# eeg_sdm1ct_0/eeg_fd_ota_full2_nc_0/stage2_0/m1_51141_n8557# 2.101150e-17
C5664 eeg_sdm1ct_0/eeg_fd_ota_full2_nc_0/stage2_0/m1_12966_n5928# eeg_sdm1ct_0/eeg_fd_ota_full2_nc_0/stage2_0/m1_51541_n15864# 2.092590e-17
C5665 eeg_sdm1ct_0/eeg_fd_ota_full2_nc_0/stage2_0/m1_12966_n5928# eeg_sdm1ct_0/eeg_fd_ota_full2_nc_0/stage2_0/m1_51941_n8557# 2.101150e-17
C5666 eeg_sdm1ct_0/eeg_fd_ota_full2_nc_0/stage2_0/m1_12966_n5928# eeg_sdm1ct_0/eeg_fd_ota_full2_nc_0/stage2_0/m1_52341_n15864# 2.092590e-17
C5667 eeg_sdm1ct_0/eeg_fd_ota_full2_nc_0/stage2_0/m1_12966_n5928# eeg_sdm1ct_0/eeg_fd_ota_full2_nc_0/stage2_0/m1_52741_n8557# 2.101150e-17
C5668 eeg_sdm1ct_0/eeg_fd_ota_full2_nc_0/stage2_0/m1_12966_n5928# eeg_sdm1ct_0/eeg_fd_ota_full2_nc_0/stage2_0/m1_53141_n15864# 2.092590e-17
C5669 eeg_sdm1ct_0/eeg_fd_ota_full2_nc_0/stage2_0/m1_12966_n5928# eeg_sdm1ct_0/eeg_fd_ota_full2_nc_0/stage2_0/m1_53541_n8557# 2.101150e-17
C5670 eeg_sdm1ct_0/eeg_fd_ota_full2_nc_0/stage2_0/m1_12966_n5928# eeg_sdm1ct_0/eeg_fd_ota_full2_nc_0/stage2_0/m1_53941_n15864# 2.092590e-17
C5671 eeg_sdm1ct_0/eeg_fd_ota_full2_nc_0/stage2_0/m1_12966_n5928# eeg_sdm1ct_0/eeg_fd_ota_full2_nc_0/stage2_0/m1_54341_n8557# 2.101150e-17
C5672 eeg_sdm1ct_0/eeg_fd_ota_full2_nc_0/stage2_0/m1_12966_n5928# eeg_sdm1ct_0/eeg_fd_ota_full2_nc_0/stage2_0/m1_54741_n15864# 2.092590e-17
C5673 eeg_sdm1ct_0/eeg_fd_ota_full2_nc_0/stage2_0/m1_12966_n5928# eeg_sdm1ct_0/eeg_fd_ota_full2_nc_0/stage2_0/m1_55141_n8557# 2.101150e-17
C5674 eeg_sdm1ct_0/eeg_fd_ota_full2_nc_0/stage2_0/m1_12966_n5928# eeg_sdm1ct_0/eeg_fd_ota_full2_nc_0/stage2_0/m1_55541_n15864# 2.092590e-17
C5675 eeg_sdm1ct_0/eeg_fd_ota_full2_nc_0/stage2_0/m1_12966_n5928# eeg_sdm1ct_0/eeg_fd_ota_full2_nc_0/stage2_0/m1_55941_n8557# 2.101150e-17
C5676 eeg_sdm1ct_0/eeg_fd_ota_full2_nc_0/stage2_0/m1_12966_n5928# eeg_sdm1ct_0/eeg_fd_ota_full2_nc_0/stage2_0/m1_56341_n15864# 2.092590e-17
C5677 eeg_sdm1ct_0/eeg_fd_ota_full2_nc_0/stage2_0/m1_12966_n5928# eeg_sdm1ct_0/eeg_fd_ota_full2_nc_0/stage2_0/m1_56741_n8557# 2.375360e-17
C5678 eeg_sdm1ct_0/eeg_fd_ota_full2_nc_0/stage2_0/m1_12966_n5928# eeg_sdm1ct_0/eeg_fd_ota_full2_nc_0/stage2_0/m1_57141_n15864# 3.119110e-17
C5679 eeg_sdm1ct_0/eeg_fd_ota_full2_nc_0/stage2_0/m1_12966_n5928# eeg_sdm1ct_0/eeg_fd_ota_full2_nc_0/stage2_0/m1_57541_n8557# 3.855600e-17
C5680 eeg_sdm1ct_0/eeg_fd_ota_full2_nc_0/stage2_0/m1_12966_n5928# eeg_sdm1ct_0/eeg_fd_ota_full2_nc_0/stage2_0/m1_57941_n15864# 5.436140e-17
C5681 eeg_sdm1ct_0/eeg_fd_ota_full2_nc_0/stage2_0/m1_12966_n5928# eeg_sdm1ct_0/eeg_fd_ota_full2_nc_0/stage2_0/m1_58341_n8557# 1.191254e-16
C5682 eeg_sdm1ct_0/eeg_fd_ota_full2_nc_0/stage2_0/m1_12966_n5928# eeg_sdm1ct_0/eeg_fd_ota_full2_nc_0/stage2_0/m1_58741_n15864# 1.705141e-16
C5683 eeg_sdm1ct_0/eeg_fd_ota_full2_nc_0/stage2_0/m1_12966_n5928# eeg_sdm1ct_0/eeg_fd_ota_full2_nc_0/stage2_0/m1_59141_n8557# 9.883835e-17
C5684 eeg_sdm1ct_0/eeg_fd_ota_full2_nc_0/stage2_0/m1_12966_n5928# eeg_sdm1ct_0/eeg_fd_ota_full2_nc_0/stage2_0/m1_59541_n15864# 5.436140e-17
C5686 eeg_sdm1ct_0/eeg_fd_ota_full2_nc_0/stage2_0/m1_12966_n5928# eeg_sdm1ct_0/eeg_fd_ota_full2_nc_0/stage2_0/m1_60341_n15864# 3.119110e-17
C5688 eeg_sdm1ct_0/eeg_fd_ota_full2_nc_0/stage2_0/m1_12966_n5928# eeg_sdm1ct_0/eeg_fd_ota_full2_nc_0/stage2_0/m1_61141_n15864# 2.092590e-17
C5689 eeg_sdm1ct_0/eeg_fd_ota_full2_nc_0/stage2_0/m1_12966_n5928# eeg_sdm1ct_0/eeg_fd_ota_full2_nc_0/stage2_0/m1_63941_n15864# 2.092590e-17
C5690 eeg_sdm1ct_0/eeg_fd_ota_full2_nc_0/stage2_0/m1_12966_n5928# eeg_sdm1ct_0/eeg_fd_ota_full2_nc_0/stage2_0/m1_64741_n15864# 2.092590e-17
C5691 eeg_sdm1ct_0/eeg_fd_ota_full2_nc_0/stage2_0/m1_12966_n5928# eeg_sdm1ct_0/eeg_fd_ota_full2_nc_0/stage2_0/m1_65541_n15864# 2.092590e-17
C5692 eeg_sdm1ct_0/eeg_fd_ota_full2_nc_0/stage2_0/m1_12966_n5928# eeg_sdm1ct_0/eeg_fd_ota_full2_nc_0/stage2_0/m1_66341_n15864# 2.092590e-17
C5693 eeg_sdm1ct_0/eeg_fd_ota_full2_nc_0/stage2_0/m1_12966_n5928# eeg_sdm1ct_0/eeg_fd_ota_full2_nc_0/stage2_0/m1_67141_n15864# 2.092590e-17
C5694 eeg_sdm1ct_0/eeg_fd_ota_full2_nc_0/stage2_0/m1_12966_n5928# eeg_sdm1ct_0/eeg_fd_ota_full2_nc_0/stage2_0/m1_67941_n15864# 2.092590e-17
C5695 eeg_sdm1ct_0/eeg_fd_ota_full2_nc_0/stage2_0/m1_12966_n5928# eeg_sdm1ct_0/eeg_fd_ota_full2_nc_0/stage2_0/m1_68741_n15864# 2.092590e-17
C5697 eeg_sdm1ct_0/eeg_fd_ota_full2_nc_0/stage2_0/m1_19941_n15864# VSS 4.702790e-16
C5698 eeg_sdm1ct_0/eeg_fd_ota_full2_nc_0/stage2_0/m1_19941_n15864# eeg_sdm1ct_0/eeg_fd_ota_full2_nc_0/stage2_0/m1_20741_n15864# 6.789059e-17
C5700 eeg_sdm1ct_0/eeg_fd_ota_full2_nc_0/stage2_0/m1_20341_n8557# VSS 4.623640e-16
C5701 eeg_sdm1ct_0/eeg_fd_ota_full2_nc_0/stage2_0/m1_20341_n8557# eeg_sdm1ct_0/eeg_fd_ota_full2_nc_0/stage2_0/m1_21141_n8557# 6.789040e-17
C5703 eeg_sdm1ct_0/eeg_fd_ota_full2_nc_0/stage2_0/m1_20741_n15864# VSS 4.190540e-16
C5704 eeg_sdm1ct_0/eeg_fd_ota_full2_nc_0/stage2_0/m1_20741_n15864# eeg_sdm1ct_0/eeg_fd_ota_full2_nc_0/stage2_0/m1_21541_n15864# 6.789049e-17
C5705 eeg_sdm1ct_0/eeg_fd_ota_full2_nc_0/stage2_0/m1_20741_n15864# eeg_sdm1ct_0/eeg_fd_ota_full2_nc_0/stage2_0/m1_3966_n5928# 2.092590e-17
C5706 eeg_sdm1ct_0/eeg_fd_ota_full2_nc_0/stage2_0/m1_21141_n8557# VSS 4.190540e-16
C5707 eeg_sdm1ct_0/eeg_fd_ota_full2_nc_0/stage2_0/m1_21141_n8557# eeg_sdm1ct_0/eeg_fd_ota_full2_nc_0/stage2_0/m1_21941_n8557# 6.789040e-17
C5709 eeg_sdm1ct_0/eeg_fd_ota_full2_nc_0/stage2_0/m1_21541_n15864# VSS 4.190540e-16
C5710 eeg_sdm1ct_0/eeg_fd_ota_full2_nc_0/stage2_0/m1_21541_n15864# eeg_sdm1ct_0/eeg_fd_ota_full2_nc_0/stage2_0/m1_22341_n15864# 6.789049e-17
C5711 eeg_sdm1ct_0/eeg_fd_ota_full2_nc_0/stage2_0/m1_21541_n15864# eeg_sdm1ct_0/eeg_fd_ota_full2_nc_0/stage2_0/m1_3966_n5928# 2.092590e-17
C5712 eeg_sdm1ct_0/eeg_fd_ota_full2_nc_0/stage2_0/m1_21941_n8557# VSS 4.190540e-16
C5713 eeg_sdm1ct_0/eeg_fd_ota_full2_nc_0/stage2_0/m1_21941_n8557# eeg_sdm1ct_0/eeg_fd_ota_full2_nc_0/stage2_0/m1_22741_n8557# 6.789040e-17
C5715 eeg_sdm1ct_0/eeg_fd_ota_full2_nc_0/stage2_0/m1_22341_n15864# VSS 4.190540e-16
C5716 eeg_sdm1ct_0/eeg_fd_ota_full2_nc_0/stage2_0/m1_22341_n15864# eeg_sdm1ct_0/eeg_fd_ota_full2_nc_0/stage2_0/m1_23141_n15864# 6.789049e-17
C5717 eeg_sdm1ct_0/eeg_fd_ota_full2_nc_0/stage2_0/m1_22341_n15864# eeg_sdm1ct_0/eeg_fd_ota_full2_nc_0/stage2_0/m1_3966_n5928# 2.092590e-17
C5718 eeg_sdm1ct_0/eeg_fd_ota_full2_nc_0/stage2_0/m1_22741_n8557# VSS 4.190540e-16
C5719 eeg_sdm1ct_0/eeg_fd_ota_full2_nc_0/stage2_0/m1_22741_n8557# eeg_sdm1ct_0/eeg_fd_ota_full2_nc_0/stage2_0/m1_23541_n8557# 6.789044e-17
C5721 eeg_sdm1ct_0/eeg_fd_ota_full2_nc_0/stage2_0/m1_23141_n15864# VSS 4.190540e-16
C5722 eeg_sdm1ct_0/eeg_fd_ota_full2_nc_0/stage2_0/m1_23141_n15864# eeg_sdm1ct_0/eeg_fd_ota_full2_nc_0/stage2_0/m1_23941_n15864# 6.789049e-17
C5723 eeg_sdm1ct_0/eeg_fd_ota_full2_nc_0/stage2_0/m1_23141_n15864# eeg_sdm1ct_0/eeg_fd_ota_full2_nc_0/stage2_0/m1_3966_n5928# 2.092590e-17
C5724 eeg_sdm1ct_0/eeg_fd_ota_full2_nc_0/stage2_0/m1_23541_n8557# VSS 4.190540e-16
C5725 eeg_sdm1ct_0/eeg_fd_ota_full2_nc_0/stage2_0/m1_23541_n8557# eeg_sdm1ct_0/eeg_fd_ota_full2_nc_0/stage2_0/m1_24341_n8557# 6.789040e-17
C5727 eeg_sdm1ct_0/eeg_fd_ota_full2_nc_0/stage2_0/m1_23941_n15864# VSS 4.190540e-16
C5728 eeg_sdm1ct_0/eeg_fd_ota_full2_nc_0/stage2_0/m1_23941_n15864# eeg_sdm1ct_0/eeg_fd_ota_full2_nc_0/stage2_0/m1_24741_n15864# 6.789049e-17
C5729 eeg_sdm1ct_0/eeg_fd_ota_full2_nc_0/stage2_0/m1_23941_n15864# eeg_sdm1ct_0/eeg_fd_ota_full2_nc_0/stage2_0/m1_3966_n5928# 2.092590e-17
C5730 eeg_sdm1ct_0/eeg_fd_ota_full2_nc_0/stage2_0/m1_24341_n8557# VSS 4.190540e-16
C5731 eeg_sdm1ct_0/eeg_fd_ota_full2_nc_0/stage2_0/m1_24341_n8557# eeg_sdm1ct_0/eeg_fd_ota_full2_nc_0/stage2_0/m1_25141_n8557# 6.789040e-17
C5733 eeg_sdm1ct_0/eeg_fd_ota_full2_nc_0/stage2_0/m1_24741_n15864# VSS 4.190540e-16
C5734 eeg_sdm1ct_0/eeg_fd_ota_full2_nc_0/stage2_0/m1_24741_n15864# eeg_sdm1ct_0/eeg_fd_ota_full2_nc_0/stage2_0/m1_25541_n15864# 6.789049e-17
C5735 eeg_sdm1ct_0/eeg_fd_ota_full2_nc_0/stage2_0/m1_24741_n15864# eeg_sdm1ct_0/eeg_fd_ota_full2_nc_0/stage2_0/m1_3966_n5928# 2.092590e-17
C5736 eeg_sdm1ct_0/eeg_fd_ota_full2_nc_0/stage2_0/m1_25141_n8557# VSS 4.190540e-16
C5737 eeg_sdm1ct_0/eeg_fd_ota_full2_nc_0/stage2_0/m1_25141_n8557# eeg_sdm1ct_0/eeg_fd_ota_full2_nc_0/stage2_0/m1_25941_n8557# 6.789040e-17
C5739 eeg_sdm1ct_0/eeg_fd_ota_full2_nc_0/stage2_0/m1_25541_n15864# VSS 4.190540e-16
C5740 eeg_sdm1ct_0/eeg_fd_ota_full2_nc_0/stage2_0/m1_25541_n15864# eeg_sdm1ct_0/eeg_fd_ota_full2_nc_0/stage2_0/m1_26341_n15864# 6.789059e-17
C5741 eeg_sdm1ct_0/eeg_fd_ota_full2_nc_0/stage2_0/m1_25541_n15864# eeg_sdm1ct_0/eeg_fd_ota_full2_nc_0/stage2_0/m1_3966_n5928# 2.092590e-17
C5742 eeg_sdm1ct_0/eeg_fd_ota_full2_nc_0/stage2_0/m1_25941_n8557# VSS 4.190540e-16
C5743 eeg_sdm1ct_0/eeg_fd_ota_full2_nc_0/stage2_0/m1_25941_n8557# eeg_sdm1ct_0/eeg_fd_ota_full2_nc_0/stage2_0/m1_26741_n8557# 6.789040e-17
C5745 eeg_sdm1ct_0/eeg_fd_ota_full2_nc_0/stage2_0/m1_26341_n15864# VSS 4.190540e-16
C5746 eeg_sdm1ct_0/eeg_fd_ota_full2_nc_0/stage2_0/m1_26341_n15864# eeg_sdm1ct_0/eeg_fd_ota_full2_nc_0/stage2_0/m1_27141_n15864# 6.789049e-17
C5747 eeg_sdm1ct_0/eeg_fd_ota_full2_nc_0/stage2_0/m1_26341_n15864# eeg_sdm1ct_0/eeg_fd_ota_full2_nc_0/stage2_0/m1_3966_n5928# 2.092590e-17
C5748 eeg_sdm1ct_0/eeg_fd_ota_full2_nc_0/stage2_0/m1_26741_n8557# VSS 4.190540e-16
C5749 eeg_sdm1ct_0/eeg_fd_ota_full2_nc_0/stage2_0/m1_26741_n8557# eeg_sdm1ct_0/eeg_fd_ota_full2_nc_0/stage2_0/m1_27541_n8557# 6.789040e-17
C5751 eeg_sdm1ct_0/eeg_fd_ota_full2_nc_0/stage2_0/m1_27141_n15864# VSS 4.190540e-16
C5752 eeg_sdm1ct_0/eeg_fd_ota_full2_nc_0/stage2_0/m1_27141_n15864# eeg_sdm1ct_0/eeg_fd_ota_full2_nc_0/stage2_0/m1_27941_n15864# 6.789049e-17
C5753 eeg_sdm1ct_0/eeg_fd_ota_full2_nc_0/stage2_0/m1_27141_n15864# eeg_sdm1ct_0/eeg_fd_ota_full2_nc_0/stage2_0/m1_3966_n5928# 2.092590e-17
C5754 eeg_sdm1ct_0/eeg_fd_ota_full2_nc_0/stage2_0/m1_27541_n8557# VSS 4.190540e-16
C5755 eeg_sdm1ct_0/eeg_fd_ota_full2_nc_0/stage2_0/m1_27541_n8557# eeg_sdm1ct_0/eeg_fd_ota_full2_nc_0/stage2_0/m1_28341_n8557# 6.789040e-17
C5757 eeg_sdm1ct_0/eeg_fd_ota_full2_nc_0/stage2_0/m1_27941_n15864# VSS 4.190540e-16
C5758 eeg_sdm1ct_0/eeg_fd_ota_full2_nc_0/stage2_0/m1_27941_n15864# eeg_sdm1ct_0/eeg_fd_ota_full2_nc_0/stage2_0/m1_28741_n15864# 6.789049e-17
C5759 eeg_sdm1ct_0/eeg_fd_ota_full2_nc_0/stage2_0/m1_27941_n15864# eeg_sdm1ct_0/eeg_fd_ota_full2_nc_0/stage2_0/m1_3966_n5928# 2.092590e-17
C5760 eeg_sdm1ct_0/eeg_fd_ota_full2_nc_0/stage2_0/m1_28341_n8557# VSS 4.190540e-16
C5761 eeg_sdm1ct_0/eeg_fd_ota_full2_nc_0/stage2_0/m1_28341_n8557# eeg_sdm1ct_0/eeg_fd_ota_full2_nc_0/stage2_0/m1_29141_n8557# 6.789044e-17
C5763 eeg_sdm1ct_0/eeg_fd_ota_full2_nc_0/stage2_0/m1_28741_n15864# VSS 4.190540e-16
C5764 eeg_sdm1ct_0/eeg_fd_ota_full2_nc_0/stage2_0/m1_28741_n15864# eeg_sdm1ct_0/eeg_fd_ota_full2_nc_0/stage2_0/m1_29541_n15864# 6.789049e-17
C5765 eeg_sdm1ct_0/eeg_fd_ota_full2_nc_0/stage2_0/m1_28741_n15864# eeg_sdm1ct_0/eeg_fd_ota_full2_nc_0/stage2_0/m1_3966_n5928# 2.366810e-17
C5766 eeg_sdm1ct_0/eeg_fd_ota_full2_nc_0/stage2_0/m1_29141_n8557# VSS 4.190540e-16
C5767 eeg_sdm1ct_0/eeg_fd_ota_full2_nc_0/stage2_0/m1_29141_n8557# eeg_sdm1ct_0/eeg_fd_ota_full2_nc_0/stage2_0/m1_29941_n8557# 6.789040e-17
C5769 eeg_sdm1ct_0/eeg_fd_ota_full2_nc_0/stage2_0/m1_29541_n15864# VSS 4.190540e-16
C5770 eeg_sdm1ct_0/eeg_fd_ota_full2_nc_0/stage2_0/m1_29541_n15864# eeg_sdm1ct_0/eeg_fd_ota_full2_nc_0/stage2_0/m1_30341_n15864# 6.789049e-17
C5771 eeg_sdm1ct_0/eeg_fd_ota_full2_nc_0/stage2_0/m1_29541_n15864# eeg_sdm1ct_0/eeg_fd_ota_full2_nc_0/stage2_0/m1_3966_n5928# 3.847050e-17
C5772 eeg_sdm1ct_0/eeg_fd_ota_full2_nc_0/stage2_0/m1_29941_n8557# VSS 4.190540e-16
C5773 eeg_sdm1ct_0/eeg_fd_ota_full2_nc_0/stage2_0/m1_29941_n8557# eeg_sdm1ct_0/eeg_fd_ota_full2_nc_0/stage2_0/m1_30741_n8557# 6.789040e-17
C5774 eeg_sdm1ct_0/eeg_fd_ota_full2_nc_0/stage2_0/m1_29941_n8557# eeg_sdm1ct_0/eeg_fd_ota_full2_nc_0/stage2_0/m1_3966_n5928# 3.505816e-17
C5775 eeg_sdm1ct_0/eeg_fd_ota_full2_nc_0/stage2_0/m1_30341_n15864# VSS 4.190540e-16
C5776 eeg_sdm1ct_0/eeg_fd_ota_full2_nc_0/stage2_0/m1_30341_n15864# eeg_sdm1ct_0/eeg_fd_ota_full2_nc_0/stage2_0/m1_31141_n15864# 6.789049e-17
C5777 eeg_sdm1ct_0/eeg_fd_ota_full2_nc_0/stage2_0/m1_30341_n15864# eeg_sdm1ct_0/eeg_fd_ota_full2_nc_0/stage2_0/m1_3966_n5928# 1.128845e-16
C5778 eeg_sdm1ct_0/eeg_fd_ota_full2_nc_0/stage2_0/m1_30741_n8557# VSS 4.190540e-16
C5779 eeg_sdm1ct_0/eeg_fd_ota_full2_nc_0/stage2_0/m1_30741_n8557# eeg_sdm1ct_0/eeg_fd_ota_full2_nc_0/stage2_0/m1_31541_n8557# 6.789040e-17
C5780 eeg_sdm1ct_0/eeg_fd_ota_full2_nc_0/stage2_0/m1_30741_n8557# eeg_sdm1ct_0/eeg_fd_ota_full2_nc_0/stage2_0/m1_3966_n5928# 1.758861e-16
C5781 eeg_sdm1ct_0/eeg_fd_ota_full2_nc_0/stage2_0/m1_31141_n15864# VSS 4.190540e-16
C5782 eeg_sdm1ct_0/eeg_fd_ota_full2_nc_0/stage2_0/m1_31141_n15864# eeg_sdm1ct_0/eeg_fd_ota_full2_nc_0/stage2_0/m1_31941_n15864# 6.789059e-17
C5783 eeg_sdm1ct_0/eeg_fd_ota_full2_nc_0/stage2_0/m1_31141_n15864# eeg_sdm1ct_0/eeg_fd_ota_full2_nc_0/stage2_0/m1_3966_n5928# 1.128845e-16
C5784 eeg_sdm1ct_0/eeg_fd_ota_full2_nc_0/stage2_0/m1_31541_n8557# VSS 4.190540e-16
C5785 eeg_sdm1ct_0/eeg_fd_ota_full2_nc_0/stage2_0/m1_31541_n8557# eeg_sdm1ct_0/eeg_fd_ota_full2_nc_0/stage2_0/m1_32341_n8557# 6.789040e-17
C5786 eeg_sdm1ct_0/eeg_fd_ota_full2_nc_0/stage2_0/m1_31541_n8557# eeg_sdm1ct_0/eeg_fd_ota_full2_nc_0/stage2_0/m1_3966_n5928# 3.343551e-17
C5787 eeg_sdm1ct_0/eeg_fd_ota_full2_nc_0/stage2_0/m1_31941_n15864# VSS 4.190540e-16
C5788 eeg_sdm1ct_0/eeg_fd_ota_full2_nc_0/stage2_0/m1_31941_n15864# eeg_sdm1ct_0/eeg_fd_ota_full2_nc_0/stage2_0/m1_32741_n15864# 6.789049e-17
C5789 eeg_sdm1ct_0/eeg_fd_ota_full2_nc_0/stage2_0/m1_31941_n15864# eeg_sdm1ct_0/eeg_fd_ota_full2_nc_0/stage2_0/m1_3966_n5928# 3.847050e-17
C5790 eeg_sdm1ct_0/eeg_fd_ota_full2_nc_0/stage2_0/m1_32341_n8557# VSS 4.190540e-16
C5791 eeg_sdm1ct_0/eeg_fd_ota_full2_nc_0/stage2_0/m1_32341_n8557# eeg_sdm1ct_0/eeg_fd_ota_full2_nc_0/stage2_0/m1_33141_n8557# 6.789040e-17
C5793 eeg_sdm1ct_0/eeg_fd_ota_full2_nc_0/stage2_0/m1_32741_n15864# VSS 4.190540e-16
C5794 eeg_sdm1ct_0/eeg_fd_ota_full2_nc_0/stage2_0/m1_32741_n15864# eeg_sdm1ct_0/eeg_fd_ota_full2_nc_0/stage2_0/m1_33541_n15864# 6.789049e-17
C5795 eeg_sdm1ct_0/eeg_fd_ota_full2_nc_0/stage2_0/m1_32741_n15864# eeg_sdm1ct_0/eeg_fd_ota_full2_nc_0/stage2_0/m1_3966_n5928# 2.366810e-17
C5796 eeg_sdm1ct_0/eeg_fd_ota_full2_nc_0/stage2_0/m1_33141_n8557# VSS 4.190540e-16
C5797 eeg_sdm1ct_0/eeg_fd_ota_full2_nc_0/stage2_0/m1_33141_n8557# eeg_sdm1ct_0/eeg_fd_ota_full2_nc_0/stage2_0/m1_33941_n8557# 6.789040e-17
C5798 eeg_sdm1ct_0/eeg_fd_ota_full2_nc_0/stage2_0/m1_33541_n15864# VSS 4.190540e-16
C5799 eeg_sdm1ct_0/eeg_fd_ota_full2_nc_0/stage2_0/m1_33541_n15864# eeg_sdm1ct_0/eeg_fd_ota_full2_nc_0/stage2_0/m1_34341_n15864# 6.789049e-17
C5800 eeg_sdm1ct_0/eeg_fd_ota_full2_nc_0/stage2_0/m1_33541_n15864# eeg_sdm1ct_0/eeg_fd_ota_full2_nc_0/stage2_0/m1_3966_n5928# 2.092590e-17
C5801 eeg_sdm1ct_0/eeg_fd_ota_full2_nc_0/stage2_0/m1_33941_n8557# VSS 4.190540e-16
C5802 eeg_sdm1ct_0/eeg_fd_ota_full2_nc_0/stage2_0/m1_33941_n8557# eeg_sdm1ct_0/eeg_fd_ota_full2_nc_0/stage2_0/m1_34741_n8557# 6.789044e-17
C5803 eeg_sdm1ct_0/eeg_fd_ota_full2_nc_0/stage2_0/m1_34341_n15864# VSS 4.190540e-16
C5804 eeg_sdm1ct_0/eeg_fd_ota_full2_nc_0/stage2_0/m1_34341_n15864# eeg_sdm1ct_0/eeg_fd_ota_full2_nc_0/stage2_0/m1_35141_n15864# 6.789049e-17
C5805 eeg_sdm1ct_0/eeg_fd_ota_full2_nc_0/stage2_0/m1_34341_n15864# eeg_sdm1ct_0/eeg_fd_ota_full2_nc_0/stage2_0/m1_3966_n5928# 2.092590e-17
C5806 eeg_sdm1ct_0/eeg_fd_ota_full2_nc_0/stage2_0/m1_34741_n8557# VSS 4.190540e-16
C5807 eeg_sdm1ct_0/eeg_fd_ota_full2_nc_0/stage2_0/m1_34741_n8557# eeg_sdm1ct_0/eeg_fd_ota_full2_nc_0/stage2_0/m1_35541_n8557# 6.789040e-17
C5808 eeg_sdm1ct_0/eeg_fd_ota_full2_nc_0/stage2_0/m1_35141_n15864# VSS 4.190540e-16
C5809 eeg_sdm1ct_0/eeg_fd_ota_full2_nc_0/stage2_0/m1_35141_n15864# eeg_sdm1ct_0/eeg_fd_ota_full2_nc_0/stage2_0/m1_35941_n15864# 6.789049e-17
C5810 eeg_sdm1ct_0/eeg_fd_ota_full2_nc_0/stage2_0/m1_35141_n15864# eeg_sdm1ct_0/eeg_fd_ota_full2_nc_0/stage2_0/m1_3966_n5928# 2.092590e-17
C5811 eeg_sdm1ct_0/eeg_fd_ota_full2_nc_0/stage2_0/m1_35541_n8557# VSS 4.190540e-16
C5812 eeg_sdm1ct_0/eeg_fd_ota_full2_nc_0/stage2_0/m1_35541_n8557# eeg_sdm1ct_0/eeg_fd_ota_full2_nc_0/stage2_0/m1_36341_n8557# 6.789040e-17
C5813 eeg_sdm1ct_0/eeg_fd_ota_full2_nc_0/stage2_0/m1_35941_n15864# VSS 4.190540e-16
C5814 eeg_sdm1ct_0/eeg_fd_ota_full2_nc_0/stage2_0/m1_35941_n15864# eeg_sdm1ct_0/eeg_fd_ota_full2_nc_0/stage2_0/m1_36741_n15864# 6.789049e-17
C5815 eeg_sdm1ct_0/eeg_fd_ota_full2_nc_0/stage2_0/m1_35941_n15864# eeg_sdm1ct_0/eeg_fd_ota_full2_nc_0/stage2_0/m1_3966_n5928# 2.092590e-17
C5816 eeg_sdm1ct_0/eeg_fd_ota_full2_nc_0/stage2_0/m1_36341_n8557# VSS 4.190540e-16
C5817 eeg_sdm1ct_0/eeg_fd_ota_full2_nc_0/stage2_0/m1_36341_n8557# eeg_sdm1ct_0/eeg_fd_ota_full2_nc_0/stage2_0/m1_37141_n8557# 6.789040e-17
C5818 eeg_sdm1ct_0/eeg_fd_ota_full2_nc_0/stage2_0/m1_36741_n15864# VSS 4.190540e-16
C5819 eeg_sdm1ct_0/eeg_fd_ota_full2_nc_0/stage2_0/m1_36741_n15864# eeg_sdm1ct_0/eeg_fd_ota_full2_nc_0/stage2_0/m1_37541_n15864# 6.789059e-17
C5820 eeg_sdm1ct_0/eeg_fd_ota_full2_nc_0/stage2_0/m1_36741_n15864# eeg_sdm1ct_0/eeg_fd_ota_full2_nc_0/stage2_0/m1_3966_n5928# 2.092590e-17
C5821 eeg_sdm1ct_0/eeg_fd_ota_full2_nc_0/stage2_0/m1_37141_n8557# VSS 4.190540e-16
C5822 eeg_sdm1ct_0/eeg_fd_ota_full2_nc_0/stage2_0/m1_37141_n8557# eeg_sdm1ct_0/eeg_fd_ota_full2_nc_0/stage2_0/m1_37941_n8557# 6.789040e-17
C5823 eeg_sdm1ct_0/eeg_fd_ota_full2_nc_0/stage2_0/m1_37541_n15864# VSS 4.190540e-16
C5824 eeg_sdm1ct_0/eeg_fd_ota_full2_nc_0/stage2_0/m1_37541_n15864# eeg_sdm1ct_0/eeg_fd_ota_full2_nc_0/stage2_0/m1_38341_n15864# 6.789049e-17
C5825 eeg_sdm1ct_0/eeg_fd_ota_full2_nc_0/stage2_0/m1_37541_n15864# eeg_sdm1ct_0/eeg_fd_ota_full2_nc_0/stage2_0/m1_3966_n5928# 2.092590e-17
C5826 eeg_sdm1ct_0/eeg_fd_ota_full2_nc_0/stage2_0/m1_37941_n8557# VSS 4.190540e-16
C5827 eeg_sdm1ct_0/eeg_fd_ota_full2_nc_0/stage2_0/m1_37941_n8557# eeg_sdm1ct_0/eeg_fd_ota_full2_nc_0/stage2_0/m1_38741_n8557# 6.789040e-17
C5828 eeg_sdm1ct_0/eeg_fd_ota_full2_nc_0/stage2_0/m1_38341_n15864# VSS 4.190540e-16
C5829 eeg_sdm1ct_0/eeg_fd_ota_full2_nc_0/stage2_0/m1_38341_n15864# eeg_sdm1ct_0/eeg_fd_ota_full2_nc_0/stage2_0/m1_39141_n15864# 6.789049e-17
C5830 eeg_sdm1ct_0/eeg_fd_ota_full2_nc_0/stage2_0/m1_38341_n15864# eeg_sdm1ct_0/eeg_fd_ota_full2_nc_0/stage2_0/m1_3966_n5928# 2.092590e-17
C5831 eeg_sdm1ct_0/eeg_fd_ota_full2_nc_0/stage2_0/m1_38741_n8557# VSS 4.623640e-16
C5832 eeg_sdm1ct_0/eeg_fd_ota_full2_nc_0/stage2_0/m1_39141_n15864# VSS 4.702790e-16
C5833 eeg_sdm1ct_0/eeg_fd_ota_full2_nc_0/stage2_0/m1_39141_n15864# eeg_sdm1ct_0/eeg_fd_ota_full2_nc_0/stage2_0/m1_3966_n5928# 2.092590e-17
C5834 eeg_sdm1ct_0/eeg_fd_ota_full2_nc_0/stage2_0/m1_3966_n5928# VSS 2.574590e-14
C5836 eeg_sdm1ct_0/eeg_fd_ota_full2_nc_0/stage2_0/m1_41941_n15864# VSS 4.702790e-16
C5837 eeg_sdm1ct_0/eeg_fd_ota_full2_nc_0/stage2_0/m1_41941_n15864# eeg_sdm1ct_0/eeg_fd_ota_full2_nc_0/stage2_0/m1_42741_n15864# 6.789049e-17
C5838 eeg_sdm1ct_0/eeg_fd_ota_full2_nc_0/stage2_0/m1_42341_n8557# VSS 4.623640e-16
C5839 eeg_sdm1ct_0/eeg_fd_ota_full2_nc_0/stage2_0/m1_42341_n8557# eeg_sdm1ct_0/eeg_fd_ota_full2_nc_0/stage2_0/m1_43141_n8557# 6.789044e-17
C5840 eeg_sdm1ct_0/eeg_fd_ota_full2_nc_0/stage2_0/m1_42741_n15864# VSS 4.190540e-16
C5841 eeg_sdm1ct_0/eeg_fd_ota_full2_nc_0/stage2_0/m1_42741_n15864# eeg_sdm1ct_0/eeg_fd_ota_full2_nc_0/stage2_0/m1_43541_n15864# 6.789049e-17
C5842 eeg_sdm1ct_0/eeg_fd_ota_full2_nc_0/stage2_0/m1_43141_n8557# VSS 4.190540e-16
C5843 eeg_sdm1ct_0/eeg_fd_ota_full2_nc_0/stage2_0/m1_43141_n8557# eeg_sdm1ct_0/eeg_fd_ota_full2_nc_0/stage2_0/m1_43941_n8557# 6.789040e-17
C5844 eeg_sdm1ct_0/eeg_fd_ota_full2_nc_0/stage2_0/m1_43541_n15864# VSS 4.190540e-16
C5845 eeg_sdm1ct_0/eeg_fd_ota_full2_nc_0/stage2_0/m1_43541_n15864# eeg_sdm1ct_0/eeg_fd_ota_full2_nc_0/stage2_0/m1_44341_n15864# 6.789049e-17
C5846 eeg_sdm1ct_0/eeg_fd_ota_full2_nc_0/stage2_0/m1_43941_n8557# VSS 4.190540e-16
C5847 eeg_sdm1ct_0/eeg_fd_ota_full2_nc_0/stage2_0/m1_43941_n8557# eeg_sdm1ct_0/eeg_fd_ota_full2_nc_0/stage2_0/m1_44741_n8557# 6.789040e-17
C5848 eeg_sdm1ct_0/eeg_fd_ota_full2_nc_0/stage2_0/m1_44341_n15864# VSS 4.190540e-16
C5849 eeg_sdm1ct_0/eeg_fd_ota_full2_nc_0/stage2_0/m1_44341_n15864# eeg_sdm1ct_0/eeg_fd_ota_full2_nc_0/stage2_0/m1_45141_n15864# 6.789049e-17
C5850 eeg_sdm1ct_0/eeg_fd_ota_full2_nc_0/stage2_0/m1_44741_n8557# VSS 4.190540e-16
C5851 eeg_sdm1ct_0/eeg_fd_ota_full2_nc_0/stage2_0/m1_44741_n8557# eeg_sdm1ct_0/eeg_fd_ota_full2_nc_0/stage2_0/m1_45541_n8557# 6.789040e-17
C5852 eeg_sdm1ct_0/eeg_fd_ota_full2_nc_0/stage2_0/m1_45141_n15864# VSS 4.190540e-16
C5853 eeg_sdm1ct_0/eeg_fd_ota_full2_nc_0/stage2_0/m1_45141_n15864# eeg_sdm1ct_0/eeg_fd_ota_full2_nc_0/stage2_0/m1_45941_n15864# 6.789059e-17
C5854 eeg_sdm1ct_0/eeg_fd_ota_full2_nc_0/stage2_0/m1_45541_n8557# VSS 4.190540e-16
C5855 eeg_sdm1ct_0/eeg_fd_ota_full2_nc_0/stage2_0/m1_45541_n8557# eeg_sdm1ct_0/eeg_fd_ota_full2_nc_0/stage2_0/m1_46341_n8557# 6.789040e-17
C5856 eeg_sdm1ct_0/eeg_fd_ota_full2_nc_0/stage2_0/m1_45941_n15864# VSS 4.190540e-16
C5857 eeg_sdm1ct_0/eeg_fd_ota_full2_nc_0/stage2_0/m1_45941_n15864# eeg_sdm1ct_0/eeg_fd_ota_full2_nc_0/stage2_0/m1_46741_n15864# 6.789049e-17
C5858 eeg_sdm1ct_0/eeg_fd_ota_full2_nc_0/stage2_0/m1_46341_n8557# VSS 4.190540e-16
C5859 eeg_sdm1ct_0/eeg_fd_ota_full2_nc_0/stage2_0/m1_46341_n8557# eeg_sdm1ct_0/eeg_fd_ota_full2_nc_0/stage2_0/m1_47141_n8557# 6.789040e-17
C5860 eeg_sdm1ct_0/eeg_fd_ota_full2_nc_0/stage2_0/m1_46741_n15864# VSS 4.190540e-16
C5861 eeg_sdm1ct_0/eeg_fd_ota_full2_nc_0/stage2_0/m1_46741_n15864# eeg_sdm1ct_0/eeg_fd_ota_full2_nc_0/stage2_0/m1_47541_n15864# 6.789049e-17
C5862 eeg_sdm1ct_0/eeg_fd_ota_full2_nc_0/stage2_0/m1_47141_n8557# VSS 4.190540e-16
C5863 eeg_sdm1ct_0/eeg_fd_ota_full2_nc_0/stage2_0/m1_47141_n8557# eeg_sdm1ct_0/eeg_fd_ota_full2_nc_0/stage2_0/m1_47941_n8557# 6.789040e-17
C5864 eeg_sdm1ct_0/eeg_fd_ota_full2_nc_0/stage2_0/m1_47541_n15864# VSS 4.190540e-16
C5865 eeg_sdm1ct_0/eeg_fd_ota_full2_nc_0/stage2_0/m1_47541_n15864# eeg_sdm1ct_0/eeg_fd_ota_full2_nc_0/stage2_0/m1_48341_n15864# 6.789049e-17
C5866 eeg_sdm1ct_0/eeg_fd_ota_full2_nc_0/stage2_0/m1_47941_n8557# VSS 4.190540e-16
C5867 eeg_sdm1ct_0/eeg_fd_ota_full2_nc_0/stage2_0/m1_47941_n8557# eeg_sdm1ct_0/eeg_fd_ota_full2_nc_0/stage2_0/m1_48741_n8557# 6.789044e-17
C5868 eeg_sdm1ct_0/eeg_fd_ota_full2_nc_0/stage2_0/m1_48341_n15864# VSS 4.190540e-16
C5869 eeg_sdm1ct_0/eeg_fd_ota_full2_nc_0/stage2_0/m1_48341_n15864# eeg_sdm1ct_0/eeg_fd_ota_full2_nc_0/stage2_0/m1_49141_n15864# 6.789049e-17
C5870 eeg_sdm1ct_0/eeg_fd_ota_full2_nc_0/stage2_0/m1_48741_n8557# VSS 4.190540e-16
C5871 eeg_sdm1ct_0/eeg_fd_ota_full2_nc_0/stage2_0/m1_48741_n8557# eeg_sdm1ct_0/eeg_fd_ota_full2_nc_0/stage2_0/m1_49541_n8557# 6.789040e-17
C5872 eeg_sdm1ct_0/eeg_fd_ota_full2_nc_0/stage2_0/m1_49141_n15864# VSS 4.190540e-16
C5873 eeg_sdm1ct_0/eeg_fd_ota_full2_nc_0/stage2_0/m1_49141_n15864# eeg_sdm1ct_0/eeg_fd_ota_full2_nc_0/stage2_0/m1_49941_n15864# 6.789049e-17
C5874 eeg_sdm1ct_0/eeg_fd_ota_full2_nc_0/stage2_0/m1_49541_n8557# VSS 4.190540e-16
C5875 eeg_sdm1ct_0/eeg_fd_ota_full2_nc_0/stage2_0/m1_49541_n8557# eeg_sdm1ct_0/eeg_fd_ota_full2_nc_0/stage2_0/m1_50341_n8557# 6.789040e-17
C5876 eeg_sdm1ct_0/eeg_fd_ota_full2_nc_0/stage2_0/m1_49941_n15864# VSS 4.190540e-16
C5877 eeg_sdm1ct_0/eeg_fd_ota_full2_nc_0/stage2_0/m1_49941_n15864# eeg_sdm1ct_0/eeg_fd_ota_full2_nc_0/stage2_0/m1_50741_n15864# 6.789049e-17
C5878 eeg_sdm1ct_0/eeg_fd_ota_full2_nc_0/stage2_0/m1_50341_n8557# VSS 4.190540e-16
C5879 eeg_sdm1ct_0/eeg_fd_ota_full2_nc_0/stage2_0/m1_50341_n8557# eeg_sdm1ct_0/eeg_fd_ota_full2_nc_0/stage2_0/m1_51141_n8557# 6.789040e-17
C5880 eeg_sdm1ct_0/eeg_fd_ota_full2_nc_0/stage2_0/m1_50741_n15864# VSS 4.190540e-16
C5881 eeg_sdm1ct_0/eeg_fd_ota_full2_nc_0/stage2_0/m1_50741_n15864# eeg_sdm1ct_0/eeg_fd_ota_full2_nc_0/stage2_0/m1_51541_n15864# 6.789059e-17
C5882 eeg_sdm1ct_0/eeg_fd_ota_full2_nc_0/stage2_0/m1_51141_n8557# VSS 4.190540e-16
C5883 eeg_sdm1ct_0/eeg_fd_ota_full2_nc_0/stage2_0/m1_51141_n8557# eeg_sdm1ct_0/eeg_fd_ota_full2_nc_0/stage2_0/m1_51941_n8557# 6.789040e-17
C5884 eeg_sdm1ct_0/eeg_fd_ota_full2_nc_0/stage2_0/m1_51541_n15864# VSS 4.190540e-16
C5885 eeg_sdm1ct_0/eeg_fd_ota_full2_nc_0/stage2_0/m1_51541_n15864# eeg_sdm1ct_0/eeg_fd_ota_full2_nc_0/stage2_0/m1_52341_n15864# 6.789049e-17
C5886 eeg_sdm1ct_0/eeg_fd_ota_full2_nc_0/stage2_0/m1_51941_n8557# VSS 4.190540e-16
C5887 eeg_sdm1ct_0/eeg_fd_ota_full2_nc_0/stage2_0/m1_51941_n8557# eeg_sdm1ct_0/eeg_fd_ota_full2_nc_0/stage2_0/m1_52741_n8557# 6.789040e-17
C5888 eeg_sdm1ct_0/eeg_fd_ota_full2_nc_0/stage2_0/m1_52341_n15864# VSS 4.190540e-16
C5889 eeg_sdm1ct_0/eeg_fd_ota_full2_nc_0/stage2_0/m1_52341_n15864# eeg_sdm1ct_0/eeg_fd_ota_full2_nc_0/stage2_0/m1_53141_n15864# 6.789049e-17
C5890 eeg_sdm1ct_0/eeg_fd_ota_full2_nc_0/stage2_0/m1_52741_n8557# VSS 4.190540e-16
C5891 eeg_sdm1ct_0/eeg_fd_ota_full2_nc_0/stage2_0/m1_52741_n8557# eeg_sdm1ct_0/eeg_fd_ota_full2_nc_0/stage2_0/m1_53541_n8557# 6.789040e-17
C5892 eeg_sdm1ct_0/eeg_fd_ota_full2_nc_0/stage2_0/m1_53141_n15864# VSS 4.190540e-16
C5893 eeg_sdm1ct_0/eeg_fd_ota_full2_nc_0/stage2_0/m1_53141_n15864# eeg_sdm1ct_0/eeg_fd_ota_full2_nc_0/stage2_0/m1_53941_n15864# 6.789049e-17
C5894 eeg_sdm1ct_0/eeg_fd_ota_full2_nc_0/stage2_0/m1_53541_n8557# VSS 4.190540e-16
C5895 eeg_sdm1ct_0/eeg_fd_ota_full2_nc_0/stage2_0/m1_53541_n8557# eeg_sdm1ct_0/eeg_fd_ota_full2_nc_0/stage2_0/m1_54341_n8557# 6.789044e-17
C5896 eeg_sdm1ct_0/eeg_fd_ota_full2_nc_0/stage2_0/m1_53941_n15864# VSS 4.190540e-16
C5897 eeg_sdm1ct_0/eeg_fd_ota_full2_nc_0/stage2_0/m1_53941_n15864# eeg_sdm1ct_0/eeg_fd_ota_full2_nc_0/stage2_0/m1_54741_n15864# 6.789049e-17
C5898 eeg_sdm1ct_0/eeg_fd_ota_full2_nc_0/stage2_0/m1_54341_n8557# VSS 4.190540e-16
C5899 eeg_sdm1ct_0/eeg_fd_ota_full2_nc_0/stage2_0/m1_54341_n8557# eeg_sdm1ct_0/eeg_fd_ota_full2_nc_0/stage2_0/m1_55141_n8557# 6.789040e-17
C5900 eeg_sdm1ct_0/eeg_fd_ota_full2_nc_0/stage2_0/m1_54741_n15864# VSS 4.190540e-16
C5901 eeg_sdm1ct_0/eeg_fd_ota_full2_nc_0/stage2_0/m1_54741_n15864# eeg_sdm1ct_0/eeg_fd_ota_full2_nc_0/stage2_0/m1_55541_n15864# 6.789049e-17
C5902 eeg_sdm1ct_0/eeg_fd_ota_full2_nc_0/stage2_0/m1_55141_n8557# VSS 4.190540e-16
C5903 eeg_sdm1ct_0/eeg_fd_ota_full2_nc_0/stage2_0/m1_55141_n8557# eeg_sdm1ct_0/eeg_fd_ota_full2_nc_0/stage2_0/m1_55941_n8557# 6.789040e-17
C5904 eeg_sdm1ct_0/eeg_fd_ota_full2_nc_0/stage2_0/m1_55541_n15864# VSS 4.190540e-16
C5905 eeg_sdm1ct_0/eeg_fd_ota_full2_nc_0/stage2_0/m1_55541_n15864# eeg_sdm1ct_0/eeg_fd_ota_full2_nc_0/stage2_0/m1_56341_n15864# 6.789049e-17
C5906 eeg_sdm1ct_0/eeg_fd_ota_full2_nc_0/stage2_0/m1_55941_n8557# VSS 4.190540e-16
C5907 eeg_sdm1ct_0/eeg_fd_ota_full2_nc_0/stage2_0/m1_55941_n8557# eeg_sdm1ct_0/eeg_fd_ota_full2_nc_0/stage2_0/m1_56741_n8557# 6.789040e-17
C5908 eeg_sdm1ct_0/eeg_fd_ota_full2_nc_0/stage2_0/m1_56341_n15864# VSS 4.190540e-16
C5909 eeg_sdm1ct_0/eeg_fd_ota_full2_nc_0/stage2_0/m1_56341_n15864# eeg_sdm1ct_0/eeg_fd_ota_full2_nc_0/stage2_0/m1_57141_n15864# 6.789059e-17
C5910 eeg_sdm1ct_0/eeg_fd_ota_full2_nc_0/stage2_0/m1_56741_n8557# VSS 4.190540e-16
C5911 eeg_sdm1ct_0/eeg_fd_ota_full2_nc_0/stage2_0/m1_56741_n8557# eeg_sdm1ct_0/eeg_fd_ota_full2_nc_0/stage2_0/m1_57541_n8557# 6.789040e-17
C5912 eeg_sdm1ct_0/eeg_fd_ota_full2_nc_0/stage2_0/m1_57141_n15864# VSS 4.190540e-16
C5913 eeg_sdm1ct_0/eeg_fd_ota_full2_nc_0/stage2_0/m1_57141_n15864# eeg_sdm1ct_0/eeg_fd_ota_full2_nc_0/stage2_0/m1_57941_n15864# 6.789049e-17
C5914 eeg_sdm1ct_0/eeg_fd_ota_full2_nc_0/stage2_0/m1_57541_n8557# VSS 4.190540e-16
C5915 eeg_sdm1ct_0/eeg_fd_ota_full2_nc_0/stage2_0/m1_57541_n8557# eeg_sdm1ct_0/eeg_fd_ota_full2_nc_0/stage2_0/m1_58341_n8557# 6.789040e-17
C5916 eeg_sdm1ct_0/eeg_fd_ota_full2_nc_0/stage2_0/m1_57941_n15864# VSS 4.190540e-16
C5917 eeg_sdm1ct_0/eeg_fd_ota_full2_nc_0/stage2_0/m1_57941_n15864# eeg_sdm1ct_0/eeg_fd_ota_full2_nc_0/stage2_0/m1_58741_n15864# 6.789049e-17
C5918 eeg_sdm1ct_0/eeg_fd_ota_full2_nc_0/stage2_0/m1_58341_n8557# VSS 4.190540e-16
C5919 eeg_sdm1ct_0/eeg_fd_ota_full2_nc_0/stage2_0/m1_58341_n8557# eeg_sdm1ct_0/eeg_fd_ota_full2_nc_0/stage2_0/m1_59141_n8557# 6.789040e-17
C5920 eeg_sdm1ct_0/eeg_fd_ota_full2_nc_0/stage2_0/m1_58741_n15864# VSS 4.190540e-16
C5921 eeg_sdm1ct_0/eeg_fd_ota_full2_nc_0/stage2_0/m1_58741_n15864# eeg_sdm1ct_0/eeg_fd_ota_full2_nc_0/stage2_0/m1_59541_n15864# 6.789049e-17
C5922 eeg_sdm1ct_0/eeg_fd_ota_full2_nc_0/stage2_0/m1_59141_n8557# VSS 4.190540e-16
C5923 eeg_sdm1ct_0/eeg_fd_ota_full2_nc_0/stage2_0/m1_59141_n8557# eeg_sdm1ct_0/eeg_fd_ota_full2_nc_0/stage2_0/m1_59941_n8557# 6.789044e-17
C5924 eeg_sdm1ct_0/eeg_fd_ota_full2_nc_0/stage2_0/m1_59541_n15864# VSS 4.190540e-16
C5925 eeg_sdm1ct_0/eeg_fd_ota_full2_nc_0/stage2_0/m1_59541_n15864# eeg_sdm1ct_0/eeg_fd_ota_full2_nc_0/stage2_0/m1_60341_n15864# 6.789049e-17
C5926 eeg_sdm1ct_0/eeg_fd_ota_full2_nc_0/stage2_0/m1_59941_n8557# VSS 4.190540e-16
C5927 eeg_sdm1ct_0/eeg_fd_ota_full2_nc_0/stage2_0/m1_59941_n8557# eeg_sdm1ct_0/eeg_fd_ota_full2_nc_0/stage2_0/m1_60741_n8557# 6.789040e-17
C5928 eeg_sdm1ct_0/eeg_fd_ota_full2_nc_0/stage2_0/m1_60341_n15864# VSS 4.190540e-16
C5929 eeg_sdm1ct_0/eeg_fd_ota_full2_nc_0/stage2_0/m1_60341_n15864# eeg_sdm1ct_0/eeg_fd_ota_full2_nc_0/stage2_0/m1_61141_n15864# 6.789049e-17
C5930 eeg_sdm1ct_0/eeg_fd_ota_full2_nc_0/stage2_0/m1_60741_n8557# VSS 4.623640e-16
C5931 eeg_sdm1ct_0/eeg_fd_ota_full2_nc_0/stage2_0/m1_61141_n15864# VSS 4.702790e-16
C5932 eeg_sdm1ct_0/eeg_fd_ota_full2_nc_0/stage2_0/m1_63941_n15864# VSS 4.702790e-16
C5933 eeg_sdm1ct_0/eeg_fd_ota_full2_nc_0/stage2_0/m1_63941_n15864# eeg_sdm1ct_0/eeg_fd_ota_full2_nc_0/stage2_0/m1_64741_n15864# 6.789049e-17
C5934 eeg_sdm1ct_0/eeg_fd_ota_full2_nc_0/stage2_0/m1_64341_n8557# VSS 4.623640e-16
C5935 eeg_sdm1ct_0/eeg_fd_ota_full2_nc_0/stage2_0/m1_64341_n8557# eeg_sdm1ct_0/eeg_fd_ota_full2_nc_0/stage2_0/m1_65141_n8557# 6.789040e-17
C5936 eeg_sdm1ct_0/eeg_fd_ota_full2_nc_0/stage2_0/m1_64741_n15864# VSS 4.190540e-16
C5937 eeg_sdm1ct_0/eeg_fd_ota_full2_nc_0/stage2_0/m1_64741_n15864# eeg_sdm1ct_0/eeg_fd_ota_full2_nc_0/stage2_0/m1_65541_n15864# 6.789059e-17
C5938 eeg_sdm1ct_0/eeg_fd_ota_full2_nc_0/stage2_0/m1_65141_n8557# VSS 4.190540e-16
C5939 eeg_sdm1ct_0/eeg_fd_ota_full2_nc_0/stage2_0/m1_65141_n8557# eeg_sdm1ct_0/eeg_fd_ota_full2_nc_0/stage2_0/m1_65941_n8557# 6.789040e-17
C5940 eeg_sdm1ct_0/eeg_fd_ota_full2_nc_0/stage2_0/m1_65541_n15864# VSS 4.190540e-16
C5941 eeg_sdm1ct_0/eeg_fd_ota_full2_nc_0/stage2_0/m1_65541_n15864# eeg_sdm1ct_0/eeg_fd_ota_full2_nc_0/stage2_0/m1_66341_n15864# 6.789049e-17
C5942 eeg_sdm1ct_0/eeg_fd_ota_full2_nc_0/stage2_0/m1_65941_n8557# VSS 4.190540e-16
C5943 eeg_sdm1ct_0/eeg_fd_ota_full2_nc_0/stage2_0/m1_65941_n8557# eeg_sdm1ct_0/eeg_fd_ota_full2_nc_0/stage2_0/m1_66741_n8557# 6.789040e-17
C5944 eeg_sdm1ct_0/eeg_fd_ota_full2_nc_0/stage2_0/m1_66341_n15864# VSS 4.190540e-16
C5945 eeg_sdm1ct_0/eeg_fd_ota_full2_nc_0/stage2_0/m1_66341_n15864# eeg_sdm1ct_0/eeg_fd_ota_full2_nc_0/stage2_0/m1_67141_n15864# 6.789049e-17
C5946 eeg_sdm1ct_0/eeg_fd_ota_full2_nc_0/stage2_0/m1_66741_n8557# VSS 4.190540e-16
C5947 eeg_sdm1ct_0/eeg_fd_ota_full2_nc_0/stage2_0/m1_66741_n8557# eeg_sdm1ct_0/eeg_fd_ota_full2_nc_0/stage2_0/m1_67541_n8557# 6.789040e-17
C5948 eeg_sdm1ct_0/eeg_fd_ota_full2_nc_0/stage2_0/m1_67141_n15864# VSS 4.190540e-16
C5949 eeg_sdm1ct_0/eeg_fd_ota_full2_nc_0/stage2_0/m1_67141_n15864# eeg_sdm1ct_0/eeg_fd_ota_full2_nc_0/stage2_0/m1_67941_n15864# 6.789049e-17
C5950 eeg_sdm1ct_0/eeg_fd_ota_full2_nc_0/stage2_0/m1_67541_n8557# VSS 4.190540e-16
C5951 eeg_sdm1ct_0/eeg_fd_ota_full2_nc_0/stage2_0/m1_67541_n8557# eeg_sdm1ct_0/eeg_fd_ota_full2_nc_0/stage2_0/m1_68341_n8557# 6.789044e-17
C5952 eeg_sdm1ct_0/eeg_fd_ota_full2_nc_0/stage2_0/m1_67941_n15864# VSS 4.190540e-16
C5953 eeg_sdm1ct_0/eeg_fd_ota_full2_nc_0/stage2_0/m1_67941_n15864# eeg_sdm1ct_0/eeg_fd_ota_full2_nc_0/stage2_0/m1_68741_n15864# 6.789049e-17
C5954 eeg_sdm1ct_0/eeg_fd_ota_full2_nc_0/stage2_0/m1_68341_n8557# VSS 4.190540e-16
C5955 eeg_sdm1ct_0/eeg_fd_ota_full2_nc_0/stage2_0/m1_68341_n8557# eeg_sdm1ct_0/eeg_fd_ota_full2_nc_0/stage2_0/m1_69141_n8557# 6.789040e-17
C5956 eeg_sdm1ct_0/eeg_fd_ota_full2_nc_0/stage2_0/m1_68741_n15864# VSS 4.190540e-16
C5957 eeg_sdm1ct_0/eeg_fd_ota_full2_nc_0/stage2_0/m1_68741_n15864# eeg_sdm1ct_0/eeg_fd_ota_full2_nc_0/stage2_0/m1_69541_n15864# 6.789049e-17
C5958 eeg_sdm1ct_0/eeg_fd_ota_full2_nc_0/stage2_0/m1_69141_n8557# VSS 4.190540e-16
C5959 eeg_sdm1ct_0/eeg_fd_ota_full2_nc_0/stage2_0/m1_69141_n8557# eeg_sdm1ct_0/eeg_fd_ota_full2_nc_0/stage2_0/m1_69941_n8557# 6.789040e-17
C5960 eeg_sdm1ct_0/eeg_fd_ota_full2_nc_0/stage2_0/m1_69541_n15864# VSS 4.190540e-16
C5961 eeg_sdm1ct_0/eeg_fd_ota_full2_nc_0/stage2_0/m1_69541_n15864# eeg_sdm1ct_0/eeg_fd_ota_full2_nc_0/stage2_0/m1_70341_n15864# 6.789049e-17
C5962 eeg_sdm1ct_0/eeg_fd_ota_full2_nc_0/stage2_0/m1_69941_n8557# VSS 4.190540e-16
C5963 eeg_sdm1ct_0/eeg_fd_ota_full2_nc_0/stage2_0/m1_69941_n8557# eeg_sdm1ct_0/eeg_fd_ota_full2_nc_0/stage2_0/m1_70741_n8557# 6.789040e-17
C5964 eeg_sdm1ct_0/eeg_fd_ota_full2_nc_0/stage2_0/m1_70341_n15864# VSS 4.190540e-16
C5965 eeg_sdm1ct_0/eeg_fd_ota_full2_nc_0/stage2_0/m1_70341_n15864# eeg_sdm1ct_0/eeg_fd_ota_full2_nc_0/stage2_0/m1_71141_n15864# 6.789059e-17
C5966 eeg_sdm1ct_0/eeg_fd_ota_full2_nc_0/stage2_0/m1_70741_n8557# VSS 4.623640e-16
C5967 eeg_sdm1ct_0/eeg_fd_ota_full2_nc_0/stage2_0/m1_71141_n15864# VSS 4.702790e-16
C5968 eeg_sdm1ct_0/eeg_fd_ota_full2_nc_0/stage2_0/m1_73941_n15864# VSS 4.702790e-16
C5969 eeg_sdm1ct_0/eeg_fd_ota_full2_nc_0/stage2_0/m1_73941_n15864# eeg_sdm1ct_0/eeg_fd_ota_full2_nc_0/stage2_0/m1_74741_n15864# 6.789049e-17
C5970 eeg_sdm1ct_0/eeg_fd_ota_full2_nc_0/stage2_0/m1_74341_n8557# VSS 4.623640e-16
C5971 eeg_sdm1ct_0/eeg_fd_ota_full2_nc_0/stage2_0/m1_74341_n8557# eeg_sdm1ct_0/eeg_fd_ota_full2_nc_0/stage2_0/m1_75141_n8557# 6.789040e-17
C5972 eeg_sdm1ct_0/eeg_fd_ota_full2_nc_0/stage2_0/m1_74741_n15864# VSS 4.190540e-16
C5973 eeg_sdm1ct_0/eeg_fd_ota_full2_nc_0/stage2_0/m1_74741_n15864# eeg_sdm1ct_0/eeg_fd_ota_full2_nc_0/stage2_0/m1_75541_n15864# 6.789049e-17
C5974 eeg_sdm1ct_0/eeg_fd_ota_full2_nc_0/stage2_0/m1_75141_n8557# VSS 4.190540e-16
C5975 eeg_sdm1ct_0/eeg_fd_ota_full2_nc_0/stage2_0/m1_75141_n8557# eeg_sdm1ct_0/eeg_fd_ota_full2_nc_0/stage2_0/m1_75941_n8557# 6.789040e-17
C5976 eeg_sdm1ct_0/eeg_fd_ota_full2_nc_0/stage2_0/m1_75541_n15864# VSS 4.190540e-16
C5977 eeg_sdm1ct_0/eeg_fd_ota_full2_nc_0/stage2_0/m1_75541_n15864# eeg_sdm1ct_0/eeg_fd_ota_full2_nc_0/stage2_0/m1_76341_n15864# 6.789049e-17
C5978 eeg_sdm1ct_0/eeg_fd_ota_full2_nc_0/stage2_0/m1_75941_n8557# VSS 4.190540e-16
C5979 eeg_sdm1ct_0/eeg_fd_ota_full2_nc_0/stage2_0/m1_75941_n8557# eeg_sdm1ct_0/eeg_fd_ota_full2_nc_0/stage2_0/m1_76741_n8557# 6.789044e-17
C5980 eeg_sdm1ct_0/eeg_fd_ota_full2_nc_0/stage2_0/m1_76341_n15864# VSS 4.190540e-16
C5981 eeg_sdm1ct_0/eeg_fd_ota_full2_nc_0/stage2_0/m1_76341_n15864# eeg_sdm1ct_0/eeg_fd_ota_full2_nc_0/stage2_0/m1_77141_n15864# 6.789049e-17
C5982 eeg_sdm1ct_0/eeg_fd_ota_full2_nc_0/stage2_0/m1_76741_n8557# VSS 4.190540e-16
C5983 eeg_sdm1ct_0/eeg_fd_ota_full2_nc_0/stage2_0/m1_76741_n8557# eeg_sdm1ct_0/eeg_fd_ota_full2_nc_0/stage2_0/m1_77541_n8557# 6.789040e-17
C5984 eeg_sdm1ct_0/eeg_fd_ota_full2_nc_0/stage2_0/m1_77141_n15864# VSS 4.190540e-16
C5985 eeg_sdm1ct_0/eeg_fd_ota_full2_nc_0/stage2_0/m1_77141_n15864# eeg_sdm1ct_0/eeg_fd_ota_full2_nc_0/stage2_0/m1_77941_n15864# 6.789049e-17
C5986 eeg_sdm1ct_0/eeg_fd_ota_full2_nc_0/stage2_0/m1_77541_n8557# VSS 4.190540e-16
C5987 eeg_sdm1ct_0/eeg_fd_ota_full2_nc_0/stage2_0/m1_77541_n8557# eeg_sdm1ct_0/eeg_fd_ota_full2_nc_0/stage2_0/m1_78341_n8557# 6.789040e-17
C5988 eeg_sdm1ct_0/eeg_fd_ota_full2_nc_0/stage2_0/m1_77941_n15864# VSS 4.190540e-16
C5989 eeg_sdm1ct_0/eeg_fd_ota_full2_nc_0/stage2_0/m1_77941_n15864# eeg_sdm1ct_0/eeg_fd_ota_full2_nc_0/stage2_0/m1_78741_n15864# 6.789049e-17
C5990 eeg_sdm1ct_0/eeg_fd_ota_full2_nc_0/stage2_0/m1_78341_n8557# VSS 4.190540e-16
C5991 eeg_sdm1ct_0/eeg_fd_ota_full2_nc_0/stage2_0/m1_78341_n8557# eeg_sdm1ct_0/eeg_fd_ota_full2_nc_0/stage2_0/m1_79141_n8557# 6.789040e-17
C5992 eeg_sdm1ct_0/eeg_fd_ota_full2_nc_0/stage2_0/m1_78741_n15864# VSS 4.190540e-16
C5993 eeg_sdm1ct_0/eeg_fd_ota_full2_nc_0/stage2_0/m1_78741_n15864# eeg_sdm1ct_0/eeg_fd_ota_full2_nc_0/stage2_0/m1_79541_n15864# 6.789059e-17
C5994 eeg_sdm1ct_0/eeg_fd_ota_full2_nc_0/stage2_0/m1_79141_n8557# VSS 4.190540e-16
C5995 eeg_sdm1ct_0/eeg_fd_ota_full2_nc_0/stage2_0/m1_79141_n8557# eeg_sdm1ct_0/eeg_fd_ota_full2_nc_0/stage2_0/m1_79941_n8557# 6.789040e-17
C5996 eeg_sdm1ct_0/eeg_fd_ota_full2_nc_0/stage2_0/m1_79541_n15864# VSS 4.190540e-16
C5997 eeg_sdm1ct_0/eeg_fd_ota_full2_nc_0/stage2_0/m1_79541_n15864# eeg_sdm1ct_0/eeg_fd_ota_full2_nc_0/stage2_0/m1_80341_n15864# 6.789049e-17
C5998 eeg_sdm1ct_0/eeg_fd_ota_full2_nc_0/stage2_0/m1_79941_n8557# VSS 4.190540e-16
C5999 eeg_sdm1ct_0/eeg_fd_ota_full2_nc_0/stage2_0/m1_79941_n8557# eeg_sdm1ct_0/eeg_fd_ota_full2_nc_0/stage2_0/m1_80741_n8557# 6.789040e-17
C6000 eeg_sdm1ct_0/eeg_fd_ota_full2_nc_0/stage2_0/m1_80341_n15864# VSS 4.190540e-16
C6001 eeg_sdm1ct_0/eeg_fd_ota_full2_nc_0/stage2_0/m1_80341_n15864# eeg_sdm1ct_0/eeg_fd_ota_full2_nc_0/stage2_0/m1_81141_n15864# 6.789049e-17
C6002 eeg_sdm1ct_0/eeg_fd_ota_full2_nc_0/stage2_0/m1_80741_n8557# VSS 4.623640e-16
C6003 eeg_sdm1ct_0/eeg_fd_ota_full2_nc_0/stage2_0/m1_81141_n15864# VSS 4.702790e-16
C6004 eeg_sdm1ct_0/eeg_fd_ota_full2_nc_0/stage2_0/m1_58341_n8557# VSS 6.746650e-16
C6005 eeg_sdm1ct_0/eeg_fd_ota_full2_nc_0/stage2_0/m1_58741_n15864# VSS 6.746650e-16
C6006 eeg_sdm1ct_0/eeg_fd_ota_full2_nc_0/stage2_0/m1_24741_n15864# VSS 6.746650e-16
C6007 eeg_sdm1ct_0/eeg_fd_ota_full2_nc_0/stage2_0/m1_25141_n8557# VSS 6.746650e-16
C6008 eeg_sdm1ct_0/eeg_fd_ota_full2_nc_0/stage2_0/m1_20341_n8557# VSS 6.746650e-16
C6009 eeg_sdm1ct_0/eeg_fd_ota_full2_nc_0/stage2_0/m1_20741_n15864# VSS 6.746650e-16
C6010 eeg_sdm1ct_0/eeg_fd_ota_full2_nc_0/stage2_0/m1_35941_n15864# VSS 6.746650e-16
C6011 eeg_sdm1ct_0/eeg_fd_ota_full2_nc_0/stage2_0/m1_36341_n8557# VSS 6.746650e-16
C6012 eeg_sdm1ct_0/eeg_fd_ota_full2_nc_0/stage2_0/m1_79941_n8557# VSS 6.746650e-16
C6013 eeg_sdm1ct_0/eeg_fd_ota_full2_nc_0/stage2_0/m1_80341_n15864# VSS 6.746650e-16
C6014 eeg_sdm1ct_0/eeg_fd_ota_full2_nc_0/stage2_0/m1_75541_n15864# VSS 6.746650e-16
C6015 eeg_sdm1ct_0/eeg_fd_ota_full2_nc_0/stage2_0/m1_75941_n8557# VSS 6.746650e-16
C6016 eeg_sdm1ct_0/eeg_fd_ota_full2_nc_0/stage2_0/m1_69141_n8557# VSS 6.746650e-16
C6017 eeg_sdm1ct_0/eeg_fd_ota_full2_nc_0/stage2_0/m1_69541_n15864# VSS 6.746650e-16
C6018 eeg_sdm1ct_0/eeg_fd_ota_full2_nc_0/stage2_0/m1_64741_n15864# VSS 6.746650e-16
C6019 eeg_sdm1ct_0/eeg_fd_ota_full2_nc_0/stage2_0/m1_65141_n8557# VSS 6.746650e-16
C6020 eeg_sdm1ct_0/eeg_fd_ota_full2_nc_0/stage2_0/m1_57941_n15864# VSS 6.746650e-16
C6021 eeg_sdm1ct_0/eeg_fd_ota_full2_nc_0/stage2_0/m1_58341_n8557# VSS 6.746650e-16
C6022 eeg_sdm1ct_0/eeg_fd_ota_full2_nc_0/stage2_0/m1_28741_n15864# VSS 6.746650e-16
C6023 eeg_sdm1ct_0/eeg_fd_ota_full2_nc_0/stage2_0/m1_29141_n8557# VSS 6.746650e-16
C6024 eeg_sdm1ct_0/eeg_fd_ota_full2_nc_0/stage2_0/m1_24341_n8557# VSS 6.746650e-16
C6025 eeg_sdm1ct_0/eeg_fd_ota_full2_nc_0/stage2_0/m1_24741_n15864# VSS 6.746650e-16
C6026 eeg_sdm1ct_0/eeg_fd_ota_full2_nc_0/stage2_0/m1_19941_n15864# VSS 6.746650e-16
C6027 eeg_sdm1ct_0/eeg_fd_ota_full2_nc_0/stage2_0/m1_20341_n8557# VSS 6.746650e-16
C6028 eeg_sdm1ct_0/eeg_fd_ota_full2_nc_0/stage2_0/m1_35541_n8557# VSS 6.746650e-16
C6029 eeg_sdm1ct_0/eeg_fd_ota_full2_nc_0/stage2_0/m1_35941_n15864# VSS 6.746650e-16
C6030 eeg_sdm1ct_0/eeg_fd_ota_full2_nc_0/stage2_0/m1_79541_n15864# VSS 6.746650e-16
C6031 eeg_sdm1ct_0/eeg_fd_ota_full2_nc_0/stage2_0/m1_79941_n8557# VSS 6.746650e-16
C6032 eeg_sdm1ct_0/eeg_fd_ota_full2_nc_0/stage2_0/m1_75141_n8557# VSS 6.746650e-16
C6033 eeg_sdm1ct_0/eeg_fd_ota_full2_nc_0/stage2_0/m1_75541_n15864# VSS 6.746650e-16
C6034 eeg_sdm1ct_0/eeg_fd_ota_full2_nc_0/stage2_0/m1_68741_n15864# VSS 6.746650e-16
C6035 eeg_sdm1ct_0/eeg_fd_ota_full2_nc_0/stage2_0/m1_69141_n8557# VSS 6.746650e-16
C6036 eeg_sdm1ct_0/eeg_fd_ota_full2_nc_0/stage2_0/m1_64341_n8557# VSS 6.746650e-16
C6037 eeg_sdm1ct_0/eeg_fd_ota_full2_nc_0/stage2_0/m1_64741_n15864# VSS 6.746650e-16
C6038 eeg_sdm1ct_0/eeg_fd_ota_full2_nc_0/stage2_0/m1_57541_n8557# VSS 6.746650e-16
C6039 eeg_sdm1ct_0/eeg_fd_ota_full2_nc_0/stage2_0/m1_57941_n15864# VSS 6.746650e-16
C6040 eeg_sdm1ct_0/eeg_fd_ota_full2_nc_0/stage2_0/m1_28341_n8557# VSS 6.746650e-16
C6041 eeg_sdm1ct_0/eeg_fd_ota_full2_nc_0/stage2_0/m1_28741_n15864# VSS 6.746650e-16
C6042 eeg_sdm1ct_0/eeg_fd_ota_full2_nc_0/stage2_0/m1_23941_n15864# VSS 6.746650e-16
C6043 eeg_sdm1ct_0/eeg_fd_ota_full2_nc_0/stage2_0/m1_24341_n8557# VSS 6.746650e-16
C6044 eeg_sdm1ct_0/OINTP VSS 6.746650e-16
C6045 eeg_sdm1ct_0/eeg_fd_ota_full2_nc_0/stage2_0/m1_19941_n15864# VSS 6.746650e-16
C6046 eeg_sdm1ct_0/eeg_fd_ota_full2_nc_0/stage2_0/m1_35141_n15864# VSS 6.746650e-16
C6047 eeg_sdm1ct_0/eeg_fd_ota_full2_nc_0/stage2_0/m1_35541_n8557# VSS 6.746650e-16
C6048 eeg_sdm1ct_0/eeg_fd_ota_full2_nc_0/stage2_0/m1_79141_n8557# VSS 6.746650e-16
C6049 eeg_sdm1ct_0/eeg_fd_ota_full2_nc_0/stage2_0/m1_79541_n15864# VSS 6.746650e-16
C6050 eeg_sdm1ct_0/eeg_fd_ota_full2_nc_0/stage2_0/m1_74741_n15864# VSS 6.746650e-16
C6051 eeg_sdm1ct_0/eeg_fd_ota_full2_nc_0/stage2_0/m1_75141_n8557# VSS 6.746650e-16
C6052 eeg_sdm1ct_0/eeg_fd_ota_full2_nc_0/stage2_0/m1_68341_n8557# VSS 6.746650e-16
C6053 eeg_sdm1ct_0/eeg_fd_ota_full2_nc_0/stage2_0/m1_68741_n15864# VSS 6.746650e-16
C6054 eeg_sdm1ct_0/eeg_fd_ota_full2_nc_0/stage2_0/m1_63941_n15864# VSS 6.746650e-16
C6055 eeg_sdm1ct_0/eeg_fd_ota_full2_nc_0/stage2_0/m1_64341_n8557# VSS 6.746650e-16
C6056 eeg_sdm1ct_0/eeg_fd_ota_full2_nc_0/stage2_0/m1_27941_n15864# VSS 6.746650e-16
C6057 eeg_sdm1ct_0/eeg_fd_ota_full2_nc_0/stage2_0/m1_28341_n8557# VSS 6.746650e-16
C6058 eeg_sdm1ct_0/eeg_fd_ota_full2_nc_0/stage2_0/m1_23541_n8557# VSS 6.746650e-16
C6059 eeg_sdm1ct_0/eeg_fd_ota_full2_nc_0/stage2_0/m1_23941_n15864# VSS 6.746650e-16
C6060 eeg_sdm1ct_0/eeg_fd_ota_full2_nc_0/stage2_0/VCM2 VSS 6.746650e-16
C6061 eeg_sdm1ct_0/eeg_fd_ota_full2_nc_0/stage2_0/m1_39141_n15864# VSS 6.746650e-16
C6062 eeg_sdm1ct_0/eeg_fd_ota_full2_nc_0/stage2_0/m1_34741_n8557# VSS 6.746650e-16
C6063 eeg_sdm1ct_0/eeg_fd_ota_full2_nc_0/stage2_0/m1_35141_n15864# VSS 6.746650e-16
C6064 eeg_sdm1ct_0/eeg_fd_ota_full2_nc_0/stage2_0/m1_78741_n15864# VSS 6.746650e-16
C6065 eeg_sdm1ct_0/eeg_fd_ota_full2_nc_0/stage2_0/m1_79141_n8557# VSS 6.746650e-16
C6066 eeg_sdm1ct_0/eeg_fd_ota_full2_nc_0/stage2_0/m1_74341_n8557# VSS 6.746650e-16
C6067 eeg_sdm1ct_0/eeg_fd_ota_full2_nc_0/stage2_0/m1_74741_n15864# VSS 6.746650e-16
C6068 eeg_sdm1ct_0/eeg_fd_ota_full2_nc_0/stage2_0/m1_67941_n15864# VSS 6.746650e-16
C6069 eeg_sdm1ct_0/eeg_fd_ota_full2_nc_0/stage2_0/m1_68341_n8557# VSS 6.746650e-16
C6070 eeg_sdm1ct_0/OINTP VSS 6.746650e-16
C6071 eeg_sdm1ct_0/eeg_fd_ota_full2_nc_0/stage2_0/m1_63941_n15864# VSS 6.746650e-16
C6072 eeg_sdm1ct_0/eeg_fd_ota_full2_nc_0/stage2_0/m1_27541_n8557# VSS 6.746650e-16
C6073 eeg_sdm1ct_0/eeg_fd_ota_full2_nc_0/stage2_0/m1_27941_n15864# VSS 6.746650e-16
C6074 eeg_sdm1ct_0/eeg_fd_ota_full2_nc_0/stage2_0/m1_23141_n15864# VSS 6.746650e-16
C6075 eeg_sdm1ct_0/eeg_fd_ota_full2_nc_0/stage2_0/m1_23541_n8557# VSS 6.746650e-16
C6076 eeg_sdm1ct_0/eeg_fd_ota_full2_nc_0/stage2_0/m1_38741_n8557# VSS 6.746650e-16
C6077 eeg_sdm1ct_0/eeg_fd_ota_full2_nc_0/stage2_0/m1_39141_n15864# VSS 6.746650e-16
C6078 eeg_sdm1ct_0/eeg_fd_ota_full2_nc_0/stage2_0/m1_34341_n15864# VSS 6.746650e-16
C6079 eeg_sdm1ct_0/eeg_fd_ota_full2_nc_0/stage2_0/m1_34741_n8557# VSS 6.746650e-16
C6080 eeg_sdm1ct_0/eeg_fd_ota_full2_nc_0/stage2_0/m1_78341_n8557# VSS 6.746650e-16
C6081 eeg_sdm1ct_0/eeg_fd_ota_full2_nc_0/stage2_0/m1_78741_n15864# VSS 6.746650e-16
C6082 eeg_sdm1ct_0/eeg_fd_ota_full2_nc_0/stage2_0/m1_73941_n15864# VSS 6.746650e-16
C6083 eeg_sdm1ct_0/eeg_fd_ota_full2_nc_0/stage2_0/m1_74341_n8557# VSS 6.746650e-16
C6084 eeg_sdm1ct_0/eeg_fd_ota_full2_nc_0/stage2_0/m1_67541_n8557# VSS 6.746650e-16
C6085 eeg_sdm1ct_0/eeg_fd_ota_full2_nc_0/stage2_0/m1_67941_n15864# VSS 6.746650e-16
C6086 eeg_sdm1ct_0/eeg_fd_ota_full2_nc_0/stage2_0/m1_27141_n15864# VSS 6.746650e-16
C6087 eeg_sdm1ct_0/eeg_fd_ota_full2_nc_0/stage2_0/m1_27541_n8557# VSS 6.746650e-16
C6088 eeg_sdm1ct_0/eeg_fd_ota_full2_nc_0/stage2_0/m1_22741_n8557# VSS 6.746650e-16
C6089 eeg_sdm1ct_0/eeg_fd_ota_full2_nc_0/stage2_0/m1_23141_n15864# VSS 6.746650e-16
C6090 eeg_sdm1ct_0/eeg_fd_ota_full2_nc_0/stage2_0/m1_38341_n15864# VSS 6.746650e-16
C6091 eeg_sdm1ct_0/eeg_fd_ota_full2_nc_0/stage2_0/m1_38741_n8557# VSS 6.746650e-16
C6092 eeg_sdm1ct_0/eeg_fd_ota_full2_nc_0/stage2_0/m1_33941_n8557# VSS 6.746650e-16
C6093 eeg_sdm1ct_0/eeg_fd_ota_full2_nc_0/stage2_0/m1_34341_n15864# VSS 6.746650e-16
C6094 eeg_sdm1ct_0/eeg_fd_ota_full2_nc_0/stage2_0/m1_77941_n15864# VSS 6.746650e-16
C6095 eeg_sdm1ct_0/eeg_fd_ota_full2_nc_0/stage2_0/m1_78341_n8557# VSS 6.746650e-16
C6096 eeg_sdm1ct_0/OINTN VSS 6.746650e-16
C6097 eeg_sdm1ct_0/eeg_fd_ota_full2_nc_0/stage2_0/m1_73941_n15864# VSS 6.746650e-16
C6098 eeg_sdm1ct_0/eeg_fd_ota_full2_nc_0/stage2_0/m1_26741_n8557# VSS 6.746650e-16
C6099 eeg_sdm1ct_0/eeg_fd_ota_full2_nc_0/stage2_0/m1_27141_n15864# VSS 6.746650e-16
C6100 eeg_sdm1ct_0/eeg_fd_ota_full2_nc_0/stage2_0/m1_22341_n15864# VSS 6.746650e-16
C6101 eeg_sdm1ct_0/eeg_fd_ota_full2_nc_0/stage2_0/m1_22741_n8557# VSS 6.746650e-16
C6102 eeg_sdm1ct_0/eeg_fd_ota_full2_nc_0/stage2_0/m1_37941_n8557# VSS 6.746650e-16
C6103 eeg_sdm1ct_0/eeg_fd_ota_full2_nc_0/stage2_0/m1_38341_n15864# VSS 6.746650e-16
C6104 eeg_sdm1ct_0/eeg_fd_ota_full2_nc_0/stage2_0/m1_33541_n15864# VSS 6.746650e-16
C6105 eeg_sdm1ct_0/eeg_fd_ota_full2_nc_0/stage2_0/m1_33941_n8557# VSS 6.746650e-16
C6106 eeg_sdm1ct_0/eeg_fd_ota_full2_nc_0/stage2_0/m1_77541_n8557# VSS 6.746650e-16
C6107 eeg_sdm1ct_0/eeg_fd_ota_full2_nc_0/stage2_0/m1_77941_n15864# VSS 6.746650e-16
C6108 eeg_sdm1ct_0/eeg_fd_ota_full2_nc_0/stage2_0/m1_26341_n15864# VSS 6.746650e-16
C6109 eeg_sdm1ct_0/eeg_fd_ota_full2_nc_0/stage2_0/m1_26741_n8557# VSS 6.746650e-16
C6110 eeg_sdm1ct_0/eeg_fd_ota_full2_nc_0/stage2_0/m1_21941_n8557# VSS 6.746650e-16
C6111 eeg_sdm1ct_0/eeg_fd_ota_full2_nc_0/stage2_0/m1_22341_n15864# VSS 6.746650e-16
C6112 eeg_sdm1ct_0/eeg_fd_ota_full2_nc_0/stage2_0/m1_37541_n15864# VSS 6.746650e-16
C6113 eeg_sdm1ct_0/eeg_fd_ota_full2_nc_0/stage2_0/m1_37941_n8557# VSS 6.746650e-16
C6114 eeg_sdm1ct_0/eeg_fd_ota_full2_nc_0/stage2_0/m1_33141_n8557# VSS 6.746650e-16
C6115 eeg_sdm1ct_0/eeg_fd_ota_full2_nc_0/stage2_0/m1_33541_n15864# VSS 6.746650e-16
C6116 eeg_sdm1ct_0/eeg_fd_ota_full2_nc_0/stage2_0/m1_25941_n8557# VSS 6.746650e-16
C6117 eeg_sdm1ct_0/eeg_fd_ota_full2_nc_0/stage2_0/m1_26341_n15864# VSS 6.746650e-16
C6118 eeg_sdm1ct_0/eeg_fd_ota_full2_nc_0/stage2_0/m1_21541_n15864# VSS 6.746650e-16
C6119 eeg_sdm1ct_0/eeg_fd_ota_full2_nc_0/stage2_0/m1_21941_n8557# VSS 6.746650e-16
C6120 eeg_sdm1ct_0/eeg_fd_ota_full2_nc_0/stage2_0/m1_37141_n8557# VSS 6.746650e-16
C6121 eeg_sdm1ct_0/eeg_fd_ota_full2_nc_0/stage2_0/m1_37541_n15864# VSS 6.746650e-16
C6122 eeg_sdm1ct_0/eeg_fd_ota_full2_nc_0/stage2_0/m1_25541_n15864# VSS 6.746650e-16
C6123 eeg_sdm1ct_0/eeg_fd_ota_full2_nc_0/stage2_0/m1_25941_n8557# VSS 6.746650e-16
C6124 eeg_sdm1ct_0/eeg_fd_ota_full2_nc_0/stage2_0/m1_21141_n8557# VSS 6.746650e-16
C6125 eeg_sdm1ct_0/eeg_fd_ota_full2_nc_0/stage2_0/m1_21541_n15864# VSS 6.746650e-16
C6126 eeg_sdm1ct_0/eeg_fd_ota_full2_nc_0/stage2_0/m1_25141_n8557# VSS 6.746650e-16
C6127 eeg_sdm1ct_0/eeg_fd_ota_full2_nc_0/stage2_0/m1_25541_n15864# VSS 6.746650e-16
C6128 VDD18 VSS 1.074004e-13
C6129 VDD18 eeg_sdm1ct_0/OINTN 9.216400e-16
C6130 VDD18 eeg_sdm1ct_0/eeg_fd_ota_full2_nc_0/stage2_0/VBP2 2.903319e-14
C6131 eeg_sdm1ct_0/OINTN VSS 4.856640e-16
C6132 eeg_sdm1ct_0/OINTN eeg_sdm1ct_0/eeg_fd_ota_full2_nc_0/stage2_0/VBP2 3.596600e-15
C6133 eeg_sdm1ct_0/eeg_fd_ota_full2_nc_0/stage2_0/VBP2 VSS 7.027174e-15
C6134 eeg_sdm1ct_0/eeg_fd_ota_full2_nc_0/stage2_0/m1_32741_n15864# VSS 6.746650e-16
C6135 eeg_sdm1ct_0/eeg_fd_ota_full2_nc_0/stage2_0/m1_33141_n8557# VSS 6.746650e-16
C6136 VSS eeg_sdm1ct_0/eeg_fd_ota_full2_nc_0/stage2_0/N2N 9.971760e-16
C6137 eeg_sdm1ct_0/OINTN VSS 1.639490e-16
C6138 eeg_sdm1ct_0/OINTN eeg_sdm1ct_0/eeg_fd_ota_full2_nc_0/stage2_0/N2N 8.991500e-16
C6139 eeg_sdm1ct_0/eeg_fd_ota_full2_nc_0/stage2_0/N2N VSS 7.765320e-15
C6140 eeg_sdm1ct_0/eeg_fd_ota_full2_nc_0/stage2_0/m1_32341_n8557# VSS 6.746650e-16
C6141 eeg_sdm1ct_0/eeg_fd_ota_full2_nc_0/stage2_0/m1_32741_n15864# VSS 6.746650e-16
C6142 eeg_sdm1ct_0/eeg_fd_ota_full2_nc_0/stage2_0/m1_31941_n15864# VSS 6.746650e-16
C6143 eeg_sdm1ct_0/eeg_fd_ota_full2_nc_0/stage2_0/m1_32341_n8557# VSS 6.746650e-16
C6144 eeg_sdm1ct_0/eeg_fd_ota_full2_nc_0/stage2_0/m1_31541_n8557# VSS 6.746650e-16
C6145 eeg_sdm1ct_0/eeg_fd_ota_full2_nc_0/stage2_0/m1_31941_n15864# VSS 6.746650e-16
C6146 eeg_sdm1ct_0/eeg_fd_ota_full2_nc_0/stage2_0/m1_31141_n15864# VSS 6.746650e-16
C6147 eeg_sdm1ct_0/eeg_fd_ota_full2_nc_0/stage2_0/m1_31541_n8557# VSS 6.746650e-16
C6148 eeg_sdm1ct_0/eeg_fd_ota_full2_nc_0/stage2_0/m1_30741_n8557# VSS 6.746650e-16
C6149 eeg_sdm1ct_0/eeg_fd_ota_full2_nc_0/stage2_0/m1_31141_n15864# VSS 6.746650e-16
C6150 eeg_sdm1ct_0/eeg_fd_ota_full2_nc_0/stage2_0/m1_30341_n15864# VSS 6.746650e-16
C6151 eeg_sdm1ct_0/eeg_fd_ota_full2_nc_0/stage2_0/m1_30741_n8557# VSS 6.746650e-16
C6152 eeg_sdm1ct_0/eeg_fd_ota_full2_nc_0/stage2_0/N2N VSS 6.668820e-16
C6154 eeg_sdm1ct_0/eeg_fd_ota_full2_nc_0/stage2_0/m1_12966_n5928# VSS 6.668820e-16
C6155 eeg_sdm1ct_0/eeg_fd_ota_full2_nc_0/stage2_0/m1_29941_n8557# VSS 6.746650e-16
C6156 eeg_sdm1ct_0/eeg_fd_ota_full2_nc_0/stage2_0/m1_30341_n15864# VSS 6.746650e-16
C6157 eeg_sdm1ct_0/eeg_fd_ota_full2_nc_0/stage2_0/m1_45141_n15864# VSS 6.746650e-16
C6158 eeg_sdm1ct_0/eeg_fd_ota_full2_nc_0/stage2_0/m1_45541_n8557# VSS 6.746650e-16
C6159 eeg_sdm1ct_0/eeg_fd_ota_full2_nc_0/stage2_0/N2P VSS 6.668820e-16
C6161 eeg_sdm1ct_0/eeg_fd_ota_full2_nc_0/stage2_0/m1_3966_n5928# VSS 6.668820e-16
C6162 eeg_sdm1ct_0/eeg_fd_ota_full2_nc_0/stage2_0/m1_29541_n15864# VSS 6.746650e-16
C6163 eeg_sdm1ct_0/eeg_fd_ota_full2_nc_0/stage2_0/m1_29941_n8557# VSS 6.746650e-16
C6164 eeg_sdm1ct_0/eeg_fd_ota_full2_nc_0/stage2_0/m1_44741_n8557# VSS 6.746650e-16
C6165 eeg_sdm1ct_0/eeg_fd_ota_full2_nc_0/stage2_0/m1_45141_n15864# VSS 6.746650e-16
C6166 eeg_sdm1ct_0/eeg_fd_ota_full2_nc_0/stage2_0/m1_49141_n15864# VSS 6.746650e-16
C6167 eeg_sdm1ct_0/eeg_fd_ota_full2_nc_0/stage2_0/m1_49541_n8557# VSS 6.746650e-16
C6168 eeg_sdm1ct_0/eeg_fd_ota_full2_nc_0/stage2_0/m1_29141_n8557# VSS 6.746650e-16
C6169 eeg_sdm1ct_0/eeg_fd_ota_full2_nc_0/stage2_0/m1_29541_n15864# VSS 6.746650e-16
C6170 eeg_sdm1ct_0/eeg_fd_ota_full2_nc_0/stage2_0/m1_44341_n15864# VSS 6.746650e-16
C6171 eeg_sdm1ct_0/eeg_fd_ota_full2_nc_0/stage2_0/m1_44741_n8557# VSS 6.746650e-16
C6172 eeg_sdm1ct_0/eeg_fd_ota_full2_nc_0/stage2_0/m1_48741_n8557# VSS 6.746650e-16
C6173 eeg_sdm1ct_0/eeg_fd_ota_full2_nc_0/stage2_0/m1_49141_n15864# VSS 6.746650e-16
C6174 eeg_sdm1ct_0/eeg_fd_ota_full2_nc_0/stage2_0/m1_53141_n15864# VSS 6.746650e-16
C6175 eeg_sdm1ct_0/eeg_fd_ota_full2_nc_0/stage2_0/m1_53541_n8557# VSS 6.746650e-16
C6176 eeg_sdm1ct_0/eeg_fd_ota_full2_nc_0/stage2_0/m1_43941_n8557# VSS 6.746650e-16
C6177 eeg_sdm1ct_0/eeg_fd_ota_full2_nc_0/stage2_0/m1_44341_n15864# VSS 6.746650e-16
C6178 eeg_sdm1ct_0/eeg_fd_ota_full2_nc_0/stage2_0/m1_48341_n15864# VSS 6.746650e-16
C6179 eeg_sdm1ct_0/eeg_fd_ota_full2_nc_0/stage2_0/m1_48741_n8557# VSS 6.746650e-16
C6180 eeg_sdm1ct_0/eeg_fd_ota_full2_nc_0/stage2_0/m1_52741_n8557# VSS 6.746650e-16
C6181 eeg_sdm1ct_0/eeg_fd_ota_full2_nc_0/stage2_0/m1_53141_n15864# VSS 6.746650e-16
C6182 eeg_sdm1ct_0/eeg_fd_ota_full2_nc_0/stage2_0/m1_57141_n15864# VSS 6.746650e-16
C6183 eeg_sdm1ct_0/eeg_fd_ota_full2_nc_0/stage2_0/m1_57541_n8557# VSS 6.746650e-16
C6184 eeg_sdm1ct_0/eeg_fd_ota_full2_nc_0/stage2_0/m1_43541_n15864# VSS 6.746650e-16
C6185 eeg_sdm1ct_0/eeg_fd_ota_full2_nc_0/stage2_0/m1_43941_n8557# VSS 6.746650e-16
C6186 eeg_sdm1ct_0/eeg_fd_ota_full2_nc_0/stage2_0/m1_47941_n8557# VSS 6.746650e-16
C6187 eeg_sdm1ct_0/eeg_fd_ota_full2_nc_0/stage2_0/m1_48341_n15864# VSS 6.746650e-16
C6188 eeg_sdm1ct_0/eeg_fd_ota_full2_nc_0/stage2_0/m1_52341_n15864# VSS 6.746650e-16
C6189 eeg_sdm1ct_0/eeg_fd_ota_full2_nc_0/stage2_0/m1_52741_n8557# VSS 6.746650e-16
C6190 eeg_sdm1ct_0/eeg_fd_ota_full2_nc_0/stage2_0/m1_56741_n8557# VSS 6.746650e-16
C6191 eeg_sdm1ct_0/eeg_fd_ota_full2_nc_0/stage2_0/m1_57141_n15864# VSS 6.746650e-16
C6192 eeg_sdm1ct_0/eeg_fd_ota_full2_nc_0/stage2_0/m1_43141_n8557# VSS 6.746650e-16
C6193 eeg_sdm1ct_0/eeg_fd_ota_full2_nc_0/stage2_0/m1_43541_n15864# VSS 6.746650e-16
C6194 eeg_sdm1ct_0/eeg_fd_ota_full2_nc_0/stage2_0/m1_47541_n15864# VSS 6.746650e-16
C6195 eeg_sdm1ct_0/eeg_fd_ota_full2_nc_0/stage2_0/m1_47941_n8557# VSS 6.746650e-16
C6196 eeg_sdm1ct_0/eeg_fd_ota_full2_nc_0/stage2_0/m1_51941_n8557# VSS 6.746650e-16
C6197 eeg_sdm1ct_0/eeg_fd_ota_full2_nc_0/stage2_0/m1_52341_n15864# VSS 6.746650e-16
C6198 eeg_sdm1ct_0/eeg_fd_ota_full2_nc_0/stage2_0/m1_56341_n15864# VSS 6.746650e-16
C6199 eeg_sdm1ct_0/eeg_fd_ota_full2_nc_0/stage2_0/m1_56741_n8557# VSS 6.746650e-16
C6200 eeg_sdm1ct_0/eeg_fd_ota_full2_nc_0/stage2_0/m1_42741_n15864# VSS 6.746650e-16
C6201 eeg_sdm1ct_0/eeg_fd_ota_full2_nc_0/stage2_0/m1_43141_n8557# VSS 6.746650e-16
C6202 eeg_sdm1ct_0/eeg_fd_ota_full2_nc_0/stage2_0/m1_47141_n8557# VSS 6.746650e-16
C6203 eeg_sdm1ct_0/eeg_fd_ota_full2_nc_0/stage2_0/m1_47541_n15864# VSS 6.746650e-16
C6204 eeg_sdm1ct_0/eeg_fd_ota_full2_nc_0/stage2_0/m1_51541_n15864# VSS 6.746650e-16
C6205 eeg_sdm1ct_0/eeg_fd_ota_full2_nc_0/stage2_0/m1_51941_n8557# VSS 6.746650e-16
C6206 eeg_sdm1ct_0/eeg_fd_ota_full2_nc_0/stage2_0/m1_55941_n8557# VSS 6.746650e-16
C6207 eeg_sdm1ct_0/eeg_fd_ota_full2_nc_0/stage2_0/m1_56341_n15864# VSS 6.746650e-16
C6208 eeg_sdm1ct_0/eeg_fd_ota_full2_nc_0/stage2_0/VCM2 VSS 6.746650e-16
C6209 eeg_sdm1ct_0/eeg_fd_ota_full2_nc_0/stage2_0/m1_61141_n15864# VSS 6.746650e-16
C6210 eeg_sdm1ct_0/eeg_fd_ota_full2_nc_0/stage2_0/m1_42341_n8557# VSS 6.746650e-16
C6211 eeg_sdm1ct_0/eeg_fd_ota_full2_nc_0/stage2_0/m1_42741_n15864# VSS 6.746650e-16
C6212 eeg_sdm1ct_0/eeg_fd_ota_full2_nc_0/stage2_0/m1_46741_n15864# VSS 6.746650e-16
C6213 eeg_sdm1ct_0/eeg_fd_ota_full2_nc_0/stage2_0/m1_47141_n8557# VSS 6.746650e-16
C6214 eeg_sdm1ct_0/eeg_fd_ota_full2_nc_0/stage2_0/m1_51141_n8557# VSS 6.746650e-16
C6215 eeg_sdm1ct_0/eeg_fd_ota_full2_nc_0/stage2_0/m1_51541_n15864# VSS 6.746650e-16
C6216 eeg_sdm1ct_0/eeg_fd_ota_full2_nc_0/stage2_0/m1_55541_n15864# VSS 6.746650e-16
C6217 eeg_sdm1ct_0/eeg_fd_ota_full2_nc_0/stage2_0/m1_55941_n8557# VSS 6.746650e-16
C6218 eeg_sdm1ct_0/eeg_fd_ota_full2_nc_0/stage2_0/m1_60741_n8557# VSS 6.746650e-16
C6219 eeg_sdm1ct_0/eeg_fd_ota_full2_nc_0/stage2_0/m1_61141_n15864# VSS 6.746650e-16
C6220 eeg_sdm1ct_0/eeg_fd_ota_full2_nc_0/stage2_0/m1_67141_n15864# VSS 6.746650e-16
C6221 eeg_sdm1ct_0/eeg_fd_ota_full2_nc_0/stage2_0/m1_67541_n8557# VSS 6.746650e-16
C6222 eeg_sdm1ct_0/eeg_fd_ota_full2_nc_0/stage2_0/m1_41941_n15864# VSS 6.746650e-16
C6223 eeg_sdm1ct_0/eeg_fd_ota_full2_nc_0/stage2_0/m1_42341_n8557# VSS 6.746650e-16
C6224 eeg_sdm1ct_0/eeg_fd_ota_full2_nc_0/stage2_0/m1_46341_n8557# VSS 6.746650e-16
C6225 eeg_sdm1ct_0/eeg_fd_ota_full2_nc_0/stage2_0/m1_46741_n15864# VSS 6.746650e-16
C6226 eeg_sdm1ct_0/eeg_fd_ota_full2_nc_0/stage2_0/m1_50741_n15864# VSS 6.746650e-16
C6227 eeg_sdm1ct_0/eeg_fd_ota_full2_nc_0/stage2_0/m1_51141_n8557# VSS 6.746650e-16
C6228 eeg_sdm1ct_0/eeg_fd_ota_full2_nc_0/stage2_0/m1_55141_n8557# VSS 6.746650e-16
C6229 eeg_sdm1ct_0/eeg_fd_ota_full2_nc_0/stage2_0/m1_55541_n15864# VSS 6.746650e-16
C6230 eeg_sdm1ct_0/eeg_fd_ota_full2_nc_0/stage2_0/m1_60341_n15864# VSS 6.746650e-16
C6231 eeg_sdm1ct_0/eeg_fd_ota_full2_nc_0/stage2_0/m1_60741_n8557# VSS 6.746650e-16
C6232 VCM_REF VSS 6.746650e-16
C6233 eeg_sdm1ct_0/eeg_fd_ota_full2_nc_0/stage2_0/m1_71141_n15864# VSS 6.746650e-16
C6234 eeg_sdm1ct_0/eeg_fd_ota_full2_nc_0/stage2_0/m1_66741_n8557# VSS 6.746650e-16
C6235 eeg_sdm1ct_0/eeg_fd_ota_full2_nc_0/stage2_0/m1_67141_n15864# VSS 6.746650e-16
C6236 eeg_sdm1ct_0/OINTN VSS 6.746650e-16
C6237 eeg_sdm1ct_0/eeg_fd_ota_full2_nc_0/stage2_0/m1_41941_n15864# VSS 6.746650e-16
C6238 eeg_sdm1ct_0/eeg_fd_ota_full2_nc_0/stage2_0/m1_45941_n15864# VSS 6.746650e-16
C6239 eeg_sdm1ct_0/eeg_fd_ota_full2_nc_0/stage2_0/m1_46341_n8557# VSS 6.746650e-16
C6240 eeg_sdm1ct_0/eeg_fd_ota_full2_nc_0/stage2_0/m1_50341_n8557# VSS 6.746650e-16
C6241 eeg_sdm1ct_0/eeg_fd_ota_full2_nc_0/stage2_0/m1_50741_n15864# VSS 6.746650e-16
C6242 eeg_sdm1ct_0/eeg_fd_ota_full2_nc_0/stage2_0/m1_54741_n15864# VSS 6.746650e-16
C6243 eeg_sdm1ct_0/eeg_fd_ota_full2_nc_0/stage2_0/m1_55141_n8557# VSS 6.746650e-16
C6244 eeg_sdm1ct_0/eeg_fd_ota_full2_nc_0/stage2_0/m1_59941_n8557# VSS 6.746650e-16
C6245 eeg_sdm1ct_0/eeg_fd_ota_full2_nc_0/stage2_0/m1_60341_n15864# VSS 6.746650e-16
C6246 eeg_sdm1ct_0/eeg_fd_ota_full2_nc_0/stage2_0/m1_77141_n15864# VSS 6.746650e-16
C6247 eeg_sdm1ct_0/eeg_fd_ota_full2_nc_0/stage2_0/m1_77541_n8557# VSS 6.746650e-16
C6248 eeg_sdm1ct_0/eeg_fd_ota_full2_nc_0/stage2_0/m1_70741_n8557# VSS 6.746650e-16
C6249 eeg_sdm1ct_0/eeg_fd_ota_full2_nc_0/stage2_0/m1_71141_n15864# VSS 6.746650e-16
C6250 eeg_sdm1ct_0/eeg_fd_ota_full2_nc_0/stage2_0/m1_66341_n15864# VSS 6.746650e-16
C6251 eeg_sdm1ct_0/eeg_fd_ota_full2_nc_0/stage2_0/m1_66741_n8557# VSS 6.746650e-16
C6252 VDD18 VSS 1.074004e-13
C6253 VDD18 eeg_sdm1ct_0/OINTP 9.216400e-16
C6254 VDD18 eeg_sdm1ct_0/eeg_fd_ota_full2_nc_0/stage2_0/VBP2 2.903319e-14
C6255 eeg_sdm1ct_0/OINTP VSS 4.856640e-16
C6256 eeg_sdm1ct_0/OINTP eeg_sdm1ct_0/eeg_fd_ota_full2_nc_0/stage2_0/VBP2 3.596600e-15
C6257 eeg_sdm1ct_0/eeg_fd_ota_full2_nc_0/stage2_0/VBP2 VSS 7.027174e-15
C6258 eeg_sdm1ct_0/eeg_fd_ota_full2_nc_0/stage2_0/m1_45541_n8557# VSS 6.746650e-16
C6259 eeg_sdm1ct_0/eeg_fd_ota_full2_nc_0/stage2_0/m1_45941_n15864# VSS 6.746650e-16
C6260 eeg_sdm1ct_0/eeg_fd_ota_full2_nc_0/stage2_0/m1_49941_n15864# VSS 6.746650e-16
C6261 eeg_sdm1ct_0/eeg_fd_ota_full2_nc_0/stage2_0/m1_50341_n8557# VSS 6.746650e-16
C6262 eeg_sdm1ct_0/eeg_fd_ota_full2_nc_0/stage2_0/m1_54341_n8557# VSS 6.746650e-16
C6263 eeg_sdm1ct_0/eeg_fd_ota_full2_nc_0/stage2_0/m1_54741_n15864# VSS 6.746650e-16
C6264 eeg_sdm1ct_0/eeg_fd_ota_full2_nc_0/stage2_0/m1_59541_n15864# VSS 6.746650e-16
C6265 eeg_sdm1ct_0/eeg_fd_ota_full2_nc_0/stage2_0/m1_59941_n8557# VSS 6.746650e-16
C6266 VCM_REF VSS 6.746650e-16
C6267 eeg_sdm1ct_0/eeg_fd_ota_full2_nc_0/stage2_0/m1_81141_n15864# VSS 6.746650e-16
C6268 eeg_sdm1ct_0/eeg_fd_ota_full2_nc_0/stage2_0/m1_76741_n8557# VSS 6.746650e-16
C6269 eeg_sdm1ct_0/eeg_fd_ota_full2_nc_0/stage2_0/m1_77141_n15864# VSS 6.746650e-16
C6270 eeg_sdm1ct_0/eeg_fd_ota_full2_nc_0/stage2_0/m1_70341_n15864# VSS 6.746650e-16
C6271 eeg_sdm1ct_0/eeg_fd_ota_full2_nc_0/stage2_0/m1_70741_n8557# VSS 6.746650e-16
C6272 eeg_sdm1ct_0/eeg_fd_ota_full2_nc_0/stage2_0/m1_65941_n8557# VSS 6.746650e-16
C6273 eeg_sdm1ct_0/eeg_fd_ota_full2_nc_0/stage2_0/m1_66341_n15864# VSS 6.746650e-16
C6274 eeg_sdm1ct_0/eeg_fd_ota_full2_nc_0/stage2_0/m1_49541_n8557# VSS 6.746650e-16
C6275 eeg_sdm1ct_0/eeg_fd_ota_full2_nc_0/stage2_0/m1_49941_n15864# VSS 6.746650e-16
C6276 eeg_sdm1ct_0/eeg_fd_ota_full2_nc_0/stage2_0/m1_53941_n15864# VSS 6.746650e-16
C6277 eeg_sdm1ct_0/eeg_fd_ota_full2_nc_0/stage2_0/m1_54341_n8557# VSS 6.746650e-16
C6278 eeg_sdm1ct_0/eeg_fd_ota_full2_nc_0/stage2_0/m1_59141_n8557# VSS 6.746650e-16
C6279 eeg_sdm1ct_0/eeg_fd_ota_full2_nc_0/stage2_0/m1_59541_n15864# VSS 6.746650e-16
C6280 eeg_sdm1ct_0/eeg_fd_ota_full2_nc_0/stage2_0/m1_36741_n15864# VSS 6.746650e-16
C6281 eeg_sdm1ct_0/eeg_fd_ota_full2_nc_0/stage2_0/m1_37141_n8557# VSS 6.746650e-16
C6282 eeg_sdm1ct_0/eeg_fd_ota_full2_nc_0/stage2_0/m1_80741_n8557# VSS 6.746650e-16
C6283 eeg_sdm1ct_0/eeg_fd_ota_full2_nc_0/stage2_0/m1_81141_n15864# VSS 6.746650e-16
C6284 eeg_sdm1ct_0/eeg_fd_ota_full2_nc_0/stage2_0/m1_76341_n15864# VSS 6.746650e-16
C6285 eeg_sdm1ct_0/eeg_fd_ota_full2_nc_0/stage2_0/m1_76741_n8557# VSS 6.746650e-16
C6286 eeg_sdm1ct_0/eeg_fd_ota_full2_nc_0/stage2_0/m1_69941_n8557# VSS 6.746650e-16
C6287 eeg_sdm1ct_0/eeg_fd_ota_full2_nc_0/stage2_0/m1_70341_n15864# VSS 6.746650e-16
C6288 eeg_sdm1ct_0/eeg_fd_ota_full2_nc_0/stage2_0/m1_65541_n15864# VSS 6.746650e-16
C6289 eeg_sdm1ct_0/eeg_fd_ota_full2_nc_0/stage2_0/m1_65941_n8557# VSS 6.746650e-16
C6290 eeg_sdm1ct_0/eeg_fd_ota_full2_nc_0/stage2_0/m1_53541_n8557# VSS 6.746650e-16
C6291 eeg_sdm1ct_0/eeg_fd_ota_full2_nc_0/stage2_0/m1_53941_n15864# VSS 6.746650e-16
C6292 eeg_sdm1ct_0/eeg_fd_ota_full2_nc_0/stage2_0/m1_58741_n15864# VSS 6.746650e-16
C6293 eeg_sdm1ct_0/eeg_fd_ota_full2_nc_0/stage2_0/m1_59141_n8557# VSS 6.746650e-16
C6294 eeg_sdm1ct_0/eeg_fd_ota_full2_nc_0/stage2_0/m1_20741_n15864# VSS 6.746650e-16
C6295 eeg_sdm1ct_0/eeg_fd_ota_full2_nc_0/stage2_0/m1_21141_n8557# VSS 6.746650e-16
C6296 eeg_sdm1ct_0/eeg_fd_ota_full2_nc_0/stage2_0/m1_36341_n8557# VSS 6.746650e-16
C6297 eeg_sdm1ct_0/eeg_fd_ota_full2_nc_0/stage2_0/m1_36741_n15864# VSS 6.746650e-16
C6298 eeg_sdm1ct_0/eeg_fd_ota_full2_nc_0/stage2_0/m1_80341_n15864# VSS 6.746650e-16
C6299 eeg_sdm1ct_0/eeg_fd_ota_full2_nc_0/stage2_0/m1_80741_n8557# VSS 6.746650e-16
C6300 eeg_sdm1ct_0/eeg_fd_ota_full2_nc_0/stage2_0/m1_75941_n8557# VSS 6.746650e-16
C6301 eeg_sdm1ct_0/eeg_fd_ota_full2_nc_0/stage2_0/m1_76341_n15864# VSS 6.746650e-16
C6302 eeg_sdm1ct_0/eeg_fd_ota_full2_nc_0/stage2_0/m1_69541_n15864# VSS 6.746650e-16
C6303 eeg_sdm1ct_0/eeg_fd_ota_full2_nc_0/stage2_0/m1_69941_n8557# VSS 6.746650e-16
C6304 eeg_sdm1ct_0/eeg_fd_ota_full2_nc_0/stage2_0/m1_65141_n8557# VSS 6.746650e-16
C6305 eeg_sdm1ct_0/eeg_fd_ota_full2_nc_0/stage2_0/m1_65541_n15864# VSS 6.746650e-16
C6306 VSS eeg_sdm1ct_0/eeg_fd_ota_full2_nc_0/stage2_0/N2P 9.971760e-16
C6307 eeg_sdm1ct_0/OINTP VSS 1.639490e-16
C6308 eeg_sdm1ct_0/OINTP eeg_sdm1ct_0/eeg_fd_ota_full2_nc_0/stage2_0/N2P 8.991500e-16
C6309 eeg_sdm1ct_0/eeg_fd_ota_full2_nc_0/stage2_0/N2P VSS 7.765320e-15
C6310 VCM_REF VDD18 2.703258e-17
C6311 VCM_REF VSS 3.540900e-14
C6313 VCM_REF eeg_sdm1ct_0/eeg_fd_ota_full2_nc_0/eeg_cmfb_amp_dl2_0/VCM_SENSE 1.587590e-14
C6314 VCM_REF eeg_sdm1ct_0/eeg_fd_ota_full2_nc_0/eeg_fd_ota_core_soft_0/m1_51141_3443# 7.672760e-17
C6316 VCM_REF eeg_sdm1ct_0/eeg_fd_ota_full2_nc_0/eeg_fd_ota_core_soft_0/m1_n51659_3443# 7.672760e-17
C6320 VDD18 VSS 1.621650e-14
C6321 VDD18 eeg_sdm1ct_0/eeg_fd_ota_full2_nc_0/eeg_cmfb_amp_dl2_0/VBP 3.427693e-15
C6322 VDD18 eeg_sdm1ct_0/eeg_fd_ota_full2_nc_0/eeg_cmfb_amp_dl2_0/VCM_SENSE 4.825121e-15
C6323 VDD18 eeg_sdm1ct_0/eeg_fd_ota_full2_nc_0/stage2_0/N2N 2.666394e-16
C6324 VDD18 eeg_sdm1ct_0/eeg_fd_ota_full2_nc_0/stage2_0/N2P 2.827840e-16
C6325 VDD18 eeg_sdm1ct_0/eeg_pseudo_res_0/B 2.563693e-17
C6326 VDD18 eeg_sdm1ct_0/eeg_pseudo_res_1/B 2.022347e-16
C6327 VSS eeg_sdm1ct_0/eeg_fd_ota_full2_nc_0/eeg_bias_gen_0/VBNF 3.521512e-15
C6328 VSS eeg_sdm1ct_0/eeg_fd_ota_full2_nc_0/eeg_fd_ota_core_soft_0/m1_n22658_111# 2.612991e-14
C6329 VSS eeg_sdm1ct_0/eeg_fd_ota_full2_nc_0/stage2_0/N2N 1.737419e-15
C6330 VSS eeg_sdm1ct_0/eeg_fd_ota_full2_nc_0/stage2_0/N2P 8.481620e-16
C6331 VSS eeg_sdm1ct_0/eeg_pseudo_res_0/B 1.319906e-14
C6332 VSS eeg_sdm1ct_0/eeg_pseudo_res_1/B 2.891675e-15
C6333 eeg_sdm1ct_0/eeg_fd_ota_full2_nc_0/eeg_bias_gen_0/VBNF VSS 6.189670e-15
C6334 eeg_sdm1ct_0/eeg_fd_ota_full2_nc_0/eeg_bias_gen_0/VBNF eeg_sdm1ct_0/eeg_fd_ota_full2_nc_0/eeg_fd_ota_core_soft_0/m1_n22658_111# 6.839995e-16
C6335 eeg_sdm1ct_0/eeg_fd_ota_full2_nc_0/eeg_bias_gen_0/VBNF eeg_sdm1ct_0/eeg_pseudo_res_0/B 6.911931e-17
C6336 eeg_sdm1ct_0/eeg_fd_ota_full2_nc_0/eeg_bias_gen_0/VBNF eeg_sdm1ct_0/eeg_pseudo_res_1/B 6.042561e-17
C6337 eeg_sdm1ct_0/eeg_fd_ota_full2_nc_0/eeg_cmfb_amp_dl2_0/VBP VSS 1.400120e-14
C6339 eeg_sdm1ct_0/eeg_fd_ota_full2_nc_0/eeg_cmfb_amp_dl2_0/VBP eeg_sdm1ct_0/eeg_fd_ota_full2_nc_0/stage2_0/N2N 7.668368e-16
C6340 eeg_sdm1ct_0/eeg_fd_ota_full2_nc_0/eeg_cmfb_amp_dl2_0/VBP eeg_sdm1ct_0/eeg_fd_ota_full2_nc_0/stage2_0/N2P 7.875883e-16
C6341 eeg_sdm1ct_0/eeg_fd_ota_full2_nc_0/eeg_cmfb_amp_dl2_0/VBP eeg_sdm1ct_0/eeg_pseudo_res_0/B 6.164535e-17
C6342 eeg_sdm1ct_0/eeg_fd_ota_full2_nc_0/eeg_cmfb_amp_dl2_0/VBP eeg_sdm1ct_0/eeg_pseudo_res_1/B 6.844558e-16
C6343 eeg_sdm1ct_0/eeg_fd_ota_full2_nc_0/eeg_cmfb_amp_dl2_0/VCM_SENSE VSS 2.834530e-14
C6344 eeg_sdm1ct_0/eeg_fd_ota_full2_nc_0/eeg_cmfb_amp_dl2_0/VCM_SENSE eeg_sdm1ct_0/eeg_fd_ota_full2_nc_0/eeg_fd_ota_core_soft_0/m1_28741_3443# 7.672760e-17
C6346 eeg_sdm1ct_0/eeg_fd_ota_full2_nc_0/eeg_cmfb_amp_dl2_0/VCM_SENSE eeg_sdm1ct_0/eeg_fd_ota_full2_nc_0/eeg_fd_ota_core_soft_0/m1_n29259_3443# 7.672760e-17
C6350 eeg_sdm1ct_0/eeg_fd_ota_full2_nc_0/eeg_fd_ota_core_soft_0/m1_28341_n3864# VSS 4.702790e-16
C6351 eeg_sdm1ct_0/eeg_fd_ota_full2_nc_0/eeg_fd_ota_core_soft_0/m1_28341_n3864# eeg_sdm1ct_0/eeg_fd_ota_full2_nc_0/eeg_fd_ota_core_soft_0/m1_29141_n3864# 6.789050e-17
C6352 eeg_sdm1ct_0/eeg_fd_ota_full2_nc_0/eeg_fd_ota_core_soft_0/m1_28741_3443# VSS 4.622480e-16
C6353 eeg_sdm1ct_0/eeg_fd_ota_full2_nc_0/eeg_fd_ota_core_soft_0/m1_28741_3443# eeg_sdm1ct_0/eeg_fd_ota_full2_nc_0/eeg_fd_ota_core_soft_0/m1_29541_3443# 6.789050e-17
C6355 eeg_sdm1ct_0/eeg_fd_ota_full2_nc_0/eeg_fd_ota_core_soft_0/m1_29141_n3864# VSS 4.190540e-16
C6356 eeg_sdm1ct_0/eeg_fd_ota_full2_nc_0/eeg_fd_ota_core_soft_0/m1_29141_n3864# eeg_sdm1ct_0/eeg_fd_ota_full2_nc_0/eeg_fd_ota_core_soft_0/m1_29941_n3864# 6.789040e-17
C6357 eeg_sdm1ct_0/eeg_fd_ota_full2_nc_0/eeg_fd_ota_core_soft_0/m1_29541_3443# VSS 4.190540e-16
C6358 eeg_sdm1ct_0/eeg_fd_ota_full2_nc_0/eeg_fd_ota_core_soft_0/m1_29541_3443# eeg_sdm1ct_0/eeg_fd_ota_full2_nc_0/eeg_fd_ota_core_soft_0/m1_30341_3443# 6.789050e-17
C6360 eeg_sdm1ct_0/eeg_fd_ota_full2_nc_0/eeg_fd_ota_core_soft_0/m1_29941_n3864# VSS 4.190540e-16
C6361 eeg_sdm1ct_0/eeg_fd_ota_full2_nc_0/eeg_fd_ota_core_soft_0/m1_29941_n3864# eeg_sdm1ct_0/eeg_fd_ota_full2_nc_0/eeg_fd_ota_core_soft_0/m1_30741_n3864# 6.789050e-17
C6362 eeg_sdm1ct_0/eeg_fd_ota_full2_nc_0/eeg_fd_ota_core_soft_0/m1_30341_3443# VSS 4.190540e-16
C6363 eeg_sdm1ct_0/eeg_fd_ota_full2_nc_0/eeg_fd_ota_core_soft_0/m1_30341_3443# eeg_sdm1ct_0/eeg_fd_ota_full2_nc_0/eeg_fd_ota_core_soft_0/m1_31141_3443# 6.789050e-17
C6365 eeg_sdm1ct_0/eeg_fd_ota_full2_nc_0/eeg_fd_ota_core_soft_0/m1_30741_n3864# VSS 4.190540e-16
C6366 eeg_sdm1ct_0/eeg_fd_ota_full2_nc_0/eeg_fd_ota_core_soft_0/m1_30741_n3864# eeg_sdm1ct_0/eeg_fd_ota_full2_nc_0/eeg_fd_ota_core_soft_0/m1_31541_n3864# 6.789040e-17
C6367 eeg_sdm1ct_0/eeg_fd_ota_full2_nc_0/eeg_fd_ota_core_soft_0/m1_31141_3443# VSS 4.190540e-16
C6368 eeg_sdm1ct_0/eeg_fd_ota_full2_nc_0/eeg_fd_ota_core_soft_0/m1_31141_3443# eeg_sdm1ct_0/eeg_fd_ota_full2_nc_0/eeg_fd_ota_core_soft_0/m1_31941_3443# 6.789050e-17
C6370 eeg_sdm1ct_0/eeg_fd_ota_full2_nc_0/eeg_fd_ota_core_soft_0/m1_31541_n3864# VSS 4.190540e-16
C6371 eeg_sdm1ct_0/eeg_fd_ota_full2_nc_0/eeg_fd_ota_core_soft_0/m1_31541_n3864# eeg_sdm1ct_0/eeg_fd_ota_full2_nc_0/eeg_fd_ota_core_soft_0/m1_32341_n3864# 6.789050e-17
C6372 eeg_sdm1ct_0/eeg_fd_ota_full2_nc_0/eeg_fd_ota_core_soft_0/m1_31941_3443# VSS 4.190540e-16
C6373 eeg_sdm1ct_0/eeg_fd_ota_full2_nc_0/eeg_fd_ota_core_soft_0/m1_31941_3443# eeg_sdm1ct_0/eeg_fd_ota_full2_nc_0/eeg_fd_ota_core_soft_0/m1_32741_3443# 6.789040e-17
C6375 eeg_sdm1ct_0/eeg_fd_ota_full2_nc_0/eeg_fd_ota_core_soft_0/m1_32341_n3864# VSS 4.190540e-16
C6376 eeg_sdm1ct_0/eeg_fd_ota_full2_nc_0/eeg_fd_ota_core_soft_0/m1_32341_n3864# eeg_sdm1ct_0/eeg_fd_ota_full2_nc_0/eeg_fd_ota_core_soft_0/m1_33141_n3864# 6.789050e-17
C6377 eeg_sdm1ct_0/eeg_fd_ota_full2_nc_0/eeg_fd_ota_core_soft_0/m1_32741_3443# VSS 4.190540e-16
C6378 eeg_sdm1ct_0/eeg_fd_ota_full2_nc_0/eeg_fd_ota_core_soft_0/m1_32741_3443# eeg_sdm1ct_0/eeg_fd_ota_full2_nc_0/eeg_fd_ota_core_soft_0/m1_33541_3443# 6.789050e-17
C6380 eeg_sdm1ct_0/eeg_fd_ota_full2_nc_0/eeg_fd_ota_core_soft_0/m1_33141_n3864# VSS 4.190540e-16
C6381 eeg_sdm1ct_0/eeg_fd_ota_full2_nc_0/eeg_fd_ota_core_soft_0/m1_33141_n3864# eeg_sdm1ct_0/eeg_fd_ota_full2_nc_0/eeg_fd_ota_core_soft_0/m1_33941_n3864# 6.789050e-17
C6382 eeg_sdm1ct_0/eeg_fd_ota_full2_nc_0/eeg_fd_ota_core_soft_0/m1_33541_3443# VSS 4.190540e-16
C6383 eeg_sdm1ct_0/eeg_fd_ota_full2_nc_0/eeg_fd_ota_core_soft_0/m1_33541_3443# eeg_sdm1ct_0/eeg_fd_ota_full2_nc_0/eeg_fd_ota_core_soft_0/m1_34341_3443# 6.789040e-17
C6385 eeg_sdm1ct_0/eeg_fd_ota_full2_nc_0/eeg_fd_ota_core_soft_0/m1_33941_n3864# VSS 4.190540e-16
C6386 eeg_sdm1ct_0/eeg_fd_ota_full2_nc_0/eeg_fd_ota_core_soft_0/m1_33941_n3864# eeg_sdm1ct_0/eeg_fd_ota_full2_nc_0/eeg_fd_ota_core_soft_0/m1_34741_n3864# 6.789050e-17
C6387 eeg_sdm1ct_0/eeg_fd_ota_full2_nc_0/eeg_fd_ota_core_soft_0/m1_34341_3443# VSS 4.190540e-16
C6388 eeg_sdm1ct_0/eeg_fd_ota_full2_nc_0/eeg_fd_ota_core_soft_0/m1_34341_3443# eeg_sdm1ct_0/eeg_fd_ota_full2_nc_0/eeg_fd_ota_core_soft_0/m1_35141_3443# 6.789050e-17
C6390 eeg_sdm1ct_0/eeg_fd_ota_full2_nc_0/eeg_fd_ota_core_soft_0/m1_34741_n3864# VSS 4.190540e-16
C6391 eeg_sdm1ct_0/eeg_fd_ota_full2_nc_0/eeg_fd_ota_core_soft_0/m1_34741_n3864# eeg_sdm1ct_0/eeg_fd_ota_full2_nc_0/eeg_fd_ota_core_soft_0/m1_35541_n3864# 6.789040e-17
C6392 eeg_sdm1ct_0/eeg_fd_ota_full2_nc_0/eeg_fd_ota_core_soft_0/m1_35141_3443# VSS 4.190540e-16
C6393 eeg_sdm1ct_0/eeg_fd_ota_full2_nc_0/eeg_fd_ota_core_soft_0/m1_35141_3443# eeg_sdm1ct_0/eeg_fd_ota_full2_nc_0/eeg_fd_ota_core_soft_0/m1_35941_3443# 6.789050e-17
C6395 eeg_sdm1ct_0/eeg_fd_ota_full2_nc_0/eeg_fd_ota_core_soft_0/m1_35541_n3864# VSS 4.190540e-16
C6396 eeg_sdm1ct_0/eeg_fd_ota_full2_nc_0/eeg_fd_ota_core_soft_0/m1_35541_n3864# eeg_sdm1ct_0/eeg_fd_ota_full2_nc_0/eeg_fd_ota_core_soft_0/m1_36341_n3864# 6.789050e-17
C6397 eeg_sdm1ct_0/eeg_fd_ota_full2_nc_0/eeg_fd_ota_core_soft_0/m1_35941_3443# VSS 4.190540e-16
C6398 eeg_sdm1ct_0/eeg_fd_ota_full2_nc_0/eeg_fd_ota_core_soft_0/m1_35941_3443# eeg_sdm1ct_0/eeg_fd_ota_full2_nc_0/eeg_fd_ota_core_soft_0/m1_36741_3443# 6.789050e-17
C6400 eeg_sdm1ct_0/eeg_fd_ota_full2_nc_0/eeg_fd_ota_core_soft_0/m1_36341_n3864# VSS 4.190540e-16
C6401 eeg_sdm1ct_0/eeg_fd_ota_full2_nc_0/eeg_fd_ota_core_soft_0/m1_36341_n3864# eeg_sdm1ct_0/eeg_fd_ota_full2_nc_0/eeg_fd_ota_core_soft_0/m1_37141_n3864# 6.789040e-17
C6402 eeg_sdm1ct_0/eeg_fd_ota_full2_nc_0/eeg_fd_ota_core_soft_0/m1_36741_3443# VSS 4.190540e-16
C6403 eeg_sdm1ct_0/eeg_fd_ota_full2_nc_0/eeg_fd_ota_core_soft_0/m1_36741_3443# eeg_sdm1ct_0/eeg_fd_ota_full2_nc_0/eeg_fd_ota_core_soft_0/m1_37541_3443# 6.789050e-17
C6405 eeg_sdm1ct_0/eeg_fd_ota_full2_nc_0/eeg_fd_ota_core_soft_0/m1_37141_n3864# VSS 4.190540e-16
C6406 eeg_sdm1ct_0/eeg_fd_ota_full2_nc_0/eeg_fd_ota_core_soft_0/m1_37141_n3864# eeg_sdm1ct_0/eeg_fd_ota_full2_nc_0/eeg_fd_ota_core_soft_0/m1_37941_n3864# 6.789050e-17
C6407 eeg_sdm1ct_0/eeg_fd_ota_full2_nc_0/eeg_fd_ota_core_soft_0/m1_37541_3443# VSS 4.190540e-16
C6408 eeg_sdm1ct_0/eeg_fd_ota_full2_nc_0/eeg_fd_ota_core_soft_0/m1_37541_3443# eeg_sdm1ct_0/eeg_fd_ota_full2_nc_0/eeg_fd_ota_core_soft_0/m1_38341_3443# 6.789040e-17
C6410 eeg_sdm1ct_0/eeg_fd_ota_full2_nc_0/eeg_fd_ota_core_soft_0/m1_37941_n3864# VSS 4.190540e-16
C6411 eeg_sdm1ct_0/eeg_fd_ota_full2_nc_0/eeg_fd_ota_core_soft_0/m1_37941_n3864# eeg_sdm1ct_0/eeg_fd_ota_full2_nc_0/eeg_fd_ota_core_soft_0/m1_38741_n3864# 6.789050e-17
C6412 eeg_sdm1ct_0/eeg_fd_ota_full2_nc_0/eeg_fd_ota_core_soft_0/m1_38341_3443# VSS 4.190540e-16
C6413 eeg_sdm1ct_0/eeg_fd_ota_full2_nc_0/eeg_fd_ota_core_soft_0/m1_38341_3443# eeg_sdm1ct_0/eeg_fd_ota_full2_nc_0/eeg_fd_ota_core_soft_0/m1_39141_3443# 6.789050e-17
C6415 eeg_sdm1ct_0/eeg_fd_ota_full2_nc_0/eeg_fd_ota_core_soft_0/m1_38741_n3864# VSS 4.190540e-16
C6416 eeg_sdm1ct_0/eeg_fd_ota_full2_nc_0/eeg_fd_ota_core_soft_0/m1_38741_n3864# eeg_sdm1ct_0/eeg_fd_ota_full2_nc_0/eeg_fd_ota_core_soft_0/m1_39541_n3864# 6.789050e-17
C6417 eeg_sdm1ct_0/eeg_fd_ota_full2_nc_0/eeg_fd_ota_core_soft_0/m1_39141_3443# VSS 4.190540e-16
C6418 eeg_sdm1ct_0/eeg_fd_ota_full2_nc_0/eeg_fd_ota_core_soft_0/m1_39141_3443# eeg_sdm1ct_0/eeg_fd_ota_full2_nc_0/eeg_fd_ota_core_soft_0/m1_39941_3443# 6.789040e-17
C6420 eeg_sdm1ct_0/eeg_fd_ota_full2_nc_0/eeg_fd_ota_core_soft_0/m1_39541_n3864# VSS 4.190540e-16
C6421 eeg_sdm1ct_0/eeg_fd_ota_full2_nc_0/eeg_fd_ota_core_soft_0/m1_39541_n3864# eeg_sdm1ct_0/eeg_fd_ota_full2_nc_0/eeg_fd_ota_core_soft_0/m1_40341_n3864# 6.789050e-17
C6422 eeg_sdm1ct_0/eeg_fd_ota_full2_nc_0/eeg_fd_ota_core_soft_0/m1_39941_3443# VSS 4.190540e-16
C6423 eeg_sdm1ct_0/eeg_fd_ota_full2_nc_0/eeg_fd_ota_core_soft_0/m1_39941_3443# eeg_sdm1ct_0/eeg_fd_ota_full2_nc_0/eeg_fd_ota_core_soft_0/m1_40741_3443# 6.789050e-17
C6425 eeg_sdm1ct_0/eeg_fd_ota_full2_nc_0/eeg_fd_ota_core_soft_0/m1_40341_n3864# VSS 4.190540e-16
C6426 eeg_sdm1ct_0/eeg_fd_ota_full2_nc_0/eeg_fd_ota_core_soft_0/m1_40341_n3864# eeg_sdm1ct_0/eeg_fd_ota_full2_nc_0/eeg_fd_ota_core_soft_0/m1_41141_n3864# 6.789040e-17
C6427 eeg_sdm1ct_0/eeg_fd_ota_full2_nc_0/eeg_fd_ota_core_soft_0/m1_40741_3443# VSS 4.190540e-16
C6428 eeg_sdm1ct_0/eeg_fd_ota_full2_nc_0/eeg_fd_ota_core_soft_0/m1_40741_3443# eeg_sdm1ct_0/eeg_fd_ota_full2_nc_0/eeg_fd_ota_core_soft_0/m1_41541_3443# 6.789050e-17
C6430 eeg_sdm1ct_0/eeg_fd_ota_full2_nc_0/eeg_fd_ota_core_soft_0/m1_41141_n3864# VSS 4.190540e-16
C6431 eeg_sdm1ct_0/eeg_fd_ota_full2_nc_0/eeg_fd_ota_core_soft_0/m1_41141_n3864# eeg_sdm1ct_0/eeg_fd_ota_full2_nc_0/eeg_fd_ota_core_soft_0/m1_41941_n3864# 6.789050e-17
C6432 eeg_sdm1ct_0/eeg_fd_ota_full2_nc_0/eeg_fd_ota_core_soft_0/m1_41541_3443# VSS 4.190540e-16
C6433 eeg_sdm1ct_0/eeg_fd_ota_full2_nc_0/eeg_fd_ota_core_soft_0/m1_41541_3443# eeg_sdm1ct_0/eeg_fd_ota_full2_nc_0/eeg_fd_ota_core_soft_0/m1_42341_3443# 6.789050e-17
C6435 eeg_sdm1ct_0/eeg_fd_ota_full2_nc_0/eeg_fd_ota_core_soft_0/m1_41941_n3864# VSS 4.190540e-16
C6436 eeg_sdm1ct_0/eeg_fd_ota_full2_nc_0/eeg_fd_ota_core_soft_0/m1_41941_n3864# eeg_sdm1ct_0/eeg_fd_ota_full2_nc_0/eeg_fd_ota_core_soft_0/m1_42741_n3864# 6.789040e-17
C6437 eeg_sdm1ct_0/eeg_fd_ota_full2_nc_0/eeg_fd_ota_core_soft_0/m1_42341_3443# VSS 4.190540e-16
C6438 eeg_sdm1ct_0/eeg_fd_ota_full2_nc_0/eeg_fd_ota_core_soft_0/m1_42341_3443# eeg_sdm1ct_0/eeg_fd_ota_full2_nc_0/eeg_fd_ota_core_soft_0/m1_43141_3443# 6.789050e-17
C6440 eeg_sdm1ct_0/eeg_fd_ota_full2_nc_0/eeg_fd_ota_core_soft_0/m1_42741_n3864# VSS 4.190540e-16
C6441 eeg_sdm1ct_0/eeg_fd_ota_full2_nc_0/eeg_fd_ota_core_soft_0/m1_42741_n3864# eeg_sdm1ct_0/eeg_fd_ota_full2_nc_0/eeg_fd_ota_core_soft_0/m1_43541_n3864# 6.789050e-17
C6442 eeg_sdm1ct_0/eeg_fd_ota_full2_nc_0/eeg_fd_ota_core_soft_0/m1_43141_3443# VSS 4.190540e-16
C6443 eeg_sdm1ct_0/eeg_fd_ota_full2_nc_0/eeg_fd_ota_core_soft_0/m1_43141_3443# eeg_sdm1ct_0/eeg_fd_ota_full2_nc_0/eeg_fd_ota_core_soft_0/m1_43941_3443# 6.789040e-17
C6445 eeg_sdm1ct_0/eeg_fd_ota_full2_nc_0/eeg_fd_ota_core_soft_0/m1_43541_n3864# VSS 4.190540e-16
C6446 eeg_sdm1ct_0/eeg_fd_ota_full2_nc_0/eeg_fd_ota_core_soft_0/m1_43541_n3864# eeg_sdm1ct_0/eeg_fd_ota_full2_nc_0/eeg_fd_ota_core_soft_0/m1_44341_n3864# 6.789050e-17
C6447 eeg_sdm1ct_0/eeg_fd_ota_full2_nc_0/eeg_fd_ota_core_soft_0/m1_43941_3443# VSS 4.190540e-16
C6448 eeg_sdm1ct_0/eeg_fd_ota_full2_nc_0/eeg_fd_ota_core_soft_0/m1_43941_3443# eeg_sdm1ct_0/eeg_fd_ota_full2_nc_0/eeg_fd_ota_core_soft_0/m1_44741_3443# 6.789050e-17
C6450 eeg_sdm1ct_0/eeg_fd_ota_full2_nc_0/eeg_fd_ota_core_soft_0/m1_44341_n3864# VSS 4.190540e-16
C6451 eeg_sdm1ct_0/eeg_fd_ota_full2_nc_0/eeg_fd_ota_core_soft_0/m1_44341_n3864# eeg_sdm1ct_0/eeg_fd_ota_full2_nc_0/eeg_fd_ota_core_soft_0/m1_45141_n3864# 6.789050e-17
C6452 eeg_sdm1ct_0/eeg_fd_ota_full2_nc_0/eeg_fd_ota_core_soft_0/m1_44741_3443# VSS 4.190540e-16
C6453 eeg_sdm1ct_0/eeg_fd_ota_full2_nc_0/eeg_fd_ota_core_soft_0/m1_44741_3443# eeg_sdm1ct_0/eeg_fd_ota_full2_nc_0/eeg_fd_ota_core_soft_0/m1_45541_3443# 6.789040e-17
C6455 eeg_sdm1ct_0/eeg_fd_ota_full2_nc_0/eeg_fd_ota_core_soft_0/m1_45141_n3864# VSS 4.190540e-16
C6456 eeg_sdm1ct_0/eeg_fd_ota_full2_nc_0/eeg_fd_ota_core_soft_0/m1_45141_n3864# eeg_sdm1ct_0/eeg_fd_ota_full2_nc_0/eeg_fd_ota_core_soft_0/m1_45941_n3864# 6.789050e-17
C6457 eeg_sdm1ct_0/eeg_fd_ota_full2_nc_0/eeg_fd_ota_core_soft_0/m1_45541_3443# VSS 4.190540e-16
C6458 eeg_sdm1ct_0/eeg_fd_ota_full2_nc_0/eeg_fd_ota_core_soft_0/m1_45541_3443# eeg_sdm1ct_0/eeg_fd_ota_full2_nc_0/eeg_fd_ota_core_soft_0/m1_46341_3443# 6.789050e-17
C6460 eeg_sdm1ct_0/eeg_fd_ota_full2_nc_0/eeg_fd_ota_core_soft_0/m1_45941_n3864# VSS 4.190540e-16
C6461 eeg_sdm1ct_0/eeg_fd_ota_full2_nc_0/eeg_fd_ota_core_soft_0/m1_45941_n3864# eeg_sdm1ct_0/eeg_fd_ota_full2_nc_0/eeg_fd_ota_core_soft_0/m1_46741_n3864# 6.789040e-17
C6462 eeg_sdm1ct_0/eeg_fd_ota_full2_nc_0/eeg_fd_ota_core_soft_0/m1_46341_3443# VSS 4.190540e-16
C6463 eeg_sdm1ct_0/eeg_fd_ota_full2_nc_0/eeg_fd_ota_core_soft_0/m1_46341_3443# eeg_sdm1ct_0/eeg_fd_ota_full2_nc_0/eeg_fd_ota_core_soft_0/m1_47141_3443# 6.789050e-17
C6465 eeg_sdm1ct_0/eeg_fd_ota_full2_nc_0/eeg_fd_ota_core_soft_0/m1_46741_n3864# VSS 4.190540e-16
C6466 eeg_sdm1ct_0/eeg_fd_ota_full2_nc_0/eeg_fd_ota_core_soft_0/m1_46741_n3864# eeg_sdm1ct_0/eeg_fd_ota_full2_nc_0/eeg_fd_ota_core_soft_0/m1_47541_n3864# 6.789050e-17
C6467 eeg_sdm1ct_0/eeg_fd_ota_full2_nc_0/eeg_fd_ota_core_soft_0/m1_47141_3443# VSS 4.607340e-16
C6468 eeg_sdm1ct_0/eeg_fd_ota_full2_nc_0/eeg_fd_ota_core_soft_0/m1_47141_3443# eeg_sdm1ct_0/eeg_fd_ota_full2_nc_0/stage2_0/N2N 9.923910e-17
C6469 eeg_sdm1ct_0/eeg_fd_ota_full2_nc_0/eeg_fd_ota_core_soft_0/m1_47541_n3864# VSS 4.702790e-16
C6470 eeg_sdm1ct_0/eeg_fd_ota_full2_nc_0/eeg_fd_ota_core_soft_0/m1_50741_n3864# VSS 4.702790e-16
C6471 eeg_sdm1ct_0/eeg_fd_ota_full2_nc_0/eeg_fd_ota_core_soft_0/m1_50741_n3864# eeg_sdm1ct_0/eeg_fd_ota_full2_nc_0/eeg_fd_ota_core_soft_0/m1_51541_n3864# 6.789050e-17
C6472 eeg_sdm1ct_0/eeg_fd_ota_full2_nc_0/eeg_fd_ota_core_soft_0/m1_51141_3443# VSS 4.622480e-16
C6473 eeg_sdm1ct_0/eeg_fd_ota_full2_nc_0/eeg_fd_ota_core_soft_0/m1_51141_3443# eeg_sdm1ct_0/eeg_fd_ota_full2_nc_0/eeg_fd_ota_core_soft_0/m1_51941_3443# 6.789050e-17
C6475 eeg_sdm1ct_0/eeg_fd_ota_full2_nc_0/eeg_fd_ota_core_soft_0/m1_51541_n3864# VSS 4.190540e-16
C6476 eeg_sdm1ct_0/eeg_fd_ota_full2_nc_0/eeg_fd_ota_core_soft_0/m1_51541_n3864# eeg_sdm1ct_0/eeg_fd_ota_full2_nc_0/eeg_fd_ota_core_soft_0/m1_52341_n3864# 6.789040e-17
C6477 eeg_sdm1ct_0/eeg_fd_ota_full2_nc_0/eeg_fd_ota_core_soft_0/m1_51941_3443# VSS 4.190540e-16
C6478 eeg_sdm1ct_0/eeg_fd_ota_full2_nc_0/eeg_fd_ota_core_soft_0/m1_51941_3443# eeg_sdm1ct_0/eeg_fd_ota_full2_nc_0/eeg_fd_ota_core_soft_0/m1_52741_3443# 6.789050e-17
C6480 eeg_sdm1ct_0/eeg_fd_ota_full2_nc_0/eeg_fd_ota_core_soft_0/m1_52341_n3864# VSS 4.190540e-16
C6481 eeg_sdm1ct_0/eeg_fd_ota_full2_nc_0/eeg_fd_ota_core_soft_0/m1_52341_n3864# eeg_sdm1ct_0/eeg_fd_ota_full2_nc_0/eeg_fd_ota_core_soft_0/m1_53141_n3864# 6.789050e-17
C6482 eeg_sdm1ct_0/eeg_fd_ota_full2_nc_0/eeg_fd_ota_core_soft_0/m1_52741_3443# VSS 4.190540e-16
C6483 eeg_sdm1ct_0/eeg_fd_ota_full2_nc_0/eeg_fd_ota_core_soft_0/m1_52741_3443# eeg_sdm1ct_0/eeg_fd_ota_full2_nc_0/eeg_fd_ota_core_soft_0/m1_53541_3443# 6.789050e-17
C6485 eeg_sdm1ct_0/eeg_fd_ota_full2_nc_0/eeg_fd_ota_core_soft_0/m1_53141_n3864# VSS 4.190540e-16
C6486 eeg_sdm1ct_0/eeg_fd_ota_full2_nc_0/eeg_fd_ota_core_soft_0/m1_53141_n3864# eeg_sdm1ct_0/eeg_fd_ota_full2_nc_0/eeg_fd_ota_core_soft_0/m1_53941_n3864# 6.789040e-17
C6487 eeg_sdm1ct_0/eeg_fd_ota_full2_nc_0/eeg_fd_ota_core_soft_0/m1_53541_3443# VSS 4.190540e-16
C6488 eeg_sdm1ct_0/eeg_fd_ota_full2_nc_0/eeg_fd_ota_core_soft_0/m1_53541_3443# eeg_sdm1ct_0/eeg_fd_ota_full2_nc_0/eeg_fd_ota_core_soft_0/m1_54341_3443# 6.789050e-17
C6490 eeg_sdm1ct_0/eeg_fd_ota_full2_nc_0/eeg_fd_ota_core_soft_0/m1_53941_n3864# VSS 4.190540e-16
C6491 eeg_sdm1ct_0/eeg_fd_ota_full2_nc_0/eeg_fd_ota_core_soft_0/m1_53941_n3864# eeg_sdm1ct_0/eeg_fd_ota_full2_nc_0/eeg_fd_ota_core_soft_0/m1_54741_n3864# 6.789050e-17
C6492 eeg_sdm1ct_0/eeg_fd_ota_full2_nc_0/eeg_fd_ota_core_soft_0/m1_54341_3443# VSS 4.190540e-16
C6493 eeg_sdm1ct_0/eeg_fd_ota_full2_nc_0/eeg_fd_ota_core_soft_0/m1_54341_3443# eeg_sdm1ct_0/eeg_fd_ota_full2_nc_0/eeg_fd_ota_core_soft_0/m1_55141_3443# 6.789040e-17
C6495 eeg_sdm1ct_0/eeg_fd_ota_full2_nc_0/eeg_fd_ota_core_soft_0/m1_54741_n3864# VSS 4.190540e-16
C6496 eeg_sdm1ct_0/eeg_fd_ota_full2_nc_0/eeg_fd_ota_core_soft_0/m1_54741_n3864# eeg_sdm1ct_0/eeg_fd_ota_full2_nc_0/eeg_fd_ota_core_soft_0/m1_55541_n3864# 6.789050e-17
C6497 eeg_sdm1ct_0/eeg_fd_ota_full2_nc_0/eeg_fd_ota_core_soft_0/m1_55141_3443# VSS 4.190540e-16
C6498 eeg_sdm1ct_0/eeg_fd_ota_full2_nc_0/eeg_fd_ota_core_soft_0/m1_55141_3443# eeg_sdm1ct_0/eeg_fd_ota_full2_nc_0/eeg_fd_ota_core_soft_0/m1_55941_3443# 6.789050e-17
C6500 eeg_sdm1ct_0/eeg_fd_ota_full2_nc_0/eeg_fd_ota_core_soft_0/m1_55541_n3864# VSS 4.190540e-16
C6501 eeg_sdm1ct_0/eeg_fd_ota_full2_nc_0/eeg_fd_ota_core_soft_0/m1_55541_n3864# eeg_sdm1ct_0/eeg_fd_ota_full2_nc_0/eeg_fd_ota_core_soft_0/m1_56341_n3864# 6.789050e-17
C6502 eeg_sdm1ct_0/eeg_fd_ota_full2_nc_0/eeg_fd_ota_core_soft_0/m1_55941_3443# VSS 4.190540e-16
C6503 eeg_sdm1ct_0/eeg_fd_ota_full2_nc_0/eeg_fd_ota_core_soft_0/m1_55941_3443# eeg_sdm1ct_0/eeg_fd_ota_full2_nc_0/eeg_fd_ota_core_soft_0/m1_56741_3443# 6.789040e-17
C6505 eeg_sdm1ct_0/eeg_fd_ota_full2_nc_0/eeg_fd_ota_core_soft_0/m1_56341_n3864# VSS 4.190540e-16
C6506 eeg_sdm1ct_0/eeg_fd_ota_full2_nc_0/eeg_fd_ota_core_soft_0/m1_56341_n3864# eeg_sdm1ct_0/eeg_fd_ota_full2_nc_0/eeg_fd_ota_core_soft_0/m1_57141_n3864# 6.789050e-17
C6507 eeg_sdm1ct_0/eeg_fd_ota_full2_nc_0/eeg_fd_ota_core_soft_0/m1_56741_3443# VSS 4.190540e-16
C6508 eeg_sdm1ct_0/eeg_fd_ota_full2_nc_0/eeg_fd_ota_core_soft_0/m1_56741_3443# eeg_sdm1ct_0/eeg_fd_ota_full2_nc_0/eeg_fd_ota_core_soft_0/m1_57541_3443# 6.789050e-17
C6510 eeg_sdm1ct_0/eeg_fd_ota_full2_nc_0/eeg_fd_ota_core_soft_0/m1_57141_n3864# VSS 4.190540e-16
C6511 eeg_sdm1ct_0/eeg_fd_ota_full2_nc_0/eeg_fd_ota_core_soft_0/m1_57141_n3864# eeg_sdm1ct_0/eeg_fd_ota_full2_nc_0/eeg_fd_ota_core_soft_0/m1_57941_n3864# 6.789040e-17
C6512 eeg_sdm1ct_0/eeg_fd_ota_full2_nc_0/eeg_fd_ota_core_soft_0/m1_57541_3443# VSS 4.607340e-16
C6513 eeg_sdm1ct_0/eeg_fd_ota_full2_nc_0/eeg_fd_ota_core_soft_0/m1_57541_3443# eeg_sdm1ct_0/eeg_fd_ota_full2_nc_0/stage2_0/N2N 9.923911e-17
C6514 eeg_sdm1ct_0/eeg_fd_ota_full2_nc_0/eeg_fd_ota_core_soft_0/m1_57941_n3864# VSS 4.702790e-16
C6515 eeg_sdm1ct_0/eeg_fd_ota_full2_nc_0/eeg_fd_ota_core_soft_0/m1_n22658_111# VSS 1.794040e-14
C6516 eeg_sdm1ct_0/eeg_fd_ota_full2_nc_0/eeg_fd_ota_core_soft_0/m1_n22658_111# eeg_sdm1ct_0/eeg_fd_ota_full2_nc_0/stage2_0/N2N 3.475590e-16
C6517 eeg_sdm1ct_0/eeg_fd_ota_full2_nc_0/eeg_fd_ota_core_soft_0/m1_n22658_111# eeg_sdm1ct_0/eeg_fd_ota_full2_nc_0/stage2_0/N2P 5.910065e-17
C6518 eeg_sdm1ct_0/eeg_fd_ota_full2_nc_0/eeg_fd_ota_core_soft_0/m1_n22658_111# eeg_sdm1ct_0/eeg_pseudo_res_0/B 4.063561e-15
C6519 eeg_sdm1ct_0/eeg_fd_ota_full2_nc_0/eeg_fd_ota_core_soft_0/m1_n22658_111# eeg_sdm1ct_0/eeg_pseudo_res_1/B 4.388117e-15
C6520 eeg_sdm1ct_0/eeg_fd_ota_full2_nc_0/eeg_fd_ota_core_soft_0/m1_n28859_n3864# VSS 4.702790e-16
C6521 eeg_sdm1ct_0/eeg_fd_ota_full2_nc_0/eeg_fd_ota_core_soft_0/m1_n28859_n3864# eeg_sdm1ct_0/eeg_fd_ota_full2_nc_0/eeg_fd_ota_core_soft_0/m1_n29659_n3864# 6.789040e-17
C6522 eeg_sdm1ct_0/eeg_fd_ota_full2_nc_0/eeg_fd_ota_core_soft_0/m1_n29259_3443# VSS 4.622480e-16
C6523 eeg_sdm1ct_0/eeg_fd_ota_full2_nc_0/eeg_fd_ota_core_soft_0/m1_n29259_3443# eeg_sdm1ct_0/eeg_fd_ota_full2_nc_0/eeg_fd_ota_core_soft_0/m1_n30059_3443# 6.789050e-17
C6525 eeg_sdm1ct_0/eeg_fd_ota_full2_nc_0/eeg_fd_ota_core_soft_0/m1_n29659_n3864# VSS 4.190540e-16
C6526 eeg_sdm1ct_0/eeg_fd_ota_full2_nc_0/eeg_fd_ota_core_soft_0/m1_n29659_n3864# eeg_sdm1ct_0/eeg_fd_ota_full2_nc_0/eeg_fd_ota_core_soft_0/m1_n30459_n3864# 6.789050e-17
C6527 eeg_sdm1ct_0/eeg_fd_ota_full2_nc_0/eeg_fd_ota_core_soft_0/m1_n30059_3443# VSS 4.190540e-16
C6528 eeg_sdm1ct_0/eeg_fd_ota_full2_nc_0/eeg_fd_ota_core_soft_0/m1_n30059_3443# eeg_sdm1ct_0/eeg_fd_ota_full2_nc_0/eeg_fd_ota_core_soft_0/m1_n30859_3443# 6.789040e-17
C6530 eeg_sdm1ct_0/eeg_fd_ota_full2_nc_0/eeg_fd_ota_core_soft_0/m1_n30459_n3864# VSS 4.190540e-16
C6531 eeg_sdm1ct_0/eeg_fd_ota_full2_nc_0/eeg_fd_ota_core_soft_0/m1_n30459_n3864# eeg_sdm1ct_0/eeg_fd_ota_full2_nc_0/eeg_fd_ota_core_soft_0/m1_n31259_n3864# 6.789050e-17
C6532 eeg_sdm1ct_0/eeg_fd_ota_full2_nc_0/eeg_fd_ota_core_soft_0/m1_n30859_3443# VSS 4.190540e-16
C6533 eeg_sdm1ct_0/eeg_fd_ota_full2_nc_0/eeg_fd_ota_core_soft_0/m1_n30859_3443# eeg_sdm1ct_0/eeg_fd_ota_full2_nc_0/eeg_fd_ota_core_soft_0/m1_n31659_3443# 6.789050e-17
C6535 eeg_sdm1ct_0/eeg_fd_ota_full2_nc_0/eeg_fd_ota_core_soft_0/m1_n31259_n3864# VSS 4.190540e-16
C6536 eeg_sdm1ct_0/eeg_fd_ota_full2_nc_0/eeg_fd_ota_core_soft_0/m1_n31259_n3864# eeg_sdm1ct_0/eeg_fd_ota_full2_nc_0/eeg_fd_ota_core_soft_0/m1_n32059_n3864# 6.789050e-17
C6537 eeg_sdm1ct_0/eeg_fd_ota_full2_nc_0/eeg_fd_ota_core_soft_0/m1_n31659_3443# VSS 4.190540e-16
C6538 eeg_sdm1ct_0/eeg_fd_ota_full2_nc_0/eeg_fd_ota_core_soft_0/m1_n31659_3443# eeg_sdm1ct_0/eeg_fd_ota_full2_nc_0/eeg_fd_ota_core_soft_0/m1_n32459_3443# 6.789040e-17
C6540 eeg_sdm1ct_0/eeg_fd_ota_full2_nc_0/eeg_fd_ota_core_soft_0/m1_n32059_n3864# VSS 4.190540e-16
C6541 eeg_sdm1ct_0/eeg_fd_ota_full2_nc_0/eeg_fd_ota_core_soft_0/m1_n32059_n3864# eeg_sdm1ct_0/eeg_fd_ota_full2_nc_0/eeg_fd_ota_core_soft_0/m1_n32859_n3864# 6.789050e-17
C6542 eeg_sdm1ct_0/eeg_fd_ota_full2_nc_0/eeg_fd_ota_core_soft_0/m1_n32459_3443# VSS 4.190540e-16
C6543 eeg_sdm1ct_0/eeg_fd_ota_full2_nc_0/eeg_fd_ota_core_soft_0/m1_n32459_3443# eeg_sdm1ct_0/eeg_fd_ota_full2_nc_0/eeg_fd_ota_core_soft_0/m1_n33259_3443# 6.789050e-17
C6545 eeg_sdm1ct_0/eeg_fd_ota_full2_nc_0/eeg_fd_ota_core_soft_0/m1_n32859_n3864# VSS 4.190540e-16
C6546 eeg_sdm1ct_0/eeg_fd_ota_full2_nc_0/eeg_fd_ota_core_soft_0/m1_n32859_n3864# eeg_sdm1ct_0/eeg_fd_ota_full2_nc_0/eeg_fd_ota_core_soft_0/m1_n33659_n3864# 6.789040e-17
C6547 eeg_sdm1ct_0/eeg_fd_ota_full2_nc_0/eeg_fd_ota_core_soft_0/m1_n33259_3443# VSS 4.190540e-16
C6548 eeg_sdm1ct_0/eeg_fd_ota_full2_nc_0/eeg_fd_ota_core_soft_0/m1_n33259_3443# eeg_sdm1ct_0/eeg_fd_ota_full2_nc_0/eeg_fd_ota_core_soft_0/m1_n34059_3443# 6.789050e-17
C6550 eeg_sdm1ct_0/eeg_fd_ota_full2_nc_0/eeg_fd_ota_core_soft_0/m1_n33659_n3864# VSS 4.190540e-16
C6551 eeg_sdm1ct_0/eeg_fd_ota_full2_nc_0/eeg_fd_ota_core_soft_0/m1_n33659_n3864# eeg_sdm1ct_0/eeg_fd_ota_full2_nc_0/eeg_fd_ota_core_soft_0/m1_n34459_n3864# 6.789050e-17
C6552 eeg_sdm1ct_0/eeg_fd_ota_full2_nc_0/eeg_fd_ota_core_soft_0/m1_n34059_3443# VSS 4.190540e-16
C6553 eeg_sdm1ct_0/eeg_fd_ota_full2_nc_0/eeg_fd_ota_core_soft_0/m1_n34059_3443# eeg_sdm1ct_0/eeg_fd_ota_full2_nc_0/eeg_fd_ota_core_soft_0/m1_n34859_3443# 6.789050e-17
C6555 eeg_sdm1ct_0/eeg_fd_ota_full2_nc_0/eeg_fd_ota_core_soft_0/m1_n34459_n3864# VSS 4.190540e-16
C6556 eeg_sdm1ct_0/eeg_fd_ota_full2_nc_0/eeg_fd_ota_core_soft_0/m1_n34459_n3864# eeg_sdm1ct_0/eeg_fd_ota_full2_nc_0/eeg_fd_ota_core_soft_0/m1_n35259_n3864# 6.789040e-17
C6557 eeg_sdm1ct_0/eeg_fd_ota_full2_nc_0/eeg_fd_ota_core_soft_0/m1_n34859_3443# VSS 4.190540e-16
C6558 eeg_sdm1ct_0/eeg_fd_ota_full2_nc_0/eeg_fd_ota_core_soft_0/m1_n34859_3443# eeg_sdm1ct_0/eeg_fd_ota_full2_nc_0/eeg_fd_ota_core_soft_0/m1_n35659_3443# 6.789050e-17
C6560 eeg_sdm1ct_0/eeg_fd_ota_full2_nc_0/eeg_fd_ota_core_soft_0/m1_n35259_n3864# VSS 4.190540e-16
C6561 eeg_sdm1ct_0/eeg_fd_ota_full2_nc_0/eeg_fd_ota_core_soft_0/m1_n35259_n3864# eeg_sdm1ct_0/eeg_fd_ota_full2_nc_0/eeg_fd_ota_core_soft_0/m1_n36059_n3864# 6.789050e-17
C6562 eeg_sdm1ct_0/eeg_fd_ota_full2_nc_0/eeg_fd_ota_core_soft_0/m1_n35659_3443# VSS 4.190540e-16
C6563 eeg_sdm1ct_0/eeg_fd_ota_full2_nc_0/eeg_fd_ota_core_soft_0/m1_n35659_3443# eeg_sdm1ct_0/eeg_fd_ota_full2_nc_0/eeg_fd_ota_core_soft_0/m1_n36459_3443# 6.789040e-17
C6565 eeg_sdm1ct_0/eeg_fd_ota_full2_nc_0/eeg_fd_ota_core_soft_0/m1_n36059_n3864# VSS 4.190540e-16
C6566 eeg_sdm1ct_0/eeg_fd_ota_full2_nc_0/eeg_fd_ota_core_soft_0/m1_n36059_n3864# eeg_sdm1ct_0/eeg_fd_ota_full2_nc_0/eeg_fd_ota_core_soft_0/m1_n36859_n3864# 6.789050e-17
C6567 eeg_sdm1ct_0/eeg_fd_ota_full2_nc_0/eeg_fd_ota_core_soft_0/m1_n36459_3443# VSS 4.190540e-16
C6568 eeg_sdm1ct_0/eeg_fd_ota_full2_nc_0/eeg_fd_ota_core_soft_0/m1_n36459_3443# eeg_sdm1ct_0/eeg_fd_ota_full2_nc_0/eeg_fd_ota_core_soft_0/m1_n37259_3443# 6.789050e-17
C6570 eeg_sdm1ct_0/eeg_fd_ota_full2_nc_0/eeg_fd_ota_core_soft_0/m1_n36859_n3864# VSS 4.190540e-16
C6571 eeg_sdm1ct_0/eeg_fd_ota_full2_nc_0/eeg_fd_ota_core_soft_0/m1_n36859_n3864# eeg_sdm1ct_0/eeg_fd_ota_full2_nc_0/eeg_fd_ota_core_soft_0/m1_n37659_n3864# 6.789050e-17
C6572 eeg_sdm1ct_0/eeg_fd_ota_full2_nc_0/eeg_fd_ota_core_soft_0/m1_n37259_3443# VSS 4.190540e-16
C6573 eeg_sdm1ct_0/eeg_fd_ota_full2_nc_0/eeg_fd_ota_core_soft_0/m1_n37259_3443# eeg_sdm1ct_0/eeg_fd_ota_full2_nc_0/eeg_fd_ota_core_soft_0/m1_n38059_3443# 6.789040e-17
C6575 eeg_sdm1ct_0/eeg_fd_ota_full2_nc_0/eeg_fd_ota_core_soft_0/m1_n37659_n3864# VSS 4.190540e-16
C6576 eeg_sdm1ct_0/eeg_fd_ota_full2_nc_0/eeg_fd_ota_core_soft_0/m1_n37659_n3864# eeg_sdm1ct_0/eeg_fd_ota_full2_nc_0/eeg_fd_ota_core_soft_0/m1_n38459_n3864# 6.789050e-17
C6577 eeg_sdm1ct_0/eeg_fd_ota_full2_nc_0/eeg_fd_ota_core_soft_0/m1_n38059_3443# VSS 4.190540e-16
C6578 eeg_sdm1ct_0/eeg_fd_ota_full2_nc_0/eeg_fd_ota_core_soft_0/m1_n38059_3443# eeg_sdm1ct_0/eeg_fd_ota_full2_nc_0/eeg_fd_ota_core_soft_0/m1_n38859_3443# 6.789050e-17
C6580 eeg_sdm1ct_0/eeg_fd_ota_full2_nc_0/eeg_fd_ota_core_soft_0/m1_n38459_n3864# VSS 4.190540e-16
C6581 eeg_sdm1ct_0/eeg_fd_ota_full2_nc_0/eeg_fd_ota_core_soft_0/m1_n38459_n3864# eeg_sdm1ct_0/eeg_fd_ota_full2_nc_0/eeg_fd_ota_core_soft_0/m1_n39259_n3864# 6.789040e-17
C6582 eeg_sdm1ct_0/eeg_fd_ota_full2_nc_0/eeg_fd_ota_core_soft_0/m1_n38859_3443# VSS 4.190540e-16
C6583 eeg_sdm1ct_0/eeg_fd_ota_full2_nc_0/eeg_fd_ota_core_soft_0/m1_n38859_3443# eeg_sdm1ct_0/eeg_fd_ota_full2_nc_0/eeg_fd_ota_core_soft_0/m1_n39659_3443# 6.789050e-17
C6585 eeg_sdm1ct_0/eeg_fd_ota_full2_nc_0/eeg_fd_ota_core_soft_0/m1_n39259_n3864# VSS 4.190540e-16
C6586 eeg_sdm1ct_0/eeg_fd_ota_full2_nc_0/eeg_fd_ota_core_soft_0/m1_n39259_n3864# eeg_sdm1ct_0/eeg_fd_ota_full2_nc_0/eeg_fd_ota_core_soft_0/m1_n40059_n3864# 6.789050e-17
C6587 eeg_sdm1ct_0/eeg_fd_ota_full2_nc_0/eeg_fd_ota_core_soft_0/m1_n39659_3443# VSS 4.190540e-16
C6588 eeg_sdm1ct_0/eeg_fd_ota_full2_nc_0/eeg_fd_ota_core_soft_0/m1_n39659_3443# eeg_sdm1ct_0/eeg_fd_ota_full2_nc_0/eeg_fd_ota_core_soft_0/m1_n40459_3443# 6.789050e-17
C6590 eeg_sdm1ct_0/eeg_fd_ota_full2_nc_0/eeg_fd_ota_core_soft_0/m1_n40059_n3864# VSS 4.190540e-16
C6591 eeg_sdm1ct_0/eeg_fd_ota_full2_nc_0/eeg_fd_ota_core_soft_0/m1_n40059_n3864# eeg_sdm1ct_0/eeg_fd_ota_full2_nc_0/eeg_fd_ota_core_soft_0/m1_n40859_n3864# 6.789040e-17
C6592 eeg_sdm1ct_0/eeg_fd_ota_full2_nc_0/eeg_fd_ota_core_soft_0/m1_n40459_3443# VSS 4.190540e-16
C6593 eeg_sdm1ct_0/eeg_fd_ota_full2_nc_0/eeg_fd_ota_core_soft_0/m1_n40459_3443# eeg_sdm1ct_0/eeg_fd_ota_full2_nc_0/eeg_fd_ota_core_soft_0/m1_n41259_3443# 6.789050e-17
C6595 eeg_sdm1ct_0/eeg_fd_ota_full2_nc_0/eeg_fd_ota_core_soft_0/m1_n40859_n3864# VSS 4.190540e-16
C6596 eeg_sdm1ct_0/eeg_fd_ota_full2_nc_0/eeg_fd_ota_core_soft_0/m1_n40859_n3864# eeg_sdm1ct_0/eeg_fd_ota_full2_nc_0/eeg_fd_ota_core_soft_0/m1_n41659_n3864# 6.789050e-17
C6597 eeg_sdm1ct_0/eeg_fd_ota_full2_nc_0/eeg_fd_ota_core_soft_0/m1_n41259_3443# VSS 4.190540e-16
C6598 eeg_sdm1ct_0/eeg_fd_ota_full2_nc_0/eeg_fd_ota_core_soft_0/m1_n41259_3443# eeg_sdm1ct_0/eeg_fd_ota_full2_nc_0/eeg_fd_ota_core_soft_0/m1_n42059_3443# 6.789040e-17
C6600 eeg_sdm1ct_0/eeg_fd_ota_full2_nc_0/eeg_fd_ota_core_soft_0/m1_n41659_n3864# VSS 4.190540e-16
C6601 eeg_sdm1ct_0/eeg_fd_ota_full2_nc_0/eeg_fd_ota_core_soft_0/m1_n41659_n3864# eeg_sdm1ct_0/eeg_fd_ota_full2_nc_0/eeg_fd_ota_core_soft_0/m1_n42459_n3864# 6.789050e-17
C6602 eeg_sdm1ct_0/eeg_fd_ota_full2_nc_0/eeg_fd_ota_core_soft_0/m1_n42059_3443# VSS 4.190540e-16
C6603 eeg_sdm1ct_0/eeg_fd_ota_full2_nc_0/eeg_fd_ota_core_soft_0/m1_n42059_3443# eeg_sdm1ct_0/eeg_fd_ota_full2_nc_0/eeg_fd_ota_core_soft_0/m1_n42859_3443# 6.789050e-17
C6605 eeg_sdm1ct_0/eeg_fd_ota_full2_nc_0/eeg_fd_ota_core_soft_0/m1_n42459_n3864# VSS 4.190540e-16
C6606 eeg_sdm1ct_0/eeg_fd_ota_full2_nc_0/eeg_fd_ota_core_soft_0/m1_n42459_n3864# eeg_sdm1ct_0/eeg_fd_ota_full2_nc_0/eeg_fd_ota_core_soft_0/m1_n43259_n3864# 6.789050e-17
C6607 eeg_sdm1ct_0/eeg_fd_ota_full2_nc_0/eeg_fd_ota_core_soft_0/m1_n42859_3443# VSS 4.190540e-16
C6608 eeg_sdm1ct_0/eeg_fd_ota_full2_nc_0/eeg_fd_ota_core_soft_0/m1_n42859_3443# eeg_sdm1ct_0/eeg_fd_ota_full2_nc_0/eeg_fd_ota_core_soft_0/m1_n43659_3443# 6.789040e-17
C6610 eeg_sdm1ct_0/eeg_fd_ota_full2_nc_0/eeg_fd_ota_core_soft_0/m1_n43259_n3864# VSS 4.190540e-16
C6611 eeg_sdm1ct_0/eeg_fd_ota_full2_nc_0/eeg_fd_ota_core_soft_0/m1_n43259_n3864# eeg_sdm1ct_0/eeg_fd_ota_full2_nc_0/eeg_fd_ota_core_soft_0/m1_n44059_n3864# 6.789050e-17
C6612 eeg_sdm1ct_0/eeg_fd_ota_full2_nc_0/eeg_fd_ota_core_soft_0/m1_n43659_3443# VSS 4.190540e-16
C6613 eeg_sdm1ct_0/eeg_fd_ota_full2_nc_0/eeg_fd_ota_core_soft_0/m1_n43659_3443# eeg_sdm1ct_0/eeg_fd_ota_full2_nc_0/eeg_fd_ota_core_soft_0/m1_n44459_3443# 6.789050e-17
C6615 eeg_sdm1ct_0/eeg_fd_ota_full2_nc_0/eeg_fd_ota_core_soft_0/m1_n44059_n3864# VSS 4.190540e-16
C6616 eeg_sdm1ct_0/eeg_fd_ota_full2_nc_0/eeg_fd_ota_core_soft_0/m1_n44059_n3864# eeg_sdm1ct_0/eeg_fd_ota_full2_nc_0/eeg_fd_ota_core_soft_0/m1_n44859_n3864# 6.789040e-17
C6617 eeg_sdm1ct_0/eeg_fd_ota_full2_nc_0/eeg_fd_ota_core_soft_0/m1_n44459_3443# VSS 4.190540e-16
C6618 eeg_sdm1ct_0/eeg_fd_ota_full2_nc_0/eeg_fd_ota_core_soft_0/m1_n44459_3443# eeg_sdm1ct_0/eeg_fd_ota_full2_nc_0/eeg_fd_ota_core_soft_0/m1_n45259_3443# 6.789050e-17
C6620 eeg_sdm1ct_0/eeg_fd_ota_full2_nc_0/eeg_fd_ota_core_soft_0/m1_n44859_n3864# VSS 4.190540e-16
C6621 eeg_sdm1ct_0/eeg_fd_ota_full2_nc_0/eeg_fd_ota_core_soft_0/m1_n44859_n3864# eeg_sdm1ct_0/eeg_fd_ota_full2_nc_0/eeg_fd_ota_core_soft_0/m1_n45659_n3864# 6.789050e-17
C6622 eeg_sdm1ct_0/eeg_fd_ota_full2_nc_0/eeg_fd_ota_core_soft_0/m1_n45259_3443# VSS 4.190540e-16
C6623 eeg_sdm1ct_0/eeg_fd_ota_full2_nc_0/eeg_fd_ota_core_soft_0/m1_n45259_3443# eeg_sdm1ct_0/eeg_fd_ota_full2_nc_0/eeg_fd_ota_core_soft_0/m1_n46059_3443# 6.789050e-17
C6625 eeg_sdm1ct_0/eeg_fd_ota_full2_nc_0/eeg_fd_ota_core_soft_0/m1_n45659_n3864# VSS 4.190540e-16
C6626 eeg_sdm1ct_0/eeg_fd_ota_full2_nc_0/eeg_fd_ota_core_soft_0/m1_n45659_n3864# eeg_sdm1ct_0/eeg_fd_ota_full2_nc_0/eeg_fd_ota_core_soft_0/m1_n46459_n3864# 6.789040e-17
C6627 eeg_sdm1ct_0/eeg_fd_ota_full2_nc_0/eeg_fd_ota_core_soft_0/m1_n46059_3443# VSS 4.190540e-16
C6628 eeg_sdm1ct_0/eeg_fd_ota_full2_nc_0/eeg_fd_ota_core_soft_0/m1_n46059_3443# eeg_sdm1ct_0/eeg_fd_ota_full2_nc_0/eeg_fd_ota_core_soft_0/m1_n46859_3443# 6.789050e-17
C6630 eeg_sdm1ct_0/eeg_fd_ota_full2_nc_0/eeg_fd_ota_core_soft_0/m1_n46459_n3864# VSS 4.190540e-16
C6631 eeg_sdm1ct_0/eeg_fd_ota_full2_nc_0/eeg_fd_ota_core_soft_0/m1_n46459_n3864# eeg_sdm1ct_0/eeg_fd_ota_full2_nc_0/eeg_fd_ota_core_soft_0/m1_n47259_n3864# 6.789050e-17
C6632 eeg_sdm1ct_0/eeg_fd_ota_full2_nc_0/eeg_fd_ota_core_soft_0/m1_n46859_3443# VSS 4.190540e-16
C6633 eeg_sdm1ct_0/eeg_fd_ota_full2_nc_0/eeg_fd_ota_core_soft_0/m1_n46859_3443# eeg_sdm1ct_0/eeg_fd_ota_full2_nc_0/eeg_fd_ota_core_soft_0/m1_n47659_3443# 6.789040e-17
C6635 eeg_sdm1ct_0/eeg_fd_ota_full2_nc_0/eeg_fd_ota_core_soft_0/m1_n47259_n3864# VSS 4.190540e-16
C6636 eeg_sdm1ct_0/eeg_fd_ota_full2_nc_0/eeg_fd_ota_core_soft_0/m1_n47259_n3864# eeg_sdm1ct_0/eeg_fd_ota_full2_nc_0/eeg_fd_ota_core_soft_0/m1_n48059_n3864# 6.789050e-17
C6637 eeg_sdm1ct_0/eeg_fd_ota_full2_nc_0/eeg_fd_ota_core_soft_0/m1_n47659_3443# VSS 4.607340e-16
C6638 eeg_sdm1ct_0/eeg_fd_ota_full2_nc_0/eeg_fd_ota_core_soft_0/m1_n47659_3443# eeg_sdm1ct_0/eeg_fd_ota_full2_nc_0/stage2_0/N2P 1.052830e-16
C6639 eeg_sdm1ct_0/eeg_fd_ota_full2_nc_0/eeg_fd_ota_core_soft_0/m1_n48059_n3864# VSS 4.702790e-16
C6640 eeg_sdm1ct_0/eeg_fd_ota_full2_nc_0/eeg_fd_ota_core_soft_0/m1_n51259_n3864# VSS 4.702790e-16
C6641 eeg_sdm1ct_0/eeg_fd_ota_full2_nc_0/eeg_fd_ota_core_soft_0/m1_n51259_n3864# eeg_sdm1ct_0/eeg_fd_ota_full2_nc_0/eeg_fd_ota_core_soft_0/m1_n52059_n3864# 6.789040e-17
C6642 eeg_sdm1ct_0/eeg_fd_ota_full2_nc_0/eeg_fd_ota_core_soft_0/m1_n51659_3443# VSS 4.622480e-16
C6643 eeg_sdm1ct_0/eeg_fd_ota_full2_nc_0/eeg_fd_ota_core_soft_0/m1_n51659_3443# eeg_sdm1ct_0/eeg_fd_ota_full2_nc_0/eeg_fd_ota_core_soft_0/m1_n52459_3443# 6.789050e-17
C6645 eeg_sdm1ct_0/eeg_fd_ota_full2_nc_0/eeg_fd_ota_core_soft_0/m1_n52059_n3864# VSS 4.190540e-16
C6646 eeg_sdm1ct_0/eeg_fd_ota_full2_nc_0/eeg_fd_ota_core_soft_0/m1_n52059_n3864# eeg_sdm1ct_0/eeg_fd_ota_full2_nc_0/eeg_fd_ota_core_soft_0/m1_n52859_n3864# 6.789050e-17
C6647 eeg_sdm1ct_0/eeg_fd_ota_full2_nc_0/eeg_fd_ota_core_soft_0/m1_n52459_3443# VSS 4.190540e-16
C6648 eeg_sdm1ct_0/eeg_fd_ota_full2_nc_0/eeg_fd_ota_core_soft_0/m1_n52459_3443# eeg_sdm1ct_0/eeg_fd_ota_full2_nc_0/eeg_fd_ota_core_soft_0/m1_n53259_3443# 6.789040e-17
C6650 eeg_sdm1ct_0/eeg_fd_ota_full2_nc_0/eeg_fd_ota_core_soft_0/m1_n52859_n3864# VSS 4.190540e-16
C6651 eeg_sdm1ct_0/eeg_fd_ota_full2_nc_0/eeg_fd_ota_core_soft_0/m1_n52859_n3864# eeg_sdm1ct_0/eeg_fd_ota_full2_nc_0/eeg_fd_ota_core_soft_0/m1_n53659_n3864# 6.789050e-17
C6652 eeg_sdm1ct_0/eeg_fd_ota_full2_nc_0/eeg_fd_ota_core_soft_0/m1_n53259_3443# VSS 4.190540e-16
C6653 eeg_sdm1ct_0/eeg_fd_ota_full2_nc_0/eeg_fd_ota_core_soft_0/m1_n53259_3443# eeg_sdm1ct_0/eeg_fd_ota_full2_nc_0/eeg_fd_ota_core_soft_0/m1_n54059_3443# 6.789050e-17
C6655 eeg_sdm1ct_0/eeg_fd_ota_full2_nc_0/eeg_fd_ota_core_soft_0/m1_n53659_n3864# VSS 4.190540e-16
C6656 eeg_sdm1ct_0/eeg_fd_ota_full2_nc_0/eeg_fd_ota_core_soft_0/m1_n53659_n3864# eeg_sdm1ct_0/eeg_fd_ota_full2_nc_0/eeg_fd_ota_core_soft_0/m1_n54459_n3864# 6.789050e-17
C6657 eeg_sdm1ct_0/eeg_fd_ota_full2_nc_0/eeg_fd_ota_core_soft_0/m1_n54059_3443# VSS 4.190540e-16
C6658 eeg_sdm1ct_0/eeg_fd_ota_full2_nc_0/eeg_fd_ota_core_soft_0/m1_n54059_3443# eeg_sdm1ct_0/eeg_fd_ota_full2_nc_0/eeg_fd_ota_core_soft_0/m1_n54859_3443# 6.789040e-17
C6660 eeg_sdm1ct_0/eeg_fd_ota_full2_nc_0/eeg_fd_ota_core_soft_0/m1_n54459_n3864# VSS 4.190540e-16
C6661 eeg_sdm1ct_0/eeg_fd_ota_full2_nc_0/eeg_fd_ota_core_soft_0/m1_n54459_n3864# eeg_sdm1ct_0/eeg_fd_ota_full2_nc_0/eeg_fd_ota_core_soft_0/m1_n55259_n3864# 6.789050e-17
C6662 eeg_sdm1ct_0/eeg_fd_ota_full2_nc_0/eeg_fd_ota_core_soft_0/m1_n54859_3443# VSS 4.190540e-16
C6663 eeg_sdm1ct_0/eeg_fd_ota_full2_nc_0/eeg_fd_ota_core_soft_0/m1_n54859_3443# eeg_sdm1ct_0/eeg_fd_ota_full2_nc_0/eeg_fd_ota_core_soft_0/m1_n55659_3443# 6.789050e-17
C6665 eeg_sdm1ct_0/eeg_fd_ota_full2_nc_0/eeg_fd_ota_core_soft_0/m1_n55259_n3864# VSS 4.190540e-16
C6666 eeg_sdm1ct_0/eeg_fd_ota_full2_nc_0/eeg_fd_ota_core_soft_0/m1_n55259_n3864# eeg_sdm1ct_0/eeg_fd_ota_full2_nc_0/eeg_fd_ota_core_soft_0/m1_n56059_n3864# 6.789040e-17
C6667 eeg_sdm1ct_0/eeg_fd_ota_full2_nc_0/eeg_fd_ota_core_soft_0/m1_n55659_3443# VSS 4.190540e-16
C6668 eeg_sdm1ct_0/eeg_fd_ota_full2_nc_0/eeg_fd_ota_core_soft_0/m1_n55659_3443# eeg_sdm1ct_0/eeg_fd_ota_full2_nc_0/eeg_fd_ota_core_soft_0/m1_n56459_3443# 6.789050e-17
C6670 eeg_sdm1ct_0/eeg_fd_ota_full2_nc_0/eeg_fd_ota_core_soft_0/m1_n56059_n3864# VSS 4.190540e-16
C6671 eeg_sdm1ct_0/eeg_fd_ota_full2_nc_0/eeg_fd_ota_core_soft_0/m1_n56059_n3864# eeg_sdm1ct_0/eeg_fd_ota_full2_nc_0/eeg_fd_ota_core_soft_0/m1_n56859_n3864# 6.789050e-17
C6672 eeg_sdm1ct_0/eeg_fd_ota_full2_nc_0/eeg_fd_ota_core_soft_0/m1_n56459_3443# VSS 4.190540e-16
C6673 eeg_sdm1ct_0/eeg_fd_ota_full2_nc_0/eeg_fd_ota_core_soft_0/m1_n56459_3443# eeg_sdm1ct_0/eeg_fd_ota_full2_nc_0/eeg_fd_ota_core_soft_0/m1_n57259_3443# 6.789050e-17
C6675 eeg_sdm1ct_0/eeg_fd_ota_full2_nc_0/eeg_fd_ota_core_soft_0/m1_n56859_n3864# VSS 4.190540e-16
C6676 eeg_sdm1ct_0/eeg_fd_ota_full2_nc_0/eeg_fd_ota_core_soft_0/m1_n56859_n3864# eeg_sdm1ct_0/eeg_fd_ota_full2_nc_0/eeg_fd_ota_core_soft_0/m1_n57659_n3864# 6.789040e-17
C6677 eeg_sdm1ct_0/eeg_fd_ota_full2_nc_0/eeg_fd_ota_core_soft_0/m1_n57259_3443# VSS 4.190540e-16
C6678 eeg_sdm1ct_0/eeg_fd_ota_full2_nc_0/eeg_fd_ota_core_soft_0/m1_n57259_3443# eeg_sdm1ct_0/eeg_fd_ota_full2_nc_0/eeg_fd_ota_core_soft_0/m1_n58059_3443# 6.789050e-17
C6680 eeg_sdm1ct_0/eeg_fd_ota_full2_nc_0/eeg_fd_ota_core_soft_0/m1_n57659_n3864# VSS 4.190540e-16
C6681 eeg_sdm1ct_0/eeg_fd_ota_full2_nc_0/eeg_fd_ota_core_soft_0/m1_n57659_n3864# eeg_sdm1ct_0/eeg_fd_ota_full2_nc_0/eeg_fd_ota_core_soft_0/m1_n58459_n3864# 6.789050e-17
C6682 eeg_sdm1ct_0/eeg_fd_ota_full2_nc_0/eeg_fd_ota_core_soft_0/m1_n58059_3443# VSS 4.607340e-16
C6683 eeg_sdm1ct_0/eeg_fd_ota_full2_nc_0/eeg_fd_ota_core_soft_0/m1_n58059_3443# eeg_sdm1ct_0/eeg_fd_ota_full2_nc_0/stage2_0/N2P 1.052831e-16
C6684 eeg_sdm1ct_0/eeg_fd_ota_full2_nc_0/eeg_fd_ota_core_soft_0/m1_n58459_n3864# VSS 4.702790e-16
C6685 eeg_sdm1ct_0/eeg_fd_ota_full2_nc_0/stage2_0/N2N VSS 3.542310e-14
C6686 eeg_sdm1ct_0/eeg_fd_ota_full2_nc_0/stage2_0/N2N eeg_sdm1ct_0/eeg_fd_ota_full2_nc_0/stage2_0/N2P 9.928293e-15
C6687 eeg_sdm1ct_0/eeg_fd_ota_full2_nc_0/stage2_0/N2N eeg_sdm1ct_0/eeg_pseudo_res_0/B 7.379468e-15
C6688 eeg_sdm1ct_0/eeg_fd_ota_full2_nc_0/stage2_0/N2N eeg_sdm1ct_0/eeg_pseudo_res_1/B 6.641364e-15
C6689 eeg_sdm1ct_0/eeg_fd_ota_full2_nc_0/stage2_0/N2P VSS 2.763250e-14
C6690 eeg_sdm1ct_0/eeg_fd_ota_full2_nc_0/stage2_0/N2P eeg_sdm1ct_0/eeg_pseudo_res_0/B 1.018187e-14
C6691 eeg_sdm1ct_0/eeg_fd_ota_full2_nc_0/stage2_0/N2P eeg_sdm1ct_0/eeg_pseudo_res_1/B 3.395166e-15
C6692 eeg_sdm1ct_0/eeg_pseudo_res_0/B VSS 1.448180e-14
C6693 eeg_sdm1ct_0/eeg_pseudo_res_0/B eeg_sdm1ct_0/eeg_pseudo_res_1/B 2.623505e-14
C6694 eeg_sdm1ct_0/eeg_pseudo_res_1/B VSS 3.261730e-14
C6695 eeg_sdm1ct_0/eeg_fd_ota_full2_nc_0/eeg_fd_ota_core_soft_0/m1_n51259_n3864# VSS 6.746650e-16
C6696 eeg_sdm1ct_0/eeg_fd_ota_full2_nc_0/eeg_fd_ota_core_soft_0/m1_n51659_3443# VSS 6.746650e-16
C6697 eeg_sdm1ct_0/eeg_fd_ota_full2_nc_0/eeg_fd_ota_core_soft_0/m1_n51659_3443# VSS 6.746650e-16
C6698 eeg_sdm1ct_0/eeg_fd_ota_full2_nc_0/eeg_fd_ota_core_soft_0/m1_n52059_n3864# VSS 6.746650e-16
C6699 eeg_sdm1ct_0/eeg_fd_ota_full2_nc_0/eeg_fd_ota_core_soft_0/m1_n52059_n3864# VSS 6.746650e-16
C6700 eeg_sdm1ct_0/eeg_fd_ota_full2_nc_0/eeg_fd_ota_core_soft_0/m1_n52459_3443# VSS 6.746650e-16
C6701 eeg_sdm1ct_0/eeg_fd_ota_full2_nc_0/eeg_fd_ota_core_soft_0/m1_n52459_3443# VSS 6.746650e-16
C6702 eeg_sdm1ct_0/eeg_fd_ota_full2_nc_0/eeg_fd_ota_core_soft_0/m1_n52859_n3864# VSS 6.746650e-16
C6703 eeg_sdm1ct_0/eeg_fd_ota_full2_nc_0/eeg_fd_ota_core_soft_0/m1_n52859_n3864# VSS 6.746650e-16
C6704 eeg_sdm1ct_0/eeg_fd_ota_full2_nc_0/eeg_fd_ota_core_soft_0/m1_n53259_3443# VSS 6.746650e-16
C6705 VSS eeg_sdm1ct_0/eeg_fd_ota_full2_nc_0/eeg_bias_gen_0/VBNF 6.766352e-15
C6706 VSS eeg_sdm1ct_0/eeg_fd_ota_full2_nc_0/eeg_fd_ota_core_soft_0/m1_n22658_111# 7.972532e-16
C6707 eeg_sdm1ct_0/eeg_fd_ota_full2_nc_0/eeg_bias_gen_0/VBNF VSS 2.104804e-14
C6708 eeg_sdm1ct_0/eeg_fd_ota_full2_nc_0/eeg_bias_gen_0/VBNF eeg_sdm1ct_0/eeg_fd_ota_full2_nc_0/eeg_fd_ota_core_soft_0/m1_n22658_111# 6.671600e-15
C6709 eeg_sdm1ct_0/eeg_fd_ota_full2_nc_0/eeg_fd_ota_core_soft_0/m1_n22658_111# VSS 2.222918e-16
C6710 eeg_sdm1ct_0/eeg_fd_ota_full2_nc_0/eeg_fd_ota_core_soft_0/m1_n53259_3443# VSS 6.746650e-16
C6711 eeg_sdm1ct_0/eeg_fd_ota_full2_nc_0/eeg_fd_ota_core_soft_0/m1_n53659_n3864# VSS 6.746650e-16
C6712 eeg_sdm1ct_0/eeg_fd_ota_full2_nc_0/eeg_fd_ota_core_soft_0/m1_31541_n3864# VSS 6.746650e-16
C6713 eeg_sdm1ct_0/eeg_fd_ota_full2_nc_0/eeg_fd_ota_core_soft_0/m1_31941_3443# VSS 6.746650e-16
C6714 eeg_sdm1ct_0/eeg_fd_ota_full2_nc_0/eeg_fd_ota_core_soft_0/m1_n53659_n3864# VSS 6.746650e-16
C6715 eeg_sdm1ct_0/eeg_fd_ota_full2_nc_0/eeg_fd_ota_core_soft_0/m1_n54059_3443# VSS 6.746650e-16
C6716 eeg_sdm1ct_0/eeg_fd_ota_full2_nc_0/eeg_fd_ota_core_soft_0/m1_31141_3443# VSS 6.746650e-16
C6717 eeg_sdm1ct_0/eeg_fd_ota_full2_nc_0/eeg_fd_ota_core_soft_0/m1_31541_n3864# VSS 6.746650e-16
C6718 eeg_sdm1ct_0/eeg_fd_ota_full2_nc_0/eeg_fd_ota_core_soft_0/m1_35541_n3864# VSS 6.746650e-16
C6719 eeg_sdm1ct_0/eeg_fd_ota_full2_nc_0/eeg_fd_ota_core_soft_0/m1_35941_3443# VSS 6.746650e-16
C6720 eeg_sdm1ct_0/eeg_fd_ota_full2_nc_0/eeg_fd_ota_core_soft_0/m1_n54059_3443# VSS 6.746650e-16
C6721 eeg_sdm1ct_0/eeg_fd_ota_full2_nc_0/eeg_fd_ota_core_soft_0/m1_n54459_n3864# VSS 6.746650e-16
C6722 eeg_sdm1ct_0/eeg_fd_ota_full2_nc_0/eeg_fd_ota_core_soft_0/m1_39541_n3864# VSS 6.746650e-16
C6723 eeg_sdm1ct_0/eeg_fd_ota_full2_nc_0/eeg_fd_ota_core_soft_0/m1_39941_3443# VSS 6.746650e-16
C6724 eeg_sdm1ct_0/eeg_fd_ota_full2_nc_0/eeg_fd_ota_core_soft_0/m1_30741_n3864# VSS 6.746650e-16
C6725 eeg_sdm1ct_0/eeg_fd_ota_full2_nc_0/eeg_fd_ota_core_soft_0/m1_31141_3443# VSS 6.746650e-16
C6726 eeg_sdm1ct_0/eeg_fd_ota_full2_nc_0/eeg_fd_ota_core_soft_0/m1_35141_3443# VSS 6.746650e-16
C6727 eeg_sdm1ct_0/eeg_fd_ota_full2_nc_0/eeg_fd_ota_core_soft_0/m1_35541_n3864# VSS 6.746650e-16
C6728 eeg_sdm1ct_0/eeg_fd_ota_full2_nc_0/eeg_fd_ota_core_soft_0/m1_n54459_n3864# VSS 6.746650e-16
C6729 eeg_sdm1ct_0/eeg_fd_ota_full2_nc_0/eeg_fd_ota_core_soft_0/m1_n54859_3443# VSS 6.746650e-16
C6730 eeg_sdm1ct_0/eeg_fd_ota_full2_nc_0/eeg_fd_ota_core_soft_0/m1_43541_n3864# VSS 6.746650e-16
C6731 eeg_sdm1ct_0/eeg_fd_ota_full2_nc_0/eeg_fd_ota_core_soft_0/m1_43941_3443# VSS 6.746650e-16
C6732 eeg_sdm1ct_0/eeg_fd_ota_full2_nc_0/eeg_fd_ota_core_soft_0/m1_39141_3443# VSS 6.746650e-16
C6733 eeg_sdm1ct_0/eeg_fd_ota_full2_nc_0/eeg_fd_ota_core_soft_0/m1_39541_n3864# VSS 6.746650e-16
C6734 eeg_sdm1ct_0/eeg_fd_ota_full2_nc_0/eeg_fd_ota_core_soft_0/m1_30341_3443# VSS 6.746650e-16
C6735 eeg_sdm1ct_0/eeg_fd_ota_full2_nc_0/eeg_fd_ota_core_soft_0/m1_30741_n3864# VSS 6.746650e-16
C6736 eeg_sdm1ct_0/eeg_fd_ota_full2_nc_0/eeg_fd_ota_core_soft_0/m1_34741_n3864# VSS 6.746650e-16
C6737 eeg_sdm1ct_0/eeg_fd_ota_full2_nc_0/eeg_fd_ota_core_soft_0/m1_35141_3443# VSS 6.746650e-16
C6738 eeg_sdm1ct_0/eeg_fd_ota_full2_nc_0/eeg_fd_ota_core_soft_0/m1_n54859_3443# VSS 6.746650e-16
C6739 eeg_sdm1ct_0/eeg_fd_ota_full2_nc_0/eeg_fd_ota_core_soft_0/m1_n55259_n3864# VSS 6.746650e-16
C6740 eeg_sdm1ct_0/eeg_fd_ota_full2_nc_0/eeg_fd_ota_core_soft_0/m1_43141_3443# VSS 6.746650e-16
C6741 eeg_sdm1ct_0/eeg_fd_ota_full2_nc_0/eeg_fd_ota_core_soft_0/m1_43541_n3864# VSS 6.746650e-16
C6742 eeg_sdm1ct_0/eeg_fd_ota_full2_nc_0/eeg_fd_ota_core_soft_0/m1_38741_n3864# VSS 6.746650e-16
C6743 eeg_sdm1ct_0/eeg_fd_ota_full2_nc_0/eeg_fd_ota_core_soft_0/m1_39141_3443# VSS 6.746650e-16
C6744 eeg_sdm1ct_0/eeg_fd_ota_full2_nc_0/eeg_fd_ota_core_soft_0/m1_29941_n3864# VSS 6.746650e-16
C6745 eeg_sdm1ct_0/eeg_fd_ota_full2_nc_0/eeg_fd_ota_core_soft_0/m1_30341_3443# VSS 6.746650e-16
C6746 eeg_sdm1ct_0/eeg_fd_ota_full2_nc_0/eeg_fd_ota_core_soft_0/m1_34341_3443# VSS 6.746650e-16
C6747 eeg_sdm1ct_0/eeg_fd_ota_full2_nc_0/eeg_fd_ota_core_soft_0/m1_34741_n3864# VSS 6.746650e-16
C6748 eeg_sdm1ct_0/eeg_fd_ota_full2_nc_0/eeg_fd_ota_core_soft_0/m1_42741_n3864# VSS 6.746650e-16
C6749 eeg_sdm1ct_0/eeg_fd_ota_full2_nc_0/eeg_fd_ota_core_soft_0/m1_43141_3443# VSS 6.746650e-16
C6750 eeg_sdm1ct_0/eeg_fd_ota_full2_nc_0/eeg_fd_ota_core_soft_0/m1_38341_3443# VSS 6.746650e-16
C6751 eeg_sdm1ct_0/eeg_fd_ota_full2_nc_0/eeg_fd_ota_core_soft_0/m1_38741_n3864# VSS 6.746650e-16
C6752 eeg_sdm1ct_0/eeg_fd_ota_full2_nc_0/eeg_fd_ota_core_soft_0/m1_29541_3443# VSS 6.746650e-16
C6753 eeg_sdm1ct_0/eeg_fd_ota_full2_nc_0/eeg_fd_ota_core_soft_0/m1_29941_n3864# VSS 6.746650e-16
C6754 eeg_sdm1ct_0/eeg_fd_ota_full2_nc_0/eeg_fd_ota_core_soft_0/m1_33941_n3864# VSS 6.746650e-16
C6755 eeg_sdm1ct_0/eeg_fd_ota_full2_nc_0/eeg_fd_ota_core_soft_0/m1_34341_3443# VSS 6.746650e-16
C6756 VSS eeg_sdm1ct_0/eeg_fd_ota_full2_nc_0/eeg_fd_ota_core_soft_0/m1_n22658_111# 1.572616e-15
C6757 VSS eeg_sdm1ct_0/eeg_fd_ota_full2_nc_0/stage2_0/N2P 1.412244e-15
C6760 eeg_sdm1ct_0/eeg_fd_ota_full2_nc_0/eeg_fd_ota_core_soft_0/m1_n22658_111# VSS 2.094330e-15
C6761 eeg_sdm1ct_0/eeg_fd_ota_full2_nc_0/eeg_fd_ota_core_soft_0/m1_n22658_111# eeg_sdm1ct_0/eeg_fd_ota_full2_nc_0/stage2_0/N2N 2.029956e-15
C6762 eeg_sdm1ct_0/eeg_fd_ota_full2_nc_0/eeg_fd_ota_core_soft_0/m1_n22658_111# eeg_sdm1ct_0/eeg_fd_ota_full2_nc_0/stage2_0/N2P 2.196456e-15
C6763 eeg_sdm1ct_0/eeg_fd_ota_full2_nc_0/eeg_fd_ota_core_soft_0/m1_n22658_111# eeg_sdm1ct_0/eeg_pseudo_res_0/B 1.694693e-14
C6764 eeg_sdm1ct_0/eeg_fd_ota_full2_nc_0/eeg_fd_ota_core_soft_0/m1_n22658_111# eeg_sdm1ct_0/eeg_pseudo_res_1/B 1.694693e-14
C6765 eeg_sdm1ct_0/eeg_fd_ota_full2_nc_0/stage2_0/N2N VSS 1.622652e-16
C6766 eeg_sdm1ct_0/eeg_fd_ota_full2_nc_0/stage2_0/N2N eeg_sdm1ct_0/eeg_pseudo_res_0/B 1.694693e-14
C6767 eeg_sdm1ct_0/eeg_fd_ota_full2_nc_0/stage2_0/N2P VSS 1.754879e-16
C6768 eeg_sdm1ct_0/eeg_fd_ota_full2_nc_0/stage2_0/N2P eeg_sdm1ct_0/eeg_pseudo_res_1/B 1.694693e-14
C6769 eeg_sdm1ct_0/eeg_pseudo_res_0/B VSS 3.113808e-14
C6770 eeg_sdm1ct_0/eeg_pseudo_res_0/B eeg_sdm1ct_0/eeg_pseudo_res_1/B 2.420658e-16
C6771 eeg_sdm1ct_0/eeg_pseudo_res_1/B VSS 3.114656e-14
C6772 eeg_sdm1ct_0/eeg_fd_ota_full2_nc_0/eeg_fd_ota_core_soft_0/m1_42341_3443# VSS 6.746650e-16
C6773 eeg_sdm1ct_0/eeg_fd_ota_full2_nc_0/eeg_fd_ota_core_soft_0/m1_42741_n3864# VSS 6.746650e-16
C6774 eeg_sdm1ct_0/eeg_fd_ota_full2_nc_0/eeg_fd_ota_core_soft_0/m1_37941_n3864# VSS 6.746650e-16
C6775 eeg_sdm1ct_0/eeg_fd_ota_full2_nc_0/eeg_fd_ota_core_soft_0/m1_38341_3443# VSS 6.746650e-16
C6776 eeg_sdm1ct_0/eeg_fd_ota_full2_nc_0/eeg_fd_ota_core_soft_0/m1_29141_n3864# VSS 6.746650e-16
C6777 eeg_sdm1ct_0/eeg_fd_ota_full2_nc_0/eeg_fd_ota_core_soft_0/m1_29541_3443# VSS 6.746650e-16
C6778 eeg_sdm1ct_0/eeg_fd_ota_full2_nc_0/eeg_fd_ota_core_soft_0/m1_33541_3443# VSS 6.746650e-16
C6779 eeg_sdm1ct_0/eeg_fd_ota_full2_nc_0/eeg_fd_ota_core_soft_0/m1_33941_n3864# VSS 6.746650e-16
C6780 eeg_sdm1ct_0/eeg_fd_ota_full2_nc_0/eeg_fd_ota_core_soft_0/m1_41941_n3864# VSS 6.746650e-16
C6781 eeg_sdm1ct_0/eeg_fd_ota_full2_nc_0/eeg_fd_ota_core_soft_0/m1_42341_3443# VSS 6.746650e-16
C6782 eeg_sdm1ct_0/eeg_fd_ota_full2_nc_0/eeg_fd_ota_core_soft_0/m1_37541_3443# VSS 6.746650e-16
C6783 eeg_sdm1ct_0/eeg_fd_ota_full2_nc_0/eeg_fd_ota_core_soft_0/m1_37941_n3864# VSS 6.746650e-16
C6784 eeg_sdm1ct_0/eeg_fd_ota_full2_nc_0/eeg_fd_ota_core_soft_0/m1_28741_3443# VSS 6.746650e-16
C6785 eeg_sdm1ct_0/eeg_fd_ota_full2_nc_0/eeg_fd_ota_core_soft_0/m1_29141_n3864# VSS 6.746650e-16
C6786 eeg_sdm1ct_0/eeg_fd_ota_full2_nc_0/eeg_fd_ota_core_soft_0/m1_33141_n3864# VSS 6.746650e-16
C6787 eeg_sdm1ct_0/eeg_fd_ota_full2_nc_0/eeg_fd_ota_core_soft_0/m1_33541_3443# VSS 6.746650e-16
C6788 eeg_sdm1ct_0/eeg_fd_ota_full2_nc_0/eeg_fd_ota_core_soft_0/m1_41541_3443# VSS 6.746650e-16
C6789 eeg_sdm1ct_0/eeg_fd_ota_full2_nc_0/eeg_fd_ota_core_soft_0/m1_41941_n3864# VSS 6.746650e-16
C6790 eeg_sdm1ct_0/eeg_fd_ota_full2_nc_0/eeg_fd_ota_core_soft_0/m1_37141_n3864# VSS 6.746650e-16
C6791 eeg_sdm1ct_0/eeg_fd_ota_full2_nc_0/eeg_fd_ota_core_soft_0/m1_37541_3443# VSS 6.746650e-16
C6792 eeg_sdm1ct_0/eeg_fd_ota_full2_nc_0/eeg_fd_ota_core_soft_0/m1_28341_n3864# VSS 6.746650e-16
C6793 eeg_sdm1ct_0/eeg_fd_ota_full2_nc_0/eeg_fd_ota_core_soft_0/m1_28741_3443# VSS 6.746650e-16
C6794 eeg_sdm1ct_0/eeg_fd_ota_full2_nc_0/eeg_fd_ota_core_soft_0/m1_32741_3443# VSS 6.746650e-16
C6795 eeg_sdm1ct_0/eeg_fd_ota_full2_nc_0/eeg_fd_ota_core_soft_0/m1_33141_n3864# VSS 6.746650e-16
C6796 eeg_sdm1ct_0/eeg_fd_ota_full2_nc_0/eeg_fd_ota_core_soft_0/m1_47541_n3864# VSS 6.746650e-16
C6797 eeg_sdm1ct_0/eeg_fd_ota_full2_nc_0/stage2_0/N2N VSS 6.746650e-16
C6798 eeg_sdm1ct_0/eeg_fd_ota_full2_nc_0/eeg_fd_ota_core_soft_0/m1_41141_n3864# VSS 6.746650e-16
C6799 eeg_sdm1ct_0/eeg_fd_ota_full2_nc_0/eeg_fd_ota_core_soft_0/m1_41541_3443# VSS 6.746650e-16
C6800 eeg_sdm1ct_0/eeg_fd_ota_full2_nc_0/eeg_cmfb_amp_dl2_0/VCM_SENSE VSS 6.746650e-16
C6801 eeg_sdm1ct_0/eeg_fd_ota_full2_nc_0/eeg_fd_ota_core_soft_0/m1_28341_n3864# VSS 6.746650e-16
C6802 eeg_sdm1ct_0/eeg_fd_ota_full2_nc_0/eeg_fd_ota_core_soft_0/m1_32341_n3864# VSS 6.746650e-16
C6803 eeg_sdm1ct_0/eeg_fd_ota_full2_nc_0/eeg_fd_ota_core_soft_0/m1_32741_3443# VSS 6.746650e-16
C6804 eeg_sdm1ct_0/eeg_fd_ota_full2_nc_0/eeg_fd_ota_core_soft_0/m1_36741_3443# VSS 6.746650e-16
C6805 eeg_sdm1ct_0/eeg_fd_ota_full2_nc_0/eeg_fd_ota_core_soft_0/m1_37141_n3864# VSS 6.746650e-16
C6806 eeg_sdm1ct_0/eeg_fd_ota_full2_nc_0/eeg_fd_ota_core_soft_0/m1_53941_n3864# VSS 6.746650e-16
C6807 eeg_sdm1ct_0/eeg_fd_ota_full2_nc_0/eeg_fd_ota_core_soft_0/m1_54341_3443# VSS 6.746650e-16
C6808 eeg_sdm1ct_0/eeg_fd_ota_full2_nc_0/eeg_fd_ota_core_soft_0/m1_47141_3443# VSS 6.746650e-16
C6809 eeg_sdm1ct_0/eeg_fd_ota_full2_nc_0/eeg_fd_ota_core_soft_0/m1_47541_n3864# VSS 6.746650e-16
C6810 eeg_sdm1ct_0/eeg_fd_ota_full2_nc_0/eeg_fd_ota_core_soft_0/m1_40741_3443# VSS 6.746650e-16
C6811 eeg_sdm1ct_0/eeg_fd_ota_full2_nc_0/eeg_fd_ota_core_soft_0/m1_41141_n3864# VSS 6.746650e-16
C6812 eeg_sdm1ct_0/eeg_fd_ota_full2_nc_0/eeg_fd_ota_core_soft_0/m1_36341_n3864# VSS 6.746650e-16
C6813 eeg_sdm1ct_0/eeg_fd_ota_full2_nc_0/eeg_fd_ota_core_soft_0/m1_36741_3443# VSS 6.746650e-16
C6814 eeg_sdm1ct_0/eeg_fd_ota_full2_nc_0/eeg_fd_ota_core_soft_0/m1_31941_3443# VSS 6.746650e-16
C6815 eeg_sdm1ct_0/eeg_fd_ota_full2_nc_0/eeg_fd_ota_core_soft_0/m1_32341_n3864# VSS 6.746650e-16
C6816 eeg_sdm1ct_0/eeg_fd_ota_full2_nc_0/eeg_fd_ota_core_soft_0/m1_57941_n3864# VSS 6.746650e-16
C6817 eeg_sdm1ct_0/eeg_fd_ota_full2_nc_0/stage2_0/N2N VSS 6.746650e-16
C6818 eeg_sdm1ct_0/eeg_fd_ota_full2_nc_0/eeg_fd_ota_core_soft_0/m1_53541_3443# VSS 6.746650e-16
C6819 eeg_sdm1ct_0/eeg_fd_ota_full2_nc_0/eeg_fd_ota_core_soft_0/m1_53941_n3864# VSS 6.746650e-16
C6820 eeg_sdm1ct_0/eeg_fd_ota_full2_nc_0/eeg_fd_ota_core_soft_0/m1_46741_n3864# VSS 6.746650e-16
C6821 eeg_sdm1ct_0/eeg_fd_ota_full2_nc_0/eeg_fd_ota_core_soft_0/m1_47141_3443# VSS 6.746650e-16
C6822 eeg_sdm1ct_0/eeg_fd_ota_full2_nc_0/eeg_fd_ota_core_soft_0/m1_40341_n3864# VSS 6.746650e-16
C6823 eeg_sdm1ct_0/eeg_fd_ota_full2_nc_0/eeg_fd_ota_core_soft_0/m1_40741_3443# VSS 6.746650e-16
C6824 eeg_sdm1ct_0/eeg_fd_ota_full2_nc_0/eeg_fd_ota_core_soft_0/m1_35941_3443# VSS 6.746650e-16
C6825 eeg_sdm1ct_0/eeg_fd_ota_full2_nc_0/eeg_fd_ota_core_soft_0/m1_36341_n3864# VSS 6.746650e-16
C6826 eeg_sdm1ct_0/eeg_fd_ota_full2_nc_0/eeg_fd_ota_core_soft_0/m1_57541_3443# VSS 6.746650e-16
C6827 eeg_sdm1ct_0/eeg_fd_ota_full2_nc_0/eeg_fd_ota_core_soft_0/m1_57941_n3864# VSS 6.746650e-16
C6828 eeg_sdm1ct_0/eeg_fd_ota_full2_nc_0/eeg_fd_ota_core_soft_0/m1_53141_n3864# VSS 6.746650e-16
C6829 eeg_sdm1ct_0/eeg_fd_ota_full2_nc_0/eeg_fd_ota_core_soft_0/m1_53541_3443# VSS 6.746650e-16
C6830 eeg_sdm1ct_0/eeg_fd_ota_full2_nc_0/eeg_fd_ota_core_soft_0/m1_46341_3443# VSS 6.746650e-16
C6831 eeg_sdm1ct_0/eeg_fd_ota_full2_nc_0/eeg_fd_ota_core_soft_0/m1_46741_n3864# VSS 6.746650e-16
C6832 eeg_sdm1ct_0/eeg_fd_ota_full2_nc_0/eeg_fd_ota_core_soft_0/m1_n44859_n3864# VSS 6.746650e-16
C6833 eeg_sdm1ct_0/eeg_fd_ota_full2_nc_0/eeg_fd_ota_core_soft_0/m1_n45259_3443# VSS 6.746650e-16
C6834 eeg_sdm1ct_0/eeg_fd_ota_full2_nc_0/eeg_fd_ota_core_soft_0/m1_39941_3443# VSS 6.746650e-16
C6835 eeg_sdm1ct_0/eeg_fd_ota_full2_nc_0/eeg_fd_ota_core_soft_0/m1_40341_n3864# VSS 6.746650e-16
C6836 eeg_sdm1ct_0/eeg_fd_ota_full2_nc_0/eeg_fd_ota_core_soft_0/m1_57141_n3864# VSS 6.746650e-16
C6837 eeg_sdm1ct_0/eeg_fd_ota_full2_nc_0/eeg_fd_ota_core_soft_0/m1_57541_3443# VSS 6.746650e-16
C6838 eeg_sdm1ct_0/eeg_fd_ota_full2_nc_0/eeg_fd_ota_core_soft_0/m1_52741_3443# VSS 6.746650e-16
C6839 eeg_sdm1ct_0/eeg_fd_ota_full2_nc_0/eeg_fd_ota_core_soft_0/m1_53141_n3864# VSS 6.746650e-16
C6840 eeg_sdm1ct_0/eeg_fd_ota_full2_nc_0/eeg_fd_ota_core_soft_0/m1_45941_n3864# VSS 6.746650e-16
C6841 eeg_sdm1ct_0/eeg_fd_ota_full2_nc_0/eeg_fd_ota_core_soft_0/m1_46341_3443# VSS 6.746650e-16
C6842 eeg_sdm1ct_0/eeg_fd_ota_full2_nc_0/eeg_fd_ota_core_soft_0/m1_n45259_3443# VSS 6.746650e-16
C6843 eeg_sdm1ct_0/eeg_fd_ota_full2_nc_0/eeg_fd_ota_core_soft_0/m1_n45659_n3864# VSS 6.746650e-16
C6844 eeg_sdm1ct_0/eeg_fd_ota_full2_nc_0/eeg_fd_ota_core_soft_0/m1_n40859_n3864# VSS 6.746650e-16
C6845 eeg_sdm1ct_0/eeg_fd_ota_full2_nc_0/eeg_fd_ota_core_soft_0/m1_n41259_3443# VSS 6.746650e-16
C6846 eeg_sdm1ct_0/eeg_fd_ota_full2_nc_0/eeg_fd_ota_core_soft_0/m1_56741_3443# VSS 6.746650e-16
C6847 eeg_sdm1ct_0/eeg_fd_ota_full2_nc_0/eeg_fd_ota_core_soft_0/m1_57141_n3864# VSS 6.746650e-16
C6848 eeg_sdm1ct_0/eeg_fd_ota_full2_nc_0/eeg_fd_ota_core_soft_0/m1_52341_n3864# VSS 6.746650e-16
C6849 eeg_sdm1ct_0/eeg_fd_ota_full2_nc_0/eeg_fd_ota_core_soft_0/m1_52741_3443# VSS 6.746650e-16
C6850 eeg_sdm1ct_0/eeg_fd_ota_full2_nc_0/eeg_fd_ota_core_soft_0/m1_45541_3443# VSS 6.746650e-16
C6851 eeg_sdm1ct_0/eeg_fd_ota_full2_nc_0/eeg_fd_ota_core_soft_0/m1_45941_n3864# VSS 6.746650e-16
C6852 eeg_sdm1ct_0/eeg_fd_ota_full2_nc_0/eeg_fd_ota_core_soft_0/m1_n45659_n3864# VSS 6.746650e-16
C6853 eeg_sdm1ct_0/eeg_fd_ota_full2_nc_0/eeg_fd_ota_core_soft_0/m1_n46059_3443# VSS 6.746650e-16
C6854 eeg_sdm1ct_0/eeg_fd_ota_full2_nc_0/eeg_fd_ota_core_soft_0/m1_n41259_3443# VSS 6.746650e-16
C6855 eeg_sdm1ct_0/eeg_fd_ota_full2_nc_0/eeg_fd_ota_core_soft_0/m1_n41659_n3864# VSS 6.746650e-16
C6856 eeg_sdm1ct_0/eeg_fd_ota_full2_nc_0/eeg_fd_ota_core_soft_0/m1_n36859_n3864# VSS 6.746650e-16
C6857 eeg_sdm1ct_0/eeg_fd_ota_full2_nc_0/eeg_fd_ota_core_soft_0/m1_n37259_3443# VSS 6.746650e-16
C6858 eeg_sdm1ct_0/eeg_fd_ota_full2_nc_0/eeg_fd_ota_core_soft_0/m1_56341_n3864# VSS 6.746650e-16
C6859 eeg_sdm1ct_0/eeg_fd_ota_full2_nc_0/eeg_fd_ota_core_soft_0/m1_56741_3443# VSS 6.746650e-16
C6860 eeg_sdm1ct_0/eeg_fd_ota_full2_nc_0/eeg_fd_ota_core_soft_0/m1_51941_3443# VSS 6.746650e-16
C6861 eeg_sdm1ct_0/eeg_fd_ota_full2_nc_0/eeg_fd_ota_core_soft_0/m1_52341_n3864# VSS 6.746650e-16
C6862 eeg_sdm1ct_0/eeg_fd_ota_full2_nc_0/eeg_fd_ota_core_soft_0/m1_45141_n3864# VSS 6.746650e-16
C6863 eeg_sdm1ct_0/eeg_fd_ota_full2_nc_0/eeg_fd_ota_core_soft_0/m1_45541_3443# VSS 6.746650e-16
C6864 eeg_sdm1ct_0/eeg_fd_ota_full2_nc_0/eeg_fd_ota_core_soft_0/m1_n46059_3443# VSS 6.746650e-16
C6865 eeg_sdm1ct_0/eeg_fd_ota_full2_nc_0/eeg_fd_ota_core_soft_0/m1_n46459_n3864# VSS 6.746650e-16
C6866 eeg_sdm1ct_0/eeg_fd_ota_full2_nc_0/eeg_fd_ota_core_soft_0/m1_n41659_n3864# VSS 6.746650e-16
C6867 eeg_sdm1ct_0/eeg_fd_ota_full2_nc_0/eeg_fd_ota_core_soft_0/m1_n42059_3443# VSS 6.746650e-16
C6868 eeg_sdm1ct_0/eeg_fd_ota_full2_nc_0/eeg_fd_ota_core_soft_0/m1_n37259_3443# VSS 6.746650e-16
C6869 eeg_sdm1ct_0/eeg_fd_ota_full2_nc_0/eeg_fd_ota_core_soft_0/m1_n37659_n3864# VSS 6.746650e-16
C6870 eeg_sdm1ct_0/eeg_fd_ota_full2_nc_0/eeg_fd_ota_core_soft_0/m1_n32859_n3864# VSS 6.746650e-16
C6871 eeg_sdm1ct_0/eeg_fd_ota_full2_nc_0/eeg_fd_ota_core_soft_0/m1_n33259_3443# VSS 6.746650e-16
C6872 eeg_sdm1ct_0/eeg_fd_ota_full2_nc_0/eeg_fd_ota_core_soft_0/m1_55941_3443# VSS 6.746650e-16
C6873 eeg_sdm1ct_0/eeg_fd_ota_full2_nc_0/eeg_fd_ota_core_soft_0/m1_56341_n3864# VSS 6.746650e-16
C6874 eeg_sdm1ct_0/eeg_fd_ota_full2_nc_0/eeg_fd_ota_core_soft_0/m1_51541_n3864# VSS 6.746650e-16
C6875 eeg_sdm1ct_0/eeg_fd_ota_full2_nc_0/eeg_fd_ota_core_soft_0/m1_51941_3443# VSS 6.746650e-16
C6876 eeg_sdm1ct_0/eeg_fd_ota_full2_nc_0/eeg_fd_ota_core_soft_0/m1_44741_3443# VSS 6.746650e-16
C6877 eeg_sdm1ct_0/eeg_fd_ota_full2_nc_0/eeg_fd_ota_core_soft_0/m1_45141_n3864# VSS 6.746650e-16
C6878 eeg_sdm1ct_0/eeg_fd_ota_full2_nc_0/eeg_fd_ota_core_soft_0/m1_n46459_n3864# VSS 6.746650e-16
C6879 eeg_sdm1ct_0/eeg_fd_ota_full2_nc_0/eeg_fd_ota_core_soft_0/m1_n46859_3443# VSS 6.746650e-16
C6880 eeg_sdm1ct_0/eeg_fd_ota_full2_nc_0/eeg_fd_ota_core_soft_0/m1_n42059_3443# VSS 6.746650e-16
C6881 eeg_sdm1ct_0/eeg_fd_ota_full2_nc_0/eeg_fd_ota_core_soft_0/m1_n42459_n3864# VSS 6.746650e-16
C6882 eeg_sdm1ct_0/eeg_fd_ota_full2_nc_0/eeg_fd_ota_core_soft_0/m1_n37659_n3864# VSS 6.746650e-16
C6883 eeg_sdm1ct_0/eeg_fd_ota_full2_nc_0/eeg_fd_ota_core_soft_0/m1_n38059_3443# VSS 6.746650e-16
C6884 eeg_sdm1ct_0/eeg_fd_ota_full2_nc_0/eeg_fd_ota_core_soft_0/m1_n33259_3443# VSS 6.746650e-16
C6885 eeg_sdm1ct_0/eeg_fd_ota_full2_nc_0/eeg_fd_ota_core_soft_0/m1_n33659_n3864# VSS 6.746650e-16
C6886 eeg_sdm1ct_0/eeg_fd_ota_full2_nc_0/eeg_fd_ota_core_soft_0/m1_n28859_n3864# VSS 6.746650e-16
C6887 eeg_sdm1ct_0/eeg_fd_ota_full2_nc_0/eeg_fd_ota_core_soft_0/m1_n29259_3443# VSS 6.746650e-16
C6888 VDD18 VSS 4.124974e-14
C6889 VDD18 eeg_sdm1ct_0/eeg_fd_ota_full2_nc_0/eeg_cmfb_amp_dl2_0/VBP 1.216293e-14
C6890 VDD18 eeg_sdm1ct_0/eeg_fd_ota_full2_nc_0/stage2_0/N2P 1.242512e-15
C6891 eeg_sdm1ct_0/eeg_fd_ota_full2_nc_0/eeg_cmfb_amp_dl2_0/VBP VSS 2.342324e-15
C6892 eeg_sdm1ct_0/eeg_fd_ota_full2_nc_0/eeg_cmfb_amp_dl2_0/VBP eeg_sdm1ct_0/eeg_fd_ota_full2_nc_0/stage2_0/N2P 3.335800e-15
C6893 eeg_sdm1ct_0/eeg_fd_ota_full2_nc_0/eeg_fd_ota_core_soft_0/m1_55541_n3864# VSS 6.746650e-16
C6894 eeg_sdm1ct_0/eeg_fd_ota_full2_nc_0/eeg_fd_ota_core_soft_0/m1_55941_3443# VSS 6.746650e-16
C6895 eeg_sdm1ct_0/eeg_fd_ota_full2_nc_0/eeg_fd_ota_core_soft_0/m1_51141_3443# VSS 6.746650e-16
C6896 eeg_sdm1ct_0/eeg_fd_ota_full2_nc_0/eeg_fd_ota_core_soft_0/m1_51541_n3864# VSS 6.746650e-16
C6897 eeg_sdm1ct_0/eeg_fd_ota_full2_nc_0/eeg_fd_ota_core_soft_0/m1_44341_n3864# VSS 6.746650e-16
C6898 eeg_sdm1ct_0/eeg_fd_ota_full2_nc_0/eeg_fd_ota_core_soft_0/m1_44741_3443# VSS 6.746650e-16
C6899 eeg_sdm1ct_0/eeg_fd_ota_full2_nc_0/eeg_fd_ota_core_soft_0/m1_n55259_n3864# VSS 6.746650e-16
C6900 eeg_sdm1ct_0/eeg_fd_ota_full2_nc_0/eeg_fd_ota_core_soft_0/m1_n55659_3443# VSS 6.746650e-16
C6901 eeg_sdm1ct_0/eeg_fd_ota_full2_nc_0/eeg_fd_ota_core_soft_0/m1_n46859_3443# VSS 6.746650e-16
C6902 eeg_sdm1ct_0/eeg_fd_ota_full2_nc_0/eeg_fd_ota_core_soft_0/m1_n47259_n3864# VSS 6.746650e-16
C6903 eeg_sdm1ct_0/eeg_fd_ota_full2_nc_0/eeg_fd_ota_core_soft_0/m1_n42459_n3864# VSS 6.746650e-16
C6904 eeg_sdm1ct_0/eeg_fd_ota_full2_nc_0/eeg_fd_ota_core_soft_0/m1_n42859_3443# VSS 6.746650e-16
C6905 eeg_sdm1ct_0/eeg_fd_ota_full2_nc_0/eeg_fd_ota_core_soft_0/m1_n38059_3443# VSS 6.746650e-16
C6906 eeg_sdm1ct_0/eeg_fd_ota_full2_nc_0/eeg_fd_ota_core_soft_0/m1_n38459_n3864# VSS 6.746650e-16
C6907 eeg_sdm1ct_0/eeg_fd_ota_full2_nc_0/eeg_fd_ota_core_soft_0/m1_n33659_n3864# VSS 6.746650e-16
C6908 eeg_sdm1ct_0/eeg_fd_ota_full2_nc_0/eeg_fd_ota_core_soft_0/m1_n34059_3443# VSS 6.746650e-16
C6909 eeg_sdm1ct_0/eeg_fd_ota_full2_nc_0/eeg_fd_ota_core_soft_0/m1_n29259_3443# VSS 6.746650e-16
C6910 eeg_sdm1ct_0/eeg_fd_ota_full2_nc_0/eeg_fd_ota_core_soft_0/m1_n29659_n3864# VSS 6.746650e-16
C6911 eeg_sdm1ct_0/eeg_fd_ota_full2_nc_0/eeg_fd_ota_core_soft_0/m1_55141_3443# VSS 6.746650e-16
C6912 eeg_sdm1ct_0/eeg_fd_ota_full2_nc_0/eeg_fd_ota_core_soft_0/m1_55541_n3864# VSS 6.746650e-16
C6913 eeg_sdm1ct_0/eeg_fd_ota_full2_nc_0/eeg_fd_ota_core_soft_0/m1_50741_n3864# VSS 6.746650e-16
C6914 eeg_sdm1ct_0/eeg_fd_ota_full2_nc_0/eeg_fd_ota_core_soft_0/m1_51141_3443# VSS 6.746650e-16
C6915 eeg_sdm1ct_0/eeg_fd_ota_full2_nc_0/eeg_fd_ota_core_soft_0/m1_43941_3443# VSS 6.746650e-16
C6916 eeg_sdm1ct_0/eeg_fd_ota_full2_nc_0/eeg_fd_ota_core_soft_0/m1_44341_n3864# VSS 6.746650e-16
C6917 eeg_sdm1ct_0/eeg_fd_ota_full2_nc_0/eeg_fd_ota_core_soft_0/m1_n55659_3443# VSS 6.746650e-16
C6918 eeg_sdm1ct_0/eeg_fd_ota_full2_nc_0/eeg_fd_ota_core_soft_0/m1_n56059_n3864# VSS 6.746650e-16
C6919 eeg_sdm1ct_0/eeg_fd_ota_full2_nc_0/eeg_fd_ota_core_soft_0/m1_n47259_n3864# VSS 6.746650e-16
C6920 eeg_sdm1ct_0/eeg_fd_ota_full2_nc_0/eeg_fd_ota_core_soft_0/m1_n47659_3443# VSS 6.746650e-16
C6921 eeg_sdm1ct_0/eeg_fd_ota_full2_nc_0/eeg_fd_ota_core_soft_0/m1_n42859_3443# VSS 6.746650e-16
C6922 eeg_sdm1ct_0/eeg_fd_ota_full2_nc_0/eeg_fd_ota_core_soft_0/m1_n43259_n3864# VSS 6.746650e-16
C6923 eeg_sdm1ct_0/eeg_fd_ota_full2_nc_0/eeg_fd_ota_core_soft_0/m1_n38459_n3864# VSS 6.746650e-16
C6924 eeg_sdm1ct_0/eeg_fd_ota_full2_nc_0/eeg_fd_ota_core_soft_0/m1_n38859_3443# VSS 6.746650e-16
C6925 eeg_sdm1ct_0/eeg_fd_ota_full2_nc_0/eeg_fd_ota_core_soft_0/m1_n34059_3443# VSS 6.746650e-16
C6926 eeg_sdm1ct_0/eeg_fd_ota_full2_nc_0/eeg_fd_ota_core_soft_0/m1_n34459_n3864# VSS 6.746650e-16
C6927 eeg_sdm1ct_0/eeg_fd_ota_full2_nc_0/eeg_fd_ota_core_soft_0/m1_n29659_n3864# VSS 6.746650e-16
C6928 eeg_sdm1ct_0/eeg_fd_ota_full2_nc_0/eeg_fd_ota_core_soft_0/m1_n30059_3443# VSS 6.746650e-16
C6929 eeg_sdm1ct_0/eeg_fd_ota_full2_nc_0/eeg_fd_ota_core_soft_0/m1_54741_n3864# VSS 6.746650e-16
C6930 eeg_sdm1ct_0/eeg_fd_ota_full2_nc_0/eeg_fd_ota_core_soft_0/m1_55141_3443# VSS 6.746650e-16
C6931 VCM_REF VSS 6.746650e-16
C6932 eeg_sdm1ct_0/eeg_fd_ota_full2_nc_0/eeg_fd_ota_core_soft_0/m1_50741_n3864# VSS 6.746650e-16
C6933 eeg_sdm1ct_0/eeg_fd_ota_full2_nc_0/eeg_fd_ota_core_soft_0/m1_n56059_n3864# VSS 6.746650e-16
C6934 eeg_sdm1ct_0/eeg_fd_ota_full2_nc_0/eeg_fd_ota_core_soft_0/m1_n56459_3443# VSS 6.746650e-16
C6935 eeg_sdm1ct_0/eeg_fd_ota_full2_nc_0/eeg_fd_ota_core_soft_0/m1_n47659_3443# VSS 6.746650e-16
C6936 eeg_sdm1ct_0/eeg_fd_ota_full2_nc_0/eeg_fd_ota_core_soft_0/m1_n48059_n3864# VSS 6.746650e-16
C6937 eeg_sdm1ct_0/eeg_fd_ota_full2_nc_0/eeg_fd_ota_core_soft_0/m1_n43259_n3864# VSS 6.746650e-16
C6938 eeg_sdm1ct_0/eeg_fd_ota_full2_nc_0/eeg_fd_ota_core_soft_0/m1_n43659_3443# VSS 6.746650e-16
C6939 eeg_sdm1ct_0/eeg_fd_ota_full2_nc_0/eeg_fd_ota_core_soft_0/m1_n38859_3443# VSS 6.746650e-16
C6940 eeg_sdm1ct_0/eeg_fd_ota_full2_nc_0/eeg_fd_ota_core_soft_0/m1_n39259_n3864# VSS 6.746650e-16
C6941 eeg_sdm1ct_0/eeg_fd_ota_full2_nc_0/eeg_fd_ota_core_soft_0/m1_n34459_n3864# VSS 6.746650e-16
C6942 eeg_sdm1ct_0/eeg_fd_ota_full2_nc_0/eeg_fd_ota_core_soft_0/m1_n34859_3443# VSS 6.746650e-16
C6943 eeg_sdm1ct_0/eeg_fd_ota_full2_nc_0/eeg_fd_ota_core_soft_0/m1_n30059_3443# VSS 6.746650e-16
C6944 eeg_sdm1ct_0/eeg_fd_ota_full2_nc_0/eeg_fd_ota_core_soft_0/m1_n30459_n3864# VSS 6.746650e-16
C6945 eeg_sdm1ct_0/eeg_fd_ota_full2_nc_0/eeg_fd_ota_core_soft_0/m1_54341_3443# VSS 6.746650e-16
C6946 eeg_sdm1ct_0/eeg_fd_ota_full2_nc_0/eeg_fd_ota_core_soft_0/m1_54741_n3864# VSS 6.746650e-16
C6947 eeg_sdm1ct_0/eeg_fd_ota_full2_nc_0/eeg_fd_ota_core_soft_0/m1_n56459_3443# VSS 6.746650e-16
C6948 eeg_sdm1ct_0/eeg_fd_ota_full2_nc_0/eeg_fd_ota_core_soft_0/m1_n56859_n3864# VSS 6.746650e-16
C6949 eeg_sdm1ct_0/eeg_fd_ota_full2_nc_0/eeg_fd_ota_core_soft_0/m1_n48059_n3864# VSS 6.746650e-16
C6950 eeg_sdm1ct_0/eeg_fd_ota_full2_nc_0/stage2_0/N2P VSS 6.746650e-16
C6951 eeg_sdm1ct_0/eeg_fd_ota_full2_nc_0/eeg_fd_ota_core_soft_0/m1_n43659_3443# VSS 6.746650e-16
C6952 eeg_sdm1ct_0/eeg_fd_ota_full2_nc_0/eeg_fd_ota_core_soft_0/m1_n44059_n3864# VSS 6.746650e-16
C6953 eeg_sdm1ct_0/eeg_fd_ota_full2_nc_0/eeg_fd_ota_core_soft_0/m1_n39259_n3864# VSS 6.746650e-16
C6954 eeg_sdm1ct_0/eeg_fd_ota_full2_nc_0/eeg_fd_ota_core_soft_0/m1_n39659_3443# VSS 6.746650e-16
C6955 eeg_sdm1ct_0/eeg_fd_ota_full2_nc_0/eeg_fd_ota_core_soft_0/m1_n34859_3443# VSS 6.746650e-16
C6956 eeg_sdm1ct_0/eeg_fd_ota_full2_nc_0/eeg_fd_ota_core_soft_0/m1_n35259_n3864# VSS 6.746650e-16
C6957 eeg_sdm1ct_0/eeg_fd_ota_full2_nc_0/eeg_fd_ota_core_soft_0/m1_n30459_n3864# VSS 6.746650e-16
C6958 eeg_sdm1ct_0/eeg_fd_ota_full2_nc_0/eeg_fd_ota_core_soft_0/m1_n30859_3443# VSS 6.746650e-16
C6959 eeg_sdm1ct_0/eeg_fd_ota_full2_nc_0/eeg_fd_ota_core_soft_0/m1_n56859_n3864# VSS 6.746650e-16
C6960 eeg_sdm1ct_0/eeg_fd_ota_full2_nc_0/eeg_fd_ota_core_soft_0/m1_n57259_3443# VSS 6.746650e-16
C6961 VCM_REF VSS 6.746650e-16
C6962 eeg_sdm1ct_0/eeg_fd_ota_full2_nc_0/eeg_fd_ota_core_soft_0/m1_n51259_n3864# VSS 6.746650e-16
C6963 eeg_sdm1ct_0/eeg_fd_ota_full2_nc_0/eeg_fd_ota_core_soft_0/m1_n44059_n3864# VSS 6.746650e-16
C6964 eeg_sdm1ct_0/eeg_fd_ota_full2_nc_0/eeg_fd_ota_core_soft_0/m1_n44459_3443# VSS 6.746650e-16
C6965 eeg_sdm1ct_0/eeg_fd_ota_full2_nc_0/eeg_fd_ota_core_soft_0/m1_n39659_3443# VSS 6.746650e-16
C6966 eeg_sdm1ct_0/eeg_fd_ota_full2_nc_0/eeg_fd_ota_core_soft_0/m1_n40059_n3864# VSS 6.746650e-16
C6967 eeg_sdm1ct_0/eeg_fd_ota_full2_nc_0/eeg_fd_ota_core_soft_0/m1_n35259_n3864# VSS 6.746650e-16
C6968 eeg_sdm1ct_0/eeg_fd_ota_full2_nc_0/eeg_fd_ota_core_soft_0/m1_n35659_3443# VSS 6.746650e-16
C6969 eeg_sdm1ct_0/eeg_fd_ota_full2_nc_0/eeg_fd_ota_core_soft_0/m1_n30859_3443# VSS 6.746650e-16
C6970 eeg_sdm1ct_0/eeg_fd_ota_full2_nc_0/eeg_fd_ota_core_soft_0/m1_n31259_n3864# VSS 6.746650e-16
C6971 eeg_sdm1ct_0/eeg_fd_ota_full2_nc_0/eeg_fd_ota_core_soft_0/m1_n57259_3443# VSS 6.746650e-16
C6972 eeg_sdm1ct_0/eeg_fd_ota_full2_nc_0/eeg_fd_ota_core_soft_0/m1_n57659_n3864# VSS 6.746650e-16
C6973 eeg_sdm1ct_0/eeg_fd_ota_full2_nc_0/eeg_fd_ota_core_soft_0/m1_n44459_3443# VSS 6.746650e-16
C6974 eeg_sdm1ct_0/eeg_fd_ota_full2_nc_0/eeg_fd_ota_core_soft_0/m1_n44859_n3864# VSS 6.746650e-16
C6975 eeg_sdm1ct_0/eeg_fd_ota_full2_nc_0/eeg_fd_ota_core_soft_0/m1_n40059_n3864# VSS 6.746650e-16
C6976 eeg_sdm1ct_0/eeg_fd_ota_full2_nc_0/eeg_fd_ota_core_soft_0/m1_n40459_3443# VSS 6.746650e-16
C6977 eeg_sdm1ct_0/eeg_fd_ota_full2_nc_0/eeg_fd_ota_core_soft_0/m1_n35659_3443# VSS 6.746650e-16
C6978 eeg_sdm1ct_0/eeg_fd_ota_full2_nc_0/eeg_fd_ota_core_soft_0/m1_n36059_n3864# VSS 6.746650e-16
C6979 eeg_sdm1ct_0/eeg_fd_ota_full2_nc_0/eeg_fd_ota_core_soft_0/m1_n31259_n3864# VSS 6.746650e-16
C6980 eeg_sdm1ct_0/eeg_fd_ota_full2_nc_0/eeg_fd_ota_core_soft_0/m1_n31659_3443# VSS 6.746650e-16
C6981 VDD18 VSS 4.124974e-14
C6982 VDD18 eeg_sdm1ct_0/eeg_fd_ota_full2_nc_0/eeg_cmfb_amp_dl2_0/VBP 1.216293e-14
C6983 VDD18 eeg_sdm1ct_0/eeg_fd_ota_full2_nc_0/stage2_0/N2N 1.242512e-15
C6984 eeg_sdm1ct_0/eeg_fd_ota_full2_nc_0/eeg_cmfb_amp_dl2_0/VBP VSS 2.342324e-15
C6985 eeg_sdm1ct_0/eeg_fd_ota_full2_nc_0/eeg_cmfb_amp_dl2_0/VBP eeg_sdm1ct_0/eeg_fd_ota_full2_nc_0/stage2_0/N2N 3.335800e-15
C6986 eeg_sdm1ct_0/eeg_fd_ota_full2_nc_0/eeg_fd_ota_core_soft_0/m1_n57659_n3864# VSS 6.746650e-16
C6987 eeg_sdm1ct_0/eeg_fd_ota_full2_nc_0/eeg_fd_ota_core_soft_0/m1_n58059_3443# VSS 6.746650e-16
C6988 eeg_sdm1ct_0/eeg_fd_ota_full2_nc_0/eeg_fd_ota_core_soft_0/m1_n40459_3443# VSS 6.746650e-16
C6989 eeg_sdm1ct_0/eeg_fd_ota_full2_nc_0/eeg_fd_ota_core_soft_0/m1_n40859_n3864# VSS 6.746650e-16
C6990 eeg_sdm1ct_0/eeg_fd_ota_full2_nc_0/eeg_fd_ota_core_soft_0/m1_n36059_n3864# VSS 6.746650e-16
C6991 eeg_sdm1ct_0/eeg_fd_ota_full2_nc_0/eeg_fd_ota_core_soft_0/m1_n36459_3443# VSS 6.746650e-16
C6992 eeg_sdm1ct_0/eeg_fd_ota_full2_nc_0/eeg_fd_ota_core_soft_0/m1_n31659_3443# VSS 6.746650e-16
C6993 eeg_sdm1ct_0/eeg_fd_ota_full2_nc_0/eeg_fd_ota_core_soft_0/m1_n32059_n3864# VSS 6.746650e-16
C6994 eeg_sdm1ct_0/eeg_fd_ota_full2_nc_0/eeg_fd_ota_core_soft_0/m1_n58059_3443# VSS 6.746650e-16
C6995 eeg_sdm1ct_0/eeg_fd_ota_full2_nc_0/eeg_fd_ota_core_soft_0/m1_n58459_n3864# VSS 6.746650e-16
C6996 eeg_sdm1ct_0/eeg_fd_ota_full2_nc_0/eeg_fd_ota_core_soft_0/m1_n36459_3443# VSS 6.746650e-16
C6997 eeg_sdm1ct_0/eeg_fd_ota_full2_nc_0/eeg_fd_ota_core_soft_0/m1_n36859_n3864# VSS 6.746650e-16
C6998 eeg_sdm1ct_0/eeg_fd_ota_full2_nc_0/eeg_fd_ota_core_soft_0/m1_n32059_n3864# VSS 6.746650e-16
C6999 eeg_sdm1ct_0/eeg_fd_ota_full2_nc_0/eeg_fd_ota_core_soft_0/m1_n32459_3443# VSS 6.746650e-16
C7000 eeg_sdm1ct_0/eeg_fd_ota_full2_nc_0/eeg_fd_ota_core_soft_0/m1_n58459_n3864# VSS 6.746650e-16
C7001 eeg_sdm1ct_0/eeg_fd_ota_full2_nc_0/stage2_0/N2P VSS 6.746650e-16
C7002 eeg_sdm1ct_0/eeg_fd_ota_full2_nc_0/eeg_fd_ota_core_soft_0/m1_n32459_3443# VSS 6.746650e-16
C7003 eeg_sdm1ct_0/eeg_fd_ota_full2_nc_0/eeg_fd_ota_core_soft_0/m1_n32859_n3864# VSS 6.746650e-16
C7004 eeg_sdm1ct_0/eeg_fd_ota_full2_nc_0/eeg_cmfb_amp_dl2_0/VCM_SENSE VSS 6.746650e-16
C7005 eeg_sdm1ct_0/eeg_fd_ota_full2_nc_0/eeg_fd_ota_core_soft_0/m1_n28859_n3864# VSS 6.746650e-16
C7006 BIT VDD18 1.658314e-16
C7007 BIT VSS 1.620786e-15
C7008 BIT eeg_sdm1ct_0/eeg_inv_0/Y 1.823050e-16
C7009 VDD18 VSS 1.332013e-15
C7010 VDD18 eeg_sdm1ct_0/eeg_inv_0/Y 7.937490e-16
C7011 VSS eeg_sdm1ct_0/eeg_inv_0/Y 7.176584e-17
C7012 eeg_sdm1ct_0/eeg_inv_0/Y VSS 9.197480e-16
C7013 BIT VDD18 1.883250e-16
C7014 BIT VSS 4.355510e-17
C7015 BIT eeg_sdm1ct_0/eeg_inv_0/Y 2.887600e-17
C7016 VDD18 VSS 2.592707e-15
C7017 VDD18 eeg_sdm1ct_0/eeg_inv_0/Y 3.212380e-16
C7018 eeg_sdm1ct_0/eeg_inv_0/Y VSS 8.691660e-17
C7019 BIT VSS 2.152613e-16
C7021 VSS eeg_sdm1ct_0/eeg_inv_0/Y 5.623600e-17
C7022 eeg_sdm1ct_0/eeg_inv_0/Y VSS 1.770690e-16
C7023 CLK16 VDD18 2.606434e-15
C7024 CLK16 VSS 8.025694e-15
C7025 CLK16 eeg_sdm1ct_0/OINTN 7.955695e-17
C7026 CLK16 eeg_sdm1ct_0/OINTP 1.039127e-16
C7027 CLK16 eeg_sdm1ct_0/eeg_nand2_0/A 3.851780e-16
C7028 CLK16 eeg_sdm1ct_0/eeg_nand2_1/A 3.626436e-16
C7029 CLK16 eeg_sdm1ct_0/eeg_strongarm_0/m1_250_166# 1.349240e-16
C7030 CLK16 eeg_sdm1ct_0/eeg_strongarm_0/m1_2620_1559# 6.501157e-17
C7031 CLK16 eeg_sdm1ct_0/eeg_strongarm_0/m1_n4_2402# 3.193121e-16
C7032 VDD18 VSS 4.309354e-15
C7035 VDD18 eeg_sdm1ct_0/eeg_nand2_0/A 9.289572e-16
C7036 VDD18 eeg_sdm1ct_0/eeg_nand2_1/A 1.074242e-15
C7038 VDD18 eeg_sdm1ct_0/eeg_strongarm_0/m1_2620_1559# 1.874353e-16
C7039 VDD18 eeg_sdm1ct_0/eeg_strongarm_0/m1_n4_2402# 1.738223e-16
C7040 VSS eeg_sdm1ct_0/OINTN 3.699477e-16
C7041 VSS eeg_sdm1ct_0/OINTP 7.175711e-16
C7042 VSS eeg_sdm1ct_0/eeg_nand2_0/A 1.601089e-15
C7043 VSS eeg_sdm1ct_0/eeg_nand2_1/A 8.262288e-16
C7044 VSS eeg_sdm1ct_0/eeg_strongarm_0/m1_250_166# 7.737294e-16
C7045 VSS eeg_sdm1ct_0/eeg_strongarm_0/m1_2620_1559# 2.038501e-16
C7046 VSS eeg_sdm1ct_0/eeg_strongarm_0/m1_n4_2402# 2.727656e-16
C7047 eeg_sdm1ct_0/OINTN VSS 9.440380e-16
C7048 eeg_sdm1ct_0/OINTN eeg_sdm1ct_0/OINTP 9.933296e-16
C7051 eeg_sdm1ct_0/OINTN eeg_sdm1ct_0/eeg_strongarm_0/m1_250_166# 1.556074e-15
C7052 eeg_sdm1ct_0/OINTN eeg_sdm1ct_0/eeg_strongarm_0/m1_2620_1559# 1.143658e-16
C7054 eeg_sdm1ct_0/OINTP VSS 1.296210e-15
C7057 eeg_sdm1ct_0/OINTP eeg_sdm1ct_0/eeg_strongarm_0/m1_250_166# 7.312386e-16
C7059 eeg_sdm1ct_0/OINTP eeg_sdm1ct_0/eeg_strongarm_0/m1_n4_2402# 1.088728e-16
C7060 eeg_sdm1ct_0/eeg_nand2_0/A VSS 1.459920e-15
C7061 eeg_sdm1ct_0/eeg_nand2_0/A eeg_sdm1ct_0/eeg_nand2_1/A 1.819334e-15
C7063 eeg_sdm1ct_0/eeg_nand2_0/A eeg_sdm1ct_0/eeg_strongarm_0/m1_2620_1559# 2.765148e-16
C7064 eeg_sdm1ct_0/eeg_nand2_0/A eeg_sdm1ct_0/eeg_strongarm_0/m1_n4_2402# 6.193080e-17
C7065 eeg_sdm1ct_0/eeg_nand2_1/A VSS 1.580510e-15
C7067 eeg_sdm1ct_0/eeg_nand2_1/A eeg_sdm1ct_0/eeg_strongarm_0/m1_2620_1559# 1.746873e-16
C7068 eeg_sdm1ct_0/eeg_nand2_1/A eeg_sdm1ct_0/eeg_strongarm_0/m1_n4_2402# 3.587802e-16
C7069 eeg_sdm1ct_0/eeg_strongarm_0/m1_250_166# VSS 1.847930e-15
C7070 eeg_sdm1ct_0/eeg_strongarm_0/m1_250_166# eeg_sdm1ct_0/eeg_strongarm_0/m1_2620_1559# 1.905126e-16
C7071 eeg_sdm1ct_0/eeg_strongarm_0/m1_250_166# eeg_sdm1ct_0/eeg_strongarm_0/m1_n4_2402# 2.354135e-16
C7072 eeg_sdm1ct_0/eeg_strongarm_0/m1_2620_1559# VSS 1.096930e-15
C7073 eeg_sdm1ct_0/eeg_strongarm_0/m1_2620_1559# eeg_sdm1ct_0/eeg_strongarm_0/m1_n4_2402# 3.747850e-17
C7074 eeg_sdm1ct_0/eeg_strongarm_0/m1_n4_2402# VSS 1.228910e-15
C7075 CLK16 VSS 7.062382e-16
C7076 CLK16 eeg_sdm1ct_0/eeg_strongarm_0/m1_250_166# 1.003644e-16
C7077 VSS eeg_sdm1ct_0/eeg_strongarm_0/m1_250_166# 4.978080e-16
C7078 eeg_sdm1ct_0/eeg_strongarm_0/m1_250_166# VSS 7.028120e-17
C7079 CLK16 VDD18 1.735233e-16
C7080 CLK16 VSS 4.470230e-17
C7082 VDD18 VSS 2.014100e-15
C7083 VDD18 eeg_sdm1ct_0/eeg_strongarm_0/m1_2620_1559# 1.740840e-16
C7084 eeg_sdm1ct_0/eeg_strongarm_0/m1_2620_1559# VSS 6.164950e-17
C7085 CLK16 VDD18 1.735233e-16
C7086 CLK16 VSS 4.470230e-17
C7088 VDD18 VSS 2.014100e-15
C7089 VDD18 eeg_sdm1ct_0/eeg_strongarm_0/m1_n4_2402# 1.740840e-16
C7090 eeg_sdm1ct_0/eeg_strongarm_0/m1_n4_2402# VSS 6.164950e-17
C7091 CLK16 VDD18 3.021706e-16
C7092 CLK16 VSS 7.012160e-17
C7093 CLK16 eeg_sdm1ct_0/eeg_nand2_0/A 2.221660e-17
C7094 VDD18 VSS 2.359843e-15
C7095 VDD18 eeg_sdm1ct_0/eeg_nand2_0/A 1.288370e-16
C7097 CLK16 VDD18 3.021706e-16
C7098 CLK16 VSS 7.012160e-17
C7099 CLK16 eeg_sdm1ct_0/eeg_nand2_1/A 2.221660e-17
C7100 VDD18 VSS 2.359843e-15
C7101 VDD18 eeg_sdm1ct_0/eeg_nand2_1/A 1.288370e-16
C7103 VDD18 VSS 1.409425e-15
C7104 VDD18 eeg_sdm1ct_0/eeg_nand2_0/A 7.598330e-17
C7105 VDD18 eeg_sdm1ct_0/eeg_nand2_1/A 2.905230e-16
C7108 eeg_sdm1ct_0/eeg_nand2_1/A VSS 8.104460e-17
C7109 VDD18 VSS 1.409425e-15
C7110 VDD18 eeg_sdm1ct_0/eeg_nand2_0/A 2.905230e-16
C7111 VDD18 eeg_sdm1ct_0/eeg_nand2_1/A 7.598330e-17
C7112 eeg_sdm1ct_0/eeg_nand2_0/A VSS 8.104460e-17
C7115 eeg_sdm1ct_0/eeg_nand2_0/A VSS 3.899740e-17
C7117 eeg_sdm1ct_0/eeg_nand2_0/A eeg_sdm1ct_0/eeg_strongarm_0/m1_n4_2402# 4.872180e-17
C7118 eeg_sdm1ct_0/eeg_nand2_1/A VSS 3.467880e-16
C7119 eeg_sdm1ct_0/eeg_nand2_1/A eeg_sdm1ct_0/eeg_strongarm_0/m1_n4_2402# 2.048900e-17
C7120 eeg_sdm1ct_0/eeg_strongarm_0/m1_n4_2402# VSS 1.091040e-16
C7121 eeg_sdm1ct_0/eeg_nand2_0/A VSS 3.467880e-16
C7123 eeg_sdm1ct_0/eeg_nand2_0/A eeg_sdm1ct_0/eeg_strongarm_0/m1_2620_1559# 2.048900e-17
C7124 eeg_sdm1ct_0/eeg_nand2_1/A VSS 3.899740e-17
C7125 eeg_sdm1ct_0/eeg_nand2_1/A eeg_sdm1ct_0/eeg_strongarm_0/m1_2620_1559# 4.872180e-17
C7126 eeg_sdm1ct_0/eeg_strongarm_0/m1_2620_1559# VSS 1.091040e-16
C7127 eeg_sdm1ct_0/OINTN VSS 8.818740e-16
C7128 eeg_sdm1ct_0/OINTN eeg_sdm1ct_0/eeg_strongarm_0/m1_250_166# 9.019660e-17
C7129 eeg_sdm1ct_0/OINTN eeg_sdm1ct_0/eeg_strongarm_0/m1_2620_1559# 8.496640e-17
C7130 eeg_sdm1ct_0/eeg_strongarm_0/m1_250_166# VSS 3.922686e-16
C7131 eeg_sdm1ct_0/eeg_strongarm_0/m1_250_166# eeg_sdm1ct_0/eeg_strongarm_0/m1_2620_1559# 1.231068e-16
C7132 eeg_sdm1ct_0/eeg_strongarm_0/m1_2620_1559# VSS 7.014680e-17
C7133 eeg_sdm1ct_0/OINTP VSS 8.818740e-16
C7134 eeg_sdm1ct_0/OINTP eeg_sdm1ct_0/eeg_strongarm_0/m1_250_166# 9.019660e-17
C7135 eeg_sdm1ct_0/OINTP eeg_sdm1ct_0/eeg_strongarm_0/m1_n4_2402# 8.496640e-17
C7136 eeg_sdm1ct_0/eeg_strongarm_0/m1_250_166# VSS 3.922686e-16
C7137 eeg_sdm1ct_0/eeg_strongarm_0/m1_250_166# eeg_sdm1ct_0/eeg_strongarm_0/m1_n4_2402# 1.231068e-16
C7138 eeg_sdm1ct_0/eeg_strongarm_0/m1_n4_2402# VSS 7.014680e-17
C7139 eeg_sdm1ct_0/eeg_tg_lowq_1/A VSS 6.746650e-16
C7140 eeg_sdm1ct_0/m1_57141_71443# VSS 6.746650e-16
C7141 eeg_sdm1ct_0/m1_56741_64136# VSS 6.746650e-16
C7142 eeg_sdm1ct_0/m1_57141_71443# VSS 6.746650e-16
C7143 eeg_sdm1ct_0/m1_56341_71443# VSS 6.746650e-16
C7144 eeg_sdm1ct_0/m1_56741_64136# VSS 6.746650e-16
C7145 eeg_sdm1ct_0/m1_55941_64136# VSS 6.746650e-16
C7146 eeg_sdm1ct_0/m1_56341_71443# VSS 6.746650e-16
.ends
