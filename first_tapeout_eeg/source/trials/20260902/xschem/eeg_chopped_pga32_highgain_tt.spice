* test6 transistor OTA integrated with 8 kHz input/output choppers and PGA32
.lib /Users/noah/.volare/volare/sky130/versions/0fe599b2afb6708d281543108caf8310912f54af/sky130A/libs.tech/ngspice/sky130.lib.spice tt
.include eeg_cmos_chopper.spice
.include eeg_fd_ota_core_highgain.spice
.include eeg_cmfb_amp.spice
.include eeg_fd_ota_twostage_highgain.spice
.param VDD=1.8 VCM=0.9 VBN=0.63 TCHOP=125u
.temp 27
VDD_SRC VDD18 0 {VDD}
VREF VCM_REF 0 {VCM}
VBN_SRC VBN 0 {VBN}

* 8 kHz, 60 us active phases, 2.5 us non-overlap at each commutation.
VPHI PHI 0 PULSE(0 {VDD} 1.25u 20n 20n 60u {TCHOP})
VPHIB PHIB 0 PULSE(0 {VDD} 63.75u 20n 20n 60u {TCHOP})
BNPHI NPHI 0 V={VDD}-v(PHI)
BNPHIB NPHIB 0 V={VDD}-v(PHIB)

* 100 uVpp differential EEG-like stimulus at 100 Hz.
VSIGP SIGP 0 SIN({VCM} 25u 100)
VSIGN SIGN 0 SIN({VCM} 25u 100 0 0 180)

* Capacitive PGA summing nodes, Cin/Cf=32.
CINP SIGP SUMP 32p
CINN SIGN SUMN 32p
CFP OUTN SUMP 1p
CFN OUTP SUMN 1p
RBIASP SUMP VCM_REF 1T
RBIASN SUMN VCM_REF 1T

* Modulate before the OTA and synchronously demodulate its raw output.
XCHIN SUMP SUMN AINP AINN PHI NPHI PHIB NPHIB VDD18 0 eeg_cmos_chopper
RBIAP AINP VCM_REF 1T
RBIAN AINN VCM_REF 1T
CHOLDP AINP VCM_REF 5p
CHOLDN AINN VCM_REF 5p
XOTA AINP AINN VCM_REF VBN RAWP RAWN VDD18 0 eeg_fd_ota_twostage_highgain
* Architecture-validation buffers isolate OTA/CMFB from demodulator kickback.
* Replace these ideal followers with transistor buffers in the next gate.
EBUFP BUFP 0 RAWP 0 1
EBUFN BUFN 0 RAWN 0 1
XCHOUT BUFP BUFN OUTP OUTN PHI NPHI PHIB NPHIB VDD18 0 eeg_cmos_chopper
RBIASOP OUTP VCM_REF 1T
RBIASON OUTN VCM_REF 1T
CLOADP OUTP 0 5p
CLOADN OUTN 0 5p

.control
set noaskquit
tran 0.5u 20m 5m
let vsigd=v(SIGP)-v(SIGN)
let voutd=v(OUTP)-v(OUTN)
let vcmout=(v(OUTP)+v(OUTN))/2
let verr=voutd-32*vsigd
let idd=-i(VDD_SRC)
meas tran vin_pp pp vsigd from=10m to=20m
meas tran vout_pp pp voutd from=10m to=20m
meas tran vcm_avg avg vcmout from=10m to=20m
meas tran vcm_pp pp vcmout from=10m to=20m
meas tran error_rms rms verr from=10m to=20m
meas tran idd_avg avg idd from=10m to=20m
meas tran out_abs_max max voutd from=10m to=20m
meas tran out_abs_min min voutd from=10m to=20m
wrdata ../results/chopped_pga32_highgain_tt.csv time vsigd voutd vcmout verr idd v(RAWP) v(RAWN) v(PHI) v(PHIB)
quit
.endc
.end
