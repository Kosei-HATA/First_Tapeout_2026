* PEX E2E / SDM spot check: electrodes -> chopped PGA x32 -> CT SDM -> BIT.
* Flat PEX netlist of eeg_afe_top.  469 uV 32 Hz differential in ~= 15 mV
* (0.6 FS) at the SDM input, matching the pre-layout tb_sdm1ct_cap SNDR
* condition (52.4 dB).  Long run: pseudo-R startup needs ~1 s to settle;
* sdm_bitstream.py skips it (--skip-ms 1100).
.lib /Users/noah/.volare/volare/sky130/versions/0fe599b2afb6708d281543108caf8310912f54af/sky130A/libs.tech/ngspice/sky130.lib.spice tt
* PEX note: .lib tt alone covers all magic-ext2spice device names
* (nfet/pfet_01v8, res_xhigh_po_0p69, cap_mim_m3_1) — extra includes
* REDEFINE the subckts and break param passing.  Merged FETs carry
* nf=<fingers> so per-finger w stays inside the PDK model bins.
.temp 27
.include eeg_afe_top_pex.spice
.param VDD=1.80 VCM={1.80/2} VCMA=0.927 TCHOP=1m TCLK=62.5u
VDD_SRC VDD18 0 {VDD}
VREF VCM_REF 0 {VCM}
VVP VP 0 {VCMA+25m}
VVN VN 0 {VCMA-25m}
VPHI PHI 0 PULSE(0 {VDD} 50n 20n 20n 499.85u {TCHOP})
VPHIB PHIB 0 PULSE(0 {VDD} 500.05u 20n 20n 499.85u {TCHOP})
BNPHI NPHI 0 V={VDD}-v(PHI)
BNPHIB NPHIB 0 V={VDD}-v(PHIB)
VCLK CLK16 0 PULSE(0 {VDD} 0 100n 100n 31.15u {TCLK})
BNCLK NCLK16 0 V={VDD}-v(CLK16)
VSIGP ELP 0 SIN({VCM} 469u 32)
VSIGN ELN 0 SIN({VCM} 469u 32 0 0 180)
VS8 S8 0 0
VS16 S16 0 0
VS32 S32 0 {VDD}
VS64 S64 0 0
XTOP ELP ELN VCM_REF VP VN PHI NPHI PHIB NPHIB PHI NPHI PHIB NPHIB CLK16 NCLK16 BIT NBIT S8 S16 S32 S64 VDD18 0 PGA_OUTP PGA_OUTN eeg_afe_top
.nodeset v(PGA_OUTP)=0.93 v(PGA_OUTN)=0.93 v(BIT)=1.8
.options method=gear reltol=1e-4 trtol=1 gmin=1e-13
.control
set noaskquit
* limit saved vectors (memory!): BIT + PGA outputs only
save time v(BIT) v(NBIT) v(PGA_OUTP) v(PGA_OUTN) v(xtop.eeg_sdm1ct_0/ointp) v(xtop.eeg_sdm1ct_0/ointn)
tran 100n 0.3s
wrdata ../results/e2e_pex_tight.csv time v(BIT) v(NBIT) v(PGA_OUTP) v(PGA_OUTN) v(xtop.eeg_sdm1ct_0/ointp) v(xtop.eeg_sdm1ct_0/ointn)
quit
.endc
.end
