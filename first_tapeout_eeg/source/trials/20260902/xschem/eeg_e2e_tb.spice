* END-TO-END: electrodes(+offset, CM interference) -> chopped PGA x32 -> CT SDM -> bitstream
* 1 s run for SNDR at 8 Hz EEG component.
.lib /Users/noah/.volare/volare/sky130/versions/0fe599b2afb6708d281543108caf8310912f54af/sky130A/libs.tech/ngspice/sky130.lib.spice tt
.include eeg_tg_lowq.spice
.include eeg_fd_ota_core_soft.spice
.include eeg_bias_gen.spice
.include eeg_fd_ota_chopped_full2.spice
.include eeg_pseudo_res.spice
.include eeg_afe_pga.spice
.include eeg_fd_ota_full2_nc.spice
.include eeg_strongarm.spice
.include eeg_sdm2.spice
.include eeg_sdm1ct.spice
.include eeg_afe_top.spice
.param VDD=1.80 VCM=0.9 VCMA=0.927 TCHOP=125u TCLK=62.5u
VDD_SRC VDD18 0 {VDD}
VREF VCM_REF 0 {VCM}
* references centered on the actual analog CM (~0.927 at TT)
VVP VP 0 {VCMA+25m}
VVN VN 0 {VCMA-25m}
* 8 kHz chopper clocks
VPHI PHI 0 PULSE(0 {VDD} 50n 20n 20n 62.35u {TCHOP})
VPHIB PHIB 0 PULSE(0 {VDD} 62.55u 20n 20n 62.35u {TCHOP})
BNPHI NPHI 0 V={VDD}-v(PHI)
BNPHIB NPHIB 0 V={VDD}-v(PHIB)
* 16 kHz SDM clock (locked to the chopper: 2 chopper periods = 1 sdm period)
VCLK CLK16 0 PULSE(0 {VDD} 0 100n 100n 31.15u {TCLK})
BNCLK NCLK16 0 V={VDD}-v(CLK16)
* electrodes: 300 mV diff offset + 200 uV 50 Hz CM interference + 100 uV 8 Hz EEG
VELP ELPD 0 {VCM+150m}
VELN ELND 0 {VCM-150m}
VCMP ELPD ELPC SIN(0 200u 50)
VCMN ELND ELNC SIN(0 200u 50)
VSGP ELPC ELP2 SIN(0 100u 8)
VSGN ELNC ELN2 SIN(0 100u 8 0 0 180)
.nodeset v(XTOP.XAFE.INP)=0.9 v(XTOP.XAFE.INN)=0.9 v(XTOP.XADC.INP)=0.92 v(XTOP.XADC.INN)=0.92 v(XTOP.PGA_OUTP)=0.93 v(XTOP.PGA_OUTN)=0.93 v(XTOP.XAFE.OUTP)=0.93 v(XTOP.XAFE.OUTN)=0.93 v(BIT)=1.8
VS8 S8N 0 0
VS16 S16N 0 0
VS32 S32N 0 {VDD}
VS64 S64N 0 0
XTOP ELP2 ELN2 VCM_REF VP VN PHI NPHI PHIB NPHIB PHI NPHI PHIB NPHIB CLK16 NCLK16 BIT NBIT S8N S16N S32N S64N VDD18 0 eeg_afe_top
.control
set noaskquit
tran 100n 1.024s
wrdata ../results/e2e_1s.csv time v(BIT)
* note: discard first 60% (AFE pseudo-R startup transient) in analysis
quit
.endc
.end
