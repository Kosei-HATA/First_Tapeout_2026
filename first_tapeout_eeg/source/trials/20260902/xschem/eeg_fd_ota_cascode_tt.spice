.lib /Users/noah/.volare/volare/sky130/versions/0fe599b2afb6708d281543108caf8310912f54af/sky130A/libs.tech/ngspice/sky130.lib.spice tt
.include eeg_fd_ota_cascode.spice
.include eeg_cmfb_amp.spice
.include eeg_fd_ota_cascode_cmfb.spice
.param VDD=1.8 VCM=0.9 VBN=0.65 VCP=0.30 VCN=0.60
VDD_SRC VDD18 0 {VDD}
VREF VCM_REF 0 {VCM}
VBN_SRC VBN 0 {VBN}
VCP_SRC VCP 0 {VCP}
VCN_SRC VCN 0 {VCN}
VINP INP 0 DC {VCM} AC 0.5 0
VINN INN 0 DC {VCM} AC 0.5 180
XAFE INP INN VCM_REF VBN VCP VCN OUTP OUTN VDD18 0 eeg_fd_ota_cascode_cmfb
CLOADP OUTP 0 1p
CLOADN OUTN 0 1p
.control
set noaskquit
op
let idd=-i(VDD_SRC)
let vcmout=(v(OUTP)+v(OUTN))/2
print v(OUTP) v(OUTN) vcmout idd
wrdata ../results/cascode_tt_op.csv v(OUTP) v(OUTN) vcmout idd
ac dec 100 0.1 100Meg
let vdiff=v(OUTP)-v(OUTN)
let gain_db=db(vdiff)
meas ac gain_10hz_db find gain_db at=10
meas ac gain_100hz_db find gain_db at=100
meas ac gain_10khz_db find gain_db at=10k
wrdata ../results/cascode_tt_diff_ac.csv frequency gain_db
quit
.endc
.end
