* Fully biased internal-chopper OTA: constant-gm bias gen + dl CMFB.
* M9 of each CMFB amp uses the same L as its stage's PMOS load for PVT tracking.
.subckt eeg_cmfb_amp_dl2 VCM_SENSE VCM_REF VBN VBP VDD18 VSS params: W9=5 L9=4
XM6 NLEFT VCM_SENSE NTAIL VSS sky130_fd_pr__nfet_01v8 L=2 W=2 nf=1
XM7 VBP VCM_REF NTAIL VSS sky130_fd_pr__nfet_01v8 L=2 W=2 nf=1
XM8 NLEFT NLEFT VDD18 VDD18 sky130_fd_pr__pfet_01v8 L=2 W=2 nf=1
XM9 VBP VBP VDD18 VDD18 sky130_fd_pr__pfet_01v8 L={L9} W={W9} nf=1
XM10 NTAIL VBN VSS VSS sky130_fd_pr__nfet_01v8 L=4 W=8 nf=2
.ends

.subckt eeg_fd_ota_chopped_full INP INN VCM_REF OUTP OUTN PHII NPHII PHIBI NPHIBI PHIM NPHIM PHIBM NPHIBM VDD18 VSS params: W91=4 L91=4 W92=1.33 L92=4 RTAP=278k CC=10p RZ=20k
XBG VBN VBP_BIAS VDD18 VSS eeg_bias_gen
XCHIN INP INN INP_M INN_M PHII NPHII PHIBI NPHIBI VDD18 VSS eeg_cmos_chopper_lowq
XSTG1 INP_M INN_M VBP1 VBN N1P N1N VCM1 VDD18 VSS eeg_fd_ota_core_highgain
RTAP1 VCM1 VCM_REF {RTAP}
XCM1 VCM1 VCM_REF VBN VBP1 VDD18 VSS eeg_cmfb_amp_dl2 W9={W91} L9={L91}
XCHMID N1P N1N N2P N2N PHIM NPHIM PHIBM NPHIBM VDD18 VSS eeg_cmos_chopper_lowq
XM21 OUTP N2P VSS VSS sky130_fd_pr__nfet_01v8 L=12 W=12 nf=2
XM22 OUTN N2N VSS VSS sky130_fd_pr__nfet_01v8 L=12 W=12 nf=2
XM23 OUTP VBP2 VDD18 VDD18 sky130_fd_pr__pfet_01v8 L=12 W=48 nf=8
XM24 OUTN VBP2 VDD18 VDD18 sky130_fd_pr__pfet_01v8 L=12 W=48 nf=8
RCMO1 OUTP VCM2 5Meg
RCMO2 OUTN VCM2 5Meg
RTAP2 VCM2 VCM_REF {RTAP}
XCM2 VCM2 VCM_REF VBN VBP2 VDD18 VSS eeg_cmfb_amp_dl2 W9={W92} L9={L92}
RZP N2P NZP {RZ}
CCP NZP OUTP {CC}
RZN N2N NZN {RZ}
CCN NZN OUTN {CC}
.ends
