* Fully biased internal-chopper OTA v2.1:
* constant-gm bias gen + diode-load CMFB + CM-softening loads both stages
* + ratio-matched M9 + direct CM sensing (no tap) + adjustable CMFB tail.
.subckt eeg_cmfb_amp_dl2 VCM_SENSE VCM_REF VBN VBP VDD18 VSS params: W9=5 L9=4 W10=12
XM6 NLEFT VCM_SENSE NTAIL VSS sky130_fd_pr__nfet_01v8 L=2 W=2 nf=1
XM7 VBP VCM_REF NTAIL VSS sky130_fd_pr__nfet_01v8 L=2 W=2 nf=1
XM8 NLEFT NLEFT VDD18 VDD18 sky130_fd_pr__pfet_01v8 L=2 W=2 nf=1
XM9 VBP VBP VDD18 VDD18 sky130_fd_pr__pfet_01v8 L={L9} W={W9} nf=1
XM10 NTAIL VBN VSS VSS sky130_fd_pr__nfet_01v8 L=4 W={W10} nf=2
.ends

* DC servo loop (DSL): senses the OTA input-gate common mode via NMOS
* followers (no DC load), integrates the error vs VCM_REF, and sinks the
* chopper pump current (~0.5 nA seen in tb_diag15/16) with NMOS current
* sinks at the gate nodes. Self-biased. Without it the demod chopper's
* commutation pumped INP to the rail within ~100 ms and killed the signal.
.subckt eeg_dsl GP GN VCM_REF OUTP OUTN VDD18 VSS params: CDSLV=2n
* local NMOS bias (~0.5 uA through R_BIAS)
RB1 VDD18 VBDSL 2Meg
XMB VBDSL VBDSL VSS VSS sky130_fd_pr__nfet_01v8 L=8 W=2 nf=1
* local PMOS bias
XMPB VDD18 VBPDSL VDD18 VDD18 sky130_fd_pr__pfet_01v8 L=4 W=4 nf=1
XMBB VBPDSL VBDSL VSS VSS sky130_fd_pr__nfet_01v8 L=8 W=1 nf=1
* sense followers: S_AVG tracks avg(GP,GN)-Vgsn
XMF1 VDD18 GP SAVG SAVG sky130_fd_pr__nfet_01v8 L=2 W=2 nf=1
XMF2 VDD18 GN SAVG SAVG sky130_fd_pr__nfet_01v8 L=2 W=2 nf=1
XMT1 SAVG VBDSL VSS VSS sky130_fd_pr__nfet_01v8 L=8 W=0.5 nf=1
XMT2 SAVG VBDSL VSS VSS sky130_fd_pr__nfet_01v8 L=8 W=0.5 nf=1
* reference follower from VCM_REF (2x tail to roughly match Vgs)
XMFR VDD18 VCM_REF SREF SREF sky130_fd_pr__nfet_01v8 L=2 W=2 nf=1
XMTR SREF VBDSL VSS VSS sky130_fd_pr__nfet_01v8 L=8 W=1 nf=1
* PMOS error pair + NMOS mirror -> VCTL integrator
XMTL ST VBPDSL VDD18 VDD18 sky130_fd_pr__pfet_01v8 L=4 W=8 nf=1
XME1 D1 SAVG ST ST sky130_fd_pr__pfet_01v8 L=2 W=4 nf=1
XME2 VCTL SREF ST ST sky130_fd_pr__pfet_01v8 L=2 W=4 nf=1
XMM1 D1 D1 VSS VSS sky130_fd_pr__nfet_01v8 L=4 W=2 nf=1
XMM2 VCTL D1 VSS VSS sky130_fd_pr__nfet_01v8 L=4 W=2 nf=1
CINT VCTL VSS 50p
* sink devices pulling the gate nodes down
XMS1 GP VCTL VSS VSS sky130_fd_pr__nfet_01v8 L=4 W=1 nf=1
XMS2 GN VCTL VSS VSS sky130_fd_pr__nfet_01v8 L=4 W=1 nf=1
* ---- differential DSL: sets the signal-path HP corner (~sub-Hz) independent
* of f_chop. The chopped feedback Cf acts as a switched-cap resistor and with
* Cin forms f_HP ~ f_chop*Cf/(pi*Cin) ~ 6-8 Hz (measured); this loop cancels
* DC/low-freq content at the gates instead. OUTP>OUTN -> VDSL up -> GP sink up
* -> INP_M down -> OUTP down (negative feedback, verified by sim).
XMDT ST2 VBDSL VSS VSS sky130_fd_pr__nfet_01v8 L=8 W=0.5 nf=1
XMD1 DD1 OUTP ST2 ST2 sky130_fd_pr__nfet_01v8 L=8 W=1 nf=1
XMD2 VDSL OUTN ST2 ST2 sky130_fd_pr__nfet_01v8 L=8 W=1 nf=1
XMPD1 DD1 DD1 VDD18 VDD18 sky130_fd_pr__pfet_01v8 L=8 W=1 nf=1
XMPD2 VDSL DD1 VDD18 VDD18 sky130_fd_pr__pfet_01v8 L=8 W=1 nf=1
CDSL VDSL VSS {CDSLV}
RBLD VDSL VSS 200Meg
* capacitive injection into GN: the chopper converts the voltage difference
* to a current I = 2*f_chop*CINJ*(VDSL - Vg). Voltage-driven, so no runaway
* sink is possible (the earlier fixed NMOS sink at VB2=0.62 V latched the
* input to VSS). Sign: VDSL up -> injection into INN_M -> OUTN up -> loop
* closes negatively against (OUTP-OUTN).
CINJ GN VDSL 1p
.ends eeg_dsl

.subckt eeg_fd_ota_chopped_full2 INP INN VCM_REF OUTP OUTN PHII NPHII PHIBI NPHIBI PHIM NPHIM PHIBM NPHIBM VDD18 VSS params: W91=4 L91=4 W92=0.5 L92=4 W10=12 RLOAD=2Meg CC=10p RZ=20k RSET=25k RFILT=1Meg CFILT=1n DVOS=0 CDSLV=2n
XBG VBNRAW VBN VBP_BIAS VDD18 VSS eeg_bias_gen RSET={RSET} RFILT={RFILT} CFILT={CFILT}
XDSL INP_M INN_M VCM_REF OUTP OUTN VDD18 VSS eeg_dsl CDSLV={CDSLV}
XCHIN INP INN INP_M INN_M PHII NPHII PHIBI NPHIBI VDD18 VSS eeg_cmos_chopper_lowq
VOS1 INP_M INP_MX {DVOS}
XSTG1 INP_MX INN_M VBP1 VBN N1P N1N VCM1 VCM_REF VDD18 VSS eeg_fd_ota_core_soft RLOAD={RLOAD}
XCM1 VCM1 VCM_REF VBN VBP1 VDD18 VSS eeg_cmfb_amp_dl2 W9={W91} L9={L91} W10={W10}
XCHMID N1P N1N N2P N2N PHIM NPHIM PHIBM NPHIBM VDD18 VSS eeg_cmos_chopper_lowq
XM21 OUTP N2P VSS VSS sky130_fd_pr__nfet_01v8 L=12 W=12 nf=2
XM22 OUTN N2N VSS VSS sky130_fd_pr__nfet_01v8 L=12 W=12 nf=2
XM23 OUTP VBP2 VDD18 VDD18 sky130_fd_pr__pfet_01v8 L=12 W=48 nf=8
XM24 OUTN VBP2 VDD18 VDD18 sky130_fd_pr__pfet_01v8 L=12 W=48 nf=8
RCMO1 OUTP VCM2 5Meg
RCMO2 OUTN VCM2 5Meg
RLOADO1 OUTP VCM_REF {RLOAD}
RLOADO2 OUTN VCM_REF {RLOAD}
XCM2 VCM2 VCM_REF VBN VBP2 VDD18 VSS eeg_cmfb_amp_dl2 W9={W92} L9={L92} W10={W10}
RZP N2P NZP {RZ}
CCP NZP OUTP {CC}
RZN N2N NZN {RZ}
CCN NZN OUTN {CC}
.ends
