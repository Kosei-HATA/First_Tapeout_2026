* Chopped OTA v3: internal chopper + multipath feedforward.
* The fast auxiliary pair (M1F/M2F) sits after the input chopper and drives
* the output through a dedicated demod chopper (XCHFF), bypassing the slow
* N1 pole (M21/22 gate Miller reflection). Its offset/flicker is chopped out
* like the main pair's. The slow high-gain path still sets DC precision.
.subckt eeg_fd_ota_chopped_full3 INP INN VCM_REF OUTP OUTN PHII NPHII PHIBI NPHIBI PHIM NPHIM PHIBM NPHIBM VDD18 VSS params: W91=4 L91=4 W92=0.5 L92=4 W10=12 RLOAD=2Meg CC=10p RZ=20k RSET=25k RFILT=1Meg CFILT=1n DVOS=0 W1F=24 L1F=1 W5F=12
XBG VBNRAW VBN VBP_BIAS VDD18 VSS eeg_bias_gen RSET={RSET} RFILT={RFILT} CFILT={CFILT}
XCHIN INP INN INP_M INN_M PHII NPHII PHIBI NPHIBI VDD18 VSS eeg_cmos_chopper_lowq
VOS1 INP_M INP_MX {DVOS}
XSTG1 INP_MX INN_M VBP1 VBN N1P N1N VCM1 VCM_REF VDD18 VSS eeg_fd_ota_core_soft RLOAD={RLOAD}
XCM1 VCM1 VCM_REF VBN VBP1 VDD18 VSS eeg_cmfb_amp_dl2 W9={W91} L9={L91} W10={W10}
XCHMID N1P N1N N2P N2N PHIM NPHIM PHIBM NPHIBM VDD18 VSS eeg_cmos_chopper_lowq
* fast feedforward pair
XM1F DFP INP_MX TF VSS sky130_fd_pr__nfet_01v8 L={L1F} W={W1F} nf=4
XM2F DFN INN_M TF VSS sky130_fd_pr__nfet_01v8 L={L1F} W={W1F} nf=4
XM5F TF VBN VSS VSS sky130_fd_pr__nfet_01v8 L=4 W={W5F} nf=2
* demod for the ff path, then inject into the output nodes
XCHFF DFP DFN DFP2 DFN2 PHIM NPHIM PHIBM NPHIBM VDD18 VSS eeg_cmos_chopper_lowq
RFPP DFP2 OUTN 5k
RFNN DFN2 OUTP 5k
* stage 2
XM21 OUTP N2P VSS VSS sky130_fd_pr__nfet_01v8 L=12 W=12 nf=2
XM22 OUTN N2N VSS VSS sky130_fd_pr__nfet_01v8 L=12 W=12 nf=2
XM23 OUTP VBP2 VDD18 VDD18 sky130_fd_pr__pfet_01v8 L=12 W=48 nf=8
XM24 OUTN VBP2 VDD18 VDD18 sky130_fd_pr__pfet_01v8 L=12 W=48 nf=8
RCMO1 OUTP VCM2 5Meg
RCMO2 OUTN VCM2 5Meg
RLOADO1 OUTP VCM_REF {RLOAD}
RLOADO2 OUTN VCM_REF {RLOAD}
XCM2 VCM2 VCM_REF VBN VBP2 VDD18 VSS eeg_cmfb_amp_dl2 W9={W92} L9={L92} W10={W10}
RZP N2P NZP {RZ}
CCP NZP OUTP {CC}
RZN N2N NZN {RZ}
CCN NZN OUTN {CC}
.ends
