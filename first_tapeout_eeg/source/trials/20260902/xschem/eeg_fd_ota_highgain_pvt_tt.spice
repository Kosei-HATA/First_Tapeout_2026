* TT nominal
.lib /Users/noah/.volare/volare/sky130/versions/0fe599b2afb6708d281543108caf8310912f54af/sky130A/libs.tech/ngspice/sky130.lib.spice tt
.param VDD=1.8 VCM=0.9 VBN=0.63
.temp 27
.include eeg_fd_ota_highgain_pvt_body.inc
