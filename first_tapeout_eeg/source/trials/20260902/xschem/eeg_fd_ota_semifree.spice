* Per-loop ground truth, transient. Two hardwired variants:
* eeg_fd_ota_f1: VBP1 forced externally, stage-2 CMFB closed
* eeg_fd_ota_f2: VBP2 forced externally, stage-1 CMFB closed
.subckt eeg_fd_ota_f1 INP INN VCM_REF VBN OUTP OUTN VBP1 VDD18 VSS
XSTG1 INP INN VBP1 VBN N1P N1N VCM1 VDD18 VSS eeg_fd_ota_core_highgain
XM21 OUTP N1P VSS VSS sky130_fd_pr__nfet_01v8 L=12 W=12 nf=2
XM22 OUTN N1N VSS VSS sky130_fd_pr__nfet_01v8 L=12 W=12 nf=2
XM23 OUTP VBP2 VDD18 VDD18 sky130_fd_pr__pfet_01v8 L=12 W=48 nf=8
XM24 OUTN VBP2 VDD18 VDD18 sky130_fd_pr__pfet_01v8 L=12 W=48 nf=8
RCMO1 OUTP VCM2 5Meg
RCMO2 OUTN VCM2 5Meg
XCM2 VCM2 VCM_REF VBN VBP2 VDD18 VSS eeg_cmfb_amp
RZP N1P NZP 1
CCP NZP OUTP 10p
RZN N1N NZN 1
CCN NZN OUTN 10p
.ends eeg_fd_ota_f1
.subckt eeg_fd_ota_f2 INP INN VCM_REF VBN OUTP OUTN VBP2 VDD18 VSS
XSTG1 INP INN VBP1 VBN N1P N1N VCM1 VDD18 VSS eeg_fd_ota_core_highgain
XCM1 VCM1 VCM_REF VBN VBP1 VDD18 VSS eeg_cmfb_amp
XM21 OUTP N1P VSS VSS sky130_fd_pr__nfet_01v8 L=12 W=12 nf=2
XM22 OUTN N1N VSS VSS sky130_fd_pr__nfet_01v8 L=12 W=12 nf=2
XM23 OUTP VBP2 VDD18 VDD18 sky130_fd_pr__pfet_01v8 L=12 W=48 nf=8
XM24 OUTN VBP2 VDD18 VDD18 sky130_fd_pr__pfet_01v8 L=12 W=48 nf=8
RCMO1 OUTP VCM2 5Meg
RCMO2 OUTN VCM2 5Meg
RZP N1P NZP 1
CCP NZP OUTP 10p
RZN N1N NZN 1
CCN NZN OUTN 10p
.ends eeg_fd_ota_f2
