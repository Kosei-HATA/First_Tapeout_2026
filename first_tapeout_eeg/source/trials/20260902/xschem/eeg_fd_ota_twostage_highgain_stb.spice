.subckt eeg_fd_ota_twostage_highgain_stb INP INN VCM_REF VBN OUTP OUTN VCM1R VCM1A VCM2R VCM2A VDD18 VSS
* Two-stage OTA with both CMFB sense nodes broken out for loop-gain analysis.
* VCMxR = resistor-divider junction (loop return), VCMxA = CMFB amp input.
* Close each loop externally (short VCMxR-VCMxA) when not under test.
XSTG1 INP INN VBP1 VBN N1P N1N VCM1R_INT VDD18 VSS eeg_fd_ota_core_highgain
VW1 VCM1R VCM1R_INT 0
XCM1 VCM1A VCM_REF VBN VBP1 VDD18 VSS eeg_cmfb_amp
XM21 OUTP N1P VSS VSS sky130_fd_pr__nfet_01v8 L=12 W=12 nf=2
XM22 OUTN N1N VSS VSS sky130_fd_pr__nfet_01v8 L=12 W=12 nf=2
XM23 OUTP VBP2 VDD18 VDD18 sky130_fd_pr__pfet_01v8 L=12 W=48 nf=8
XM24 OUTN VBP2 VDD18 VDD18 sky130_fd_pr__pfet_01v8 L=12 W=48 nf=8
RCMO1 OUTP VCM2R 5Meg
RCMO2 OUTN VCM2R 5Meg
XCM2 VCM2A VCM_REF VBN VBP2 VDD18 VSS eeg_cmfb_amp
RZP N1P NZP 1
CCP NZP OUTP 10p
RZN N1N NZN 1
CCN NZN OUTN 10p
.ends eeg_fd_ota_twostage_highgain_stb
