* Chopped PGA x32 PVT corner sweep. sed tokens: @CORNER@ @VDD@ @TEMP@ @TAG@
.lib /Users/noah/.volare/volare/sky130/versions/0fe599b2afb6708d281543108caf8310912f54af/sky130A/libs.tech/ngspice/sky130.lib.spice @CORNER@
.temp @TEMP@
.include eeg_tg_lowq.spice
.include eeg_fd_ota_core_highgain.spice
.include eeg_cmfb_amp_dl.spice
.include eeg_fd_ota_chopped_dl.spice
.param VDD=@VDD@ VCM={@VDD@/2} VBN=0.63 TCHOP=125u CHOP=1
VDD_SRC VDD18 0 {VDD}
VREF VCM_REF 0 {VCM}
VBN_SRC VBN 0 {VBN}
VPHI PHI 0 PULSE(0 {VDD} 50n 20n 20n 62.35u {TCHOP})
VPHIB PHIB 0 PULSE(0 {VDD} 62.55u 20n 20n 62.35u {TCHOP})
BNPHI NPHI 0 V={VDD}-v(PHI)
BNPHIB NPHIB 0 V={VDD}-v(PHIB)
VSIGP SIGP 0 SIN({VCM} 500u 100)
VSIGN SIGN 0 SIN({VCM} 500u 100 0 0 180)
CINP SIGP INP 32p
CINN SIGN INN 32p
CFP OUTN INP 1p
CFN OUTP INN 1p
RBIASP INP VCM_REF 1T
RBIASN INN VCM_REF 1T
XAFE INP INN VCM_REF VBN OUTP OUTN PHI NPHI PHIB NPHIB PHI NPHI PHIB NPHIB VDD18 0 eeg_fd_ota_chopped_dl
CLOADP OUTP 0 5p
CLOADN OUTN 0 5p
.control
set noaskquit
tran 50n 25m 5m
let voutd=v(OUTP)-v(OUTN)
let vcmout=(v(OUTP)+v(OUTN))/2
let idd=-i(VDD_SRC)
meas tran idd_avg avg idd from=20m to=25m
meas tran vcm_avg avg vcmout from=20m to=25m
meas tran vcm_pp pp vcmout from=15m to=25m
wrdata ../results/pga32_pvt_@TAG@.csv time voutd vcmout
quit
.endc
.end
