* 1st-order 1-bit continuous-time Sigma-Delta modulator, fs=16 kHz.
* Fully differential CT integrator (R-C) + NRZ 1-bit DAC (resistive,
* level-selected, no switched-cap charge dumps) + strong-arm + NAND SR latch.
* Integrator unity-gain ~ fs: RIN*CI ~ 1/(2*pi*fs).
* Loop: vin>0 -> o_int<0 (inverting) -> QP low -> BIT=1 -> DAC pulls INP up.
.subckt eeg_sdm1ct VINP VINN VCM_REF VP VN BIT NBIT OINTP OINTN CLK NCLK VDD18 VSS params: RIN=500k CI=20p RDAC=500k RF=100Meg
* CT integrator
RINP VINP INP {RIN}
RINN VINN INN {RIN}
XOTA INP INN VCM_REF OINTP OINTN VDD18 VSS eeg_fd_ota_full2_nc
CIP OINTN INP {CI}
RFP OINTN INP {RF}
CIN OINTP INN {CI}
RFN OINTP INN {RF}
* NRZ DAC: summing nodes pulled toward VP/VN through RDAC per BIT
XDP INP VDACP BIT1 NBIT1 VDD18 VSS eeg_tg_lowq
XDN INN VDACN BIT0 NBIT0 VDD18 VSS eeg_tg_lowq
* select the reference per BIT (both sides always driven: P side by BIT, N side by ~BIT)
XREFP1 VDACP VP BIT1 NBIT1 VDD18 VSS eeg_tg_lowq
XREFP0 VDACP VN BIT0 NBIT0 VDD18 VSS eeg_tg_lowq
XREFN1 VDACN VN BIT1 NBIT1 VDD18 VSS eeg_tg_lowq
XREFN0 VDACN VP BIT0 NBIT0 VDD18 VSS eeg_tg_lowq
RDACP INP VDACP {RDAC}
RDACN INN VDACN {RDAC}
BBIT1 BIT1 0 V=v(BIT)
BNBIT1 NBIT1 0 V=v(VDD18)-v(BIT)
BBIT0 BIT0 0 V=v(VDD18)-v(BIT)
BNBIT0 NBIT0 0 V=v(BIT)
* quantizer
XCMP OINTP OINTN QP QN CLK VDD18 VSS eeg_strongarm
XND1 QP NBIT BIT VDD18 VSS eeg_nand2
XND2 QN BIT NBIT VDD18 VSS eeg_nand2
.ends
