* NGSPICE flat PEX netlist for eeg_sdm1ct (sky130A)
* Devices: magic `ext2spice lvs` netlist, hierarchy inlined by ext2pex.py
* (parallel fingers/unit devices merged: exact BSIM equivalence);
* Parasitic capacitors: magic .ext database (node->substrate, cap->coupling)
* sky130A extraction excludes FET gate/diffusion caps (kept in BSIM
* ad/as/pd/ps terms), so no double counting. Caps in farads.
* totals: 510 devices (306 parallel merged), 2661 caps (3842.999 fF substrate + 9395.883 fF coupling)

.subckt eeg_sdm1ct VINP VINN VCM_REF VP VN BIT NBIT OINTP OINTN CLK NCLK VDD18 VSS
R0 eeg_pseudo_res_0/B m1_55941_64136# 100000
R1 m1_57225_55443# eeg_tg_lowq_3/A 100000
R2 m1_56797_48136# m1_57225_55443# 100000
R3 m1_56369_55443# m1_56797_48136# 100000
R4 m1_55941_48136# m1_56369_55443# 100000
R5 eeg_pseudo_res_1/B m1_55941_48136# 100000
R6 m1_57225_39443# eeg_pseudo_res_0/B 100000
R7 m1_56797_32136# m1_57225_39443# 100000
X8 eeg_pseudo_res_0/B eeg_pseudo_res_0/m1_68_66# eeg_pseudo_res_0/m1_68_66# eeg_pseudo_res_0/B sky130_fd_pr__pfet_01v8 ad=1.02 pd=4.04 as=1.02 ps=4.04 w=1 l=4 nf=1
X9 OINTP eeg_pseudo_res_0/m1_68_66# eeg_pseudo_res_0/m1_68_66# OINTP sky130_fd_pr__pfet_01v8 ad=1.02 pd=4.04 as=1.02 ps=4.04 w=1 l=4 nf=1
R10 m1_56369_39443# m1_56797_32136# 100000
X11 eeg_pseudo_res_1/B eeg_pseudo_res_1/m1_68_66# eeg_pseudo_res_1/m1_68_66# eeg_pseudo_res_1/B sky130_fd_pr__pfet_01v8 ad=1.02 pd=4.04 as=1.02 ps=4.04 w=1 l=4 nf=1
X12 OINTN eeg_pseudo_res_1/m1_68_66# eeg_pseudo_res_1/m1_68_66# OINTN sky130_fd_pr__pfet_01v8 ad=1.02 pd=4.04 as=1.02 ps=4.04 w=1 l=4 nf=1
R13 m1_55941_32136# m1_56369_39443# 100000
R14 VINN m1_55941_32136# 100000
R15 m1_57225_23443# eeg_pseudo_res_1/B 100000
R16 m1_56797_16136# m1_57225_23443# 100000
R17 m1_56369_23443# m1_56797_16136# 100000
R18 m1_55941_16136# m1_56369_23443# 100000
R19 VINP m1_55941_16136# 100000
X20 VP eeg_inv_0/Y VP VDD18 sky130_fd_pr__pfet_01v8 ad=0.5544 pd=3 as=0.5544 ps=3 w=0.84 l=0.15 nf=1
X21 eeg_tg_lowq_1/A BIT eeg_tg_lowq_1/A VSS sky130_fd_pr__nfet_01v8 ad=0.126 pd=1.44 as=0.126 ps=1.44 w=0.42 l=0.15 nf=1
X22 VP BIT VP VSS sky130_fd_pr__nfet_01v8 ad=0.126 pd=1.44 as=0.126 ps=1.44 w=0.42 l=0.15 nf=1
X23 VP BIT eeg_tg_lowq_1/A VDD18 sky130_fd_pr__pfet_01v8 ad=1.7136 pd=5.4 as=1.7136 ps=5.4 w=1.68 l=0.15 nf=1
X24 eeg_tg_lowq_1/A eeg_inv_0/Y eeg_tg_lowq_1/A VDD18 sky130_fd_pr__pfet_01v8 ad=0.5544 pd=3 as=0.5544 ps=3 w=0.84 l=0.15 nf=1
X25 VP eeg_inv_0/Y eeg_tg_lowq_1/A VSS sky130_fd_pr__nfet_01v8 ad=0.5544 pd=3 as=0.5544 ps=3 w=0.84 l=0.15 nf=1
X26 VDD18 eeg_nand2_0/A NBIT VDD18 sky130_fd_pr__pfet_01v8 ad=2.04 pd=6.04 as=2.04 ps=6.04 w=2 l=0.15 nf=1
X27 eeg_nand2_0/m1_302_66# eeg_nand2_0/A NBIT VSS sky130_fd_pr__nfet_01v8 ad=1.02 pd=4.04 as=1.02 ps=4.04 w=1 l=0.15 nf=1
X28 VDD18 BIT NBIT VDD18 sky130_fd_pr__pfet_01v8 ad=2.04 pd=6.04 as=2.04 ps=6.04 w=2 l=0.15 nf=1
X29 VSS BIT eeg_nand2_0/m1_302_66# VSS sky130_fd_pr__nfet_01v8 ad=1.02 pd=4.04 as=1.02 ps=4.04 w=1 l=0.15 nf=1
X30 VN BIT VN VDD18 sky130_fd_pr__pfet_01v8 ad=0.5544 pd=3 as=0.5544 ps=3 w=0.84 l=0.15 nf=1
X31 eeg_tg_lowq_1/A eeg_inv_0/Y eeg_tg_lowq_1/A VSS sky130_fd_pr__nfet_01v8 ad=0.126 pd=1.44 as=0.126 ps=1.44 w=0.42 l=0.15 nf=1
X32 VN eeg_inv_0/Y VN VSS sky130_fd_pr__nfet_01v8 ad=0.126 pd=1.44 as=0.126 ps=1.44 w=0.42 l=0.15 nf=1
X33 VN eeg_inv_0/Y eeg_tg_lowq_1/A VDD18 sky130_fd_pr__pfet_01v8 ad=1.7136 pd=5.4 as=1.7136 ps=5.4 w=1.68 l=0.15 nf=1
X34 eeg_tg_lowq_1/A BIT eeg_tg_lowq_1/A VDD18 sky130_fd_pr__pfet_01v8 ad=0.5544 pd=3 as=0.5544 ps=3 w=0.84 l=0.15 nf=1
X35 VN BIT eeg_tg_lowq_1/A VSS sky130_fd_pr__nfet_01v8 ad=0.5544 pd=3 as=0.5544 ps=3 w=0.84 l=0.15 nf=1
X36 VDD18 eeg_nand2_1/A BIT VDD18 sky130_fd_pr__pfet_01v8 ad=2.04 pd=6.04 as=2.04 ps=6.04 w=2 l=0.15 nf=1
X37 eeg_nand2_1/m1_302_66# eeg_nand2_1/A BIT VSS sky130_fd_pr__nfet_01v8 ad=1.02 pd=4.04 as=1.02 ps=4.04 w=1 l=0.15 nf=1
X38 VDD18 NBIT BIT VDD18 sky130_fd_pr__pfet_01v8 ad=2.04 pd=6.04 as=2.04 ps=6.04 w=2 l=0.15 nf=1
X39 VSS NBIT eeg_nand2_1/m1_302_66# VSS sky130_fd_pr__nfet_01v8 ad=1.02 pd=4.04 as=1.02 ps=4.04 w=1 l=0.15 nf=1
X40 VN eeg_inv_0/Y VN VDD18 sky130_fd_pr__pfet_01v8 ad=0.5544 pd=3 as=0.5544 ps=3 w=0.84 l=0.15 nf=1
X41 eeg_tg_lowq_3/A BIT eeg_tg_lowq_3/A VSS sky130_fd_pr__nfet_01v8 ad=0.126 pd=1.44 as=0.126 ps=1.44 w=0.42 l=0.15 nf=1
X42 VN BIT VN VSS sky130_fd_pr__nfet_01v8 ad=0.126 pd=1.44 as=0.126 ps=1.44 w=0.42 l=0.15 nf=1
X43 VN BIT eeg_tg_lowq_3/A VDD18 sky130_fd_pr__pfet_01v8 ad=1.7136 pd=5.4 as=1.7136 ps=5.4 w=1.68 l=0.15 nf=1
X44 eeg_tg_lowq_3/A eeg_inv_0/Y eeg_tg_lowq_3/A VDD18 sky130_fd_pr__pfet_01v8 ad=0.5544 pd=3 as=0.5544 ps=3 w=0.84 l=0.15 nf=1
X45 VN eeg_inv_0/Y eeg_tg_lowq_3/A VSS sky130_fd_pr__nfet_01v8 ad=0.5544 pd=3 as=0.5544 ps=3 w=0.84 l=0.15 nf=1
X46 VP BIT VP VDD18 sky130_fd_pr__pfet_01v8 ad=0.5544 pd=3 as=0.5544 ps=3 w=0.84 l=0.15 nf=1
X47 eeg_tg_lowq_3/A eeg_inv_0/Y eeg_tg_lowq_3/A VSS sky130_fd_pr__nfet_01v8 ad=0.126 pd=1.44 as=0.126 ps=1.44 w=0.42 l=0.15 nf=1
X48 VP eeg_inv_0/Y VP VSS sky130_fd_pr__nfet_01v8 ad=0.126 pd=1.44 as=0.126 ps=1.44 w=0.42 l=0.15 nf=1
X49 VP eeg_inv_0/Y eeg_tg_lowq_3/A VDD18 sky130_fd_pr__pfet_01v8 ad=1.7136 pd=5.4 as=1.7136 ps=5.4 w=1.68 l=0.15 nf=1
X50 eeg_tg_lowq_3/A BIT eeg_tg_lowq_3/A VDD18 sky130_fd_pr__pfet_01v8 ad=0.5544 pd=3 as=0.5544 ps=3 w=0.84 l=0.15 nf=1
X51 VP BIT eeg_tg_lowq_3/A VSS sky130_fd_pr__nfet_01v8 ad=0.5544 pd=3 as=0.5544 ps=3 w=0.84 l=0.15 nf=1
X52 VDD18 eeg_fd_ota_full2_nc_0/eeg_bias_gen_0/VBP eeg_fd_ota_full2_nc_0/eeg_bias_gen_0/VBN VDD18 sky130_fd_pr__pfet_01v8 ad=5.1 pd=12.04 as=1.25 ps=5.5 w=5 l=4 nf=1
X53 eeg_fd_ota_full2_nc_0/eeg_bias_gen_0/VBN eeg_fd_ota_full2_nc_0/eeg_bias_gen_0/VBP VDD18 VDD18 sky130_fd_pr__pfet_01v8 ad=1.25 pd=5.5 as=5.1 ps=12.04 w=5 l=4 nf=1
R54 eeg_fd_ota_full2_nc_0/eeg_bias_gen_0/m1_6509_n27552# eeg_fd_ota_full2_nc_0/eeg_bias_gen_0/m1_6937_n20245# 100000
X55 eeg_fd_ota_full2_nc_0/eeg_bias_gen_0/VBN eeg_fd_ota_full2_nc_0/eeg_bias_gen_0/eeg_pseudo_res_0/m1_68_66# eeg_fd_ota_full2_nc_0/eeg_bias_gen_0/eeg_pseudo_res_0/m1_68_66# eeg_fd_ota_full2_nc_0/eeg_bias_gen_0/VBN sky130_fd_pr__pfet_01v8 ad=1.02 pd=4.04 as=1.02 ps=4.04 w=1 l=4 nf=1
X56 VDD18 eeg_fd_ota_full2_nc_0/eeg_bias_gen_0/eeg_pseudo_res_0/m1_68_66# eeg_fd_ota_full2_nc_0/eeg_bias_gen_0/eeg_pseudo_res_0/m1_68_66# VDD18 sky130_fd_pr__pfet_01v8 ad=1.02 pd=4.04 as=1.02 ps=4.04 w=1 l=4 nf=1
R57 eeg_fd_ota_full2_nc_0/eeg_bias_gen_0/m1_12073_n37933# eeg_fd_ota_full2_nc_0/eeg_bias_gen_0/m1_11763_n36396# 100000
X58 eeg_fd_ota_full2_nc_0/eeg_bias_gen_0/VBN eeg_fd_ota_full2_nc_0/eeg_bias_gen_0/VBN VSS VSS sky130_fd_pr__nfet_01v8 ad=1.25 pd=5.5 as=5.1 ps=12.04 w=5 l=4 nf=1
X59 VSS eeg_fd_ota_full2_nc_0/eeg_bias_gen_0/VBN eeg_fd_ota_full2_nc_0/eeg_bias_gen_0/VBN VSS sky130_fd_pr__nfet_01v8 ad=5.1 pd=12.04 as=1.25 ps=5.5 w=5 l=4 nf=1
R60 eeg_fd_ota_full2_nc_0/eeg_bias_gen_0/m1_6081_n20245# eeg_fd_ota_full2_nc_0/eeg_bias_gen_0/m1_6509_n27552# 100000
R61 eeg_fd_ota_full2_nc_0/eeg_bias_gen_0/m1_10789_n27552# eeg_fd_ota_full2_nc_0/eeg_bias_gen_0/m1_11217_n20245# 100000
R62 eeg_fd_ota_full2_nc_0/eeg_bias_gen_0/m1_2552_466# VSS 24985.5
R63 eeg_fd_ota_full2_nc_0/eeg_bias_gen_0/m1_11645_n45240# eeg_fd_ota_full2_nc_0/eeg_bias_gen_0/m1_12073_n37933# 100000
R64 eeg_fd_ota_full2_nc_0/eeg_bias_gen_0/m1_10789_n9864# eeg_fd_ota_full2_nc_0/eeg_bias_gen_0/m1_11217_n2557# 100000
R65 eeg_fd_ota_full2_nc_0/eeg_bias_gen_0/m1_11217_n37933# eeg_fd_ota_full2_nc_0/eeg_bias_gen_0/m1_11645_n45240# 100000
R66 eeg_fd_ota_full2_nc_0/eeg_bias_gen_0/m1_5653_n27552# eeg_fd_ota_full2_nc_0/eeg_bias_gen_0/m1_6081_n20245# 100000
R67 eeg_fd_ota_full2_nc_0/eeg_bias_gen_0/m1_10361_n20245# eeg_fd_ota_full2_nc_0/eeg_bias_gen_0/m1_10789_n27552# 100000
R68 eeg_fd_ota_full2_nc_0/eeg_bias_gen_0/m1_5225_n20245# eeg_fd_ota_full2_nc_0/eeg_bias_gen_0/m1_5653_n27552# 100000
R69 eeg_fd_ota_full2_nc_0/eeg_bias_gen_0/m1_9933_n27552# eeg_fd_ota_full2_nc_0/eeg_bias_gen_0/m1_10361_n20245# 100000
R70 eeg_fd_ota_full2_nc_0/eeg_bias_gen_0/m1_5343_n11401# eeg_fd_ota_full2_nc_0/eeg_bias_gen_0/m1_4915_n18708# 100000
R71 eeg_fd_ota_full2_nc_0/eeg_bias_gen_0/m1_10361_n2557# eeg_fd_ota_full2_nc_0/eeg_bias_gen_0/m1_10789_n9864# 100000
R72 eeg_fd_ota_full2_nc_0/eeg_bias_gen_0/m1_10789_n45240# eeg_fd_ota_full2_nc_0/eeg_bias_gen_0/m1_11217_n37933# 100000
R73 eeg_fd_ota_full2_nc_0/eeg_bias_gen_0/m1_4797_n27552# eeg_fd_ota_full2_nc_0/eeg_bias_gen_0/m1_5225_n20245# 100000
R74 eeg_fd_ota_full2_nc_0/eeg_bias_gen_0/m1_9505_n20245# eeg_fd_ota_full2_nc_0/eeg_bias_gen_0/m1_9933_n27552# 100000
R75 eeg_fd_ota_full2_nc_0/eeg_bias_gen_0/m1_5771_n18708# eeg_fd_ota_full2_nc_0/eeg_bias_gen_0/m1_5343_n11401# 100000
R76 eeg_fd_ota_full2_nc_0/eeg_bias_gen_0/m1_10907_n18708# eeg_fd_ota_full2_nc_0/eeg_bias_gen_0/m1_10479_n11401# 100000
R77 eeg_fd_ota_full2_nc_0/eeg_bias_gen_0/m1_6081_n2557# eeg_fd_ota_full2_nc_0/eeg_bias_gen_0/m1_6509_n9864# 100000
R78 eeg_fd_ota_full2_nc_0/eeg_bias_gen_0/m1_10361_n37933# eeg_fd_ota_full2_nc_0/eeg_bias_gen_0/m1_10789_n45240# 100000
R79 eeg_fd_ota_full2_nc_0/eeg_bias_gen_0/m1_4369_n20245# eeg_fd_ota_full2_nc_0/eeg_bias_gen_0/m1_4797_n27552# 100000
R80 eeg_fd_ota_full2_nc_0/eeg_bias_gen_0/m1_9077_n27552# eeg_fd_ota_full2_nc_0/eeg_bias_gen_0/m1_9505_n20245# 100000
R81 eeg_fd_ota_full2_nc_0/eeg_bias_gen_0/m1_6199_n11401# eeg_fd_ota_full2_nc_0/eeg_bias_gen_0/m1_5771_n18708# 100000
R82 eeg_fd_ota_full2_nc_0/eeg_bias_gen_0/m1_9623_n11401# eeg_fd_ota_full2_nc_0/eeg_bias_gen_0/m1_9195_n18708# 100000
R83 eeg_fd_ota_full2_nc_0/eeg_bias_gen_0/m1_11335_n11401# eeg_fd_ota_full2_nc_0/eeg_bias_gen_0/m1_10907_n18708# 100000
R84 eeg_fd_ota_full2_nc_0/eeg_bias_gen_0/m1_5653_n9864# eeg_fd_ota_full2_nc_0/eeg_bias_gen_0/m1_6081_n2557# 100000
R85 eeg_fd_ota_full2_nc_0/eeg_bias_gen_0/m1_10907_n36396# eeg_fd_ota_full2_nc_0/eeg_bias_gen_0/m1_10479_n29089# 100000
X86 VDD18 eeg_fd_ota_full2_nc_0/eeg_bias_gen_0/VBP eeg_fd_ota_full2_nc_0/eeg_bias_gen_0/VBP VDD18 sky130_fd_pr__pfet_01v8 ad=5.1 pd=12.04 as=1.25 ps=5.5 w=5 l=4 nf=1
X87 eeg_fd_ota_full2_nc_0/eeg_bias_gen_0/VBP eeg_fd_ota_full2_nc_0/eeg_bias_gen_0/VBP VDD18 VDD18 sky130_fd_pr__pfet_01v8 ad=1.25 pd=5.5 as=5.1 ps=12.04 w=5 l=4 nf=1
R88 eeg_fd_ota_full2_nc_0/eeg_bias_gen_0/m1_7793_n37933# eeg_fd_ota_full2_nc_0/eeg_bias_gen_0/m1_8221_n45240# 100000
R89 eeg_fd_ota_full2_nc_0/eeg_bias_gen_0/m1_3941_n27552# eeg_fd_ota_full2_nc_0/eeg_bias_gen_0/m1_4369_n20245# 100000
R90 eeg_fd_ota_full2_nc_0/eeg_bias_gen_0/m1_8649_n20245# eeg_fd_ota_full2_nc_0/eeg_bias_gen_0/m1_9077_n27552# 100000
R91 eeg_fd_ota_full2_nc_0/eeg_bias_gen_0/m1_6627_n18708# eeg_fd_ota_full2_nc_0/eeg_bias_gen_0/m1_6199_n11401# 100000
R92 eeg_fd_ota_full2_nc_0/eeg_bias_gen_0/m1_10051_n18708# eeg_fd_ota_full2_nc_0/eeg_bias_gen_0/m1_9623_n11401# 100000
R93 eeg_fd_ota_full2_nc_0/eeg_bias_gen_0/m1_11763_n18708# eeg_fd_ota_full2_nc_0/eeg_bias_gen_0/m1_11335_n11401# 100000
R94 eeg_fd_ota_full2_nc_0/eeg_bias_gen_0/m1_5225_n2557# eeg_fd_ota_full2_nc_0/eeg_bias_gen_0/m1_5653_n9864# 100000
R95 eeg_fd_ota_full2_nc_0/eeg_bias_gen_0/m1_11335_n29089# eeg_fd_ota_full2_nc_0/eeg_bias_gen_0/m1_10907_n36396# 100000
R96 eeg_fd_ota_full2_nc_0/eeg_bias_gen_0/m1_7365_n45240# eeg_fd_ota_full2_nc_0/eeg_bias_gen_0/m1_7793_n37933# 100000
R97 eeg_fd_ota_full2_nc_0/eeg_bias_gen_0/m1_8767_n29089# eeg_fd_ota_full2_nc_0/eeg_bias_gen_0/m1_8339_n36396# 100000
R98 eeg_fd_ota_full2_nc_0/eeg_bias_gen_0/m1_3701_n29089# eeg_fd_ota_full2_nc_0/eeg_bias_gen_0/m1_3941_n27552# 100000
R99 eeg_fd_ota_full2_nc_0/eeg_bias_gen_0/m1_8221_n27552# eeg_fd_ota_full2_nc_0/eeg_bias_gen_0/m1_8649_n20245# 100000
R100 eeg_fd_ota_full2_nc_0/eeg_bias_gen_0/m1_7055_n11401# eeg_fd_ota_full2_nc_0/eeg_bias_gen_0/m1_6627_n18708# 100000
R101 eeg_fd_ota_full2_nc_0/eeg_bias_gen_0/m1_12073_n20245# eeg_fd_ota_full2_nc_0/eeg_bias_gen_0/m1_11763_n18708# 100000
R102 eeg_fd_ota_full2_nc_0/eeg_bias_gen_0/m1_4797_n9864# eeg_fd_ota_full2_nc_0/eeg_bias_gen_0/m1_5225_n2557# 100000
R103 eeg_fd_ota_full2_nc_0/eeg_bias_gen_0/m1_9505_n2557# eeg_fd_ota_full2_nc_0/eeg_bias_gen_0/m1_9933_n9864# 100000
R104 eeg_fd_ota_full2_nc_0/eeg_bias_gen_0/m1_11763_n36396# eeg_fd_ota_full2_nc_0/eeg_bias_gen_0/m1_11335_n29089# 100000
R105 eeg_fd_ota_full2_nc_0/eeg_bias_gen_0/m1_9933_n9864# eeg_fd_ota_full2_nc_0/eeg_bias_gen_0/m1_10361_n2557# 100000
R106 eeg_fd_ota_full2_nc_0/eeg_bias_gen_0/m1_6937_n37933# eeg_fd_ota_full2_nc_0/eeg_bias_gen_0/m1_7365_n45240# 100000
R107 eeg_fd_ota_full2_nc_0/eeg_bias_gen_0/m1_4487_n29089# eeg_fd_ota_full2_nc_0/eeg_bias_gen_0/m1_4059_n36396# 100000
R108 eeg_fd_ota_full2_nc_0/eeg_bias_gen_0/m1_9195_n36396# eeg_fd_ota_full2_nc_0/eeg_bias_gen_0/m1_8767_n29089# 100000
R109 eeg_fd_ota_full2_nc_0/eeg_bias_gen_0/m1_10479_n29089# eeg_fd_ota_full2_nc_0/eeg_bias_gen_0/m1_10051_n36396# 100000
R110 eeg_fd_ota_full2_nc_0/eeg_bias_gen_0/m1_7793_n20245# eeg_fd_ota_full2_nc_0/eeg_bias_gen_0/m1_8221_n27552# 100000
R111 eeg_fd_ota_full2_nc_0/eeg_bias_gen_0/m1_7483_n18708# eeg_fd_ota_full2_nc_0/eeg_bias_gen_0/m1_7055_n11401# 100000
R112 eeg_fd_ota_full2_nc_0/eeg_bias_gen_0/m1_4369_n2557# eeg_fd_ota_full2_nc_0/eeg_bias_gen_0/m1_4797_n9864# 100000
R113 eeg_fd_ota_full2_nc_0/eeg_bias_gen_0/m1_9077_n9864# eeg_fd_ota_full2_nc_0/eeg_bias_gen_0/m1_9505_n2557# 100000
R114 eeg_fd_ota_full2_nc_0/eeg_bias_gen_0/m1_4369_n37933# eeg_fd_ota_full2_nc_0/eeg_bias_gen_0/m1_4797_n45240# 100000
R115 eeg_fd_ota_full2_nc_0/eeg_bias_gen_0/m1_6509_n45240# eeg_fd_ota_full2_nc_0/eeg_bias_gen_0/m1_6937_n37933# 100000
R116 eeg_fd_ota_full2_nc_0/eeg_bias_gen_0/m1_9933_n45240# eeg_fd_ota_full2_nc_0/eeg_bias_gen_0/m1_10361_n37933# 100000
R117 eeg_fd_ota_full2_nc_0/eeg_bias_gen_0/m1_4915_n36396# eeg_fd_ota_full2_nc_0/eeg_bias_gen_0/m1_4487_n29089# 100000
R118 eeg_fd_ota_full2_nc_0/eeg_bias_gen_0/m1_9623_n29089# eeg_fd_ota_full2_nc_0/eeg_bias_gen_0/m1_9195_n36396# 100000
R119 eeg_fd_ota_full2_nc_0/eeg_bias_gen_0/m1_7365_n27552# eeg_fd_ota_full2_nc_0/eeg_bias_gen_0/m1_7793_n20245# 100000
R120 eeg_fd_ota_full2_nc_0/eeg_bias_gen_0/m1_7911_n11401# eeg_fd_ota_full2_nc_0/eeg_bias_gen_0/m1_7483_n18708# 100000
R121 eeg_fd_ota_full2_nc_0/eeg_bias_gen_0/m1_10479_n11401# eeg_fd_ota_full2_nc_0/eeg_bias_gen_0/m1_10051_n18708# 100000
R122 eeg_fd_ota_full2_nc_0/eeg_bias_gen_0/m1_3941_n9864# eeg_fd_ota_full2_nc_0/eeg_bias_gen_0/m1_4369_n2557# 100000
R123 eeg_fd_ota_full2_nc_0/eeg_bias_gen_0/m1_8649_n2557# eeg_fd_ota_full2_nc_0/eeg_bias_gen_0/m1_9077_n9864# 100000
R124 eeg_fd_ota_full2_nc_0/eeg_bias_gen_0/m1_4059_n36396# eeg_fd_ota_full2_nc_0/eeg_bias_gen_0/m1_3701_n29089# 100000
R125 eeg_fd_ota_full2_nc_0/eeg_bias_gen_0/m1_6081_n37933# eeg_fd_ota_full2_nc_0/eeg_bias_gen_0/m1_6509_n45240# 100000
R126 eeg_fd_ota_full2_nc_0/eeg_bias_gen_0/m1_5343_n29089# eeg_fd_ota_full2_nc_0/eeg_bias_gen_0/m1_4915_n36396# 100000
R127 eeg_fd_ota_full2_nc_0/eeg_bias_gen_0/m1_10051_n36396# eeg_fd_ota_full2_nc_0/eeg_bias_gen_0/m1_9623_n29089# 100000
R128 eeg_fd_ota_full2_nc_0/eeg_bias_gen_0/m1_6937_n20245# eeg_fd_ota_full2_nc_0/eeg_bias_gen_0/m1_7365_n27552# 100000
R129 eeg_fd_ota_full2_nc_0/eeg_bias_gen_0/m1_11645_n27552# eeg_fd_ota_full2_nc_0/eeg_bias_gen_0/m1_12073_n20245# 100000
R130 eeg_fd_ota_full2_nc_0/eeg_bias_gen_0/m1_8339_n18708# eeg_fd_ota_full2_nc_0/eeg_bias_gen_0/m1_7911_n11401# 100000
R131 eeg_fd_ota_full2_nc_0/eeg_bias_gen_0/m1_3701_n11401# eeg_fd_ota_full2_nc_0/eeg_bias_gen_0/m1_3941_n9864# 100000
R132 eeg_fd_ota_full2_nc_0/eeg_bias_gen_0/m1_8221_n9864# eeg_fd_ota_full2_nc_0/eeg_bias_gen_0/m1_8649_n2557# 100000
R133 eeg_fd_ota_full2_nc_0/eeg_bias_gen_0/m1_11645_n9864# eeg_fd_ota_full2_nc_0/eeg_bias_gen_0/VBNF 100000
R134 eeg_fd_ota_full2_nc_0/eeg_bias_gen_0/m1_5653_n45240# eeg_fd_ota_full2_nc_0/eeg_bias_gen_0/m1_6081_n37933# 100000
R135 eeg_fd_ota_full2_nc_0/eeg_bias_gen_0/m1_3941_n45240# eeg_fd_ota_full2_nc_0/eeg_bias_gen_0/m1_4369_n37933# 100000
R136 eeg_fd_ota_full2_nc_0/eeg_bias_gen_0/m1_5771_n36396# eeg_fd_ota_full2_nc_0/eeg_bias_gen_0/m1_5343_n29089# 100000
R137 eeg_fd_ota_full2_nc_0/eeg_bias_gen_0/m1_11217_n20245# eeg_fd_ota_full2_nc_0/eeg_bias_gen_0/m1_11645_n27552# 100000
R138 eeg_fd_ota_full2_nc_0/eeg_bias_gen_0/m1_4059_n18708# eeg_fd_ota_full2_nc_0/eeg_bias_gen_0/m1_3701_n11401# 100000
R139 eeg_fd_ota_full2_nc_0/eeg_bias_gen_0/m1_7793_n2557# eeg_fd_ota_full2_nc_0/eeg_bias_gen_0/m1_8221_n9864# 100000
R140 eeg_fd_ota_full2_nc_0/eeg_bias_gen_0/m1_11217_n2557# eeg_fd_ota_full2_nc_0/eeg_bias_gen_0/m1_11645_n9864# 100000
R141 eeg_fd_ota_full2_nc_0/eeg_bias_gen_0/m1_5225_n37933# eeg_fd_ota_full2_nc_0/eeg_bias_gen_0/m1_5653_n45240# 100000
R142 eeg_fd_ota_full2_nc_0/eeg_bias_gen_0/VBN eeg_fd_ota_full2_nc_0/eeg_bias_gen_0/m1_3941_n45240# 100000
R143 eeg_fd_ota_full2_nc_0/eeg_bias_gen_0/m1_6199_n29089# eeg_fd_ota_full2_nc_0/eeg_bias_gen_0/m1_5771_n36396# 100000
R144 eeg_fd_ota_full2_nc_0/eeg_bias_gen_0/m1_4487_n11401# eeg_fd_ota_full2_nc_0/eeg_bias_gen_0/m1_4059_n18708# 100000
R145 eeg_fd_ota_full2_nc_0/eeg_bias_gen_0/m1_7365_n9864# eeg_fd_ota_full2_nc_0/eeg_bias_gen_0/m1_7793_n2557# 100000
R146 eeg_fd_ota_full2_nc_0/eeg_bias_gen_0/m1_4797_n45240# eeg_fd_ota_full2_nc_0/eeg_bias_gen_0/m1_5225_n37933# 100000
R147 eeg_fd_ota_full2_nc_0/eeg_bias_gen_0/m1_9505_n37933# eeg_fd_ota_full2_nc_0/eeg_bias_gen_0/m1_9933_n45240# 100000
R148 eeg_fd_ota_full2_nc_0/eeg_bias_gen_0/m1_6627_n36396# eeg_fd_ota_full2_nc_0/eeg_bias_gen_0/m1_6199_n29089# 100000
R149 eeg_fd_ota_full2_nc_0/eeg_bias_gen_0/m1_4915_n18708# eeg_fd_ota_full2_nc_0/eeg_bias_gen_0/m1_4487_n11401# 100000
R150 eeg_fd_ota_full2_nc_0/eeg_bias_gen_0/m1_6937_n2557# eeg_fd_ota_full2_nc_0/eeg_bias_gen_0/m1_7365_n9864# 100000
R151 eeg_fd_ota_full2_nc_0/eeg_bias_gen_0/m1_9077_n45240# eeg_fd_ota_full2_nc_0/eeg_bias_gen_0/m1_9505_n37933# 100000
R152 eeg_fd_ota_full2_nc_0/eeg_bias_gen_0/m1_7055_n29089# eeg_fd_ota_full2_nc_0/eeg_bias_gen_0/m1_6627_n36396# 100000
R153 eeg_fd_ota_full2_nc_0/eeg_bias_gen_0/m1_8767_n11401# eeg_fd_ota_full2_nc_0/eeg_bias_gen_0/m1_8339_n18708# 100000
R154 eeg_fd_ota_full2_nc_0/eeg_bias_gen_0/m1_6509_n9864# eeg_fd_ota_full2_nc_0/eeg_bias_gen_0/m1_6937_n2557# 100000
R155 eeg_fd_ota_full2_nc_0/eeg_bias_gen_0/m1_8649_n37933# eeg_fd_ota_full2_nc_0/eeg_bias_gen_0/m1_9077_n45240# 100000
R156 eeg_fd_ota_full2_nc_0/eeg_bias_gen_0/m1_7483_n36396# eeg_fd_ota_full2_nc_0/eeg_bias_gen_0/m1_7055_n29089# 100000
R157 eeg_fd_ota_full2_nc_0/eeg_bias_gen_0/m1_9195_n18708# eeg_fd_ota_full2_nc_0/eeg_bias_gen_0/m1_8767_n11401# 100000
R158 eeg_fd_ota_full2_nc_0/eeg_bias_gen_0/m1_8221_n45240# eeg_fd_ota_full2_nc_0/eeg_bias_gen_0/m1_8649_n37933# 100000
R159 eeg_fd_ota_full2_nc_0/eeg_bias_gen_0/m1_7911_n29089# eeg_fd_ota_full2_nc_0/eeg_bias_gen_0/m1_7483_n36396# 100000
R160 eeg_fd_ota_full2_nc_0/eeg_bias_gen_0/m1_8339_n36396# eeg_fd_ota_full2_nc_0/eeg_bias_gen_0/m1_7911_n29089# 100000
X161 eeg_fd_ota_full2_nc_0/eeg_bias_gen_0/VBP eeg_fd_ota_full2_nc_0/eeg_bias_gen_0/VBN eeg_fd_ota_full2_nc_0/eeg_bias_gen_0/m1_2552_466# VSS sky130_fd_pr__nfet_01v8 ad=5 pd=22 as=8.85 ps=28.54 w=20 l=4 nf=4
X164 eeg_fd_ota_full2_nc_0/eeg_bias_gen_0/m1_2552_466# eeg_fd_ota_full2_nc_0/eeg_bias_gen_0/VBN eeg_fd_ota_full2_nc_0/eeg_bias_gen_0/VBP VSS sky130_fd_pr__nfet_01v8 ad=8.85 pd=28.54 as=5 ps=22 w=20 l=4 nf=4
CMIM169 eeg_fd_ota_full2_nc_0/eeg_bias_gen_0/VBNF VSS 1.000000e-10
X294 eeg_fd_ota_full2_nc_0/eeg_cmfb_amp_dl2_s2_0/m1_370_1493# eeg_fd_ota_full2_nc_0/eeg_cmfb_amp_dl2_s2_0/m1_370_1493# VDD18 VDD18 sky130_fd_pr__pfet_01v8 ad=2.04 pd=6.04 as=2.04 ps=6.04 w=2 l=2 nf=1
X295 eeg_fd_ota_full2_nc_0/eeg_cmfb_amp_dl2_s2_0/m1_370_1493# eeg_fd_ota_full2_nc_0/stage2_0/VCM2 eeg_fd_ota_full2_nc_0/eeg_cmfb_amp_dl2_s2_0/m1_68_166# VSS sky130_fd_pr__nfet_01v8 ad=2.04 pd=6.04 as=2.04 ps=6.04 w=2 l=2 nf=1
X296 eeg_fd_ota_full2_nc_0/eeg_cmfb_amp_dl2_s2_0/m1_68_166# eeg_fd_ota_full2_nc_0/eeg_bias_gen_0/VBNF VSS VSS sky130_fd_pr__nfet_01v8 ad=1.5 pd=6.5 as=6.12 ps=14.04 w=6 l=4 nf=1
X297 VSS eeg_fd_ota_full2_nc_0/eeg_bias_gen_0/VBNF eeg_fd_ota_full2_nc_0/eeg_cmfb_amp_dl2_s2_0/m1_68_166# VSS sky130_fd_pr__nfet_01v8 ad=6.12 pd=14.04 as=1.5 ps=6.5 w=6 l=4 nf=1
X298 eeg_fd_ota_full2_nc_0/stage2_0/VBP2 eeg_fd_ota_full2_nc_0/stage2_0/VBP2 VDD18 VDD18 sky130_fd_pr__pfet_01v8 ad=0.15 pd=1.6 as=0.15 ps=1.6 w=0.5 l=4 nf=1
X299 eeg_fd_ota_full2_nc_0/stage2_0/VBP2 VCM_REF eeg_fd_ota_full2_nc_0/eeg_cmfb_amp_dl2_s2_0/m1_68_166# VSS sky130_fd_pr__nfet_01v8 ad=2.04 pd=6.04 as=2.04 ps=6.04 w=2 l=2 nf=1
X300 eeg_fd_ota_full2_nc_0/eeg_cmfb_amp_dl2_0/VBP eeg_fd_ota_full2_nc_0/eeg_cmfb_amp_dl2_0/VBP VDD18 VDD18 sky130_fd_pr__pfet_01v8 ad=4.08 pd=10.04 as=4.08 ps=10.04 w=4 l=4 nf=1
X301 eeg_fd_ota_full2_nc_0/eeg_cmfb_amp_dl2_0/VBP VCM_REF eeg_fd_ota_full2_nc_0/eeg_cmfb_amp_dl2_0/m1_68_166# VSS sky130_fd_pr__nfet_01v8 ad=2.04 pd=6.04 as=2.04 ps=6.04 w=2 l=2 nf=1
X302 eeg_fd_ota_full2_nc_0/eeg_cmfb_amp_dl2_0/m1_68_166# eeg_fd_ota_full2_nc_0/eeg_bias_gen_0/VBNF VSS VSS sky130_fd_pr__nfet_01v8 ad=1.5 pd=6.5 as=6.12 ps=14.04 w=6 l=4 nf=1
X303 VSS eeg_fd_ota_full2_nc_0/eeg_bias_gen_0/VBNF eeg_fd_ota_full2_nc_0/eeg_cmfb_amp_dl2_0/m1_68_166# VSS sky130_fd_pr__nfet_01v8 ad=6.12 pd=14.04 as=1.5 ps=6.5 w=6 l=4 nf=1
X304 eeg_fd_ota_full2_nc_0/eeg_cmfb_amp_dl2_0/m1_370_1493# eeg_fd_ota_full2_nc_0/eeg_cmfb_amp_dl2_0/m1_370_1493# VDD18 VDD18 sky130_fd_pr__pfet_01v8 ad=2.04 pd=6.04 as=2.04 ps=6.04 w=2 l=2 nf=1
X305 eeg_fd_ota_full2_nc_0/eeg_cmfb_amp_dl2_0/m1_370_1493# eeg_fd_ota_full2_nc_0/eeg_cmfb_amp_dl2_0/VCM_SENSE eeg_fd_ota_full2_nc_0/eeg_cmfb_amp_dl2_0/m1_68_166# VSS sky130_fd_pr__nfet_01v8 ad=2.04 pd=6.04 as=2.04 ps=6.04 w=2 l=2 nf=1
R306 eeg_fd_ota_full2_nc_0/stage2_0/m1_59061_n15864# eeg_fd_ota_full2_nc_0/stage2_0/m1_59489_n8557# 100000
R307 eeg_fd_ota_full2_nc_0/stage2_0/m1_25933_n15864# eeg_fd_ota_full2_nc_0/stage2_0/m1_26361_n8557# 100000
R308 eeg_fd_ota_full2_nc_0/stage2_0/m1_21225_n8557# eeg_fd_ota_full2_nc_0/stage2_0/m1_21653_n15864# 100000
R309 eeg_fd_ota_full2_nc_0/stage2_0/m1_37489_n8557# eeg_fd_ota_full2_nc_0/stage2_0/m1_37917_n15864# 100000
R310 eeg_fd_ota_full2_nc_0/stage2_0/m1_79933_n15864# eeg_fd_ota_full2_nc_0/stage2_0/m1_80361_n8557# 100000
R311 eeg_fd_ota_full2_nc_0/stage2_0/m1_75225_n8557# eeg_fd_ota_full2_nc_0/stage2_0/m1_75653_n15864# 100000
R312 eeg_fd_ota_full2_nc_0/stage2_0/m1_69077_n15864# eeg_fd_ota_full2_nc_0/stage2_0/m1_69505_n8557# 100000
R313 eeg_fd_ota_full2_nc_0/stage2_0/m1_64369_n8557# eeg_fd_ota_full2_nc_0/stage2_0/m1_64797_n15864# 100000
R314 eeg_fd_ota_full2_nc_0/stage2_0/m1_58633_n8557# eeg_fd_ota_full2_nc_0/stage2_0/m1_59061_n15864# 100000
R315 eeg_fd_ota_full2_nc_0/stage2_0/m1_30213_n15864# eeg_fd_ota_full2_nc_0/stage2_0/m1_30641_n8557# 100000
R316 eeg_fd_ota_full2_nc_0/stage2_0/m1_25505_n8557# eeg_fd_ota_full2_nc_0/stage2_0/m1_25933_n15864# 100000
R317 eeg_fd_ota_full2_nc_0/stage2_0/m1_20797_n15864# eeg_fd_ota_full2_nc_0/stage2_0/m1_21225_n8557# 100000
R318 eeg_fd_ota_full2_nc_0/stage2_0/m1_37061_n15864# eeg_fd_ota_full2_nc_0/stage2_0/m1_37489_n8557# 100000
R319 eeg_fd_ota_full2_nc_0/stage2_0/m1_79505_n8557# eeg_fd_ota_full2_nc_0/stage2_0/m1_79933_n15864# 100000
R320 eeg_fd_ota_full2_nc_0/stage2_0/m1_74797_n15864# eeg_fd_ota_full2_nc_0/stage2_0/m1_75225_n8557# 100000
R321 eeg_fd_ota_full2_nc_0/stage2_0/m1_68649_n8557# eeg_fd_ota_full2_nc_0/stage2_0/m1_69077_n15864# 100000
R322 eeg_fd_ota_full2_nc_0/stage2_0/m1_63941_n15864# eeg_fd_ota_full2_nc_0/stage2_0/m1_64369_n8557# 100000
R323 eeg_fd_ota_full2_nc_0/stage2_0/m1_58205_n15864# eeg_fd_ota_full2_nc_0/stage2_0/m1_58633_n8557# 100000
R324 eeg_fd_ota_full2_nc_0/stage2_0/m1_29785_n8557# eeg_fd_ota_full2_nc_0/stage2_0/m1_30213_n15864# 100000
R325 eeg_fd_ota_full2_nc_0/stage2_0/m1_25077_n15864# eeg_fd_ota_full2_nc_0/stage2_0/m1_25505_n8557# 100000
R326 eeg_fd_ota_full2_nc_0/stage2_0/m1_20369_n8557# eeg_fd_ota_full2_nc_0/stage2_0/m1_20797_n15864# 100000
R327 eeg_fd_ota_full2_nc_0/stage2_0/m1_36633_n8557# eeg_fd_ota_full2_nc_0/stage2_0/m1_37061_n15864# 100000
R328 eeg_fd_ota_full2_nc_0/stage2_0/m1_79077_n15864# eeg_fd_ota_full2_nc_0/stage2_0/m1_79505_n8557# 100000
R329 eeg_fd_ota_full2_nc_0/stage2_0/m1_74369_n8557# eeg_fd_ota_full2_nc_0/stage2_0/m1_74797_n15864# 100000
R330 eeg_fd_ota_full2_nc_0/stage2_0/m1_68221_n15864# eeg_fd_ota_full2_nc_0/stage2_0/m1_68649_n8557# 100000
R331 OINTP eeg_fd_ota_full2_nc_0/stage2_0/m1_63941_n15864# 100000
R332 eeg_fd_ota_full2_nc_0/stage2_0/m1_29357_n15864# eeg_fd_ota_full2_nc_0/stage2_0/m1_29785_n8557# 100000
R333 eeg_fd_ota_full2_nc_0/stage2_0/m1_24649_n8557# eeg_fd_ota_full2_nc_0/stage2_0/m1_25077_n15864# 100000
R334 eeg_fd_ota_full2_nc_0/stage2_0/m1_19941_n15864# eeg_fd_ota_full2_nc_0/stage2_0/m1_20369_n8557# 100000
R335 eeg_fd_ota_full2_nc_0/stage2_0/m1_36205_n15864# eeg_fd_ota_full2_nc_0/stage2_0/m1_36633_n8557# 100000
R336 eeg_fd_ota_full2_nc_0/stage2_0/m1_78649_n8557# eeg_fd_ota_full2_nc_0/stage2_0/m1_79077_n15864# 100000
R337 eeg_fd_ota_full2_nc_0/stage2_0/m1_73941_n15864# eeg_fd_ota_full2_nc_0/stage2_0/m1_74369_n8557# 100000
R338 eeg_fd_ota_full2_nc_0/stage2_0/m1_67793_n8557# eeg_fd_ota_full2_nc_0/stage2_0/m1_68221_n15864# 100000
R339 eeg_fd_ota_full2_nc_0/stage2_0/m1_62485_n15864# eeg_fd_ota_full2_nc_0/stage2_0/VCM2 100000
R340 eeg_fd_ota_full2_nc_0/stage2_0/m1_28929_n8557# eeg_fd_ota_full2_nc_0/stage2_0/m1_29357_n15864# 100000
R341 eeg_fd_ota_full2_nc_0/stage2_0/m1_24221_n15864# eeg_fd_ota_full2_nc_0/stage2_0/m1_24649_n8557# 100000
R342 OINTP eeg_fd_ota_full2_nc_0/stage2_0/m1_19941_n15864# 100000
R343 eeg_fd_ota_full2_nc_0/stage2_0/m1_35777_n8557# eeg_fd_ota_full2_nc_0/stage2_0/m1_36205_n15864# 100000
R344 eeg_fd_ota_full2_nc_0/stage2_0/m1_78221_n15864# eeg_fd_ota_full2_nc_0/stage2_0/m1_78649_n8557# 100000
R345 OINTN eeg_fd_ota_full2_nc_0/stage2_0/m1_73941_n15864# 100000
R346 eeg_fd_ota_full2_nc_0/stage2_0/m1_67365_n15864# eeg_fd_ota_full2_nc_0/stage2_0/m1_67793_n8557# 100000
R347 eeg_fd_ota_full2_nc_0/stage2_0/m1_28501_n15864# eeg_fd_ota_full2_nc_0/stage2_0/m1_28929_n8557# 100000
R348 eeg_fd_ota_full2_nc_0/stage2_0/m1_23793_n8557# eeg_fd_ota_full2_nc_0/stage2_0/m1_24221_n15864# 100000
R349 eeg_fd_ota_full2_nc_0/stage2_0/m1_40057_n8557# eeg_fd_ota_full2_nc_0/stage2_0/m1_40485_n15864# 100000
R350 eeg_fd_ota_full2_nc_0/stage2_0/m1_35349_n15864# eeg_fd_ota_full2_nc_0/stage2_0/m1_35777_n8557# 100000
R351 eeg_fd_ota_full2_nc_0/stage2_0/m1_77793_n8557# eeg_fd_ota_full2_nc_0/stage2_0/m1_78221_n15864# 100000
R352 eeg_fd_ota_full2_nc_0/stage2_0/m1_71645_n15864# VCM_REF 100000
R353 eeg_fd_ota_full2_nc_0/stage2_0/m1_28073_n8557# eeg_fd_ota_full2_nc_0/stage2_0/m1_28501_n15864# 100000
R354 eeg_fd_ota_full2_nc_0/stage2_0/m1_23365_n15864# eeg_fd_ota_full2_nc_0/stage2_0/m1_23793_n8557# 100000
R355 eeg_fd_ota_full2_nc_0/stage2_0/m1_39629_n15864# eeg_fd_ota_full2_nc_0/stage2_0/m1_40057_n8557# 100000
R356 eeg_fd_ota_full2_nc_0/stage2_0/m1_34921_n8557# eeg_fd_ota_full2_nc_0/stage2_0/m1_35349_n15864# 100000
R357 eeg_fd_ota_full2_nc_0/stage2_0/m1_77365_n15864# eeg_fd_ota_full2_nc_0/stage2_0/m1_77793_n8557# 100000
R358 eeg_fd_ota_full2_nc_0/stage2_0/m1_27645_n15864# eeg_fd_ota_full2_nc_0/stage2_0/m1_28073_n8557# 100000
R359 eeg_fd_ota_full2_nc_0/stage2_0/m1_22937_n8557# eeg_fd_ota_full2_nc_0/stage2_0/m1_23365_n15864# 100000
R360 eeg_fd_ota_full2_nc_0/stage2_0/m1_39201_n8557# eeg_fd_ota_full2_nc_0/stage2_0/m1_39629_n15864# 100000
R361 eeg_fd_ota_full2_nc_0/stage2_0/m1_81645_n15864# VCM_REF 100000
R362 eeg_fd_ota_full2_nc_0/stage2_0/m1_27217_n8557# eeg_fd_ota_full2_nc_0/stage2_0/m1_27645_n15864# 100000
R363 eeg_fd_ota_full2_nc_0/stage2_0/m1_22509_n15864# eeg_fd_ota_full2_nc_0/stage2_0/m1_22937_n8557# 100000
R364 eeg_fd_ota_full2_nc_0/stage2_0/m1_38773_n15864# eeg_fd_ota_full2_nc_0/stage2_0/m1_39201_n8557# 100000
R365 eeg_fd_ota_full2_nc_0/stage2_0/m1_26789_n15864# eeg_fd_ota_full2_nc_0/stage2_0/m1_27217_n8557# 100000
R366 eeg_fd_ota_full2_nc_0/stage2_0/m1_22081_n8557# eeg_fd_ota_full2_nc_0/stage2_0/m1_22509_n15864# 100000
R367 eeg_fd_ota_full2_nc_0/stage2_0/m1_26361_n8557# eeg_fd_ota_full2_nc_0/stage2_0/m1_26789_n15864# 100000
X368 OINTN eeg_fd_ota_full2_nc_0/stage2_0/VBP2 VDD18 VDD18 sky130_fd_pr__pfet_01v8 ad=6 pd=26 as=10.62 ps=33.54 w=24 l=12 nf=4
X369 VDD18 eeg_fd_ota_full2_nc_0/stage2_0/VBP2 OINTN VDD18 sky130_fd_pr__pfet_01v8 ad=10.62 pd=33.54 as=6 ps=26 w=24 l=12 nf=4
R376 eeg_fd_ota_full2_nc_0/stage2_0/m1_34493_n15864# eeg_fd_ota_full2_nc_0/stage2_0/m1_34921_n8557# 100000
X377 OINTN eeg_fd_ota_full2_nc_0/stage2_0/N2N VSS VSS sky130_fd_pr__nfet_01v8 ad=1.5 pd=6.5 as=6.12 ps=14.04 w=6 l=12 nf=1
X378 VSS eeg_fd_ota_full2_nc_0/stage2_0/N2N OINTN VSS sky130_fd_pr__nfet_01v8 ad=6.12 pd=14.04 as=1.5 ps=6.5 w=6 l=12 nf=1
R379 eeg_fd_ota_full2_nc_0/stage2_0/m1_34065_n8557# eeg_fd_ota_full2_nc_0/stage2_0/m1_34493_n15864# 100000
R380 eeg_fd_ota_full2_nc_0/stage2_0/m1_33637_n15864# eeg_fd_ota_full2_nc_0/stage2_0/m1_34065_n8557# 100000
R381 eeg_fd_ota_full2_nc_0/stage2_0/m1_33209_n8557# eeg_fd_ota_full2_nc_0/stage2_0/m1_33637_n15864# 100000
R382 eeg_fd_ota_full2_nc_0/stage2_0/m1_32781_n15864# eeg_fd_ota_full2_nc_0/stage2_0/m1_33209_n8557# 100000
R383 eeg_fd_ota_full2_nc_0/stage2_0/m1_32353_n8557# eeg_fd_ota_full2_nc_0/stage2_0/m1_32781_n15864# 100000
R384 eeg_fd_ota_full2_nc_0/stage2_0/m1_31925_n15864# eeg_fd_ota_full2_nc_0/stage2_0/m1_32353_n8557# 100000
R385 eeg_fd_ota_full2_nc_0/stage2_0/N2N eeg_fd_ota_full2_nc_0/stage2_0/m1_12966_n5928# 20000
R386 eeg_fd_ota_full2_nc_0/stage2_0/m1_31497_n8557# eeg_fd_ota_full2_nc_0/stage2_0/m1_31925_n15864# 100000
R387 eeg_fd_ota_full2_nc_0/stage2_0/m1_44937_n8557# eeg_fd_ota_full2_nc_0/stage2_0/m1_45365_n15864# 100000
R388 eeg_fd_ota_full2_nc_0/stage2_0/N2P eeg_fd_ota_full2_nc_0/stage2_0/m1_3966_n5928# 20000
R389 eeg_fd_ota_full2_nc_0/stage2_0/m1_31069_n15864# eeg_fd_ota_full2_nc_0/stage2_0/m1_31497_n8557# 100000
R390 eeg_fd_ota_full2_nc_0/stage2_0/m1_44509_n15864# eeg_fd_ota_full2_nc_0/stage2_0/m1_44937_n8557# 100000
R391 eeg_fd_ota_full2_nc_0/stage2_0/m1_49217_n8557# eeg_fd_ota_full2_nc_0/stage2_0/m1_49645_n15864# 100000
R392 eeg_fd_ota_full2_nc_0/stage2_0/m1_30641_n8557# eeg_fd_ota_full2_nc_0/stage2_0/m1_31069_n15864# 100000
R393 eeg_fd_ota_full2_nc_0/stage2_0/m1_44081_n8557# eeg_fd_ota_full2_nc_0/stage2_0/m1_44509_n15864# 100000
R394 eeg_fd_ota_full2_nc_0/stage2_0/m1_48789_n15864# eeg_fd_ota_full2_nc_0/stage2_0/m1_49217_n8557# 100000
R395 eeg_fd_ota_full2_nc_0/stage2_0/m1_53497_n8557# eeg_fd_ota_full2_nc_0/stage2_0/m1_53925_n15864# 100000
R396 eeg_fd_ota_full2_nc_0/stage2_0/m1_43653_n15864# eeg_fd_ota_full2_nc_0/stage2_0/m1_44081_n8557# 100000
R397 eeg_fd_ota_full2_nc_0/stage2_0/m1_48361_n8557# eeg_fd_ota_full2_nc_0/stage2_0/m1_48789_n15864# 100000
R398 eeg_fd_ota_full2_nc_0/stage2_0/m1_53069_n15864# eeg_fd_ota_full2_nc_0/stage2_0/m1_53497_n8557# 100000
R399 eeg_fd_ota_full2_nc_0/stage2_0/m1_57777_n8557# eeg_fd_ota_full2_nc_0/stage2_0/m1_58205_n15864# 100000
R400 eeg_fd_ota_full2_nc_0/stage2_0/m1_43225_n8557# eeg_fd_ota_full2_nc_0/stage2_0/m1_43653_n15864# 100000
R401 eeg_fd_ota_full2_nc_0/stage2_0/m1_47933_n15864# eeg_fd_ota_full2_nc_0/stage2_0/m1_48361_n8557# 100000
R402 eeg_fd_ota_full2_nc_0/stage2_0/m1_52641_n8557# eeg_fd_ota_full2_nc_0/stage2_0/m1_53069_n15864# 100000
R403 eeg_fd_ota_full2_nc_0/stage2_0/m1_57349_n15864# eeg_fd_ota_full2_nc_0/stage2_0/m1_57777_n8557# 100000
R404 eeg_fd_ota_full2_nc_0/stage2_0/m1_42797_n15864# eeg_fd_ota_full2_nc_0/stage2_0/m1_43225_n8557# 100000
R405 eeg_fd_ota_full2_nc_0/stage2_0/m1_47505_n8557# eeg_fd_ota_full2_nc_0/stage2_0/m1_47933_n15864# 100000
R406 eeg_fd_ota_full2_nc_0/stage2_0/m1_52213_n15864# eeg_fd_ota_full2_nc_0/stage2_0/m1_52641_n8557# 100000
R407 eeg_fd_ota_full2_nc_0/stage2_0/m1_56921_n8557# eeg_fd_ota_full2_nc_0/stage2_0/m1_57349_n15864# 100000
R408 eeg_fd_ota_full2_nc_0/stage2_0/m1_42369_n8557# eeg_fd_ota_full2_nc_0/stage2_0/m1_42797_n15864# 100000
R409 eeg_fd_ota_full2_nc_0/stage2_0/m1_47077_n15864# eeg_fd_ota_full2_nc_0/stage2_0/m1_47505_n8557# 100000
R410 eeg_fd_ota_full2_nc_0/stage2_0/m1_51785_n8557# eeg_fd_ota_full2_nc_0/stage2_0/m1_52213_n15864# 100000
R411 eeg_fd_ota_full2_nc_0/stage2_0/m1_56493_n15864# eeg_fd_ota_full2_nc_0/stage2_0/m1_56921_n8557# 100000
R412 eeg_fd_ota_full2_nc_0/stage2_0/m1_62057_n8557# eeg_fd_ota_full2_nc_0/stage2_0/m1_62485_n15864# 100000
R413 eeg_fd_ota_full2_nc_0/stage2_0/m1_41941_n15864# eeg_fd_ota_full2_nc_0/stage2_0/m1_42369_n8557# 100000
R414 eeg_fd_ota_full2_nc_0/stage2_0/m1_46649_n8557# eeg_fd_ota_full2_nc_0/stage2_0/m1_47077_n15864# 100000
R415 eeg_fd_ota_full2_nc_0/stage2_0/m1_51357_n15864# eeg_fd_ota_full2_nc_0/stage2_0/m1_51785_n8557# 100000
R416 eeg_fd_ota_full2_nc_0/stage2_0/m1_56065_n8557# eeg_fd_ota_full2_nc_0/stage2_0/m1_56493_n15864# 100000
R417 eeg_fd_ota_full2_nc_0/stage2_0/m1_61629_n15864# eeg_fd_ota_full2_nc_0/stage2_0/m1_62057_n8557# 100000
R418 eeg_fd_ota_full2_nc_0/stage2_0/m1_66937_n8557# eeg_fd_ota_full2_nc_0/stage2_0/m1_67365_n15864# 100000
R419 OINTN eeg_fd_ota_full2_nc_0/stage2_0/m1_41941_n15864# 100000
R420 eeg_fd_ota_full2_nc_0/stage2_0/m1_46221_n15864# eeg_fd_ota_full2_nc_0/stage2_0/m1_46649_n8557# 100000
R421 eeg_fd_ota_full2_nc_0/stage2_0/m1_50929_n8557# eeg_fd_ota_full2_nc_0/stage2_0/m1_51357_n15864# 100000
R422 eeg_fd_ota_full2_nc_0/stage2_0/m1_55637_n15864# eeg_fd_ota_full2_nc_0/stage2_0/m1_56065_n8557# 100000
R423 eeg_fd_ota_full2_nc_0/stage2_0/m1_61201_n8557# eeg_fd_ota_full2_nc_0/stage2_0/m1_61629_n15864# 100000
R424 eeg_fd_ota_full2_nc_0/stage2_0/m1_71217_n8557# eeg_fd_ota_full2_nc_0/stage2_0/m1_71645_n15864# 100000
R425 eeg_fd_ota_full2_nc_0/stage2_0/m1_66509_n15864# eeg_fd_ota_full2_nc_0/stage2_0/m1_66937_n8557# 100000
R426 eeg_fd_ota_full2_nc_0/stage2_0/m1_40485_n15864# eeg_fd_ota_full2_nc_0/stage2_0/VCM2 100000
R427 eeg_fd_ota_full2_nc_0/stage2_0/m1_45793_n8557# eeg_fd_ota_full2_nc_0/stage2_0/m1_46221_n15864# 100000
R428 eeg_fd_ota_full2_nc_0/stage2_0/m1_50501_n15864# eeg_fd_ota_full2_nc_0/stage2_0/m1_50929_n8557# 100000
R429 eeg_fd_ota_full2_nc_0/stage2_0/m1_55209_n8557# eeg_fd_ota_full2_nc_0/stage2_0/m1_55637_n15864# 100000
R430 eeg_fd_ota_full2_nc_0/stage2_0/m1_60773_n15864# eeg_fd_ota_full2_nc_0/stage2_0/m1_61201_n8557# 100000
R431 eeg_fd_ota_full2_nc_0/stage2_0/m1_76937_n8557# eeg_fd_ota_full2_nc_0/stage2_0/m1_77365_n15864# 100000
R432 eeg_fd_ota_full2_nc_0/stage2_0/m1_70789_n15864# eeg_fd_ota_full2_nc_0/stage2_0/m1_71217_n8557# 100000
R433 eeg_fd_ota_full2_nc_0/stage2_0/m1_66081_n8557# eeg_fd_ota_full2_nc_0/stage2_0/m1_66509_n15864# 100000
X434 OINTP eeg_fd_ota_full2_nc_0/stage2_0/VBP2 VDD18 VDD18 sky130_fd_pr__pfet_01v8 ad=6 pd=26 as=10.62 ps=33.54 w=24 l=12 nf=4
X435 VDD18 eeg_fd_ota_full2_nc_0/stage2_0/VBP2 OINTP VDD18 sky130_fd_pr__pfet_01v8 ad=10.62 pd=33.54 as=6 ps=26 w=24 l=12 nf=4
R442 eeg_fd_ota_full2_nc_0/stage2_0/m1_45365_n15864# eeg_fd_ota_full2_nc_0/stage2_0/m1_45793_n8557# 100000
R443 eeg_fd_ota_full2_nc_0/stage2_0/m1_50073_n8557# eeg_fd_ota_full2_nc_0/stage2_0/m1_50501_n15864# 100000
R444 eeg_fd_ota_full2_nc_0/stage2_0/m1_54781_n15864# eeg_fd_ota_full2_nc_0/stage2_0/m1_55209_n8557# 100000
R445 eeg_fd_ota_full2_nc_0/stage2_0/m1_60345_n8557# eeg_fd_ota_full2_nc_0/stage2_0/m1_60773_n15864# 100000
R446 eeg_fd_ota_full2_nc_0/stage2_0/m1_81217_n8557# eeg_fd_ota_full2_nc_0/stage2_0/m1_81645_n15864# 100000
R447 eeg_fd_ota_full2_nc_0/stage2_0/m1_76509_n15864# eeg_fd_ota_full2_nc_0/stage2_0/m1_76937_n8557# 100000
R448 eeg_fd_ota_full2_nc_0/stage2_0/m1_70361_n8557# eeg_fd_ota_full2_nc_0/stage2_0/m1_70789_n15864# 100000
R449 eeg_fd_ota_full2_nc_0/stage2_0/m1_65653_n15864# eeg_fd_ota_full2_nc_0/stage2_0/m1_66081_n8557# 100000
R450 eeg_fd_ota_full2_nc_0/stage2_0/m1_49645_n15864# eeg_fd_ota_full2_nc_0/stage2_0/m1_50073_n8557# 100000
R451 eeg_fd_ota_full2_nc_0/stage2_0/m1_54353_n8557# eeg_fd_ota_full2_nc_0/stage2_0/m1_54781_n15864# 100000
R452 eeg_fd_ota_full2_nc_0/stage2_0/m1_59917_n15864# eeg_fd_ota_full2_nc_0/stage2_0/m1_60345_n8557# 100000
R453 eeg_fd_ota_full2_nc_0/stage2_0/m1_38345_n8557# eeg_fd_ota_full2_nc_0/stage2_0/m1_38773_n15864# 100000
R454 eeg_fd_ota_full2_nc_0/stage2_0/m1_80789_n15864# eeg_fd_ota_full2_nc_0/stage2_0/m1_81217_n8557# 100000
R455 eeg_fd_ota_full2_nc_0/stage2_0/m1_76081_n8557# eeg_fd_ota_full2_nc_0/stage2_0/m1_76509_n15864# 100000
R456 eeg_fd_ota_full2_nc_0/stage2_0/m1_69933_n15864# eeg_fd_ota_full2_nc_0/stage2_0/m1_70361_n8557# 100000
R457 eeg_fd_ota_full2_nc_0/stage2_0/m1_65225_n8557# eeg_fd_ota_full2_nc_0/stage2_0/m1_65653_n15864# 100000
R458 eeg_fd_ota_full2_nc_0/stage2_0/m1_53925_n15864# eeg_fd_ota_full2_nc_0/stage2_0/m1_54353_n8557# 100000
R459 eeg_fd_ota_full2_nc_0/stage2_0/m1_59489_n8557# eeg_fd_ota_full2_nc_0/stage2_0/m1_59917_n15864# 100000
R460 eeg_fd_ota_full2_nc_0/stage2_0/m1_21653_n15864# eeg_fd_ota_full2_nc_0/stage2_0/m1_22081_n8557# 100000
R461 eeg_fd_ota_full2_nc_0/stage2_0/m1_37917_n15864# eeg_fd_ota_full2_nc_0/stage2_0/m1_38345_n8557# 100000
R462 eeg_fd_ota_full2_nc_0/stage2_0/m1_80361_n8557# eeg_fd_ota_full2_nc_0/stage2_0/m1_80789_n15864# 100000
R463 eeg_fd_ota_full2_nc_0/stage2_0/m1_75653_n15864# eeg_fd_ota_full2_nc_0/stage2_0/m1_76081_n8557# 100000
R464 eeg_fd_ota_full2_nc_0/stage2_0/m1_69505_n8557# eeg_fd_ota_full2_nc_0/stage2_0/m1_69933_n15864# 100000
R465 eeg_fd_ota_full2_nc_0/stage2_0/m1_64797_n15864# eeg_fd_ota_full2_nc_0/stage2_0/m1_65225_n8557# 100000
X466 OINTP eeg_fd_ota_full2_nc_0/stage2_0/N2P VSS VSS sky130_fd_pr__nfet_01v8 ad=1.5 pd=6.5 as=6.12 ps=14.04 w=6 l=12 nf=1
X467 VSS eeg_fd_ota_full2_nc_0/stage2_0/N2P OINTP VSS sky130_fd_pr__nfet_01v8 ad=6.12 pd=14.04 as=1.5 ps=6.5 w=6 l=12 nf=1
CMIM468 eeg_fd_ota_full2_nc_0/stage2_0/m1_3966_n5928# OINTP 1.000000e-11
CMIM469 eeg_fd_ota_full2_nc_0/stage2_0/m1_12966_n5928# OINTN 1.000000e-11
R508 eeg_fd_ota_full2_nc_0/eeg_fd_ota_core_soft_0/m1_n51183_3443# eeg_fd_ota_full2_nc_0/eeg_fd_ota_core_soft_0/m1_n50755_n3864# 100000
R509 eeg_fd_ota_full2_nc_0/eeg_fd_ota_core_soft_0/m1_n51611_n3864# eeg_fd_ota_full2_nc_0/eeg_fd_ota_core_soft_0/m1_n51183_3443# 100000
R510 eeg_fd_ota_full2_nc_0/eeg_fd_ota_core_soft_0/m1_n52039_3443# eeg_fd_ota_full2_nc_0/eeg_fd_ota_core_soft_0/m1_n51611_n3864# 100000
R511 eeg_fd_ota_full2_nc_0/eeg_fd_ota_core_soft_0/m1_n52467_n3864# eeg_fd_ota_full2_nc_0/eeg_fd_ota_core_soft_0/m1_n52039_3443# 100000
R512 eeg_fd_ota_full2_nc_0/eeg_fd_ota_core_soft_0/m1_n52895_3443# eeg_fd_ota_full2_nc_0/eeg_fd_ota_core_soft_0/m1_n52467_n3864# 100000
X513 VSS eeg_fd_ota_full2_nc_0/eeg_bias_gen_0/VBNF eeg_fd_ota_full2_nc_0/eeg_fd_ota_core_soft_0/m1_n22658_111# VSS sky130_fd_pr__nfet_01v8 ad=16.62 pd=59.54 as=12 ps=52 w=48 l=4 nf=8
X514 eeg_fd_ota_full2_nc_0/eeg_fd_ota_core_soft_0/m1_n22658_111# eeg_fd_ota_full2_nc_0/eeg_bias_gen_0/VBNF VSS VSS sky130_fd_pr__nfet_01v8 ad=12 pd=52 as=16.62 ps=59.54 w=48 l=4 nf=8
R529 eeg_fd_ota_full2_nc_0/eeg_fd_ota_core_soft_0/m1_n53323_n3864# eeg_fd_ota_full2_nc_0/eeg_fd_ota_core_soft_0/m1_n52895_3443# 100000
R530 eeg_fd_ota_full2_nc_0/eeg_fd_ota_core_soft_0/m1_30393_n3864# eeg_fd_ota_full2_nc_0/eeg_fd_ota_core_soft_0/m1_30821_3443# 100000
R531 eeg_fd_ota_full2_nc_0/eeg_fd_ota_core_soft_0/m1_n53751_3443# eeg_fd_ota_full2_nc_0/eeg_fd_ota_core_soft_0/m1_n53323_n3864# 100000
R532 eeg_fd_ota_full2_nc_0/eeg_fd_ota_core_soft_0/m1_29965_3443# eeg_fd_ota_full2_nc_0/eeg_fd_ota_core_soft_0/m1_30393_n3864# 100000
R533 eeg_fd_ota_full2_nc_0/eeg_fd_ota_core_soft_0/m1_34673_n3864# eeg_fd_ota_full2_nc_0/eeg_fd_ota_core_soft_0/m1_35101_3443# 100000
R534 eeg_fd_ota_full2_nc_0/eeg_fd_ota_core_soft_0/m1_n54179_n3864# eeg_fd_ota_full2_nc_0/eeg_fd_ota_core_soft_0/m1_n53751_3443# 100000
R535 eeg_fd_ota_full2_nc_0/eeg_fd_ota_core_soft_0/m1_38953_n3864# eeg_fd_ota_full2_nc_0/eeg_fd_ota_core_soft_0/m1_39381_3443# 100000
R536 eeg_fd_ota_full2_nc_0/eeg_fd_ota_core_soft_0/m1_29537_n3864# eeg_fd_ota_full2_nc_0/eeg_fd_ota_core_soft_0/m1_29965_3443# 100000
R537 eeg_fd_ota_full2_nc_0/eeg_fd_ota_core_soft_0/m1_34245_3443# eeg_fd_ota_full2_nc_0/eeg_fd_ota_core_soft_0/m1_34673_n3864# 100000
R538 eeg_fd_ota_full2_nc_0/eeg_fd_ota_core_soft_0/m1_n54607_3443# eeg_fd_ota_full2_nc_0/eeg_fd_ota_core_soft_0/m1_n54179_n3864# 100000
R539 eeg_fd_ota_full2_nc_0/eeg_fd_ota_core_soft_0/m1_43233_n3864# eeg_fd_ota_full2_nc_0/eeg_fd_ota_core_soft_0/m1_43661_3443# 100000
R540 eeg_fd_ota_full2_nc_0/eeg_fd_ota_core_soft_0/m1_38525_3443# eeg_fd_ota_full2_nc_0/eeg_fd_ota_core_soft_0/m1_38953_n3864# 100000
R541 eeg_fd_ota_full2_nc_0/eeg_fd_ota_core_soft_0/m1_29109_3443# eeg_fd_ota_full2_nc_0/eeg_fd_ota_core_soft_0/m1_29537_n3864# 100000
R542 eeg_fd_ota_full2_nc_0/eeg_fd_ota_core_soft_0/m1_33817_n3864# eeg_fd_ota_full2_nc_0/eeg_fd_ota_core_soft_0/m1_34245_3443# 100000
R543 eeg_fd_ota_full2_nc_0/eeg_fd_ota_core_soft_0/m1_n55035_n3864# eeg_fd_ota_full2_nc_0/eeg_fd_ota_core_soft_0/m1_n54607_3443# 100000
R544 eeg_fd_ota_full2_nc_0/eeg_fd_ota_core_soft_0/m1_42805_3443# eeg_fd_ota_full2_nc_0/eeg_fd_ota_core_soft_0/m1_43233_n3864# 100000
R545 eeg_fd_ota_full2_nc_0/eeg_fd_ota_core_soft_0/m1_38097_n3864# eeg_fd_ota_full2_nc_0/eeg_fd_ota_core_soft_0/m1_38525_3443# 100000
R546 eeg_fd_ota_full2_nc_0/eeg_fd_ota_core_soft_0/m1_28681_n3864# eeg_fd_ota_full2_nc_0/eeg_fd_ota_core_soft_0/m1_29109_3443# 100000
R547 eeg_fd_ota_full2_nc_0/eeg_fd_ota_core_soft_0/m1_33389_3443# eeg_fd_ota_full2_nc_0/eeg_fd_ota_core_soft_0/m1_33817_n3864# 100000
R548 eeg_fd_ota_full2_nc_0/eeg_fd_ota_core_soft_0/m1_42377_n3864# eeg_fd_ota_full2_nc_0/eeg_fd_ota_core_soft_0/m1_42805_3443# 100000
R549 eeg_fd_ota_full2_nc_0/eeg_fd_ota_core_soft_0/m1_37669_3443# eeg_fd_ota_full2_nc_0/eeg_fd_ota_core_soft_0/m1_38097_n3864# 100000
R550 eeg_fd_ota_full2_nc_0/eeg_fd_ota_core_soft_0/m1_28253_3443# eeg_fd_ota_full2_nc_0/eeg_fd_ota_core_soft_0/m1_28681_n3864# 100000
R551 eeg_fd_ota_full2_nc_0/eeg_fd_ota_core_soft_0/m1_32961_n3864# eeg_fd_ota_full2_nc_0/eeg_fd_ota_core_soft_0/m1_33389_3443# 100000
X552 eeg_fd_ota_full2_nc_0/stage2_0/N2P eeg_pseudo_res_1/B eeg_fd_ota_full2_nc_0/eeg_fd_ota_core_soft_0/m1_n22658_111# VSS sky130_fd_pr__nfet_01v8 ad=30 pd=126 as=30 ps=126 w=120 l=4 nf=12
X553 eeg_fd_ota_full2_nc_0/eeg_fd_ota_core_soft_0/m1_n22658_111# eeg_pseudo_res_0/B eeg_fd_ota_full2_nc_0/stage2_0/N2N VSS sky130_fd_pr__nfet_01v8 ad=30 pd=126 as=30 ps=126 w=120 l=4 nf=12
X554 eeg_fd_ota_full2_nc_0/eeg_fd_ota_core_soft_0/m1_n22658_111# eeg_pseudo_res_1/B eeg_fd_ota_full2_nc_0/stage2_0/N2P VSS sky130_fd_pr__nfet_01v8 ad=30 pd=126 as=30 ps=126 w=120 l=4 nf=12
X555 eeg_fd_ota_full2_nc_0/stage2_0/N2N eeg_pseudo_res_0/B eeg_fd_ota_full2_nc_0/eeg_fd_ota_core_soft_0/m1_n22658_111# VSS sky130_fd_pr__nfet_01v8 ad=30 pd=126 as=30 ps=126 w=120 l=4 nf=12
X564 eeg_fd_ota_full2_nc_0/eeg_fd_ota_core_soft_0/m1_n22658_111# VSS eeg_fd_ota_full2_nc_0/stage2_0/N2P VSS sky130_fd_pr__nfet_01v8 ad=17.4 pd=23.48 as=2.5 ps=10.5 w=10 l=4 nf=1
X596 eeg_fd_ota_full2_nc_0/stage2_0/N2P VSS eeg_fd_ota_full2_nc_0/eeg_fd_ota_core_soft_0/m1_n22658_111# VSS sky130_fd_pr__nfet_01v8 ad=2.5 pd=10.5 as=17.4 ps=23.48 w=10 l=4 nf=1
R602 eeg_fd_ota_full2_nc_0/eeg_fd_ota_core_soft_0/m1_41949_3443# eeg_fd_ota_full2_nc_0/eeg_fd_ota_core_soft_0/m1_42377_n3864# 100000
R603 eeg_fd_ota_full2_nc_0/eeg_fd_ota_core_soft_0/m1_37241_n3864# eeg_fd_ota_full2_nc_0/eeg_fd_ota_core_soft_0/m1_37669_3443# 100000
R604 eeg_fd_ota_full2_nc_0/eeg_fd_ota_core_soft_0/m1_27825_n3864# eeg_fd_ota_full2_nc_0/eeg_fd_ota_core_soft_0/m1_28253_3443# 100000
R605 eeg_fd_ota_full2_nc_0/eeg_fd_ota_core_soft_0/m1_32533_3443# eeg_fd_ota_full2_nc_0/eeg_fd_ota_core_soft_0/m1_32961_n3864# 100000
R606 eeg_fd_ota_full2_nc_0/eeg_fd_ota_core_soft_0/m1_41521_n3864# eeg_fd_ota_full2_nc_0/eeg_fd_ota_core_soft_0/m1_41949_3443# 100000
R607 eeg_fd_ota_full2_nc_0/eeg_fd_ota_core_soft_0/m1_36813_3443# eeg_fd_ota_full2_nc_0/eeg_fd_ota_core_soft_0/m1_37241_n3864# 100000
R608 eeg_fd_ota_full2_nc_0/eeg_fd_ota_core_soft_0/m1_27397_3443# eeg_fd_ota_full2_nc_0/eeg_fd_ota_core_soft_0/m1_27825_n3864# 100000
R609 eeg_fd_ota_full2_nc_0/eeg_fd_ota_core_soft_0/m1_32105_n3864# eeg_fd_ota_full2_nc_0/eeg_fd_ota_core_soft_0/m1_32533_3443# 100000
R610 eeg_fd_ota_full2_nc_0/eeg_fd_ota_core_soft_0/m1_41093_3443# eeg_fd_ota_full2_nc_0/eeg_fd_ota_core_soft_0/m1_41521_n3864# 100000
R611 eeg_fd_ota_full2_nc_0/eeg_fd_ota_core_soft_0/m1_36385_n3864# eeg_fd_ota_full2_nc_0/eeg_fd_ota_core_soft_0/m1_36813_3443# 100000
R612 eeg_fd_ota_full2_nc_0/eeg_fd_ota_core_soft_0/m1_26969_n3864# eeg_fd_ota_full2_nc_0/eeg_fd_ota_core_soft_0/m1_27397_3443# 100000
R613 eeg_fd_ota_full2_nc_0/eeg_fd_ota_core_soft_0/m1_31677_3443# eeg_fd_ota_full2_nc_0/eeg_fd_ota_core_soft_0/m1_32105_n3864# 100000
R614 eeg_fd_ota_full2_nc_0/eeg_fd_ota_core_soft_0/m1_47513_n3864# eeg_fd_ota_full2_nc_0/stage2_0/N2N 100000
R615 eeg_fd_ota_full2_nc_0/eeg_fd_ota_core_soft_0/m1_40665_n3864# eeg_fd_ota_full2_nc_0/eeg_fd_ota_core_soft_0/m1_41093_3443# 100000
R616 eeg_fd_ota_full2_nc_0/eeg_cmfb_amp_dl2_0/VCM_SENSE eeg_fd_ota_full2_nc_0/eeg_fd_ota_core_soft_0/m1_26969_n3864# 100000
R617 eeg_fd_ota_full2_nc_0/eeg_fd_ota_core_soft_0/m1_31249_n3864# eeg_fd_ota_full2_nc_0/eeg_fd_ota_core_soft_0/m1_31677_3443# 100000
R618 eeg_fd_ota_full2_nc_0/eeg_fd_ota_core_soft_0/m1_35957_3443# eeg_fd_ota_full2_nc_0/eeg_fd_ota_core_soft_0/m1_36385_n3864# 100000
R619 eeg_fd_ota_full2_nc_0/eeg_fd_ota_core_soft_0/m1_53633_n3864# eeg_fd_ota_full2_nc_0/eeg_fd_ota_core_soft_0/m1_54061_3443# 100000
R620 eeg_fd_ota_full2_nc_0/eeg_fd_ota_core_soft_0/m1_47085_3443# eeg_fd_ota_full2_nc_0/eeg_fd_ota_core_soft_0/m1_47513_n3864# 100000
R621 eeg_fd_ota_full2_nc_0/eeg_fd_ota_core_soft_0/m1_40237_3443# eeg_fd_ota_full2_nc_0/eeg_fd_ota_core_soft_0/m1_40665_n3864# 100000
R622 eeg_fd_ota_full2_nc_0/eeg_fd_ota_core_soft_0/m1_35529_n3864# eeg_fd_ota_full2_nc_0/eeg_fd_ota_core_soft_0/m1_35957_3443# 100000
R623 eeg_fd_ota_full2_nc_0/eeg_fd_ota_core_soft_0/m1_30821_3443# eeg_fd_ota_full2_nc_0/eeg_fd_ota_core_soft_0/m1_31249_n3864# 100000
R624 eeg_fd_ota_full2_nc_0/eeg_fd_ota_core_soft_0/m1_57913_n3864# eeg_fd_ota_full2_nc_0/stage2_0/N2N 100000
R625 eeg_fd_ota_full2_nc_0/eeg_fd_ota_core_soft_0/m1_53205_3443# eeg_fd_ota_full2_nc_0/eeg_fd_ota_core_soft_0/m1_53633_n3864# 100000
R626 eeg_fd_ota_full2_nc_0/eeg_fd_ota_core_soft_0/m1_46657_n3864# eeg_fd_ota_full2_nc_0/eeg_fd_ota_core_soft_0/m1_47085_3443# 100000
R627 eeg_fd_ota_full2_nc_0/eeg_fd_ota_core_soft_0/m1_39809_n3864# eeg_fd_ota_full2_nc_0/eeg_fd_ota_core_soft_0/m1_40237_3443# 100000
R628 eeg_fd_ota_full2_nc_0/eeg_fd_ota_core_soft_0/m1_35101_3443# eeg_fd_ota_full2_nc_0/eeg_fd_ota_core_soft_0/m1_35529_n3864# 100000
R629 eeg_fd_ota_full2_nc_0/eeg_fd_ota_core_soft_0/m1_57485_3443# eeg_fd_ota_full2_nc_0/eeg_fd_ota_core_soft_0/m1_57913_n3864# 100000
R630 eeg_fd_ota_full2_nc_0/eeg_fd_ota_core_soft_0/m1_52777_n3864# eeg_fd_ota_full2_nc_0/eeg_fd_ota_core_soft_0/m1_53205_3443# 100000
R631 eeg_fd_ota_full2_nc_0/eeg_fd_ota_core_soft_0/m1_46229_3443# eeg_fd_ota_full2_nc_0/eeg_fd_ota_core_soft_0/m1_46657_n3864# 100000
R632 eeg_fd_ota_full2_nc_0/eeg_fd_ota_core_soft_0/m1_n45063_3443# eeg_fd_ota_full2_nc_0/eeg_fd_ota_core_soft_0/m1_n44635_n3864# 100000
R633 eeg_fd_ota_full2_nc_0/eeg_fd_ota_core_soft_0/m1_39381_3443# eeg_fd_ota_full2_nc_0/eeg_fd_ota_core_soft_0/m1_39809_n3864# 100000
R634 eeg_fd_ota_full2_nc_0/eeg_fd_ota_core_soft_0/m1_57057_n3864# eeg_fd_ota_full2_nc_0/eeg_fd_ota_core_soft_0/m1_57485_3443# 100000
R635 eeg_fd_ota_full2_nc_0/eeg_fd_ota_core_soft_0/m1_52349_3443# eeg_fd_ota_full2_nc_0/eeg_fd_ota_core_soft_0/m1_52777_n3864# 100000
R636 eeg_fd_ota_full2_nc_0/eeg_fd_ota_core_soft_0/m1_45801_n3864# eeg_fd_ota_full2_nc_0/eeg_fd_ota_core_soft_0/m1_46229_3443# 100000
R637 eeg_fd_ota_full2_nc_0/eeg_fd_ota_core_soft_0/m1_n45491_n3864# eeg_fd_ota_full2_nc_0/eeg_fd_ota_core_soft_0/m1_n45063_3443# 100000
R638 eeg_fd_ota_full2_nc_0/eeg_fd_ota_core_soft_0/m1_n40783_3443# eeg_fd_ota_full2_nc_0/eeg_fd_ota_core_soft_0/m1_n40355_n3864# 100000
R639 eeg_fd_ota_full2_nc_0/eeg_fd_ota_core_soft_0/m1_56629_3443# eeg_fd_ota_full2_nc_0/eeg_fd_ota_core_soft_0/m1_57057_n3864# 100000
R640 eeg_fd_ota_full2_nc_0/eeg_fd_ota_core_soft_0/m1_51921_n3864# eeg_fd_ota_full2_nc_0/eeg_fd_ota_core_soft_0/m1_52349_3443# 100000
R641 eeg_fd_ota_full2_nc_0/eeg_fd_ota_core_soft_0/m1_45373_3443# eeg_fd_ota_full2_nc_0/eeg_fd_ota_core_soft_0/m1_45801_n3864# 100000
R642 eeg_fd_ota_full2_nc_0/eeg_fd_ota_core_soft_0/m1_n45919_3443# eeg_fd_ota_full2_nc_0/eeg_fd_ota_core_soft_0/m1_n45491_n3864# 100000
R643 eeg_fd_ota_full2_nc_0/eeg_fd_ota_core_soft_0/m1_n41211_n3864# eeg_fd_ota_full2_nc_0/eeg_fd_ota_core_soft_0/m1_n40783_3443# 100000
R644 eeg_fd_ota_full2_nc_0/eeg_fd_ota_core_soft_0/m1_n36503_3443# eeg_fd_ota_full2_nc_0/eeg_fd_ota_core_soft_0/m1_n36075_n3864# 100000
R645 eeg_fd_ota_full2_nc_0/eeg_fd_ota_core_soft_0/m1_56201_n3864# eeg_fd_ota_full2_nc_0/eeg_fd_ota_core_soft_0/m1_56629_3443# 100000
R646 eeg_fd_ota_full2_nc_0/eeg_fd_ota_core_soft_0/m1_51493_3443# eeg_fd_ota_full2_nc_0/eeg_fd_ota_core_soft_0/m1_51921_n3864# 100000
R647 eeg_fd_ota_full2_nc_0/eeg_fd_ota_core_soft_0/m1_44945_n3864# eeg_fd_ota_full2_nc_0/eeg_fd_ota_core_soft_0/m1_45373_3443# 100000
R648 eeg_fd_ota_full2_nc_0/eeg_fd_ota_core_soft_0/m1_n46347_n3864# eeg_fd_ota_full2_nc_0/eeg_fd_ota_core_soft_0/m1_n45919_3443# 100000
R649 eeg_fd_ota_full2_nc_0/eeg_fd_ota_core_soft_0/m1_n41639_3443# eeg_fd_ota_full2_nc_0/eeg_fd_ota_core_soft_0/m1_n41211_n3864# 100000
R650 eeg_fd_ota_full2_nc_0/eeg_fd_ota_core_soft_0/m1_n36931_n3864# eeg_fd_ota_full2_nc_0/eeg_fd_ota_core_soft_0/m1_n36503_3443# 100000
R651 eeg_fd_ota_full2_nc_0/eeg_fd_ota_core_soft_0/m1_n32223_3443# eeg_fd_ota_full2_nc_0/eeg_fd_ota_core_soft_0/m1_n31795_n3864# 100000
R652 eeg_fd_ota_full2_nc_0/eeg_fd_ota_core_soft_0/m1_55773_3443# eeg_fd_ota_full2_nc_0/eeg_fd_ota_core_soft_0/m1_56201_n3864# 100000
R653 eeg_fd_ota_full2_nc_0/eeg_fd_ota_core_soft_0/m1_51065_n3864# eeg_fd_ota_full2_nc_0/eeg_fd_ota_core_soft_0/m1_51493_3443# 100000
R654 eeg_fd_ota_full2_nc_0/eeg_fd_ota_core_soft_0/m1_44517_3443# eeg_fd_ota_full2_nc_0/eeg_fd_ota_core_soft_0/m1_44945_n3864# 100000
R655 eeg_fd_ota_full2_nc_0/eeg_fd_ota_core_soft_0/m1_n46775_3443# eeg_fd_ota_full2_nc_0/eeg_fd_ota_core_soft_0/m1_n46347_n3864# 100000
R656 eeg_fd_ota_full2_nc_0/eeg_fd_ota_core_soft_0/m1_n42067_n3864# eeg_fd_ota_full2_nc_0/eeg_fd_ota_core_soft_0/m1_n41639_3443# 100000
R657 eeg_fd_ota_full2_nc_0/eeg_fd_ota_core_soft_0/m1_n37359_3443# eeg_fd_ota_full2_nc_0/eeg_fd_ota_core_soft_0/m1_n36931_n3864# 100000
R658 eeg_fd_ota_full2_nc_0/eeg_fd_ota_core_soft_0/m1_n32651_n3864# eeg_fd_ota_full2_nc_0/eeg_fd_ota_core_soft_0/m1_n32223_3443# 100000
R659 eeg_fd_ota_full2_nc_0/eeg_fd_ota_core_soft_0/m1_n27943_3443# eeg_fd_ota_full2_nc_0/eeg_fd_ota_core_soft_0/m1_n27515_n3864# 100000
X660 eeg_fd_ota_full2_nc_0/stage2_0/N2P eeg_fd_ota_full2_nc_0/eeg_cmfb_amp_dl2_0/VBP VDD18 VDD18 sky130_fd_pr__pfet_01v8 ad=6 pd=26 as=10.62 ps=33.54 w=24 l=4 nf=4
X661 VDD18 eeg_fd_ota_full2_nc_0/eeg_cmfb_amp_dl2_0/VBP eeg_fd_ota_full2_nc_0/stage2_0/N2P VDD18 sky130_fd_pr__pfet_01v8 ad=10.62 pd=33.54 as=6 ps=26 w=24 l=4 nf=4
R668 eeg_fd_ota_full2_nc_0/eeg_fd_ota_core_soft_0/m1_55345_n3864# eeg_fd_ota_full2_nc_0/eeg_fd_ota_core_soft_0/m1_55773_3443# 100000
R669 eeg_fd_ota_full2_nc_0/eeg_fd_ota_core_soft_0/m1_50637_3443# eeg_fd_ota_full2_nc_0/eeg_fd_ota_core_soft_0/m1_51065_n3864# 100000
R670 eeg_fd_ota_full2_nc_0/eeg_fd_ota_core_soft_0/m1_44089_n3864# eeg_fd_ota_full2_nc_0/eeg_fd_ota_core_soft_0/m1_44517_3443# 100000
R671 eeg_fd_ota_full2_nc_0/eeg_fd_ota_core_soft_0/m1_n55463_3443# eeg_fd_ota_full2_nc_0/eeg_fd_ota_core_soft_0/m1_n55035_n3864# 100000
R672 eeg_fd_ota_full2_nc_0/eeg_fd_ota_core_soft_0/m1_n47203_n3864# eeg_fd_ota_full2_nc_0/eeg_fd_ota_core_soft_0/m1_n46775_3443# 100000
R673 eeg_fd_ota_full2_nc_0/eeg_fd_ota_core_soft_0/m1_n42495_3443# eeg_fd_ota_full2_nc_0/eeg_fd_ota_core_soft_0/m1_n42067_n3864# 100000
R674 eeg_fd_ota_full2_nc_0/eeg_fd_ota_core_soft_0/m1_n37787_n3864# eeg_fd_ota_full2_nc_0/eeg_fd_ota_core_soft_0/m1_n37359_3443# 100000
R675 eeg_fd_ota_full2_nc_0/eeg_fd_ota_core_soft_0/m1_n33079_3443# eeg_fd_ota_full2_nc_0/eeg_fd_ota_core_soft_0/m1_n32651_n3864# 100000
R676 eeg_fd_ota_full2_nc_0/eeg_fd_ota_core_soft_0/m1_n28371_n3864# eeg_fd_ota_full2_nc_0/eeg_fd_ota_core_soft_0/m1_n27943_3443# 100000
R677 eeg_fd_ota_full2_nc_0/eeg_fd_ota_core_soft_0/m1_54917_3443# eeg_fd_ota_full2_nc_0/eeg_fd_ota_core_soft_0/m1_55345_n3864# 100000
R678 eeg_fd_ota_full2_nc_0/eeg_fd_ota_core_soft_0/m1_50209_n3864# eeg_fd_ota_full2_nc_0/eeg_fd_ota_core_soft_0/m1_50637_3443# 100000
R679 eeg_fd_ota_full2_nc_0/eeg_fd_ota_core_soft_0/m1_43661_3443# eeg_fd_ota_full2_nc_0/eeg_fd_ota_core_soft_0/m1_44089_n3864# 100000
R680 eeg_fd_ota_full2_nc_0/eeg_fd_ota_core_soft_0/m1_n55891_n3864# eeg_fd_ota_full2_nc_0/eeg_fd_ota_core_soft_0/m1_n55463_3443# 100000
R681 eeg_fd_ota_full2_nc_0/eeg_fd_ota_core_soft_0/m1_n47631_3443# eeg_fd_ota_full2_nc_0/eeg_fd_ota_core_soft_0/m1_n47203_n3864# 100000
R682 eeg_fd_ota_full2_nc_0/eeg_fd_ota_core_soft_0/m1_n42923_n3864# eeg_fd_ota_full2_nc_0/eeg_fd_ota_core_soft_0/m1_n42495_3443# 100000
R683 eeg_fd_ota_full2_nc_0/eeg_fd_ota_core_soft_0/m1_n38215_3443# eeg_fd_ota_full2_nc_0/eeg_fd_ota_core_soft_0/m1_n37787_n3864# 100000
R684 eeg_fd_ota_full2_nc_0/eeg_fd_ota_core_soft_0/m1_n33507_n3864# eeg_fd_ota_full2_nc_0/eeg_fd_ota_core_soft_0/m1_n33079_3443# 100000
R685 eeg_fd_ota_full2_nc_0/eeg_fd_ota_core_soft_0/m1_n28799_3443# eeg_fd_ota_full2_nc_0/eeg_fd_ota_core_soft_0/m1_n28371_n3864# 100000
R686 eeg_fd_ota_full2_nc_0/eeg_fd_ota_core_soft_0/m1_54489_n3864# eeg_fd_ota_full2_nc_0/eeg_fd_ota_core_soft_0/m1_54917_3443# 100000
R687 VCM_REF eeg_fd_ota_full2_nc_0/eeg_fd_ota_core_soft_0/m1_50209_n3864# 100000
R688 eeg_fd_ota_full2_nc_0/eeg_fd_ota_core_soft_0/m1_n56319_3443# eeg_fd_ota_full2_nc_0/eeg_fd_ota_core_soft_0/m1_n55891_n3864# 100000
R689 eeg_fd_ota_full2_nc_0/eeg_fd_ota_core_soft_0/m1_n48059_n3864# eeg_fd_ota_full2_nc_0/eeg_fd_ota_core_soft_0/m1_n47631_3443# 100000
R690 eeg_fd_ota_full2_nc_0/eeg_fd_ota_core_soft_0/m1_n43351_3443# eeg_fd_ota_full2_nc_0/eeg_fd_ota_core_soft_0/m1_n42923_n3864# 100000
R691 eeg_fd_ota_full2_nc_0/eeg_fd_ota_core_soft_0/m1_n38643_n3864# eeg_fd_ota_full2_nc_0/eeg_fd_ota_core_soft_0/m1_n38215_3443# 100000
R692 eeg_fd_ota_full2_nc_0/eeg_fd_ota_core_soft_0/m1_n33935_3443# eeg_fd_ota_full2_nc_0/eeg_fd_ota_core_soft_0/m1_n33507_n3864# 100000
R693 eeg_fd_ota_full2_nc_0/eeg_fd_ota_core_soft_0/m1_n29227_n3864# eeg_fd_ota_full2_nc_0/eeg_fd_ota_core_soft_0/m1_n28799_3443# 100000
R694 eeg_fd_ota_full2_nc_0/eeg_fd_ota_core_soft_0/m1_54061_3443# eeg_fd_ota_full2_nc_0/eeg_fd_ota_core_soft_0/m1_54489_n3864# 100000
R695 eeg_fd_ota_full2_nc_0/eeg_fd_ota_core_soft_0/m1_n56747_n3864# eeg_fd_ota_full2_nc_0/eeg_fd_ota_core_soft_0/m1_n56319_3443# 100000
R696 eeg_fd_ota_full2_nc_0/stage2_0/N2P eeg_fd_ota_full2_nc_0/eeg_fd_ota_core_soft_0/m1_n48059_n3864# 100000
R697 eeg_fd_ota_full2_nc_0/eeg_fd_ota_core_soft_0/m1_n43779_n3864# eeg_fd_ota_full2_nc_0/eeg_fd_ota_core_soft_0/m1_n43351_3443# 100000
R698 eeg_fd_ota_full2_nc_0/eeg_fd_ota_core_soft_0/m1_n39071_3443# eeg_fd_ota_full2_nc_0/eeg_fd_ota_core_soft_0/m1_n38643_n3864# 100000
R699 eeg_fd_ota_full2_nc_0/eeg_fd_ota_core_soft_0/m1_n34363_n3864# eeg_fd_ota_full2_nc_0/eeg_fd_ota_core_soft_0/m1_n33935_3443# 100000
R700 eeg_fd_ota_full2_nc_0/eeg_fd_ota_core_soft_0/m1_n29655_3443# eeg_fd_ota_full2_nc_0/eeg_fd_ota_core_soft_0/m1_n29227_n3864# 100000
R701 eeg_fd_ota_full2_nc_0/eeg_fd_ota_core_soft_0/m1_n57175_3443# eeg_fd_ota_full2_nc_0/eeg_fd_ota_core_soft_0/m1_n56747_n3864# 100000
R702 eeg_fd_ota_full2_nc_0/eeg_fd_ota_core_soft_0/m1_n50755_n3864# VCM_REF 100000
R703 eeg_fd_ota_full2_nc_0/eeg_fd_ota_core_soft_0/m1_n44207_3443# eeg_fd_ota_full2_nc_0/eeg_fd_ota_core_soft_0/m1_n43779_n3864# 100000
R704 eeg_fd_ota_full2_nc_0/eeg_fd_ota_core_soft_0/m1_n39499_n3864# eeg_fd_ota_full2_nc_0/eeg_fd_ota_core_soft_0/m1_n39071_3443# 100000
R705 eeg_fd_ota_full2_nc_0/eeg_fd_ota_core_soft_0/m1_n34791_3443# eeg_fd_ota_full2_nc_0/eeg_fd_ota_core_soft_0/m1_n34363_n3864# 100000
R706 eeg_fd_ota_full2_nc_0/eeg_fd_ota_core_soft_0/m1_n30083_n3864# eeg_fd_ota_full2_nc_0/eeg_fd_ota_core_soft_0/m1_n29655_3443# 100000
R707 eeg_fd_ota_full2_nc_0/eeg_fd_ota_core_soft_0/m1_n57603_n3864# eeg_fd_ota_full2_nc_0/eeg_fd_ota_core_soft_0/m1_n57175_3443# 100000
R708 eeg_fd_ota_full2_nc_0/eeg_fd_ota_core_soft_0/m1_n44635_n3864# eeg_fd_ota_full2_nc_0/eeg_fd_ota_core_soft_0/m1_n44207_3443# 100000
R709 eeg_fd_ota_full2_nc_0/eeg_fd_ota_core_soft_0/m1_n39927_3443# eeg_fd_ota_full2_nc_0/eeg_fd_ota_core_soft_0/m1_n39499_n3864# 100000
R710 eeg_fd_ota_full2_nc_0/eeg_fd_ota_core_soft_0/m1_n35219_n3864# eeg_fd_ota_full2_nc_0/eeg_fd_ota_core_soft_0/m1_n34791_3443# 100000
R711 eeg_fd_ota_full2_nc_0/eeg_fd_ota_core_soft_0/m1_n30511_3443# eeg_fd_ota_full2_nc_0/eeg_fd_ota_core_soft_0/m1_n30083_n3864# 100000
X712 eeg_fd_ota_full2_nc_0/stage2_0/N2N eeg_fd_ota_full2_nc_0/eeg_cmfb_amp_dl2_0/VBP VDD18 VDD18 sky130_fd_pr__pfet_01v8 ad=6 pd=26 as=10.62 ps=33.54 w=24 l=4 nf=4
X713 VDD18 eeg_fd_ota_full2_nc_0/eeg_cmfb_amp_dl2_0/VBP eeg_fd_ota_full2_nc_0/stage2_0/N2N VDD18 sky130_fd_pr__pfet_01v8 ad=10.62 pd=33.54 as=6 ps=26 w=24 l=4 nf=4
R720 eeg_fd_ota_full2_nc_0/eeg_fd_ota_core_soft_0/m1_n58031_3443# eeg_fd_ota_full2_nc_0/eeg_fd_ota_core_soft_0/m1_n57603_n3864# 100000
R721 eeg_fd_ota_full2_nc_0/eeg_fd_ota_core_soft_0/m1_n40355_n3864# eeg_fd_ota_full2_nc_0/eeg_fd_ota_core_soft_0/m1_n39927_3443# 100000
R722 eeg_fd_ota_full2_nc_0/eeg_fd_ota_core_soft_0/m1_n35647_3443# eeg_fd_ota_full2_nc_0/eeg_fd_ota_core_soft_0/m1_n35219_n3864# 100000
R723 eeg_fd_ota_full2_nc_0/eeg_fd_ota_core_soft_0/m1_n30939_n3864# eeg_fd_ota_full2_nc_0/eeg_fd_ota_core_soft_0/m1_n30511_3443# 100000
R724 eeg_fd_ota_full2_nc_0/eeg_fd_ota_core_soft_0/m1_n58459_n3864# eeg_fd_ota_full2_nc_0/eeg_fd_ota_core_soft_0/m1_n58031_3443# 100000
R725 eeg_fd_ota_full2_nc_0/eeg_fd_ota_core_soft_0/m1_n36075_n3864# eeg_fd_ota_full2_nc_0/eeg_fd_ota_core_soft_0/m1_n35647_3443# 100000
R726 eeg_fd_ota_full2_nc_0/eeg_fd_ota_core_soft_0/m1_n31367_3443# eeg_fd_ota_full2_nc_0/eeg_fd_ota_core_soft_0/m1_n30939_n3864# 100000
R727 eeg_fd_ota_full2_nc_0/stage2_0/N2P eeg_fd_ota_full2_nc_0/eeg_fd_ota_core_soft_0/m1_n58459_n3864# 100000
R728 eeg_fd_ota_full2_nc_0/eeg_fd_ota_core_soft_0/m1_n31795_n3864# eeg_fd_ota_full2_nc_0/eeg_fd_ota_core_soft_0/m1_n31367_3443# 100000
R729 eeg_fd_ota_full2_nc_0/eeg_fd_ota_core_soft_0/m1_n27515_n3864# eeg_fd_ota_full2_nc_0/eeg_cmfb_amp_dl2_0/VCM_SENSE 100000
X730 VDD18 BIT eeg_inv_0/Y VDD18 sky130_fd_pr__pfet_01v8 ad=2.04 pd=6.04 as=2.04 ps=6.04 w=2 l=0.15 nf=1
X731 VSS BIT eeg_inv_0/Y VSS sky130_fd_pr__nfet_01v8 ad=1.02 pd=4.04 as=1.02 ps=4.04 w=1 l=0.15 nf=1
X732 eeg_strongarm_0/m1_250_166# CLK VSS VSS sky130_fd_pr__nfet_01v8 ad=1 pd=5 as=2.54 ps=8.54 w=4 l=0.15 nf=2
X733 VSS CLK eeg_strongarm_0/m1_250_166# VSS sky130_fd_pr__nfet_01v8 ad=2.54 pd=8.54 as=1 ps=5 w=4 l=0.15 nf=2
X736 eeg_strongarm_0/m1_2620_1559# CLK VDD18 VDD18 sky130_fd_pr__pfet_01v8 ad=1.02 pd=4.04 as=1.02 ps=4.04 w=1 l=0.15 nf=1
X737 eeg_strongarm_0/m1_n4_2402# CLK VDD18 VDD18 sky130_fd_pr__pfet_01v8 ad=1.02 pd=4.04 as=1.02 ps=4.04 w=1 l=0.15 nf=1
X738 VDD18 CLK eeg_nand2_0/A VDD18 sky130_fd_pr__pfet_01v8 ad=1.02 pd=4.04 as=0.25 ps=1.5 w=1 l=0.15 nf=1
X739 eeg_nand2_0/A CLK VDD18 VDD18 sky130_fd_pr__pfet_01v8 ad=0.25 pd=1.5 as=1.02 ps=4.04 w=1 l=0.15 nf=1
X740 VDD18 CLK eeg_nand2_1/A VDD18 sky130_fd_pr__pfet_01v8 ad=1.02 pd=4.04 as=0.25 ps=1.5 w=1 l=0.15 nf=1
X741 eeg_nand2_1/A CLK VDD18 VDD18 sky130_fd_pr__pfet_01v8 ad=0.25 pd=1.5 as=1.02 ps=4.04 w=1 l=0.15 nf=1
X742 eeg_nand2_0/A eeg_nand2_1/A VDD18 VDD18 sky130_fd_pr__pfet_01v8 ad=0.125 pd=1 as=0.15 ps=1.6 w=0.5 l=0.15 nf=1
X743 VDD18 eeg_nand2_1/A eeg_nand2_0/A VDD18 sky130_fd_pr__pfet_01v8 ad=0.15 pd=1.6 as=0.125 ps=1 w=0.5 l=0.15 nf=1
X744 eeg_nand2_1/A eeg_nand2_0/A VDD18 VDD18 sky130_fd_pr__pfet_01v8 ad=0.125 pd=1 as=0.15 ps=1.6 w=0.5 l=0.15 nf=1
X745 VDD18 eeg_nand2_0/A eeg_nand2_1/A VDD18 sky130_fd_pr__pfet_01v8 ad=0.15 pd=1.6 as=0.125 ps=1 w=0.5 l=0.15 nf=1
X746 eeg_nand2_0/A eeg_nand2_1/A eeg_strongarm_0/m1_n4_2402# VSS sky130_fd_pr__nfet_01v8 ad=0.125 pd=1 as=0.15 ps=1.6 w=0.5 l=0.15 nf=1
X747 eeg_strongarm_0/m1_n4_2402# eeg_nand2_1/A eeg_nand2_0/A VSS sky130_fd_pr__nfet_01v8 ad=0.15 pd=1.6 as=0.125 ps=1 w=0.5 l=0.15 nf=1
X748 eeg_nand2_1/A eeg_nand2_0/A eeg_strongarm_0/m1_2620_1559# VSS sky130_fd_pr__nfet_01v8 ad=0.125 pd=1 as=0.15 ps=1.6 w=0.5 l=0.15 nf=1
X749 eeg_strongarm_0/m1_2620_1559# eeg_nand2_0/A eeg_nand2_1/A VSS sky130_fd_pr__nfet_01v8 ad=0.15 pd=1.6 as=0.125 ps=1 w=0.5 l=0.15 nf=1
X750 eeg_strongarm_0/m1_2620_1559# OINTN eeg_strongarm_0/m1_250_166# VSS sky130_fd_pr__nfet_01v8 ad=0.5 pd=3 as=1.27 ps=5.54 w=2 l=0.5 nf=2
X751 eeg_strongarm_0/m1_250_166# OINTN eeg_strongarm_0/m1_2620_1559# VSS sky130_fd_pr__nfet_01v8 ad=1.27 pd=5.54 as=0.5 ps=3 w=2 l=0.5 nf=2
X754 eeg_strongarm_0/m1_n4_2402# OINTP eeg_strongarm_0/m1_250_166# VSS sky130_fd_pr__nfet_01v8 ad=0.5 pd=3 as=1.27 ps=5.54 w=2 l=0.5 nf=2
X755 eeg_strongarm_0/m1_250_166# OINTP eeg_strongarm_0/m1_n4_2402# VSS sky130_fd_pr__nfet_01v8 ad=1.27 pd=5.54 as=0.5 ps=3 w=2 l=0.5 nf=2
R758 m1_57225_71443# eeg_tg_lowq_1/A 100000
R759 m1_56797_64136# m1_57225_71443# 100000
R760 m1_56369_71443# m1_56797_64136# 100000
R761 m1_55941_64136# m1_56369_71443# 100000
CMIM762 VSS eeg_nand2_0/A 1.000000e-12
CMIM763 eeg_pseudo_res_1/B OINTN 2.000000e-11
CMIM764 eeg_pseudo_res_0/B OINTP 2.000000e-11
CMIM788 VSS eeg_nand2_1/A 1.000000e-12
C0 BIT NBIT 2.509232e-16
C1 BIT OINTP 1.202550e-16
C2 BIT VDD18 1.354559e-15
C3 BIT VN 4.692243e-16
C4 BIT VP 6.308619e-16
C5 BIT VSS 9.421594e-14
C6 BIT eeg_inv_0/Y 6.327567e-15
C7 BIT eeg_nand2_0/A 1.021312e-16
C11 BIT eeg_pseudo_res_0/B 1.234980e-16
C12 BIT eeg_pseudo_res_1/B 1.550740e-16
C13 BIT eeg_tg_lowq_1/A 2.931400e-16
C14 BIT eeg_tg_lowq_3/A 3.196065e-16
C15 CLK NCLK 4.395850e-17
C16 CLK OINTN 1.006990e-16
C17 CLK OINTP 1.614110e-16
C19 CLK VSS 1.037626e-14
C20 CLK eeg_nand2_0/A 8.875192e-16
C21 CLK eeg_nand2_1/A 1.079367e-16
C23 CLK eeg_pseudo_res_1/B 1.223579e-16
C24 NBIT OINTN 1.093840e-16
C25 NBIT OINTP 9.784730e-17
C26 NBIT VDD18 6.346509e-15
C27 NBIT VSS 1.406443e-14
C28 NBIT eeg_nand2_0/A 1.039117e-16
C30 NBIT eeg_nand2_1/A 4.111122e-16
C31 NBIT eeg_nand2_1/m1_302_66# 1.146100e-16
C32 NBIT eeg_pseudo_res_0/B 3.691700e-17
C33 NBIT eeg_pseudo_res_1/B 1.429910e-16
C36 NCLK VSS 5.677109e-16
C38 NCLK eeg_pseudo_res_1/B 8.417050e-17
C39 OINTN OINTP 3.051830e-14
C41 OINTN VDD18 4.401251e-16
C42 OINTN VSS 2.861652e-13
C43 OINTN eeg_fd_ota_full2_nc_0/eeg_fd_ota_core_soft_0/m1_n22658_111# 3.600006e-15
C44 OINTN eeg_fd_ota_full2_nc_0/eeg_fd_ota_core_soft_0/m1_n29227_n3864# 7.153055e-17
C45 OINTN eeg_fd_ota_full2_nc_0/eeg_fd_ota_core_soft_0/m1_n30083_n3864# 8.387298e-17
C47 OINTN eeg_fd_ota_full2_nc_0/stage2_0/N2N 6.910636e-16
C48 OINTN eeg_fd_ota_full2_nc_0/stage2_0/N2P 7.154944e-16
C50 OINTN eeg_nand2_0/A 2.893960e-16
C51 OINTN eeg_nand2_1/A 4.901190e-17
C52 OINTN eeg_pseudo_res_0/B 8.165229e-15
C53 OINTN eeg_pseudo_res_1/B 1.029878e-12
C56 OINTP VDD18 4.598390e-16
C57 OINTP VSS 2.991423e-13
C59 OINTP eeg_fd_ota_full2_nc_0/eeg_fd_ota_core_soft_0/m1_n22658_111# 2.356488e-15
C61 OINTP eeg_fd_ota_full2_nc_0/eeg_fd_ota_core_soft_0/m1_n28371_n3864# 4.081942e-17
C62 OINTP eeg_fd_ota_full2_nc_0/eeg_fd_ota_core_soft_0/m1_n29227_n3864# 1.433511e-16
C64 OINTP eeg_fd_ota_full2_nc_0/stage2_0/N2N 1.502409e-16
C65 OINTP eeg_fd_ota_full2_nc_0/stage2_0/N2P 1.362988e-16
C67 OINTP eeg_inv_0/Y 1.202550e-16
C68 OINTP eeg_nand2_0/A 5.509870e-15
C69 OINTP eeg_nand2_1/A 2.391850e-16
C70 OINTP eeg_pseudo_res_0/B 1.023553e-12
C72 OINTP eeg_pseudo_res_1/B 1.307526e-14
C76 VDD18 VN 2.168581e-15
C77 VDD18 VP 1.011448e-16
C78 VDD18 VSS 1.913523e-13
C79 VDD18 eeg_inv_0/Y 1.228193e-15
C80 VDD18 eeg_nand2_0/A 2.054854e-15
C81 VDD18 eeg_nand2_1/A 4.368980e-16
C83 VDD18 eeg_pseudo_res_0/B 9.892970e-15
C84 VDD18 eeg_pseudo_res_1/B 1.293366e-15
C87 VINN VSS 3.467990e-16
C88 VINN eeg_pseudo_res_0/B 3.182660e-16
C89 VINN m1_56369_39443# 6.563147e-17
C91 VINP VSS 3.467530e-16
C92 VINP eeg_pseudo_res_1/B 3.193030e-16
C93 VINP m1_56369_23443# 6.564952e-17
C95 VN VP 9.593358e-17
C96 VN VSS 5.887863e-15
C97 VN eeg_inv_0/Y 4.909950e-15
C98 VN eeg_tg_lowq_1/A 1.555021e-16
C99 VN eeg_tg_lowq_3/A 7.268920e-17
C100 VP VSS 3.748362e-15
C101 VP eeg_inv_0/Y 2.428380e-17
C102 VP eeg_tg_lowq_1/A 3.423360e-16
C103 VP eeg_tg_lowq_3/A 1.024077e-16
C104 VSS eeg_fd_ota_full2_nc_0/eeg_bias_gen_0/VBNF 1.892084e-15
C105 VSS eeg_fd_ota_full2_nc_0/eeg_fd_ota_core_soft_0/m1_n22658_111# 3.986086e-16
C142 VSS eeg_inv_0/Y 5.177803e-16
C143 VSS eeg_nand2_0/A 5.453755e-14
C144 VSS eeg_nand2_0/m1_302_66# 1.312782e-16
C145 VSS eeg_nand2_1/A 4.822974e-14
C147 VSS eeg_pseudo_res_0/B 1.901368e-15
C148 VSS eeg_pseudo_res_1/B 4.851100e-16
C150 VSS eeg_tg_lowq_3/A 2.030524e-17
C154 eeg_fd_ota_full2_nc_0/eeg_fd_ota_core_soft_0/m1_n22658_111# eeg_pseudo_res_0/B 3.009528e-17
C155 eeg_fd_ota_full2_nc_0/eeg_fd_ota_core_soft_0/m1_n22658_111# eeg_pseudo_res_1/B 3.539512e-16
C223 eeg_fd_ota_full2_nc_0/stage2_0/N2N eeg_pseudo_res_0/B 3.751993e-15
C224 eeg_fd_ota_full2_nc_0/stage2_0/N2N eeg_pseudo_res_1/B 1.212278e-15
C225 eeg_fd_ota_full2_nc_0/stage2_0/N2P eeg_pseudo_res_0/B 1.766998e-15
C226 eeg_fd_ota_full2_nc_0/stage2_0/N2P eeg_pseudo_res_1/B 8.850098e-16
C227 eeg_inv_0/Y VSS 6.761550e-14
C228 eeg_inv_0/Y eeg_tg_lowq_1/A 2.168647e-16
C230 eeg_nand2_0/A VSS 3.669990e-14
C232 eeg_nand2_0/A eeg_nand2_1/A 7.726884e-15
C234 eeg_nand2_0/A eeg_pseudo_res_1/B 8.492450e-17
C235 eeg_nand2_1/A VSS 3.751750e-14
C237 eeg_nand2_1/A eeg_pseudo_res_0/B 8.467370e-17
C238 eeg_nand2_1/A eeg_pseudo_res_1/B 3.156290e-16
C239 eeg_pseudo_res_0/B VSS 1.750820e-13
C240 eeg_pseudo_res_0/B eeg_pseudo_res_1/B 5.060546e-14
C243 eeg_pseudo_res_0/B m1_56369_39443# 4.752376e-16
C244 eeg_pseudo_res_0/B m1_56369_71443# 6.482175e-17
C245 eeg_pseudo_res_0/B m1_56797_32136# 7.037490e-17
C246 eeg_pseudo_res_0/B m1_57225_39443# 5.557751e-16
C248 eeg_pseudo_res_1/B VSS 1.662220e-13
C251 eeg_pseudo_res_1/B m1_56369_23443# 4.752376e-16
C252 eeg_pseudo_res_1/B m1_56369_55443# 6.482175e-17
C253 eeg_pseudo_res_1/B m1_56797_16136# 7.037490e-17
C254 eeg_pseudo_res_1/B m1_57225_23443# 5.557751e-16
C256 eeg_tg_lowq_1/A VSS 1.324720e-14
C257 eeg_tg_lowq_1/A eeg_tg_lowq_3/A 3.098350e-16
C260 eeg_tg_lowq_1/A m1_56797_64136# 7.037490e-17
C261 eeg_tg_lowq_1/A m1_57225_71443# 3.430889e-16
C262 eeg_tg_lowq_3/A VSS 2.428280e-14
C265 eeg_tg_lowq_3/A m1_56797_48136# 7.037480e-17
C266 eeg_tg_lowq_3/A m1_57225_55443# 2.518010e-16
C267 m1_55941_16136# VSS 4.917160e-16
C268 m1_55941_16136# m1_56797_16136# 6.207710e-17
C269 m1_55941_32136# VSS 4.917160e-16
C270 m1_55941_32136# m1_56797_32136# 6.207710e-17
C271 m1_55941_48136# VSS 4.917160e-16
C272 m1_55941_48136# m1_56797_48136# 6.207710e-17
C273 m1_55941_64136# VSS 4.917160e-16
C274 m1_55941_64136# m1_56797_64136# 6.207710e-17
C275 m1_56369_23443# VSS 4.860300e-16
C276 m1_56369_23443# m1_57225_23443# 6.207710e-17
C277 m1_56369_39443# VSS 4.860300e-16
C278 m1_56369_39443# m1_57225_39443# 6.207710e-17
C279 m1_56369_55443# VSS 4.860300e-16
C280 m1_56369_55443# m1_57225_55443# 6.207710e-17
C281 m1_56369_71443# VSS 4.860300e-16
C282 m1_56369_71443# m1_57225_71443# 6.207710e-17
C283 m1_56797_16136# VSS 4.860300e-16
C284 m1_56797_32136# VSS 4.860300e-16
C285 m1_56797_48136# VSS 4.860300e-16
C286 m1_56797_64136# VSS 4.860300e-16
C287 m1_57225_23443# VSS 4.917160e-16
C288 m1_57225_39443# VSS 4.917160e-16
C289 m1_57225_55443# VSS 4.917160e-16
C290 m1_57225_71443# VSS 4.917160e-16
C291 eeg_pseudo_res_0/B VSS 6.746650e-16
C292 m1_55941_64136# VSS 6.746650e-16
C293 eeg_tg_lowq_3/A VSS 6.746650e-16
C294 m1_57225_55443# VSS 6.746650e-16
C295 m1_56797_48136# VSS 6.746650e-16
C296 m1_57225_55443# VSS 6.746650e-16
C297 m1_56369_55443# VSS 6.746650e-16
C298 m1_56797_48136# VSS 6.746650e-16
C299 m1_55941_48136# VSS 6.746650e-16
C300 m1_56369_55443# VSS 6.746650e-16
C301 eeg_pseudo_res_1/B VSS 6.746650e-16
C302 m1_55941_48136# VSS 6.746650e-16
C303 eeg_pseudo_res_0/B VSS 6.746650e-16
C304 m1_57225_39443# VSS 6.746650e-16
C305 m1_56797_32136# VSS 6.746650e-16
C306 m1_57225_39443# VSS 6.746650e-16
C307 OINTP VSS 8.414800e-16
C308 OINTP eeg_pseudo_res_0/B 8.460309e-16
C309 OINTP eeg_pseudo_res_0/m1_68_66# 1.314672e-15
C310 eeg_pseudo_res_0/B VSS 1.699680e-15
C311 eeg_pseudo_res_0/B eeg_pseudo_res_0/m1_68_66# 5.017998e-16
C312 eeg_pseudo_res_0/m1_68_66# VSS 3.582030e-15
C313 eeg_pseudo_res_0/B VSS 3.678650e-15
C314 eeg_pseudo_res_0/B eeg_pseudo_res_0/m1_68_66# 1.322042e-15
C315 eeg_pseudo_res_0/m1_68_66# VSS 4.103261e-16
C316 OINTP VSS 3.678650e-15
C317 OINTP eeg_pseudo_res_0/m1_68_66# 1.322042e-15
C318 eeg_pseudo_res_0/m1_68_66# VSS 4.103261e-16
C319 m1_56369_39443# VSS 6.746650e-16
C320 m1_56797_32136# VSS 6.746650e-16
C321 OINTN VSS 8.414800e-16
C322 OINTN eeg_pseudo_res_1/B 8.460309e-16
C323 OINTN eeg_pseudo_res_1/m1_68_66# 1.314672e-15
C324 eeg_pseudo_res_1/B VSS 1.699680e-15
C325 eeg_pseudo_res_1/B eeg_pseudo_res_1/m1_68_66# 5.017998e-16
C326 eeg_pseudo_res_1/m1_68_66# VSS 3.582030e-15
C327 eeg_pseudo_res_1/B VSS 3.678650e-15
C328 eeg_pseudo_res_1/B eeg_pseudo_res_1/m1_68_66# 1.322042e-15
C329 eeg_pseudo_res_1/m1_68_66# VSS 4.103261e-16
C330 OINTN VSS 3.678650e-15
C331 OINTN eeg_pseudo_res_1/m1_68_66# 1.322042e-15
C332 eeg_pseudo_res_1/m1_68_66# VSS 4.103261e-16
C333 m1_55941_32136# VSS 6.746650e-16
C334 m1_56369_39443# VSS 6.746650e-16
C335 VINN VSS 6.746650e-16
C336 m1_55941_32136# VSS 6.746650e-16
C337 eeg_pseudo_res_1/B VSS 6.746650e-16
C338 m1_57225_23443# VSS 6.746650e-16
C339 m1_56797_16136# VSS 6.746650e-16
C340 m1_57225_23443# VSS 6.746650e-16
C341 m1_56369_23443# VSS 6.746650e-16
C342 m1_56797_16136# VSS 6.746650e-16
C343 m1_55941_16136# VSS 6.746650e-16
C344 m1_56369_23443# VSS 6.746650e-16
C345 VINP VSS 6.746650e-16
C346 m1_55941_16136# VSS 6.746650e-16
C347 BIT VDD18 5.262242e-16
C348 BIT VP 1.076105e-16
C349 BIT VSS 2.537269e-15
C350 BIT eeg_inv_0/Y 1.215812e-15
C351 BIT eeg_tg_lowq_1/A 4.755154e-17
C352 VDD18 VP 3.128723e-16
C353 VDD18 VSS 3.714735e-15
C354 VDD18 eeg_inv_0/Y 6.588032e-16
C355 VDD18 eeg_tg_lowq_1/A 1.484229e-16
C356 VP VSS 1.572561e-15
C357 VP eeg_inv_0/Y 2.857784e-16
C358 VP eeg_tg_lowq_1/A 1.492117e-15
C359 VSS eeg_inv_0/Y 4.062507e-16
C360 VSS eeg_tg_lowq_1/A 7.819878e-17
C361 eeg_inv_0/Y VSS 1.383700e-15
C362 eeg_inv_0/Y eeg_tg_lowq_1/A 1.181323e-16
C363 eeg_tg_lowq_1/A VSS 2.430800e-15
C364 VDD18 VP 1.697704e-16
C365 VDD18 VSS 1.561810e-15
C366 VDD18 eeg_inv_0/Y 1.564350e-16
C367 VP VSS 8.867300e-17
C368 VP eeg_inv_0/Y 2.862080e-17
C369 eeg_inv_0/Y VSS 4.901000e-17
C370 BIT VSS 2.062020e-16
C371 BIT eeg_tg_lowq_1/A 2.084120e-17
C372 eeg_tg_lowq_1/A VSS 1.088312e-16
C373 BIT VP 2.084120e-17
C374 BIT VSS 2.062020e-16
C375 VP VSS 1.088312e-16
C376 BIT VDD18 1.594600e-16
C377 BIT VP 2.402360e-17
C378 BIT VSS 4.382640e-17
C379 BIT eeg_tg_lowq_1/A 2.402360e-17
C380 VDD18 VP 1.554040e-16
C381 VDD18 VSS 2.327590e-15
C382 VDD18 eeg_tg_lowq_1/A 1.554040e-16
C383 VP VSS 7.837880e-17
C384 VP eeg_tg_lowq_1/A 1.170160e-16
C385 eeg_tg_lowq_1/A VSS 7.837880e-17
C386 VDD18 VSS 1.561810e-15
C387 VDD18 eeg_inv_0/Y 1.564350e-16
C388 VDD18 eeg_tg_lowq_1/A 1.697704e-16
C389 eeg_inv_0/Y VSS 4.901000e-17
C390 eeg_inv_0/Y eeg_tg_lowq_1/A 2.862080e-17
C391 eeg_tg_lowq_1/A VSS 8.867300e-17
C392 VP VSS 1.267930e-16
C394 VP eeg_tg_lowq_1/A 5.623600e-17
C395 eeg_inv_0/Y VSS 2.027230e-16
C397 eeg_tg_lowq_1/A VSS 1.267930e-16
C398 BIT NBIT 6.303448e-17
C399 BIT VDD18 1.464399e-16
C400 BIT VSS 1.902322e-15
C401 BIT eeg_nand2_0/A 8.494133e-16
C402 BIT eeg_nand2_0/m1_302_66# 6.174150e-17
C403 NBIT VDD18 1.256867e-15
C404 NBIT VSS 1.325098e-15
C405 NBIT eeg_nand2_0/A 2.203847e-16
C406 NBIT eeg_nand2_0/m1_302_66# 2.752348e-17
C407 VDD18 VSS 1.680823e-15
C408 VDD18 eeg_nand2_0/A 2.677469e-16
C410 VSS eeg_nand2_0/A 4.465582e-16
C411 VSS eeg_nand2_0/m1_302_66# 4.991170e-17
C412 eeg_nand2_0/A VSS 1.147970e-15
C414 eeg_nand2_0/m1_302_66# VSS 1.841810e-16
C415 NBIT VDD18 3.212380e-16
C416 NBIT VSS 8.691660e-17
C417 NBIT eeg_nand2_0/A 2.887600e-17
C418 VDD18 VSS 2.592707e-15
C419 VDD18 eeg_nand2_0/A 1.883250e-16
C420 eeg_nand2_0/A VSS 4.355510e-17
C421 NBIT VSS 1.770690e-16
C423 NBIT eeg_nand2_0/m1_302_66# 5.623600e-17
C424 eeg_nand2_0/A VSS 2.011170e-16
C426 eeg_nand2_0/m1_302_66# VSS 1.770690e-16
C427 BIT NBIT 2.887600e-17
C428 BIT VDD18 1.883250e-16
C429 BIT VSS 4.355510e-17
C430 NBIT VDD18 3.212380e-16
C431 NBIT VSS 8.691660e-17
C432 VDD18 VSS 2.592707e-15
C433 BIT VSS 2.152613e-16
C435 VSS eeg_nand2_0/m1_302_66# 5.623600e-17
C436 eeg_nand2_0/m1_302_66# VSS 1.770690e-16
C437 BIT VDD18 6.588032e-16
C438 BIT VN 2.857784e-16
C439 BIT VSS 1.789951e-15
C440 BIT eeg_inv_0/Y 1.215812e-15
C441 BIT eeg_tg_lowq_1/A 1.181323e-16
C442 VDD18 VN 3.128723e-16
C443 VDD18 VSS 3.714735e-15
C444 VDD18 eeg_inv_0/Y 5.262242e-16
C445 VDD18 eeg_tg_lowq_1/A 1.484229e-16
C446 VN VSS 1.572561e-15
C447 VN eeg_inv_0/Y 1.076105e-16
C448 VN eeg_tg_lowq_1/A 1.492117e-15
C449 VSS eeg_inv_0/Y 1.446619e-15
C450 VSS eeg_tg_lowq_1/A 7.819878e-17
C451 eeg_inv_0/Y VSS 1.090650e-15
C452 eeg_inv_0/Y eeg_tg_lowq_1/A 4.755154e-17
C453 eeg_tg_lowq_1/A VSS 2.430800e-15
C454 BIT VDD18 1.564350e-16
C455 BIT VN 2.862080e-17
C456 BIT VSS 4.901000e-17
C457 VDD18 VN 1.697704e-16
C458 VDD18 VSS 1.561810e-15
C459 VN VSS 8.867300e-17
C460 eeg_inv_0/Y VSS 2.062020e-16
C461 eeg_inv_0/Y eeg_tg_lowq_1/A 2.084120e-17
C462 eeg_tg_lowq_1/A VSS 1.088312e-16
C463 VN VSS 1.088312e-16
C464 VN eeg_inv_0/Y 2.084120e-17
C465 eeg_inv_0/Y VSS 2.062020e-16
C466 VDD18 VN 1.554040e-16
C467 VDD18 VSS 2.327590e-15
C468 VDD18 eeg_inv_0/Y 1.594600e-16
C469 VDD18 eeg_tg_lowq_1/A 1.554040e-16
C470 VN VSS 7.837880e-17
C471 VN eeg_inv_0/Y 2.402360e-17
C472 VN eeg_tg_lowq_1/A 1.170160e-16
C473 eeg_inv_0/Y VSS 4.382640e-17
C474 eeg_inv_0/Y eeg_tg_lowq_1/A 2.402360e-17
C475 eeg_tg_lowq_1/A VSS 7.837880e-17
C476 BIT VDD18 1.564350e-16
C477 BIT VSS 4.901000e-17
C478 BIT eeg_tg_lowq_1/A 2.862080e-17
C479 VDD18 VSS 1.561810e-15
C480 VDD18 eeg_tg_lowq_1/A 1.697704e-16
C481 eeg_tg_lowq_1/A VSS 8.867300e-17
C483 BIT VSS 2.027230e-16
C485 VN VSS 1.267930e-16
C486 VN eeg_tg_lowq_1/A 5.623600e-17
C487 eeg_tg_lowq_1/A VSS 1.267930e-16
C488 BIT NBIT 6.303448e-17
C489 BIT VDD18 1.256867e-15
C490 BIT VSS 1.325098e-15
C491 BIT eeg_nand2_1/A 2.203847e-16
C492 BIT eeg_nand2_1/m1_302_66# 2.752348e-17
C493 NBIT VDD18 1.464399e-16
C494 NBIT VSS 1.902322e-15
C495 NBIT eeg_nand2_1/A 8.494133e-16
C496 NBIT eeg_nand2_1/m1_302_66# 6.174150e-17
C497 VDD18 VSS 1.680823e-15
C498 VDD18 eeg_nand2_1/A 2.677469e-16
C500 VSS eeg_nand2_1/A 4.465582e-16
C501 VSS eeg_nand2_1/m1_302_66# 4.991170e-17
C502 eeg_nand2_1/A VSS 1.147970e-15
C504 eeg_nand2_1/m1_302_66# VSS 1.841810e-16
C505 BIT VDD18 3.212380e-16
C506 BIT VSS 8.691660e-17
C507 BIT eeg_nand2_1/A 2.887600e-17
C508 VDD18 VSS 2.592707e-15
C509 VDD18 eeg_nand2_1/A 1.883250e-16
C510 eeg_nand2_1/A VSS 4.355510e-17
C511 BIT VSS 1.770690e-16
C513 BIT eeg_nand2_1/m1_302_66# 5.623600e-17
C514 eeg_nand2_1/A VSS 2.011170e-16
C516 eeg_nand2_1/m1_302_66# VSS 1.770690e-16
C517 BIT NBIT 2.887600e-17
C518 BIT VDD18 3.212380e-16
C519 BIT VSS 8.691660e-17
C520 NBIT VDD18 1.883250e-16
C521 NBIT VSS 4.355510e-17
C522 VDD18 VSS 2.592707e-15
C523 NBIT VSS 2.152613e-16
C525 VSS eeg_nand2_1/m1_302_66# 5.623600e-17
C526 eeg_nand2_1/m1_302_66# VSS 1.770690e-16
C527 BIT VDD18 5.262242e-16
C528 BIT VN 1.076105e-16
C529 BIT VSS 2.537269e-15
C530 BIT eeg_inv_0/Y 1.215812e-15
C531 BIT eeg_tg_lowq_3/A 4.755154e-17
C532 VDD18 VN 3.128723e-16
C533 VDD18 VSS 3.714735e-15
C534 VDD18 eeg_inv_0/Y 6.588032e-16
C535 VDD18 eeg_tg_lowq_3/A 1.484229e-16
C536 VN VSS 1.572561e-15
C537 VN eeg_inv_0/Y 2.857784e-16
C538 VN eeg_tg_lowq_3/A 1.492117e-15
C539 VSS eeg_inv_0/Y 4.062507e-16
C540 VSS eeg_tg_lowq_3/A 7.819878e-17
C541 eeg_inv_0/Y VSS 1.383700e-15
C542 eeg_inv_0/Y eeg_tg_lowq_3/A 1.181323e-16
C543 eeg_tg_lowq_3/A VSS 2.430800e-15
C544 VDD18 VN 1.697704e-16
C545 VDD18 VSS 1.561810e-15
C546 VDD18 eeg_inv_0/Y 1.564350e-16
C547 VN VSS 8.867300e-17
C548 VN eeg_inv_0/Y 2.862080e-17
C549 eeg_inv_0/Y VSS 4.901000e-17
C550 BIT VSS 2.062020e-16
C551 BIT eeg_tg_lowq_3/A 2.084120e-17
C552 eeg_tg_lowq_3/A VSS 1.088312e-16
C553 BIT VN 2.084120e-17
C554 BIT VSS 2.062020e-16
C555 VN VSS 1.088312e-16
C556 BIT VDD18 1.594600e-16
C557 BIT VN 2.402360e-17
C558 BIT VSS 4.382640e-17
C559 BIT eeg_tg_lowq_3/A 2.402360e-17
C560 VDD18 VN 1.554040e-16
C561 VDD18 VSS 2.327590e-15
C562 VDD18 eeg_tg_lowq_3/A 1.554040e-16
C563 VN VSS 7.837880e-17
C564 VN eeg_tg_lowq_3/A 1.170160e-16
C565 eeg_tg_lowq_3/A VSS 7.837880e-17
C566 VDD18 VSS 1.561810e-15
C567 VDD18 eeg_inv_0/Y 1.564350e-16
C568 VDD18 eeg_tg_lowq_3/A 1.697704e-16
C569 eeg_inv_0/Y VSS 4.901000e-17
C570 eeg_inv_0/Y eeg_tg_lowq_3/A 2.862080e-17
C571 eeg_tg_lowq_3/A VSS 8.867300e-17
C572 VN VSS 1.267930e-16
C574 VN eeg_tg_lowq_3/A 5.623600e-17
C575 eeg_inv_0/Y VSS 2.027230e-16
C577 eeg_tg_lowq_3/A VSS 1.267930e-16
C578 BIT VDD18 6.588032e-16
C579 BIT VP 2.857784e-16
C580 BIT VSS 1.789951e-15
C581 BIT eeg_inv_0/Y 1.215812e-15
C582 BIT eeg_tg_lowq_3/A 1.181323e-16
C583 VDD18 VP 3.128723e-16
C584 VDD18 VSS 3.714735e-15
C585 VDD18 eeg_inv_0/Y 5.262242e-16
C586 VDD18 eeg_tg_lowq_3/A 1.484229e-16
C587 VP VSS 1.572561e-15
C588 VP eeg_inv_0/Y 1.076105e-16
C589 VP eeg_tg_lowq_3/A 1.492117e-15
C590 VSS eeg_inv_0/Y 1.446619e-15
C591 VSS eeg_tg_lowq_3/A 7.819878e-17
C592 eeg_inv_0/Y VSS 1.090650e-15
C593 eeg_inv_0/Y eeg_tg_lowq_3/A 4.755154e-17
C594 eeg_tg_lowq_3/A VSS 2.430800e-15
C595 BIT VDD18 1.564350e-16
C596 BIT VP 2.862080e-17
C597 BIT VSS 4.901000e-17
C598 VDD18 VP 1.697704e-16
C599 VDD18 VSS 1.561810e-15
C600 VP VSS 8.867300e-17
C601 eeg_inv_0/Y VSS 2.062020e-16
C602 eeg_inv_0/Y eeg_tg_lowq_3/A 2.084120e-17
C603 eeg_tg_lowq_3/A VSS 1.088312e-16
C604 VP VSS 1.088312e-16
C605 VP eeg_inv_0/Y 2.084120e-17
C606 eeg_inv_0/Y VSS 2.062020e-16
C607 VDD18 VP 1.554040e-16
C608 VDD18 VSS 2.327590e-15
C609 VDD18 eeg_inv_0/Y 1.594600e-16
C610 VDD18 eeg_tg_lowq_3/A 1.554040e-16
C611 VP VSS 7.837880e-17
C612 VP eeg_inv_0/Y 2.402360e-17
C613 VP eeg_tg_lowq_3/A 1.170160e-16
C614 eeg_inv_0/Y VSS 4.382640e-17
C615 eeg_inv_0/Y eeg_tg_lowq_3/A 2.402360e-17
C616 eeg_tg_lowq_3/A VSS 7.837880e-17
C617 BIT VDD18 1.564350e-16
C618 BIT VSS 4.901000e-17
C619 BIT eeg_tg_lowq_3/A 2.862080e-17
C620 VDD18 VSS 1.561810e-15
C621 VDD18 eeg_tg_lowq_3/A 1.697704e-16
C622 eeg_tg_lowq_3/A VSS 8.867300e-17
C624 BIT VSS 2.027230e-16
C626 VP VSS 1.267930e-16
C627 VP eeg_tg_lowq_3/A 5.623600e-17
C628 eeg_tg_lowq_3/A VSS 1.267930e-16
C630 OINTN VSS 4.962613e-16
C631 OINTN eeg_fd_ota_full2_nc_0/eeg_bias_gen_0/VBNF 1.365910e-16
C633 OINTN eeg_fd_ota_full2_nc_0/stage2_0/VBP2 6.008432e-15
C634 OINTN eeg_fd_ota_full2_nc_0/stage2_0/VCM2 1.365910e-16
C636 OINTP VSS 3.737272e-16
C637 OINTP eeg_fd_ota_full2_nc_0/eeg_bias_gen_0/VBNF 2.070634e-16
C640 OINTP eeg_fd_ota_full2_nc_0/stage2_0/VCM2 1.333710e-16
C641 VCM_REF VDD18 2.978039e-15
C642 VCM_REF VSS 4.754464e-14
C643 VCM_REF eeg_fd_ota_full2_nc_0/eeg_bias_gen_0/VBNF 1.760183e-14
C644 VCM_REF eeg_fd_ota_full2_nc_0/eeg_cmfb_amp_dl2_0/VBP 3.196830e-15
C645 VCM_REF eeg_fd_ota_full2_nc_0/eeg_cmfb_amp_dl2_0/VCM_SENSE 3.349959e-16
C648 VCM_REF eeg_fd_ota_full2_nc_0/stage2_0/N2N 1.978811e-16
C649 VCM_REF eeg_fd_ota_full2_nc_0/stage2_0/N2P 3.238353e-16
C650 VCM_REF eeg_fd_ota_full2_nc_0/stage2_0/VBP2 4.861444e-15
C651 VCM_REF eeg_fd_ota_full2_nc_0/stage2_0/VCM2 1.339766e-16
C652 VDD18 VSS 6.340594e-14
C654 VDD18 eeg_fd_ota_full2_nc_0/eeg_bias_gen_0/VBNF 2.278372e-14
C655 VDD18 eeg_fd_ota_full2_nc_0/eeg_bias_gen_0/eeg_pseudo_res_0/m1_68_66# 9.173605e-17
C656 VDD18 eeg_fd_ota_full2_nc_0/eeg_cmfb_amp_dl2_0/VBP 5.385723e-16
C657 VDD18 eeg_fd_ota_full2_nc_0/eeg_cmfb_amp_dl2_0/VCM_SENSE 6.617475e-16
C661 VDD18 eeg_fd_ota_full2_nc_0/stage2_0/N2P 2.623749e-16
C662 VDD18 eeg_fd_ota_full2_nc_0/stage2_0/VBP2 3.082431e-16
C664 VSS eeg_fd_ota_full2_nc_0/eeg_bias_gen_0/VBN 6.624060e-17
C665 VSS eeg_fd_ota_full2_nc_0/eeg_bias_gen_0/VBNF 6.362253e-15
C667 VSS eeg_fd_ota_full2_nc_0/eeg_bias_gen_0/m1_3701_n11401# 5.447830e-17
C668 VSS eeg_fd_ota_full2_nc_0/eeg_bias_gen_0/m1_4369_n2557# 7.002590e-17
C669 VSS eeg_fd_ota_full2_nc_0/eeg_bias_gen_0/m1_5225_n2557# 7.002590e-17
C670 VSS eeg_fd_ota_full2_nc_0/eeg_bias_gen_0/m1_6081_n2557# 7.002590e-17
C671 VSS eeg_fd_ota_full2_nc_0/eeg_bias_gen_0/m1_6937_n2557# 7.002590e-17
C672 VSS eeg_fd_ota_full2_nc_0/eeg_bias_gen_0/m1_7793_n2557# 7.232562e-17
C673 VSS eeg_fd_ota_full2_nc_0/eeg_bias_gen_0/m1_8649_n2557# 8.131770e-17
C674 VSS eeg_fd_ota_full2_nc_0/eeg_bias_gen_0/m1_9505_n2557# 9.211493e-17
C675 VSS eeg_fd_ota_full2_nc_0/eeg_cmfb_amp_dl2_0/VCM_SENSE 2.286714e-16
C684 VSS eeg_fd_ota_full2_nc_0/eeg_fd_ota_core_soft_0/m1_31677_3443# 3.600780e-17
C686 VSS eeg_fd_ota_full2_nc_0/eeg_fd_ota_core_soft_0/m1_32533_3443# 5.459370e-17
C716 VSS eeg_fd_ota_full2_nc_0/eeg_fd_ota_core_soft_0/m1_n22658_111# 2.315806e-16
C717 VSS eeg_fd_ota_full2_nc_0/stage2_0/N2N 8.321908e-16
C718 VSS eeg_fd_ota_full2_nc_0/stage2_0/N2P 5.585855e-16
C719 VSS eeg_fd_ota_full2_nc_0/stage2_0/VBP2 5.043806e-15
C720 VSS eeg_fd_ota_full2_nc_0/stage2_0/VCM2 7.298323e-16
C723 eeg_fd_ota_full2_nc_0/eeg_bias_gen_0/VBN eeg_fd_ota_full2_nc_0/eeg_bias_gen_0/VBNF 3.944226e-16
C724 eeg_fd_ota_full2_nc_0/eeg_bias_gen_0/VBNF VSS 6.360630e-14
C726 eeg_fd_ota_full2_nc_0/eeg_bias_gen_0/VBNF eeg_fd_ota_full2_nc_0/eeg_bias_gen_0/eeg_pseudo_res_0/m1_68_66# 1.772766e-16
C731 eeg_fd_ota_full2_nc_0/eeg_bias_gen_0/VBNF eeg_fd_ota_full2_nc_0/eeg_cmfb_amp_dl2_0/VBP 3.035589e-16
C732 eeg_fd_ota_full2_nc_0/eeg_bias_gen_0/VBNF eeg_fd_ota_full2_nc_0/eeg_cmfb_amp_dl2_0/VCM_SENSE 2.222844e-16
C733 eeg_fd_ota_full2_nc_0/eeg_bias_gen_0/VBNF eeg_fd_ota_full2_nc_0/eeg_cmfb_amp_dl2_0/m1_370_1493# 4.385371e-17
C734 eeg_fd_ota_full2_nc_0/eeg_bias_gen_0/VBNF eeg_fd_ota_full2_nc_0/eeg_cmfb_amp_dl2_0/m1_68_166# 3.222660e-17
C735 eeg_fd_ota_full2_nc_0/eeg_bias_gen_0/VBNF eeg_fd_ota_full2_nc_0/eeg_cmfb_amp_dl2_s2_0/m1_370_1493# 4.385371e-17
C737 eeg_fd_ota_full2_nc_0/eeg_bias_gen_0/VBNF eeg_fd_ota_full2_nc_0/eeg_fd_ota_core_soft_0/m1_26969_n3864# 5.450440e-17
C738 eeg_fd_ota_full2_nc_0/eeg_bias_gen_0/VBNF eeg_fd_ota_full2_nc_0/eeg_fd_ota_core_soft_0/m1_27825_n3864# 5.321460e-17
C739 eeg_fd_ota_full2_nc_0/eeg_bias_gen_0/VBNF eeg_fd_ota_full2_nc_0/eeg_fd_ota_core_soft_0/m1_28681_n3864# 5.321460e-17
C740 eeg_fd_ota_full2_nc_0/eeg_bias_gen_0/VBNF eeg_fd_ota_full2_nc_0/eeg_fd_ota_core_soft_0/m1_29537_n3864# 5.321460e-17
C741 eeg_fd_ota_full2_nc_0/eeg_bias_gen_0/VBNF eeg_fd_ota_full2_nc_0/eeg_fd_ota_core_soft_0/m1_30393_n3864# 5.321460e-17
C742 eeg_fd_ota_full2_nc_0/eeg_bias_gen_0/VBNF eeg_fd_ota_full2_nc_0/eeg_fd_ota_core_soft_0/m1_31249_n3864# 5.321463e-17
C743 eeg_fd_ota_full2_nc_0/eeg_bias_gen_0/VBNF eeg_fd_ota_full2_nc_0/eeg_fd_ota_core_soft_0/m1_32105_n3864# 5.321460e-17
C744 eeg_fd_ota_full2_nc_0/eeg_bias_gen_0/VBNF eeg_fd_ota_full2_nc_0/eeg_fd_ota_core_soft_0/m1_32961_n3864# 5.321460e-17
C745 eeg_fd_ota_full2_nc_0/eeg_bias_gen_0/VBNF eeg_fd_ota_full2_nc_0/eeg_fd_ota_core_soft_0/m1_33817_n3864# 5.321460e-17
C746 eeg_fd_ota_full2_nc_0/eeg_bias_gen_0/VBNF eeg_fd_ota_full2_nc_0/eeg_fd_ota_core_soft_0/m1_34673_n3864# 5.321460e-17
C747 eeg_fd_ota_full2_nc_0/eeg_bias_gen_0/VBNF eeg_fd_ota_full2_nc_0/eeg_fd_ota_core_soft_0/m1_35529_n3864# 5.321460e-17
C748 eeg_fd_ota_full2_nc_0/eeg_bias_gen_0/VBNF eeg_fd_ota_full2_nc_0/eeg_fd_ota_core_soft_0/m1_36385_n3864# 5.321463e-17
C749 eeg_fd_ota_full2_nc_0/eeg_bias_gen_0/VBNF eeg_fd_ota_full2_nc_0/eeg_fd_ota_core_soft_0/m1_37241_n3864# 5.321460e-17
C750 eeg_fd_ota_full2_nc_0/eeg_bias_gen_0/VBNF eeg_fd_ota_full2_nc_0/eeg_fd_ota_core_soft_0/m1_38097_n3864# 5.321460e-17
C751 eeg_fd_ota_full2_nc_0/eeg_bias_gen_0/VBNF eeg_fd_ota_full2_nc_0/eeg_fd_ota_core_soft_0/m1_38953_n3864# 5.321460e-17
C752 eeg_fd_ota_full2_nc_0/eeg_bias_gen_0/VBNF eeg_fd_ota_full2_nc_0/eeg_fd_ota_core_soft_0/m1_39809_n3864# 5.321460e-17
C753 eeg_fd_ota_full2_nc_0/eeg_bias_gen_0/VBNF eeg_fd_ota_full2_nc_0/eeg_fd_ota_core_soft_0/m1_40665_n3864# 5.321460e-17
C754 eeg_fd_ota_full2_nc_0/eeg_bias_gen_0/VBNF eeg_fd_ota_full2_nc_0/eeg_fd_ota_core_soft_0/m1_41521_n3864# 5.321460e-17
C755 eeg_fd_ota_full2_nc_0/eeg_bias_gen_0/VBNF eeg_fd_ota_full2_nc_0/eeg_fd_ota_core_soft_0/m1_42377_n3864# 5.321460e-17
C756 eeg_fd_ota_full2_nc_0/eeg_bias_gen_0/VBNF eeg_fd_ota_full2_nc_0/eeg_fd_ota_core_soft_0/m1_43233_n3864# 5.321460e-17
C757 eeg_fd_ota_full2_nc_0/eeg_bias_gen_0/VBNF eeg_fd_ota_full2_nc_0/eeg_fd_ota_core_soft_0/m1_44089_n3864# 5.321460e-17
C758 eeg_fd_ota_full2_nc_0/eeg_bias_gen_0/VBNF eeg_fd_ota_full2_nc_0/eeg_fd_ota_core_soft_0/m1_44945_n3864# 5.321460e-17
C759 eeg_fd_ota_full2_nc_0/eeg_bias_gen_0/VBNF eeg_fd_ota_full2_nc_0/eeg_fd_ota_core_soft_0/m1_45801_n3864# 5.321460e-17
C760 eeg_fd_ota_full2_nc_0/eeg_bias_gen_0/VBNF eeg_fd_ota_full2_nc_0/eeg_fd_ota_core_soft_0/m1_46657_n3864# 5.321460e-17
C761 eeg_fd_ota_full2_nc_0/eeg_bias_gen_0/VBNF eeg_fd_ota_full2_nc_0/eeg_fd_ota_core_soft_0/m1_47513_n3864# 5.450440e-17
C762 eeg_fd_ota_full2_nc_0/eeg_bias_gen_0/VBNF eeg_fd_ota_full2_nc_0/eeg_fd_ota_core_soft_0/m1_50209_n3864# 5.450440e-17
C763 eeg_fd_ota_full2_nc_0/eeg_bias_gen_0/VBNF eeg_fd_ota_full2_nc_0/eeg_fd_ota_core_soft_0/m1_51065_n3864# 5.321460e-17
C764 eeg_fd_ota_full2_nc_0/eeg_bias_gen_0/VBNF eeg_fd_ota_full2_nc_0/eeg_fd_ota_core_soft_0/m1_51921_n3864# 5.321460e-17
C765 eeg_fd_ota_full2_nc_0/eeg_bias_gen_0/VBNF eeg_fd_ota_full2_nc_0/eeg_fd_ota_core_soft_0/m1_52777_n3864# 5.321460e-17
C766 eeg_fd_ota_full2_nc_0/eeg_bias_gen_0/VBNF eeg_fd_ota_full2_nc_0/eeg_fd_ota_core_soft_0/m1_53633_n3864# 5.321457e-17
C767 eeg_fd_ota_full2_nc_0/eeg_bias_gen_0/VBNF eeg_fd_ota_full2_nc_0/eeg_fd_ota_core_soft_0/m1_54489_n3864# 5.321460e-17
C768 eeg_fd_ota_full2_nc_0/eeg_bias_gen_0/VBNF eeg_fd_ota_full2_nc_0/eeg_fd_ota_core_soft_0/m1_55345_n3864# 5.321460e-17
C769 eeg_fd_ota_full2_nc_0/eeg_bias_gen_0/VBNF eeg_fd_ota_full2_nc_0/eeg_fd_ota_core_soft_0/m1_56201_n3864# 5.321460e-17
C770 eeg_fd_ota_full2_nc_0/eeg_bias_gen_0/VBNF eeg_fd_ota_full2_nc_0/eeg_fd_ota_core_soft_0/m1_57057_n3864# 5.321460e-17
C771 eeg_fd_ota_full2_nc_0/eeg_bias_gen_0/VBNF eeg_fd_ota_full2_nc_0/eeg_fd_ota_core_soft_0/m1_57913_n3864# 5.450441e-17
C773 eeg_fd_ota_full2_nc_0/eeg_bias_gen_0/VBNF eeg_fd_ota_full2_nc_0/stage2_0/N2N 3.712090e-16
C774 eeg_fd_ota_full2_nc_0/eeg_bias_gen_0/VBNF eeg_fd_ota_full2_nc_0/stage2_0/N2P 9.506756e-16
C775 eeg_fd_ota_full2_nc_0/eeg_bias_gen_0/VBNF eeg_fd_ota_full2_nc_0/stage2_0/VBP2 1.128255e-15
C776 eeg_fd_ota_full2_nc_0/eeg_bias_gen_0/VBNF eeg_fd_ota_full2_nc_0/stage2_0/VCM2 3.880655e-16
C777 eeg_fd_ota_full2_nc_0/eeg_cmfb_amp_dl2_0/VBP VSS 1.364910e-14
C778 eeg_fd_ota_full2_nc_0/eeg_cmfb_amp_dl2_0/VBP eeg_fd_ota_full2_nc_0/eeg_cmfb_amp_dl2_0/VCM_SENSE 3.069697e-16
C779 eeg_fd_ota_full2_nc_0/eeg_cmfb_amp_dl2_0/VBP eeg_fd_ota_full2_nc_0/stage2_0/N2P 1.614594e-16
C781 eeg_fd_ota_full2_nc_0/eeg_cmfb_amp_dl2_0/VBP eeg_pseudo_res_1/B 3.185803e-17
C782 eeg_fd_ota_full2_nc_0/eeg_cmfb_amp_dl2_0/VCM_SENSE VSS 1.553050e-14
C783 eeg_fd_ota_full2_nc_0/eeg_cmfb_amp_dl2_0/VCM_SENSE eeg_fd_ota_full2_nc_0/eeg_cmfb_amp_dl2_0/m1_370_1493# 9.450030e-17
C784 eeg_fd_ota_full2_nc_0/eeg_cmfb_amp_dl2_0/VCM_SENSE eeg_fd_ota_full2_nc_0/eeg_cmfb_amp_dl2_0/m1_68_166# 1.874921e-16
C785 eeg_fd_ota_full2_nc_0/eeg_cmfb_amp_dl2_0/VCM_SENSE eeg_fd_ota_full2_nc_0/stage2_0/N2N 1.526407e-16
C786 eeg_fd_ota_full2_nc_0/eeg_cmfb_amp_dl2_0/VCM_SENSE eeg_fd_ota_full2_nc_0/stage2_0/N2P 3.196946e-16
C788 eeg_fd_ota_full2_nc_0/eeg_cmfb_amp_dl2_0/m1_68_166# eeg_fd_ota_full2_nc_0/stage2_0/N2P 2.370177e-17
C790 eeg_fd_ota_full2_nc_0/eeg_cmfb_amp_dl2_s2_0/m1_68_166# eeg_fd_ota_full2_nc_0/stage2_0/VCM2 3.437010e-17
C792 eeg_fd_ota_full2_nc_0/stage2_0/N2N VSS 2.096300e-14
C793 eeg_fd_ota_full2_nc_0/stage2_0/N2N eeg_fd_ota_full2_nc_0/stage2_0/N2P 1.370712e-14
C795 eeg_fd_ota_full2_nc_0/stage2_0/N2N eeg_pseudo_res_0/B 1.390907e-16
C796 eeg_fd_ota_full2_nc_0/stage2_0/N2N eeg_pseudo_res_1/B 1.390910e-16
C797 eeg_fd_ota_full2_nc_0/stage2_0/N2P VSS 3.813280e-14
C798 eeg_fd_ota_full2_nc_0/stage2_0/N2P eeg_fd_ota_full2_nc_0/stage2_0/VBP2 9.732428e-17
C799 eeg_fd_ota_full2_nc_0/stage2_0/N2P eeg_pseudo_res_0/B 1.514485e-16
C800 eeg_fd_ota_full2_nc_0/stage2_0/N2P eeg_pseudo_res_1/B 1.567700e-16
C801 eeg_fd_ota_full2_nc_0/stage2_0/VBP2 VSS 3.102510e-14
C802 eeg_fd_ota_full2_nc_0/stage2_0/VBP2 eeg_fd_ota_full2_nc_0/stage2_0/VCM2 1.483105e-16
C803 eeg_fd_ota_full2_nc_0/stage2_0/VCM2 VSS 4.437230e-15
C804 VDD18 VSS 1.077490e-14
C805 VDD18 eeg_fd_ota_full2_nc_0/eeg_bias_gen_0/VBN 1.082819e-15
C806 VDD18 eeg_fd_ota_full2_nc_0/eeg_bias_gen_0/VBNF 1.599904e-15
C807 VDD18 eeg_fd_ota_full2_nc_0/eeg_bias_gen_0/VBP 1.288983e-15
C808 VDD18 eeg_fd_ota_full2_nc_0/eeg_bias_gen_0/eeg_pseudo_res_0/m1_68_66# 4.622759e-16
C809 VDD18 eeg_fd_ota_full2_nc_0/eeg_bias_gen_0/m1_2552_466# 2.080658e-15
C810 VSS eeg_fd_ota_full2_nc_0/eeg_bias_gen_0/VBN 1.959533e-15
C811 VSS eeg_fd_ota_full2_nc_0/eeg_bias_gen_0/VBNF 5.192036e-12
C812 VSS eeg_fd_ota_full2_nc_0/eeg_bias_gen_0/VBP 5.473114e-16
C814 VSS eeg_fd_ota_full2_nc_0/eeg_bias_gen_0/m1_10789_n45240# 2.699880e-17
C816 VSS eeg_fd_ota_full2_nc_0/eeg_bias_gen_0/m1_11645_n45240# 2.699880e-17
C818 VSS eeg_fd_ota_full2_nc_0/eeg_bias_gen_0/m1_2552_466# 5.804743e-16
C820 VSS eeg_fd_ota_full2_nc_0/eeg_bias_gen_0/m1_3941_n45240# 2.699880e-17
C822 VSS eeg_fd_ota_full2_nc_0/eeg_bias_gen_0/m1_4797_n45240# 2.699880e-17
C824 VSS eeg_fd_ota_full2_nc_0/eeg_bias_gen_0/m1_5653_n45240# 2.699880e-17
C826 VSS eeg_fd_ota_full2_nc_0/eeg_bias_gen_0/m1_6509_n45240# 2.699880e-17
C828 VSS eeg_fd_ota_full2_nc_0/eeg_bias_gen_0/m1_7365_n45240# 2.699880e-17
C830 VSS eeg_fd_ota_full2_nc_0/eeg_bias_gen_0/m1_8221_n45240# 2.699880e-17
C832 VSS eeg_fd_ota_full2_nc_0/eeg_bias_gen_0/m1_9077_n45240# 2.699880e-17
C834 VSS eeg_fd_ota_full2_nc_0/eeg_bias_gen_0/m1_9933_n45240# 2.699880e-17
C835 eeg_fd_ota_full2_nc_0/eeg_bias_gen_0/VBN VSS 2.463760e-14
C836 eeg_fd_ota_full2_nc_0/eeg_bias_gen_0/VBN eeg_fd_ota_full2_nc_0/eeg_bias_gen_0/VBNF 3.683289e-15
C837 eeg_fd_ota_full2_nc_0/eeg_bias_gen_0/VBN eeg_fd_ota_full2_nc_0/eeg_bias_gen_0/VBP 4.736529e-15
C838 eeg_fd_ota_full2_nc_0/eeg_bias_gen_0/VBN eeg_fd_ota_full2_nc_0/eeg_bias_gen_0/eeg_pseudo_res_0/m1_68_66# 4.676611e-16
C839 eeg_fd_ota_full2_nc_0/eeg_bias_gen_0/VBN eeg_fd_ota_full2_nc_0/eeg_bias_gen_0/m1_2552_466# 1.444672e-15
C840 eeg_fd_ota_full2_nc_0/eeg_bias_gen_0/VBN eeg_fd_ota_full2_nc_0/eeg_bias_gen_0/m1_3701_n11401# 9.237684e-16
C841 eeg_fd_ota_full2_nc_0/eeg_bias_gen_0/VBN eeg_fd_ota_full2_nc_0/eeg_bias_gen_0/m1_3701_n29089# 9.231557e-16
C842 eeg_fd_ota_full2_nc_0/eeg_bias_gen_0/VBN eeg_fd_ota_full2_nc_0/eeg_bias_gen_0/m1_3941_n27552# 3.125837e-16
C843 eeg_fd_ota_full2_nc_0/eeg_bias_gen_0/VBN eeg_fd_ota_full2_nc_0/eeg_bias_gen_0/m1_3941_n9864# 3.125837e-16
C844 eeg_fd_ota_full2_nc_0/eeg_bias_gen_0/VBN eeg_fd_ota_full2_nc_0/eeg_bias_gen_0/m1_4059_n18708# 3.125840e-16
C845 eeg_fd_ota_full2_nc_0/eeg_bias_gen_0/VBN eeg_fd_ota_full2_nc_0/eeg_bias_gen_0/m1_4059_n36396# 3.179795e-16
C848 eeg_fd_ota_full2_nc_0/eeg_bias_gen_0/VBN eeg_fd_ota_full2_nc_0/eeg_bias_gen_0/m1_4369_n37933# 7.005580e-17
C860 eeg_fd_ota_full2_nc_0/eeg_bias_gen_0/VBNF VSS 7.286790e-14
C861 eeg_fd_ota_full2_nc_0/eeg_bias_gen_0/VBNF eeg_fd_ota_full2_nc_0/eeg_bias_gen_0/VBP 2.158698e-15
C862 eeg_fd_ota_full2_nc_0/eeg_bias_gen_0/VBNF eeg_fd_ota_full2_nc_0/eeg_bias_gen_0/m1_10051_n18708# 3.740510e-17
C863 eeg_fd_ota_full2_nc_0/eeg_bias_gen_0/VBNF eeg_fd_ota_full2_nc_0/eeg_bias_gen_0/m1_10051_n36396# 3.740515e-17
C864 eeg_fd_ota_full2_nc_0/eeg_bias_gen_0/VBNF eeg_fd_ota_full2_nc_0/eeg_bias_gen_0/m1_10361_n20245# 1.172719e-16
C865 eeg_fd_ota_full2_nc_0/eeg_bias_gen_0/VBNF eeg_fd_ota_full2_nc_0/eeg_bias_gen_0/m1_10361_n2557# 1.194606e-16
C866 eeg_fd_ota_full2_nc_0/eeg_bias_gen_0/VBNF eeg_fd_ota_full2_nc_0/eeg_bias_gen_0/m1_10361_n37933# 1.172718e-16
C867 eeg_fd_ota_full2_nc_0/eeg_bias_gen_0/VBNF eeg_fd_ota_full2_nc_0/eeg_bias_gen_0/m1_10479_n11401# 1.172719e-16
C868 eeg_fd_ota_full2_nc_0/eeg_bias_gen_0/VBNF eeg_fd_ota_full2_nc_0/eeg_bias_gen_0/m1_10479_n29089# 1.172718e-16
C869 eeg_fd_ota_full2_nc_0/eeg_bias_gen_0/VBNF eeg_fd_ota_full2_nc_0/eeg_bias_gen_0/m1_10789_n27552# 1.824401e-16
C870 eeg_fd_ota_full2_nc_0/eeg_bias_gen_0/VBNF eeg_fd_ota_full2_nc_0/eeg_bias_gen_0/m1_10789_n45240# 1.766467e-16
C871 eeg_fd_ota_full2_nc_0/eeg_bias_gen_0/VBNF eeg_fd_ota_full2_nc_0/eeg_bias_gen_0/m1_10789_n9864# 1.824401e-16
C872 eeg_fd_ota_full2_nc_0/eeg_bias_gen_0/VBNF eeg_fd_ota_full2_nc_0/eeg_bias_gen_0/m1_10907_n18708# 1.824398e-16
C873 eeg_fd_ota_full2_nc_0/eeg_bias_gen_0/VBNF eeg_fd_ota_full2_nc_0/eeg_bias_gen_0/m1_10907_n36396# 1.824398e-16
C874 eeg_fd_ota_full2_nc_0/eeg_bias_gen_0/VBNF eeg_fd_ota_full2_nc_0/eeg_bias_gen_0/m1_11217_n20245# 8.565560e-17
C875 eeg_fd_ota_full2_nc_0/eeg_bias_gen_0/VBNF eeg_fd_ota_full2_nc_0/eeg_bias_gen_0/m1_11217_n2557# 1.569581e-16
C876 eeg_fd_ota_full2_nc_0/eeg_bias_gen_0/VBNF eeg_fd_ota_full2_nc_0/eeg_bias_gen_0/m1_11217_n37933# 8.565555e-17
C877 eeg_fd_ota_full2_nc_0/eeg_bias_gen_0/VBNF eeg_fd_ota_full2_nc_0/eeg_bias_gen_0/m1_11335_n11401# 8.565560e-17
C878 eeg_fd_ota_full2_nc_0/eeg_bias_gen_0/VBNF eeg_fd_ota_full2_nc_0/eeg_bias_gen_0/m1_11335_n29089# 8.565560e-17
C879 eeg_fd_ota_full2_nc_0/eeg_bias_gen_0/VBNF eeg_fd_ota_full2_nc_0/eeg_bias_gen_0/m1_11645_n27552# 2.773181e-17
C880 eeg_fd_ota_full2_nc_0/eeg_bias_gen_0/VBNF eeg_fd_ota_full2_nc_0/eeg_bias_gen_0/m1_11645_n45240# 4.590106e-17
C881 eeg_fd_ota_full2_nc_0/eeg_bias_gen_0/VBNF eeg_fd_ota_full2_nc_0/eeg_bias_gen_0/m1_11645_n9864# 2.773181e-17
C882 eeg_fd_ota_full2_nc_0/eeg_bias_gen_0/VBNF eeg_fd_ota_full2_nc_0/eeg_bias_gen_0/m1_11763_n18708# 2.773187e-17
C883 eeg_fd_ota_full2_nc_0/eeg_bias_gen_0/VBNF eeg_fd_ota_full2_nc_0/eeg_bias_gen_0/m1_11763_n36396# 2.773183e-17
C884 eeg_fd_ota_full2_nc_0/eeg_bias_gen_0/VBNF eeg_fd_ota_full2_nc_0/eeg_bias_gen_0/m1_12073_n20245# 1.279720e-16
C885 eeg_fd_ota_full2_nc_0/eeg_bias_gen_0/VBNF eeg_fd_ota_full2_nc_0/eeg_bias_gen_0/m1_12073_n37933# 1.279720e-16
C886 eeg_fd_ota_full2_nc_0/eeg_bias_gen_0/VBNF eeg_fd_ota_full2_nc_0/eeg_bias_gen_0/m1_2552_466# 5.878024e-16
C899 eeg_fd_ota_full2_nc_0/eeg_bias_gen_0/VBNF eeg_fd_ota_full2_nc_0/eeg_bias_gen_0/m1_9077_n45240# 2.816113e-17
C908 eeg_fd_ota_full2_nc_0/eeg_bias_gen_0/VBNF eeg_fd_ota_full2_nc_0/eeg_bias_gen_0/m1_9933_n27552# 3.740514e-17
C909 eeg_fd_ota_full2_nc_0/eeg_bias_gen_0/VBNF eeg_fd_ota_full2_nc_0/eeg_bias_gen_0/m1_9933_n45240# 5.557439e-17
C910 eeg_fd_ota_full2_nc_0/eeg_bias_gen_0/VBNF eeg_fd_ota_full2_nc_0/eeg_bias_gen_0/m1_9933_n9864# 3.740514e-17
C911 eeg_fd_ota_full2_nc_0/eeg_bias_gen_0/VBP VSS 5.244210e-15
C912 eeg_fd_ota_full2_nc_0/eeg_bias_gen_0/VBP eeg_fd_ota_full2_nc_0/eeg_bias_gen_0/m1_2552_466# 4.600933e-15
C913 eeg_fd_ota_full2_nc_0/eeg_bias_gen_0/m1_10051_n18708# VSS 3.135120e-16
C915 eeg_fd_ota_full2_nc_0/eeg_bias_gen_0/m1_10051_n18708# eeg_fd_ota_full2_nc_0/eeg_bias_gen_0/m1_10907_n18708# 6.207710e-17
C916 eeg_fd_ota_full2_nc_0/eeg_bias_gen_0/m1_10051_n18708# eeg_fd_ota_full2_nc_0/eeg_bias_gen_0/m1_9195_n18708# 6.207710e-17
C918 eeg_fd_ota_full2_nc_0/eeg_bias_gen_0/m1_10051_n36396# VSS 3.135120e-16
C920 eeg_fd_ota_full2_nc_0/eeg_bias_gen_0/m1_10051_n36396# eeg_fd_ota_full2_nc_0/eeg_bias_gen_0/m1_10907_n36396# 6.207720e-17
C921 eeg_fd_ota_full2_nc_0/eeg_bias_gen_0/m1_10051_n36396# eeg_fd_ota_full2_nc_0/eeg_bias_gen_0/m1_9195_n36396# 6.207720e-17
C923 eeg_fd_ota_full2_nc_0/eeg_bias_gen_0/m1_10361_n20245# VSS 4.429720e-16
C925 eeg_fd_ota_full2_nc_0/eeg_bias_gen_0/m1_10361_n20245# eeg_fd_ota_full2_nc_0/eeg_bias_gen_0/m1_11217_n20245# 6.207710e-17
C927 eeg_fd_ota_full2_nc_0/eeg_bias_gen_0/m1_10361_n20245# eeg_fd_ota_full2_nc_0/eeg_bias_gen_0/m1_9505_n20245# 6.207714e-17
C928 eeg_fd_ota_full2_nc_0/eeg_bias_gen_0/m1_10361_n2557# VSS 4.429720e-16
C929 eeg_fd_ota_full2_nc_0/eeg_bias_gen_0/m1_10361_n2557# eeg_fd_ota_full2_nc_0/eeg_bias_gen_0/m1_11217_n2557# 6.207710e-17
C930 eeg_fd_ota_full2_nc_0/eeg_bias_gen_0/m1_10361_n2557# eeg_fd_ota_full2_nc_0/eeg_bias_gen_0/m1_9505_n2557# 6.207714e-17
C931 eeg_fd_ota_full2_nc_0/eeg_bias_gen_0/m1_10361_n37933# VSS 4.429720e-16
C933 eeg_fd_ota_full2_nc_0/eeg_bias_gen_0/m1_10361_n37933# eeg_fd_ota_full2_nc_0/eeg_bias_gen_0/m1_11217_n37933# 6.207710e-17
C935 eeg_fd_ota_full2_nc_0/eeg_bias_gen_0/m1_10361_n37933# eeg_fd_ota_full2_nc_0/eeg_bias_gen_0/m1_9505_n37933# 6.207714e-17
C936 eeg_fd_ota_full2_nc_0/eeg_bias_gen_0/m1_10479_n11401# VSS 3.135120e-16
C938 eeg_fd_ota_full2_nc_0/eeg_bias_gen_0/m1_10479_n11401# eeg_fd_ota_full2_nc_0/eeg_bias_gen_0/m1_11335_n11401# 6.207714e-17
C940 eeg_fd_ota_full2_nc_0/eeg_bias_gen_0/m1_10479_n11401# eeg_fd_ota_full2_nc_0/eeg_bias_gen_0/m1_9623_n11401# 6.207713e-17
C942 eeg_fd_ota_full2_nc_0/eeg_bias_gen_0/m1_10479_n29089# VSS 3.135120e-16
C944 eeg_fd_ota_full2_nc_0/eeg_bias_gen_0/m1_10479_n29089# eeg_fd_ota_full2_nc_0/eeg_bias_gen_0/m1_11335_n29089# 6.207710e-17
C946 eeg_fd_ota_full2_nc_0/eeg_bias_gen_0/m1_10479_n29089# eeg_fd_ota_full2_nc_0/eeg_bias_gen_0/m1_9623_n29089# 6.207719e-17
C948 eeg_fd_ota_full2_nc_0/eeg_bias_gen_0/m1_10789_n27552# VSS 4.429720e-16
C950 eeg_fd_ota_full2_nc_0/eeg_bias_gen_0/m1_10789_n27552# eeg_fd_ota_full2_nc_0/eeg_bias_gen_0/m1_11645_n27552# 6.207710e-17
C951 eeg_fd_ota_full2_nc_0/eeg_bias_gen_0/m1_10789_n27552# eeg_fd_ota_full2_nc_0/eeg_bias_gen_0/m1_9933_n27552# 6.207710e-17
C952 eeg_fd_ota_full2_nc_0/eeg_bias_gen_0/m1_10789_n45240# VSS 4.429720e-16
C953 eeg_fd_ota_full2_nc_0/eeg_bias_gen_0/m1_10789_n45240# eeg_fd_ota_full2_nc_0/eeg_bias_gen_0/m1_11645_n45240# 6.207710e-17
C954 eeg_fd_ota_full2_nc_0/eeg_bias_gen_0/m1_10789_n45240# eeg_fd_ota_full2_nc_0/eeg_bias_gen_0/m1_9933_n45240# 6.207710e-17
C955 eeg_fd_ota_full2_nc_0/eeg_bias_gen_0/m1_10789_n9864# VSS 4.429720e-16
C957 eeg_fd_ota_full2_nc_0/eeg_bias_gen_0/m1_10789_n9864# eeg_fd_ota_full2_nc_0/eeg_bias_gen_0/m1_11645_n9864# 6.207710e-17
C958 eeg_fd_ota_full2_nc_0/eeg_bias_gen_0/m1_10789_n9864# eeg_fd_ota_full2_nc_0/eeg_bias_gen_0/m1_9933_n9864# 6.207710e-17
C959 eeg_fd_ota_full2_nc_0/eeg_bias_gen_0/m1_10907_n18708# VSS 3.135120e-16
C961 eeg_fd_ota_full2_nc_0/eeg_bias_gen_0/m1_10907_n18708# eeg_fd_ota_full2_nc_0/eeg_bias_gen_0/m1_11763_n18708# 6.207717e-17
C963 eeg_fd_ota_full2_nc_0/eeg_bias_gen_0/m1_10907_n36396# VSS 3.135120e-16
C965 eeg_fd_ota_full2_nc_0/eeg_bias_gen_0/m1_10907_n36396# eeg_fd_ota_full2_nc_0/eeg_bias_gen_0/m1_11763_n36396# 6.207717e-17
C967 eeg_fd_ota_full2_nc_0/eeg_bias_gen_0/m1_11217_n20245# VSS 4.429720e-16
C969 eeg_fd_ota_full2_nc_0/eeg_bias_gen_0/m1_11217_n20245# eeg_fd_ota_full2_nc_0/eeg_bias_gen_0/m1_12073_n20245# 6.212270e-17
C970 eeg_fd_ota_full2_nc_0/eeg_bias_gen_0/m1_11217_n2557# VSS 4.841780e-16
C971 eeg_fd_ota_full2_nc_0/eeg_bias_gen_0/m1_11217_n37933# VSS 4.429720e-16
C973 eeg_fd_ota_full2_nc_0/eeg_bias_gen_0/m1_11217_n37933# eeg_fd_ota_full2_nc_0/eeg_bias_gen_0/m1_12073_n37933# 6.212260e-17
C974 eeg_fd_ota_full2_nc_0/eeg_bias_gen_0/m1_11335_n11401# VSS 3.070650e-16
C976 eeg_fd_ota_full2_nc_0/eeg_bias_gen_0/m1_11335_n11401# eeg_fd_ota_full2_nc_0/eeg_bias_gen_0/m1_12073_n20245# 6.214547e-17
C977 eeg_fd_ota_full2_nc_0/eeg_bias_gen_0/m1_11335_n29089# VSS 3.070650e-16
C979 eeg_fd_ota_full2_nc_0/eeg_bias_gen_0/m1_11335_n29089# eeg_fd_ota_full2_nc_0/eeg_bias_gen_0/m1_12073_n37933# 6.214542e-17
C980 eeg_fd_ota_full2_nc_0/eeg_bias_gen_0/m1_11645_n27552# VSS 4.866180e-16
C982 eeg_fd_ota_full2_nc_0/eeg_bias_gen_0/m1_11645_n45240# VSS 4.917160e-16
C983 eeg_fd_ota_full2_nc_0/eeg_bias_gen_0/m1_11645_n9864# VSS 4.866180e-16
C985 eeg_fd_ota_full2_nc_0/eeg_bias_gen_0/m1_11763_n18708# VSS 2.946600e-16
C986 eeg_fd_ota_full2_nc_0/eeg_bias_gen_0/m1_11763_n18708# eeg_fd_ota_full2_nc_0/eeg_bias_gen_0/m1_12073_n20245# 6.170330e-17
C987 eeg_fd_ota_full2_nc_0/eeg_bias_gen_0/m1_11763_n36396# VSS 2.946600e-16
C988 eeg_fd_ota_full2_nc_0/eeg_bias_gen_0/m1_11763_n36396# eeg_fd_ota_full2_nc_0/eeg_bias_gen_0/m1_12073_n37933# 6.170330e-17
C989 eeg_fd_ota_full2_nc_0/eeg_bias_gen_0/m1_12073_n20245# VSS 4.398630e-15
C990 eeg_fd_ota_full2_nc_0/eeg_bias_gen_0/m1_12073_n37933# VSS 4.398630e-15
C991 eeg_fd_ota_full2_nc_0/eeg_bias_gen_0/m1_2552_466# VSS 6.611080e-15
C992 eeg_fd_ota_full2_nc_0/eeg_bias_gen_0/m1_3701_n11401# VSS 4.385850e-15
C993 eeg_fd_ota_full2_nc_0/eeg_bias_gen_0/m1_3701_n11401# eeg_fd_ota_full2_nc_0/eeg_bias_gen_0/m1_3941_n9864# 6.170325e-17
C994 eeg_fd_ota_full2_nc_0/eeg_bias_gen_0/m1_3701_n11401# eeg_fd_ota_full2_nc_0/eeg_bias_gen_0/m1_4369_n2557# 6.214540e-17
C995 eeg_fd_ota_full2_nc_0/eeg_bias_gen_0/m1_3701_n11401# eeg_fd_ota_full2_nc_0/eeg_bias_gen_0/m1_4487_n11401# 6.212263e-17
C999 eeg_fd_ota_full2_nc_0/eeg_bias_gen_0/m1_3701_n29089# VSS 4.385850e-15
C1000 eeg_fd_ota_full2_nc_0/eeg_bias_gen_0/m1_3701_n29089# eeg_fd_ota_full2_nc_0/eeg_bias_gen_0/m1_3941_n27552# 6.170329e-17
C1002 eeg_fd_ota_full2_nc_0/eeg_bias_gen_0/m1_3701_n29089# eeg_fd_ota_full2_nc_0/eeg_bias_gen_0/m1_4369_n20245# 6.214540e-17
C1003 eeg_fd_ota_full2_nc_0/eeg_bias_gen_0/m1_3701_n29089# eeg_fd_ota_full2_nc_0/eeg_bias_gen_0/m1_4487_n29089# 6.212270e-17
C1007 eeg_fd_ota_full2_nc_0/eeg_bias_gen_0/m1_3941_n27552# VSS 4.214000e-16
C1009 eeg_fd_ota_full2_nc_0/eeg_bias_gen_0/m1_3941_n27552# eeg_fd_ota_full2_nc_0/eeg_bias_gen_0/m1_4797_n27552# 6.207720e-17
C1010 eeg_fd_ota_full2_nc_0/eeg_bias_gen_0/m1_3941_n45240# VSS 4.917160e-16
C1011 eeg_fd_ota_full2_nc_0/eeg_bias_gen_0/m1_3941_n45240# eeg_fd_ota_full2_nc_0/eeg_bias_gen_0/m1_4797_n45240# 6.207720e-17
C1012 eeg_fd_ota_full2_nc_0/eeg_bias_gen_0/m1_3941_n9864# VSS 4.214000e-16
C1014 eeg_fd_ota_full2_nc_0/eeg_bias_gen_0/m1_3941_n9864# eeg_fd_ota_full2_nc_0/eeg_bias_gen_0/m1_4797_n9864# 6.207712e-17
C1015 eeg_fd_ota_full2_nc_0/eeg_bias_gen_0/m1_4059_n18708# VSS 3.470960e-16
C1017 eeg_fd_ota_full2_nc_0/eeg_bias_gen_0/m1_4059_n18708# eeg_fd_ota_full2_nc_0/eeg_bias_gen_0/m1_4915_n18708# 6.207710e-17
C1018 eeg_fd_ota_full2_nc_0/eeg_bias_gen_0/m1_4059_n36396# VSS 3.470960e-16
C1020 eeg_fd_ota_full2_nc_0/eeg_bias_gen_0/m1_4059_n36396# eeg_fd_ota_full2_nc_0/eeg_bias_gen_0/m1_4915_n36396# 6.207718e-17
C1021 eeg_fd_ota_full2_nc_0/eeg_bias_gen_0/m1_4369_n20245# VSS 4.429720e-16
C1023 eeg_fd_ota_full2_nc_0/eeg_bias_gen_0/m1_4369_n20245# eeg_fd_ota_full2_nc_0/eeg_bias_gen_0/m1_5225_n20245# 6.207710e-17
C1024 eeg_fd_ota_full2_nc_0/eeg_bias_gen_0/m1_4369_n2557# VSS 4.429720e-16
C1025 eeg_fd_ota_full2_nc_0/eeg_bias_gen_0/m1_4369_n2557# eeg_fd_ota_full2_nc_0/eeg_bias_gen_0/m1_5225_n2557# 6.207710e-17
C1026 eeg_fd_ota_full2_nc_0/eeg_bias_gen_0/m1_4369_n37933# VSS 4.842880e-16
C1028 eeg_fd_ota_full2_nc_0/eeg_bias_gen_0/m1_4369_n37933# eeg_fd_ota_full2_nc_0/eeg_bias_gen_0/m1_5225_n37933# 6.207710e-17
C1029 eeg_fd_ota_full2_nc_0/eeg_bias_gen_0/m1_4487_n11401# VSS 3.070650e-16
C1031 eeg_fd_ota_full2_nc_0/eeg_bias_gen_0/m1_4487_n11401# eeg_fd_ota_full2_nc_0/eeg_bias_gen_0/m1_5343_n11401# 6.207714e-17
C1032 eeg_fd_ota_full2_nc_0/eeg_bias_gen_0/m1_4487_n29089# VSS 3.070650e-16
C1034 eeg_fd_ota_full2_nc_0/eeg_bias_gen_0/m1_4487_n29089# eeg_fd_ota_full2_nc_0/eeg_bias_gen_0/m1_5343_n29089# 6.207710e-17
C1035 eeg_fd_ota_full2_nc_0/eeg_bias_gen_0/m1_4797_n27552# VSS 4.429720e-16
C1037 eeg_fd_ota_full2_nc_0/eeg_bias_gen_0/m1_4797_n27552# eeg_fd_ota_full2_nc_0/eeg_bias_gen_0/m1_5653_n27552# 6.207710e-17
C1038 eeg_fd_ota_full2_nc_0/eeg_bias_gen_0/m1_4797_n45240# VSS 4.429720e-16
C1039 eeg_fd_ota_full2_nc_0/eeg_bias_gen_0/m1_4797_n45240# eeg_fd_ota_full2_nc_0/eeg_bias_gen_0/m1_5653_n45240# 6.207710e-17
C1040 eeg_fd_ota_full2_nc_0/eeg_bias_gen_0/m1_4797_n9864# VSS 4.429720e-16
C1042 eeg_fd_ota_full2_nc_0/eeg_bias_gen_0/m1_4797_n9864# eeg_fd_ota_full2_nc_0/eeg_bias_gen_0/m1_5653_n9864# 6.207710e-17
C1043 eeg_fd_ota_full2_nc_0/eeg_bias_gen_0/m1_4915_n18708# VSS 3.135120e-16
C1045 eeg_fd_ota_full2_nc_0/eeg_bias_gen_0/m1_4915_n18708# eeg_fd_ota_full2_nc_0/eeg_bias_gen_0/m1_5771_n18708# 6.207710e-17
C1046 eeg_fd_ota_full2_nc_0/eeg_bias_gen_0/m1_4915_n36396# VSS 3.135120e-16
C1048 eeg_fd_ota_full2_nc_0/eeg_bias_gen_0/m1_4915_n36396# eeg_fd_ota_full2_nc_0/eeg_bias_gen_0/m1_5771_n36396# 6.207720e-17
C1049 eeg_fd_ota_full2_nc_0/eeg_bias_gen_0/m1_5225_n20245# VSS 4.429720e-16
C1051 eeg_fd_ota_full2_nc_0/eeg_bias_gen_0/m1_5225_n20245# eeg_fd_ota_full2_nc_0/eeg_bias_gen_0/m1_6081_n20245# 6.207710e-17
C1052 eeg_fd_ota_full2_nc_0/eeg_bias_gen_0/m1_5225_n2557# VSS 4.429720e-16
C1053 eeg_fd_ota_full2_nc_0/eeg_bias_gen_0/m1_5225_n2557# eeg_fd_ota_full2_nc_0/eeg_bias_gen_0/m1_6081_n2557# 6.207710e-17
C1054 eeg_fd_ota_full2_nc_0/eeg_bias_gen_0/m1_5225_n37933# VSS 4.429720e-16
C1056 eeg_fd_ota_full2_nc_0/eeg_bias_gen_0/m1_5225_n37933# eeg_fd_ota_full2_nc_0/eeg_bias_gen_0/m1_6081_n37933# 6.207710e-17
C1057 eeg_fd_ota_full2_nc_0/eeg_bias_gen_0/m1_5343_n11401# VSS 3.135120e-16
C1059 eeg_fd_ota_full2_nc_0/eeg_bias_gen_0/m1_5343_n11401# eeg_fd_ota_full2_nc_0/eeg_bias_gen_0/m1_6199_n11401# 6.207719e-17
C1060 eeg_fd_ota_full2_nc_0/eeg_bias_gen_0/m1_5343_n29089# VSS 3.135120e-16
C1062 eeg_fd_ota_full2_nc_0/eeg_bias_gen_0/m1_5343_n29089# eeg_fd_ota_full2_nc_0/eeg_bias_gen_0/m1_6199_n29089# 6.207717e-17
C1063 eeg_fd_ota_full2_nc_0/eeg_bias_gen_0/m1_5653_n27552# VSS 4.429720e-16
C1065 eeg_fd_ota_full2_nc_0/eeg_bias_gen_0/m1_5653_n27552# eeg_fd_ota_full2_nc_0/eeg_bias_gen_0/m1_6509_n27552# 6.207710e-17
C1066 eeg_fd_ota_full2_nc_0/eeg_bias_gen_0/m1_5653_n45240# VSS 4.429720e-16
C1067 eeg_fd_ota_full2_nc_0/eeg_bias_gen_0/m1_5653_n45240# eeg_fd_ota_full2_nc_0/eeg_bias_gen_0/m1_6509_n45240# 6.207710e-17
C1068 eeg_fd_ota_full2_nc_0/eeg_bias_gen_0/m1_5653_n9864# VSS 4.429720e-16
C1070 eeg_fd_ota_full2_nc_0/eeg_bias_gen_0/m1_5653_n9864# eeg_fd_ota_full2_nc_0/eeg_bias_gen_0/m1_6509_n9864# 6.207710e-17
C1071 eeg_fd_ota_full2_nc_0/eeg_bias_gen_0/m1_5771_n18708# VSS 3.135120e-16
C1073 eeg_fd_ota_full2_nc_0/eeg_bias_gen_0/m1_5771_n18708# eeg_fd_ota_full2_nc_0/eeg_bias_gen_0/m1_6627_n18708# 6.207717e-17
C1074 eeg_fd_ota_full2_nc_0/eeg_bias_gen_0/m1_5771_n36396# VSS 3.135120e-16
C1076 eeg_fd_ota_full2_nc_0/eeg_bias_gen_0/m1_5771_n36396# eeg_fd_ota_full2_nc_0/eeg_bias_gen_0/m1_6627_n36396# 6.207717e-17
C1077 eeg_fd_ota_full2_nc_0/eeg_bias_gen_0/m1_6081_n20245# VSS 4.429720e-16
C1079 eeg_fd_ota_full2_nc_0/eeg_bias_gen_0/m1_6081_n20245# eeg_fd_ota_full2_nc_0/eeg_bias_gen_0/m1_6937_n20245# 6.207710e-17
C1080 eeg_fd_ota_full2_nc_0/eeg_bias_gen_0/m1_6081_n2557# VSS 4.429720e-16
C1081 eeg_fd_ota_full2_nc_0/eeg_bias_gen_0/m1_6081_n2557# eeg_fd_ota_full2_nc_0/eeg_bias_gen_0/m1_6937_n2557# 6.207710e-17
C1082 eeg_fd_ota_full2_nc_0/eeg_bias_gen_0/m1_6081_n37933# VSS 4.429720e-16
C1084 eeg_fd_ota_full2_nc_0/eeg_bias_gen_0/m1_6081_n37933# eeg_fd_ota_full2_nc_0/eeg_bias_gen_0/m1_6937_n37933# 6.207710e-17
C1085 eeg_fd_ota_full2_nc_0/eeg_bias_gen_0/m1_6199_n11401# VSS 3.135120e-16
C1087 eeg_fd_ota_full2_nc_0/eeg_bias_gen_0/m1_6199_n11401# eeg_fd_ota_full2_nc_0/eeg_bias_gen_0/m1_7055_n11401# 6.207714e-17
C1088 eeg_fd_ota_full2_nc_0/eeg_bias_gen_0/m1_6199_n29089# VSS 3.135120e-16
C1090 eeg_fd_ota_full2_nc_0/eeg_bias_gen_0/m1_6199_n29089# eeg_fd_ota_full2_nc_0/eeg_bias_gen_0/m1_7055_n29089# 6.207710e-17
C1091 eeg_fd_ota_full2_nc_0/eeg_bias_gen_0/m1_6509_n27552# VSS 4.429720e-16
C1093 eeg_fd_ota_full2_nc_0/eeg_bias_gen_0/m1_6509_n27552# eeg_fd_ota_full2_nc_0/eeg_bias_gen_0/m1_7365_n27552# 6.207710e-17
C1094 eeg_fd_ota_full2_nc_0/eeg_bias_gen_0/m1_6509_n45240# VSS 4.429720e-16
C1095 eeg_fd_ota_full2_nc_0/eeg_bias_gen_0/m1_6509_n45240# eeg_fd_ota_full2_nc_0/eeg_bias_gen_0/m1_7365_n45240# 6.207710e-17
C1096 eeg_fd_ota_full2_nc_0/eeg_bias_gen_0/m1_6509_n9864# VSS 4.429720e-16
C1098 eeg_fd_ota_full2_nc_0/eeg_bias_gen_0/m1_6509_n9864# eeg_fd_ota_full2_nc_0/eeg_bias_gen_0/m1_7365_n9864# 6.207710e-17
C1099 eeg_fd_ota_full2_nc_0/eeg_bias_gen_0/m1_6627_n18708# VSS 3.135120e-16
C1101 eeg_fd_ota_full2_nc_0/eeg_bias_gen_0/m1_6627_n18708# eeg_fd_ota_full2_nc_0/eeg_bias_gen_0/m1_7483_n18708# 6.207710e-17
C1102 eeg_fd_ota_full2_nc_0/eeg_bias_gen_0/m1_6627_n36396# VSS 3.135120e-16
C1104 eeg_fd_ota_full2_nc_0/eeg_bias_gen_0/m1_6627_n36396# eeg_fd_ota_full2_nc_0/eeg_bias_gen_0/m1_7483_n36396# 6.207720e-17
C1105 eeg_fd_ota_full2_nc_0/eeg_bias_gen_0/m1_6937_n20245# VSS 4.429720e-16
C1107 eeg_fd_ota_full2_nc_0/eeg_bias_gen_0/m1_6937_n20245# eeg_fd_ota_full2_nc_0/eeg_bias_gen_0/m1_7793_n20245# 6.207720e-17
C1108 eeg_fd_ota_full2_nc_0/eeg_bias_gen_0/m1_6937_n2557# VSS 4.429720e-16
C1109 eeg_fd_ota_full2_nc_0/eeg_bias_gen_0/m1_6937_n2557# eeg_fd_ota_full2_nc_0/eeg_bias_gen_0/m1_7793_n2557# 6.207720e-17
C1110 eeg_fd_ota_full2_nc_0/eeg_bias_gen_0/m1_6937_n37933# VSS 4.429720e-16
C1112 eeg_fd_ota_full2_nc_0/eeg_bias_gen_0/m1_6937_n37933# eeg_fd_ota_full2_nc_0/eeg_bias_gen_0/m1_7793_n37933# 6.207720e-17
C1113 eeg_fd_ota_full2_nc_0/eeg_bias_gen_0/m1_7055_n11401# VSS 3.135120e-16
C1115 eeg_fd_ota_full2_nc_0/eeg_bias_gen_0/m1_7055_n11401# eeg_fd_ota_full2_nc_0/eeg_bias_gen_0/m1_7911_n11401# 6.207714e-17
C1116 eeg_fd_ota_full2_nc_0/eeg_bias_gen_0/m1_7055_n29089# VSS 3.135120e-16
C1118 eeg_fd_ota_full2_nc_0/eeg_bias_gen_0/m1_7055_n29089# eeg_fd_ota_full2_nc_0/eeg_bias_gen_0/m1_7911_n29089# 6.207710e-17
C1119 eeg_fd_ota_full2_nc_0/eeg_bias_gen_0/m1_7365_n27552# VSS 4.429720e-16
C1121 eeg_fd_ota_full2_nc_0/eeg_bias_gen_0/m1_7365_n27552# eeg_fd_ota_full2_nc_0/eeg_bias_gen_0/m1_8221_n27552# 6.207710e-17
C1122 eeg_fd_ota_full2_nc_0/eeg_bias_gen_0/m1_7365_n45240# VSS 4.429720e-16
C1123 eeg_fd_ota_full2_nc_0/eeg_bias_gen_0/m1_7365_n45240# eeg_fd_ota_full2_nc_0/eeg_bias_gen_0/m1_8221_n45240# 6.207710e-17
C1124 eeg_fd_ota_full2_nc_0/eeg_bias_gen_0/m1_7365_n9864# VSS 4.429720e-16
C1126 eeg_fd_ota_full2_nc_0/eeg_bias_gen_0/m1_7365_n9864# eeg_fd_ota_full2_nc_0/eeg_bias_gen_0/m1_8221_n9864# 6.207710e-17
C1127 eeg_fd_ota_full2_nc_0/eeg_bias_gen_0/m1_7483_n18708# VSS 3.135120e-16
C1129 eeg_fd_ota_full2_nc_0/eeg_bias_gen_0/m1_7483_n18708# eeg_fd_ota_full2_nc_0/eeg_bias_gen_0/m1_8339_n18708# 6.207710e-17
C1130 eeg_fd_ota_full2_nc_0/eeg_bias_gen_0/m1_7483_n36396# VSS 3.135120e-16
C1132 eeg_fd_ota_full2_nc_0/eeg_bias_gen_0/m1_7483_n36396# eeg_fd_ota_full2_nc_0/eeg_bias_gen_0/m1_8339_n36396# 6.207720e-17
C1133 eeg_fd_ota_full2_nc_0/eeg_bias_gen_0/m1_7793_n20245# VSS 4.429720e-16
C1135 eeg_fd_ota_full2_nc_0/eeg_bias_gen_0/m1_7793_n20245# eeg_fd_ota_full2_nc_0/eeg_bias_gen_0/m1_8649_n20245# 6.207710e-17
C1136 eeg_fd_ota_full2_nc_0/eeg_bias_gen_0/m1_7793_n2557# VSS 4.429720e-16
C1137 eeg_fd_ota_full2_nc_0/eeg_bias_gen_0/m1_7793_n2557# eeg_fd_ota_full2_nc_0/eeg_bias_gen_0/m1_8649_n2557# 6.207710e-17
C1138 eeg_fd_ota_full2_nc_0/eeg_bias_gen_0/m1_7793_n37933# VSS 4.429720e-16
C1140 eeg_fd_ota_full2_nc_0/eeg_bias_gen_0/m1_7793_n37933# eeg_fd_ota_full2_nc_0/eeg_bias_gen_0/m1_8649_n37933# 6.207710e-17
C1141 eeg_fd_ota_full2_nc_0/eeg_bias_gen_0/m1_7911_n11401# VSS 3.135120e-16
C1143 eeg_fd_ota_full2_nc_0/eeg_bias_gen_0/m1_7911_n11401# eeg_fd_ota_full2_nc_0/eeg_bias_gen_0/m1_8767_n11401# 6.207714e-17
C1144 eeg_fd_ota_full2_nc_0/eeg_bias_gen_0/m1_7911_n29089# VSS 3.135120e-16
C1146 eeg_fd_ota_full2_nc_0/eeg_bias_gen_0/m1_7911_n29089# eeg_fd_ota_full2_nc_0/eeg_bias_gen_0/m1_8767_n29089# 6.207710e-17
C1147 eeg_fd_ota_full2_nc_0/eeg_bias_gen_0/m1_8221_n27552# VSS 4.429720e-16
C1149 eeg_fd_ota_full2_nc_0/eeg_bias_gen_0/m1_8221_n27552# eeg_fd_ota_full2_nc_0/eeg_bias_gen_0/m1_9077_n27552# 6.207720e-17
C1150 eeg_fd_ota_full2_nc_0/eeg_bias_gen_0/m1_8221_n45240# VSS 4.429720e-16
C1151 eeg_fd_ota_full2_nc_0/eeg_bias_gen_0/m1_8221_n45240# eeg_fd_ota_full2_nc_0/eeg_bias_gen_0/m1_9077_n45240# 6.207720e-17
C1152 eeg_fd_ota_full2_nc_0/eeg_bias_gen_0/m1_8221_n9864# VSS 4.429720e-16
C1154 eeg_fd_ota_full2_nc_0/eeg_bias_gen_0/m1_8221_n9864# eeg_fd_ota_full2_nc_0/eeg_bias_gen_0/m1_9077_n9864# 6.207712e-17
C1155 eeg_fd_ota_full2_nc_0/eeg_bias_gen_0/m1_8339_n18708# VSS 3.135120e-16
C1157 eeg_fd_ota_full2_nc_0/eeg_bias_gen_0/m1_8339_n18708# eeg_fd_ota_full2_nc_0/eeg_bias_gen_0/m1_9195_n18708# 6.207710e-17
C1158 eeg_fd_ota_full2_nc_0/eeg_bias_gen_0/m1_8339_n36396# VSS 3.135120e-16
C1160 eeg_fd_ota_full2_nc_0/eeg_bias_gen_0/m1_8339_n36396# eeg_fd_ota_full2_nc_0/eeg_bias_gen_0/m1_9195_n36396# 6.207718e-17
C1161 eeg_fd_ota_full2_nc_0/eeg_bias_gen_0/m1_8649_n20245# VSS 4.429720e-16
C1163 eeg_fd_ota_full2_nc_0/eeg_bias_gen_0/m1_8649_n20245# eeg_fd_ota_full2_nc_0/eeg_bias_gen_0/m1_9505_n20245# 6.207710e-17
C1164 eeg_fd_ota_full2_nc_0/eeg_bias_gen_0/m1_8649_n2557# VSS 4.429720e-16
C1165 eeg_fd_ota_full2_nc_0/eeg_bias_gen_0/m1_8649_n2557# eeg_fd_ota_full2_nc_0/eeg_bias_gen_0/m1_9505_n2557# 6.207710e-17
C1166 eeg_fd_ota_full2_nc_0/eeg_bias_gen_0/m1_8649_n37933# VSS 4.429720e-16
C1168 eeg_fd_ota_full2_nc_0/eeg_bias_gen_0/m1_8649_n37933# eeg_fd_ota_full2_nc_0/eeg_bias_gen_0/m1_9505_n37933# 6.207710e-17
C1169 eeg_fd_ota_full2_nc_0/eeg_bias_gen_0/m1_8767_n11401# VSS 3.135120e-16
C1171 eeg_fd_ota_full2_nc_0/eeg_bias_gen_0/m1_8767_n11401# eeg_fd_ota_full2_nc_0/eeg_bias_gen_0/m1_9623_n11401# 6.207714e-17
C1172 eeg_fd_ota_full2_nc_0/eeg_bias_gen_0/m1_8767_n29089# VSS 3.135120e-16
C1174 eeg_fd_ota_full2_nc_0/eeg_bias_gen_0/m1_8767_n29089# eeg_fd_ota_full2_nc_0/eeg_bias_gen_0/m1_9623_n29089# 6.207710e-17
C1175 eeg_fd_ota_full2_nc_0/eeg_bias_gen_0/m1_9077_n27552# VSS 4.429720e-16
C1177 eeg_fd_ota_full2_nc_0/eeg_bias_gen_0/m1_9077_n27552# eeg_fd_ota_full2_nc_0/eeg_bias_gen_0/m1_9933_n27552# 6.207710e-17
C1178 eeg_fd_ota_full2_nc_0/eeg_bias_gen_0/m1_9077_n45240# VSS 4.429720e-16
C1179 eeg_fd_ota_full2_nc_0/eeg_bias_gen_0/m1_9077_n45240# eeg_fd_ota_full2_nc_0/eeg_bias_gen_0/m1_9933_n45240# 6.207710e-17
C1180 eeg_fd_ota_full2_nc_0/eeg_bias_gen_0/m1_9077_n9864# VSS 4.429720e-16
C1182 eeg_fd_ota_full2_nc_0/eeg_bias_gen_0/m1_9077_n9864# eeg_fd_ota_full2_nc_0/eeg_bias_gen_0/m1_9933_n9864# 6.207710e-17
C1183 eeg_fd_ota_full2_nc_0/eeg_bias_gen_0/m1_9195_n18708# VSS 3.135120e-16
C1185 eeg_fd_ota_full2_nc_0/eeg_bias_gen_0/m1_9195_n36396# VSS 3.135120e-16
C1187 eeg_fd_ota_full2_nc_0/eeg_bias_gen_0/m1_9505_n20245# VSS 4.429720e-16
C1188 eeg_fd_ota_full2_nc_0/eeg_bias_gen_0/m1_9505_n2557# VSS 4.429720e-16
C1189 eeg_fd_ota_full2_nc_0/eeg_bias_gen_0/m1_9505_n37933# VSS 4.429720e-16
C1190 eeg_fd_ota_full2_nc_0/eeg_bias_gen_0/m1_9623_n11401# VSS 3.135120e-16
C1192 eeg_fd_ota_full2_nc_0/eeg_bias_gen_0/m1_9623_n29089# VSS 3.135120e-16
C1194 eeg_fd_ota_full2_nc_0/eeg_bias_gen_0/m1_9933_n27552# VSS 4.429720e-16
C1195 eeg_fd_ota_full2_nc_0/eeg_bias_gen_0/m1_9933_n45240# VSS 4.429720e-16
C1196 eeg_fd_ota_full2_nc_0/eeg_bias_gen_0/m1_9933_n9864# VSS 4.429720e-16
C1197 VDD18 VSS 1.198063e-14
C1198 VDD18 eeg_fd_ota_full2_nc_0/eeg_bias_gen_0/VBN 2.562736e-16
C1199 VDD18 eeg_fd_ota_full2_nc_0/eeg_bias_gen_0/VBP 2.977050e-15
C1200 eeg_fd_ota_full2_nc_0/eeg_bias_gen_0/VBN eeg_fd_ota_full2_nc_0/eeg_bias_gen_0/VBP 6.762340e-16
C1201 eeg_fd_ota_full2_nc_0/eeg_bias_gen_0/VBP VSS 6.072420e-16
C1202 eeg_fd_ota_full2_nc_0/eeg_bias_gen_0/m1_6509_n27552# VSS 6.746650e-16
C1203 eeg_fd_ota_full2_nc_0/eeg_bias_gen_0/m1_6937_n20245# VSS 6.746650e-16
C1204 VDD18 VSS 8.414800e-16
C1205 VDD18 eeg_fd_ota_full2_nc_0/eeg_bias_gen_0/VBN 8.460309e-16
C1206 VDD18 eeg_fd_ota_full2_nc_0/eeg_bias_gen_0/eeg_pseudo_res_0/m1_68_66# 1.314672e-15
C1207 eeg_fd_ota_full2_nc_0/eeg_bias_gen_0/VBN VSS 1.699680e-15
C1208 eeg_fd_ota_full2_nc_0/eeg_bias_gen_0/VBN eeg_fd_ota_full2_nc_0/eeg_bias_gen_0/eeg_pseudo_res_0/m1_68_66# 5.017998e-16
C1209 eeg_fd_ota_full2_nc_0/eeg_bias_gen_0/eeg_pseudo_res_0/m1_68_66# VSS 3.582030e-15
C1210 eeg_fd_ota_full2_nc_0/eeg_bias_gen_0/VBN VSS 3.678650e-15
C1211 eeg_fd_ota_full2_nc_0/eeg_bias_gen_0/VBN eeg_fd_ota_full2_nc_0/eeg_bias_gen_0/eeg_pseudo_res_0/m1_68_66# 1.322042e-15
C1212 eeg_fd_ota_full2_nc_0/eeg_bias_gen_0/eeg_pseudo_res_0/m1_68_66# VSS 4.103261e-16
C1213 VDD18 VSS 3.678650e-15
C1214 VDD18 eeg_fd_ota_full2_nc_0/eeg_bias_gen_0/eeg_pseudo_res_0/m1_68_66# 1.322042e-15
C1215 eeg_fd_ota_full2_nc_0/eeg_bias_gen_0/eeg_pseudo_res_0/m1_68_66# VSS 4.103261e-16
C1216 eeg_fd_ota_full2_nc_0/eeg_bias_gen_0/m1_11763_n36396# VSS 6.746650e-16
C1217 eeg_fd_ota_full2_nc_0/eeg_bias_gen_0/m1_12073_n37933# VSS 6.746650e-16
C1218 VSS eeg_fd_ota_full2_nc_0/eeg_bias_gen_0/VBN 8.327656e-16
C1219 eeg_fd_ota_full2_nc_0/eeg_bias_gen_0/VBN VSS 2.737979e-15
C1220 eeg_fd_ota_full2_nc_0/eeg_bias_gen_0/m1_6081_n20245# VSS 6.746650e-16
C1221 eeg_fd_ota_full2_nc_0/eeg_bias_gen_0/m1_6509_n27552# VSS 6.746650e-16
C1222 eeg_fd_ota_full2_nc_0/eeg_bias_gen_0/m1_10789_n27552# VSS 6.746650e-16
C1223 eeg_fd_ota_full2_nc_0/eeg_bias_gen_0/m1_11217_n20245# VSS 6.746650e-16
C1224 eeg_fd_ota_full2_nc_0/eeg_bias_gen_0/m1_2552_466# VSS 6.747650e-16
C1225 eeg_fd_ota_full2_nc_0/eeg_bias_gen_0/m1_11645_n45240# VSS 6.746650e-16
C1226 eeg_fd_ota_full2_nc_0/eeg_bias_gen_0/m1_12073_n37933# VSS 6.746650e-16
C1227 eeg_fd_ota_full2_nc_0/eeg_bias_gen_0/m1_10789_n9864# VSS 6.746650e-16
C1228 eeg_fd_ota_full2_nc_0/eeg_bias_gen_0/m1_11217_n2557# VSS 6.746650e-16
C1229 eeg_fd_ota_full2_nc_0/eeg_bias_gen_0/m1_11217_n37933# VSS 6.746650e-16
C1230 eeg_fd_ota_full2_nc_0/eeg_bias_gen_0/m1_11645_n45240# VSS 6.746650e-16
C1231 eeg_fd_ota_full2_nc_0/eeg_bias_gen_0/m1_5653_n27552# VSS 6.746650e-16
C1232 eeg_fd_ota_full2_nc_0/eeg_bias_gen_0/m1_6081_n20245# VSS 6.746650e-16
C1233 eeg_fd_ota_full2_nc_0/eeg_bias_gen_0/m1_10361_n20245# VSS 6.746650e-16
C1234 eeg_fd_ota_full2_nc_0/eeg_bias_gen_0/m1_10789_n27552# VSS 6.746650e-16
C1235 eeg_fd_ota_full2_nc_0/eeg_bias_gen_0/m1_5225_n20245# VSS 6.746650e-16
C1236 eeg_fd_ota_full2_nc_0/eeg_bias_gen_0/m1_5653_n27552# VSS 6.746650e-16
C1237 eeg_fd_ota_full2_nc_0/eeg_bias_gen_0/m1_10361_n20245# VSS 6.746650e-16
C1238 eeg_fd_ota_full2_nc_0/eeg_bias_gen_0/m1_9933_n27552# VSS 6.746650e-16
C1239 eeg_fd_ota_full2_nc_0/eeg_bias_gen_0/m1_4915_n18708# VSS 6.746650e-16
C1240 eeg_fd_ota_full2_nc_0/eeg_bias_gen_0/m1_5343_n11401# VSS 6.746650e-16
C1241 eeg_fd_ota_full2_nc_0/eeg_bias_gen_0/m1_10361_n2557# VSS 6.746650e-16
C1242 eeg_fd_ota_full2_nc_0/eeg_bias_gen_0/m1_10789_n9864# VSS 6.746650e-16
C1243 eeg_fd_ota_full2_nc_0/eeg_bias_gen_0/m1_10789_n45240# VSS 6.746650e-16
C1244 eeg_fd_ota_full2_nc_0/eeg_bias_gen_0/m1_11217_n37933# VSS 6.746650e-16
C1245 eeg_fd_ota_full2_nc_0/eeg_bias_gen_0/m1_4797_n27552# VSS 6.746650e-16
C1246 eeg_fd_ota_full2_nc_0/eeg_bias_gen_0/m1_5225_n20245# VSS 6.746650e-16
C1247 eeg_fd_ota_full2_nc_0/eeg_bias_gen_0/m1_9505_n20245# VSS 6.746650e-16
C1248 eeg_fd_ota_full2_nc_0/eeg_bias_gen_0/m1_9933_n27552# VSS 6.746650e-16
C1249 eeg_fd_ota_full2_nc_0/eeg_bias_gen_0/m1_5343_n11401# VSS 6.746650e-16
C1250 eeg_fd_ota_full2_nc_0/eeg_bias_gen_0/m1_5771_n18708# VSS 6.746650e-16
C1251 eeg_fd_ota_full2_nc_0/eeg_bias_gen_0/m1_10479_n11401# VSS 6.746650e-16
C1252 eeg_fd_ota_full2_nc_0/eeg_bias_gen_0/m1_10907_n18708# VSS 6.746650e-16
C1253 eeg_fd_ota_full2_nc_0/eeg_bias_gen_0/m1_6081_n2557# VSS 6.746650e-16
C1254 eeg_fd_ota_full2_nc_0/eeg_bias_gen_0/m1_6509_n9864# VSS 6.746650e-16
C1255 eeg_fd_ota_full2_nc_0/eeg_bias_gen_0/m1_10361_n37933# VSS 6.746650e-16
C1256 eeg_fd_ota_full2_nc_0/eeg_bias_gen_0/m1_10789_n45240# VSS 6.746650e-16
C1257 eeg_fd_ota_full2_nc_0/eeg_bias_gen_0/m1_4369_n20245# VSS 6.746650e-16
C1258 eeg_fd_ota_full2_nc_0/eeg_bias_gen_0/m1_4797_n27552# VSS 6.746650e-16
C1259 eeg_fd_ota_full2_nc_0/eeg_bias_gen_0/m1_9077_n27552# VSS 6.746650e-16
C1260 eeg_fd_ota_full2_nc_0/eeg_bias_gen_0/m1_9505_n20245# VSS 6.746650e-16
C1261 eeg_fd_ota_full2_nc_0/eeg_bias_gen_0/m1_5771_n18708# VSS 6.746650e-16
C1262 eeg_fd_ota_full2_nc_0/eeg_bias_gen_0/m1_6199_n11401# VSS 6.746650e-16
C1263 eeg_fd_ota_full2_nc_0/eeg_bias_gen_0/m1_9195_n18708# VSS 6.746650e-16
C1264 eeg_fd_ota_full2_nc_0/eeg_bias_gen_0/m1_9623_n11401# VSS 6.746650e-16
C1265 eeg_fd_ota_full2_nc_0/eeg_bias_gen_0/m1_10907_n18708# VSS 6.746650e-16
C1266 eeg_fd_ota_full2_nc_0/eeg_bias_gen_0/m1_11335_n11401# VSS 6.746650e-16
C1267 eeg_fd_ota_full2_nc_0/eeg_bias_gen_0/m1_5653_n9864# VSS 6.746650e-16
C1268 eeg_fd_ota_full2_nc_0/eeg_bias_gen_0/m1_6081_n2557# VSS 6.746650e-16
C1269 eeg_fd_ota_full2_nc_0/eeg_bias_gen_0/m1_10479_n29089# VSS 6.746650e-16
C1270 eeg_fd_ota_full2_nc_0/eeg_bias_gen_0/m1_10907_n36396# VSS 6.746650e-16
C1271 VDD18 VSS 1.198063e-14
C1272 VDD18 eeg_fd_ota_full2_nc_0/eeg_bias_gen_0/VBP 3.233324e-15
C1273 eeg_fd_ota_full2_nc_0/eeg_bias_gen_0/VBP VSS 6.072420e-16
C1274 eeg_fd_ota_full2_nc_0/eeg_bias_gen_0/m1_7793_n37933# VSS 6.746650e-16
C1275 eeg_fd_ota_full2_nc_0/eeg_bias_gen_0/m1_8221_n45240# VSS 6.746650e-16
C1276 eeg_fd_ota_full2_nc_0/eeg_bias_gen_0/m1_3941_n27552# VSS 6.746650e-16
C1277 eeg_fd_ota_full2_nc_0/eeg_bias_gen_0/m1_4369_n20245# VSS 6.746650e-16
C1278 eeg_fd_ota_full2_nc_0/eeg_bias_gen_0/m1_8649_n20245# VSS 6.746650e-16
C1279 eeg_fd_ota_full2_nc_0/eeg_bias_gen_0/m1_9077_n27552# VSS 6.746650e-16
C1280 eeg_fd_ota_full2_nc_0/eeg_bias_gen_0/m1_6199_n11401# VSS 6.746650e-16
C1281 eeg_fd_ota_full2_nc_0/eeg_bias_gen_0/m1_6627_n18708# VSS 6.746650e-16
C1282 eeg_fd_ota_full2_nc_0/eeg_bias_gen_0/m1_10051_n18708# VSS 6.746650e-16
C1283 eeg_fd_ota_full2_nc_0/eeg_bias_gen_0/m1_9623_n11401# VSS 6.746650e-16
C1284 eeg_fd_ota_full2_nc_0/eeg_bias_gen_0/m1_11335_n11401# VSS 6.746650e-16
C1285 eeg_fd_ota_full2_nc_0/eeg_bias_gen_0/m1_11763_n18708# VSS 6.746650e-16
C1286 eeg_fd_ota_full2_nc_0/eeg_bias_gen_0/m1_5225_n2557# VSS 6.746650e-16
C1287 eeg_fd_ota_full2_nc_0/eeg_bias_gen_0/m1_5653_n9864# VSS 6.746650e-16
C1288 eeg_fd_ota_full2_nc_0/eeg_bias_gen_0/m1_10907_n36396# VSS 6.746650e-16
C1289 eeg_fd_ota_full2_nc_0/eeg_bias_gen_0/m1_11335_n29089# VSS 6.746650e-16
C1290 eeg_fd_ota_full2_nc_0/eeg_bias_gen_0/m1_7365_n45240# VSS 6.746650e-16
C1291 eeg_fd_ota_full2_nc_0/eeg_bias_gen_0/m1_7793_n37933# VSS 6.746650e-16
C1292 eeg_fd_ota_full2_nc_0/eeg_bias_gen_0/m1_8339_n36396# VSS 6.746650e-16
C1293 eeg_fd_ota_full2_nc_0/eeg_bias_gen_0/m1_8767_n29089# VSS 6.746650e-16
C1294 eeg_fd_ota_full2_nc_0/eeg_bias_gen_0/m1_3701_n29089# VSS 6.746650e-16
C1295 eeg_fd_ota_full2_nc_0/eeg_bias_gen_0/m1_3941_n27552# VSS 6.746650e-16
C1296 eeg_fd_ota_full2_nc_0/eeg_bias_gen_0/m1_8221_n27552# VSS 6.746650e-16
C1297 eeg_fd_ota_full2_nc_0/eeg_bias_gen_0/m1_8649_n20245# VSS 6.746650e-16
C1298 eeg_fd_ota_full2_nc_0/eeg_bias_gen_0/m1_6627_n18708# VSS 6.746650e-16
C1299 eeg_fd_ota_full2_nc_0/eeg_bias_gen_0/m1_7055_n11401# VSS 6.746650e-16
C1300 eeg_fd_ota_full2_nc_0/eeg_bias_gen_0/m1_11763_n18708# VSS 6.746650e-16
C1301 eeg_fd_ota_full2_nc_0/eeg_bias_gen_0/m1_12073_n20245# VSS 6.746650e-16
C1302 eeg_fd_ota_full2_nc_0/eeg_bias_gen_0/m1_4797_n9864# VSS 6.746650e-16
C1303 eeg_fd_ota_full2_nc_0/eeg_bias_gen_0/m1_5225_n2557# VSS 6.746650e-16
C1304 eeg_fd_ota_full2_nc_0/eeg_bias_gen_0/m1_9505_n2557# VSS 6.746650e-16
C1305 eeg_fd_ota_full2_nc_0/eeg_bias_gen_0/m1_9933_n9864# VSS 6.746650e-16
C1306 eeg_fd_ota_full2_nc_0/eeg_bias_gen_0/m1_11335_n29089# VSS 6.746650e-16
C1307 eeg_fd_ota_full2_nc_0/eeg_bias_gen_0/m1_11763_n36396# VSS 6.746650e-16
C1308 eeg_fd_ota_full2_nc_0/eeg_bias_gen_0/m1_10361_n2557# VSS 6.746650e-16
C1309 eeg_fd_ota_full2_nc_0/eeg_bias_gen_0/m1_9933_n9864# VSS 6.746650e-16
C1310 eeg_fd_ota_full2_nc_0/eeg_bias_gen_0/m1_6937_n37933# VSS 6.746650e-16
C1311 eeg_fd_ota_full2_nc_0/eeg_bias_gen_0/m1_7365_n45240# VSS 6.746650e-16
C1312 eeg_fd_ota_full2_nc_0/eeg_bias_gen_0/m1_4059_n36396# VSS 6.746650e-16
C1313 eeg_fd_ota_full2_nc_0/eeg_bias_gen_0/m1_4487_n29089# VSS 6.746650e-16
C1314 eeg_fd_ota_full2_nc_0/eeg_bias_gen_0/m1_8767_n29089# VSS 6.746650e-16
C1315 eeg_fd_ota_full2_nc_0/eeg_bias_gen_0/m1_9195_n36396# VSS 6.746650e-16
C1316 eeg_fd_ota_full2_nc_0/eeg_bias_gen_0/m1_10051_n36396# VSS 6.746650e-16
C1317 eeg_fd_ota_full2_nc_0/eeg_bias_gen_0/m1_10479_n29089# VSS 6.746650e-16
C1318 eeg_fd_ota_full2_nc_0/eeg_bias_gen_0/m1_7793_n20245# VSS 6.746650e-16
C1319 eeg_fd_ota_full2_nc_0/eeg_bias_gen_0/m1_8221_n27552# VSS 6.746650e-16
C1320 eeg_fd_ota_full2_nc_0/eeg_bias_gen_0/m1_7055_n11401# VSS 6.746650e-16
C1321 eeg_fd_ota_full2_nc_0/eeg_bias_gen_0/m1_7483_n18708# VSS 6.746650e-16
C1322 eeg_fd_ota_full2_nc_0/eeg_bias_gen_0/m1_4369_n2557# VSS 6.746650e-16
C1323 eeg_fd_ota_full2_nc_0/eeg_bias_gen_0/m1_4797_n9864# VSS 6.746650e-16
C1324 eeg_fd_ota_full2_nc_0/eeg_bias_gen_0/m1_9077_n9864# VSS 6.746650e-16
C1325 eeg_fd_ota_full2_nc_0/eeg_bias_gen_0/m1_9505_n2557# VSS 6.746650e-16
C1326 eeg_fd_ota_full2_nc_0/eeg_bias_gen_0/m1_4369_n37933# VSS 6.746650e-16
C1327 eeg_fd_ota_full2_nc_0/eeg_bias_gen_0/m1_4797_n45240# VSS 6.746650e-16
C1328 eeg_fd_ota_full2_nc_0/eeg_bias_gen_0/m1_6509_n45240# VSS 6.746650e-16
C1329 eeg_fd_ota_full2_nc_0/eeg_bias_gen_0/m1_6937_n37933# VSS 6.746650e-16
C1330 eeg_fd_ota_full2_nc_0/eeg_bias_gen_0/m1_10361_n37933# VSS 6.746650e-16
C1331 eeg_fd_ota_full2_nc_0/eeg_bias_gen_0/m1_9933_n45240# VSS 6.746650e-16
C1332 eeg_fd_ota_full2_nc_0/eeg_bias_gen_0/m1_4487_n29089# VSS 6.746650e-16
C1333 eeg_fd_ota_full2_nc_0/eeg_bias_gen_0/m1_4915_n36396# VSS 6.746650e-16
C1334 eeg_fd_ota_full2_nc_0/eeg_bias_gen_0/m1_9195_n36396# VSS 6.746650e-16
C1335 eeg_fd_ota_full2_nc_0/eeg_bias_gen_0/m1_9623_n29089# VSS 6.746650e-16
C1336 eeg_fd_ota_full2_nc_0/eeg_bias_gen_0/m1_7365_n27552# VSS 6.746650e-16
C1337 eeg_fd_ota_full2_nc_0/eeg_bias_gen_0/m1_7793_n20245# VSS 6.746650e-16
C1338 eeg_fd_ota_full2_nc_0/eeg_bias_gen_0/m1_7483_n18708# VSS 6.746650e-16
C1339 eeg_fd_ota_full2_nc_0/eeg_bias_gen_0/m1_7911_n11401# VSS 6.746650e-16
C1340 eeg_fd_ota_full2_nc_0/eeg_bias_gen_0/m1_10051_n18708# VSS 6.746650e-16
C1341 eeg_fd_ota_full2_nc_0/eeg_bias_gen_0/m1_10479_n11401# VSS 6.746650e-16
C1342 eeg_fd_ota_full2_nc_0/eeg_bias_gen_0/m1_3941_n9864# VSS 6.746650e-16
C1343 eeg_fd_ota_full2_nc_0/eeg_bias_gen_0/m1_4369_n2557# VSS 6.746650e-16
C1344 eeg_fd_ota_full2_nc_0/eeg_bias_gen_0/m1_8649_n2557# VSS 6.746650e-16
C1345 eeg_fd_ota_full2_nc_0/eeg_bias_gen_0/m1_9077_n9864# VSS 6.746650e-16
C1346 eeg_fd_ota_full2_nc_0/eeg_bias_gen_0/m1_3701_n29089# VSS 6.746650e-16
C1347 eeg_fd_ota_full2_nc_0/eeg_bias_gen_0/m1_4059_n36396# VSS 6.746650e-16
C1348 eeg_fd_ota_full2_nc_0/eeg_bias_gen_0/m1_6081_n37933# VSS 6.746650e-16
C1349 eeg_fd_ota_full2_nc_0/eeg_bias_gen_0/m1_6509_n45240# VSS 6.746650e-16
C1350 eeg_fd_ota_full2_nc_0/eeg_bias_gen_0/m1_4915_n36396# VSS 6.746650e-16
C1351 eeg_fd_ota_full2_nc_0/eeg_bias_gen_0/m1_5343_n29089# VSS 6.746650e-16
C1352 eeg_fd_ota_full2_nc_0/eeg_bias_gen_0/m1_10051_n36396# VSS 6.746650e-16
C1353 eeg_fd_ota_full2_nc_0/eeg_bias_gen_0/m1_9623_n29089# VSS 6.746650e-16
C1354 eeg_fd_ota_full2_nc_0/eeg_bias_gen_0/m1_6937_n20245# VSS 6.746650e-16
C1355 eeg_fd_ota_full2_nc_0/eeg_bias_gen_0/m1_7365_n27552# VSS 6.746650e-16
C1356 eeg_fd_ota_full2_nc_0/eeg_bias_gen_0/m1_11645_n27552# VSS 6.746650e-16
C1357 eeg_fd_ota_full2_nc_0/eeg_bias_gen_0/m1_12073_n20245# VSS 6.746650e-16
C1358 eeg_fd_ota_full2_nc_0/eeg_bias_gen_0/m1_7911_n11401# VSS 6.746650e-16
C1359 eeg_fd_ota_full2_nc_0/eeg_bias_gen_0/m1_8339_n18708# VSS 6.746650e-16
C1360 eeg_fd_ota_full2_nc_0/eeg_bias_gen_0/m1_3701_n11401# VSS 6.746650e-16
C1361 eeg_fd_ota_full2_nc_0/eeg_bias_gen_0/m1_3941_n9864# VSS 6.746650e-16
C1362 eeg_fd_ota_full2_nc_0/eeg_bias_gen_0/m1_8221_n9864# VSS 6.746650e-16
C1363 eeg_fd_ota_full2_nc_0/eeg_bias_gen_0/m1_8649_n2557# VSS 6.746650e-16
C1364 eeg_fd_ota_full2_nc_0/eeg_bias_gen_0/VBNF VSS 6.746650e-16
C1365 eeg_fd_ota_full2_nc_0/eeg_bias_gen_0/m1_11645_n9864# VSS 6.746650e-16
C1366 eeg_fd_ota_full2_nc_0/eeg_bias_gen_0/m1_5653_n45240# VSS 6.746650e-16
C1367 eeg_fd_ota_full2_nc_0/eeg_bias_gen_0/m1_6081_n37933# VSS 6.746650e-16
C1368 eeg_fd_ota_full2_nc_0/eeg_bias_gen_0/m1_3941_n45240# VSS 6.746650e-16
C1369 eeg_fd_ota_full2_nc_0/eeg_bias_gen_0/m1_4369_n37933# VSS 6.746650e-16
C1370 eeg_fd_ota_full2_nc_0/eeg_bias_gen_0/m1_5343_n29089# VSS 6.746650e-16
C1371 eeg_fd_ota_full2_nc_0/eeg_bias_gen_0/m1_5771_n36396# VSS 6.746650e-16
C1372 eeg_fd_ota_full2_nc_0/eeg_bias_gen_0/m1_11217_n20245# VSS 6.746650e-16
C1373 eeg_fd_ota_full2_nc_0/eeg_bias_gen_0/m1_11645_n27552# VSS 6.746650e-16
C1374 eeg_fd_ota_full2_nc_0/eeg_bias_gen_0/m1_3701_n11401# VSS 6.746650e-16
C1375 eeg_fd_ota_full2_nc_0/eeg_bias_gen_0/m1_4059_n18708# VSS 6.746650e-16
C1376 eeg_fd_ota_full2_nc_0/eeg_bias_gen_0/m1_7793_n2557# VSS 6.746650e-16
C1377 eeg_fd_ota_full2_nc_0/eeg_bias_gen_0/m1_8221_n9864# VSS 6.746650e-16
C1378 eeg_fd_ota_full2_nc_0/eeg_bias_gen_0/m1_11217_n2557# VSS 6.746650e-16
C1379 eeg_fd_ota_full2_nc_0/eeg_bias_gen_0/m1_11645_n9864# VSS 6.746650e-16
C1380 eeg_fd_ota_full2_nc_0/eeg_bias_gen_0/m1_5225_n37933# VSS 6.746650e-16
C1381 eeg_fd_ota_full2_nc_0/eeg_bias_gen_0/m1_5653_n45240# VSS 6.746650e-16
C1382 eeg_fd_ota_full2_nc_0/eeg_bias_gen_0/VBN VSS 6.746650e-16
C1383 eeg_fd_ota_full2_nc_0/eeg_bias_gen_0/m1_3941_n45240# VSS 6.746650e-16
C1384 eeg_fd_ota_full2_nc_0/eeg_bias_gen_0/m1_5771_n36396# VSS 6.746650e-16
C1385 eeg_fd_ota_full2_nc_0/eeg_bias_gen_0/m1_6199_n29089# VSS 6.746650e-16
C1386 eeg_fd_ota_full2_nc_0/eeg_bias_gen_0/m1_4059_n18708# VSS 6.746650e-16
C1387 eeg_fd_ota_full2_nc_0/eeg_bias_gen_0/m1_4487_n11401# VSS 6.746650e-16
C1388 eeg_fd_ota_full2_nc_0/eeg_bias_gen_0/m1_7365_n9864# VSS 6.746650e-16
C1389 eeg_fd_ota_full2_nc_0/eeg_bias_gen_0/m1_7793_n2557# VSS 6.746650e-16
C1390 eeg_fd_ota_full2_nc_0/eeg_bias_gen_0/m1_4797_n45240# VSS 6.746650e-16
C1391 eeg_fd_ota_full2_nc_0/eeg_bias_gen_0/m1_5225_n37933# VSS 6.746650e-16
C1392 eeg_fd_ota_full2_nc_0/eeg_bias_gen_0/m1_9505_n37933# VSS 6.746650e-16
C1393 eeg_fd_ota_full2_nc_0/eeg_bias_gen_0/m1_9933_n45240# VSS 6.746650e-16
C1394 eeg_fd_ota_full2_nc_0/eeg_bias_gen_0/m1_6199_n29089# VSS 6.746650e-16
C1395 eeg_fd_ota_full2_nc_0/eeg_bias_gen_0/m1_6627_n36396# VSS 6.746650e-16
C1396 eeg_fd_ota_full2_nc_0/eeg_bias_gen_0/m1_4487_n11401# VSS 6.746650e-16
C1397 eeg_fd_ota_full2_nc_0/eeg_bias_gen_0/m1_4915_n18708# VSS 6.746650e-16
C1398 eeg_fd_ota_full2_nc_0/eeg_bias_gen_0/m1_6937_n2557# VSS 6.746650e-16
C1399 eeg_fd_ota_full2_nc_0/eeg_bias_gen_0/m1_7365_n9864# VSS 6.746650e-16
C1400 eeg_fd_ota_full2_nc_0/eeg_bias_gen_0/m1_9077_n45240# VSS 6.746650e-16
C1401 eeg_fd_ota_full2_nc_0/eeg_bias_gen_0/m1_9505_n37933# VSS 6.746650e-16
C1402 eeg_fd_ota_full2_nc_0/eeg_bias_gen_0/m1_6627_n36396# VSS 6.746650e-16
C1403 eeg_fd_ota_full2_nc_0/eeg_bias_gen_0/m1_7055_n29089# VSS 6.746650e-16
C1404 eeg_fd_ota_full2_nc_0/eeg_bias_gen_0/m1_8339_n18708# VSS 6.746650e-16
C1405 eeg_fd_ota_full2_nc_0/eeg_bias_gen_0/m1_8767_n11401# VSS 6.746650e-16
C1406 eeg_fd_ota_full2_nc_0/eeg_bias_gen_0/m1_6509_n9864# VSS 6.746650e-16
C1407 eeg_fd_ota_full2_nc_0/eeg_bias_gen_0/m1_6937_n2557# VSS 6.746650e-16
C1408 eeg_fd_ota_full2_nc_0/eeg_bias_gen_0/m1_8649_n37933# VSS 6.746650e-16
C1409 eeg_fd_ota_full2_nc_0/eeg_bias_gen_0/m1_9077_n45240# VSS 6.746650e-16
C1410 eeg_fd_ota_full2_nc_0/eeg_bias_gen_0/m1_7055_n29089# VSS 6.746650e-16
C1411 eeg_fd_ota_full2_nc_0/eeg_bias_gen_0/m1_7483_n36396# VSS 6.746650e-16
C1412 eeg_fd_ota_full2_nc_0/eeg_bias_gen_0/m1_8767_n11401# VSS 6.746650e-16
C1413 eeg_fd_ota_full2_nc_0/eeg_bias_gen_0/m1_9195_n18708# VSS 6.746650e-16
C1414 eeg_fd_ota_full2_nc_0/eeg_bias_gen_0/m1_8221_n45240# VSS 6.746650e-16
C1415 eeg_fd_ota_full2_nc_0/eeg_bias_gen_0/m1_8649_n37933# VSS 6.746650e-16
C1416 eeg_fd_ota_full2_nc_0/eeg_bias_gen_0/m1_7483_n36396# VSS 6.746650e-16
C1417 eeg_fd_ota_full2_nc_0/eeg_bias_gen_0/m1_7911_n29089# VSS 6.746650e-16
C1418 eeg_fd_ota_full2_nc_0/eeg_bias_gen_0/m1_7911_n29089# VSS 6.746650e-16
C1419 eeg_fd_ota_full2_nc_0/eeg_bias_gen_0/m1_8339_n36396# VSS 6.746650e-16
C1420 eeg_fd_ota_full2_nc_0/eeg_bias_gen_0/VBN VSS 1.059610e-14
C1421 eeg_fd_ota_full2_nc_0/eeg_bias_gen_0/VBN eeg_fd_ota_full2_nc_0/eeg_bias_gen_0/VBP 2.704936e-15
C1422 eeg_fd_ota_full2_nc_0/eeg_bias_gen_0/VBN eeg_fd_ota_full2_nc_0/eeg_bias_gen_0/m1_2552_466# 2.781792e-15
C1423 eeg_fd_ota_full2_nc_0/eeg_bias_gen_0/VBP VSS 1.199796e-16
C1424 eeg_fd_ota_full2_nc_0/eeg_bias_gen_0/VBP eeg_fd_ota_full2_nc_0/eeg_bias_gen_0/m1_2552_466# 3.225268e-16
C1425 eeg_fd_ota_full2_nc_0/eeg_bias_gen_0/m1_2552_466# VSS 9.907064e-16
C1427 VCM_REF VSS 6.276408e-16
C1428 VCM_REF eeg_fd_ota_full2_nc_0/eeg_bias_gen_0/VBNF 2.510694e-16
C1430 VCM_REF eeg_fd_ota_full2_nc_0/eeg_cmfb_amp_dl2_s2_0/m1_68_166# 2.427824e-16
C1431 VCM_REF eeg_fd_ota_full2_nc_0/stage2_0/VBP2 3.807563e-17
C1433 VDD18 VSS 2.612770e-15
C1434 VDD18 eeg_fd_ota_full2_nc_0/eeg_cmfb_amp_dl2_s2_0/m1_370_1493# 2.522786e-16
C1436 VDD18 eeg_fd_ota_full2_nc_0/stage2_0/VBP2 7.539492e-16
C1438 VSS eeg_fd_ota_full2_nc_0/eeg_bias_gen_0/VBNF 2.369513e-15
C1439 VSS eeg_fd_ota_full2_nc_0/eeg_cmfb_amp_dl2_s2_0/m1_370_1493# 5.700428e-17
C1440 VSS eeg_fd_ota_full2_nc_0/eeg_cmfb_amp_dl2_s2_0/m1_68_166# 5.221927e-16
C1441 VSS eeg_fd_ota_full2_nc_0/stage2_0/VBP2 3.370669e-17
C1442 VSS eeg_fd_ota_full2_nc_0/stage2_0/VCM2 2.749285e-16
C1443 eeg_fd_ota_full2_nc_0/eeg_bias_gen_0/VBNF VSS 1.604850e-15
C1445 eeg_fd_ota_full2_nc_0/eeg_bias_gen_0/VBNF eeg_fd_ota_full2_nc_0/eeg_cmfb_amp_dl2_s2_0/m1_68_166# 3.152511e-16
C1447 eeg_fd_ota_full2_nc_0/eeg_bias_gen_0/VBNF eeg_fd_ota_full2_nc_0/stage2_0/VCM2 3.744583e-17
C1448 eeg_fd_ota_full2_nc_0/eeg_cmfb_amp_dl2_s2_0/m1_370_1493# VSS 9.918890e-16
C1449 eeg_fd_ota_full2_nc_0/eeg_cmfb_amp_dl2_s2_0/m1_370_1493# eeg_fd_ota_full2_nc_0/eeg_cmfb_amp_dl2_s2_0/m1_68_166# 4.867321e-17
C1450 eeg_fd_ota_full2_nc_0/eeg_cmfb_amp_dl2_s2_0/m1_370_1493# eeg_fd_ota_full2_nc_0/stage2_0/VBP2 3.844261e-17
C1451 eeg_fd_ota_full2_nc_0/eeg_cmfb_amp_dl2_s2_0/m1_370_1493# eeg_fd_ota_full2_nc_0/stage2_0/VCM2 3.677346e-17
C1452 eeg_fd_ota_full2_nc_0/eeg_cmfb_amp_dl2_s2_0/m1_68_166# VSS 1.237070e-15
C1454 eeg_fd_ota_full2_nc_0/eeg_cmfb_amp_dl2_s2_0/m1_68_166# eeg_fd_ota_full2_nc_0/stage2_0/VCM2 3.012335e-16
C1455 eeg_fd_ota_full2_nc_0/stage2_0/VBP2 VSS 1.996710e-15
C1456 eeg_fd_ota_full2_nc_0/stage2_0/VCM2 VSS 3.299460e-16
C1457 VDD18 VSS 3.587888e-15
C1458 VDD18 eeg_fd_ota_full2_nc_0/eeg_cmfb_amp_dl2_s2_0/m1_370_1493# 9.654664e-16
C1459 eeg_fd_ota_full2_nc_0/eeg_cmfb_amp_dl2_s2_0/m1_370_1493# VSS 2.472537e-16
C1460 eeg_fd_ota_full2_nc_0/eeg_cmfb_amp_dl2_s2_0/m1_370_1493# VSS 2.522110e-16
C1461 eeg_fd_ota_full2_nc_0/eeg_cmfb_amp_dl2_s2_0/m1_370_1493# eeg_fd_ota_full2_nc_0/eeg_cmfb_amp_dl2_s2_0/m1_68_166# 2.845540e-17
C1462 eeg_fd_ota_full2_nc_0/eeg_cmfb_amp_dl2_s2_0/m1_370_1493# eeg_fd_ota_full2_nc_0/stage2_0/VCM2 1.233540e-16
C1463 eeg_fd_ota_full2_nc_0/eeg_cmfb_amp_dl2_s2_0/m1_68_166# VSS 2.522110e-16
C1464 eeg_fd_ota_full2_nc_0/eeg_cmfb_amp_dl2_s2_0/m1_68_166# eeg_fd_ota_full2_nc_0/stage2_0/VCM2 1.233540e-16
C1465 eeg_fd_ota_full2_nc_0/stage2_0/VCM2 VSS 7.517030e-16
C1466 VSS eeg_fd_ota_full2_nc_0/eeg_bias_gen_0/VBNF 9.287020e-16
C1467 VSS eeg_fd_ota_full2_nc_0/eeg_cmfb_amp_dl2_s2_0/m1_68_166# 9.828080e-17
C1468 eeg_fd_ota_full2_nc_0/eeg_bias_gen_0/VBNF VSS 2.698520e-15
C1469 eeg_fd_ota_full2_nc_0/eeg_bias_gen_0/VBNF eeg_fd_ota_full2_nc_0/eeg_cmfb_amp_dl2_s2_0/m1_68_166# 8.339500e-16
C1470 eeg_fd_ota_full2_nc_0/eeg_cmfb_amp_dl2_s2_0/m1_68_166# VSS 2.771420e-17
C1471 VDD18 VSS 2.586521e-15
C1472 VDD18 eeg_fd_ota_full2_nc_0/stage2_0/VBP2 1.198369e-15
C1473 eeg_fd_ota_full2_nc_0/stage2_0/VBP2 VSS 3.939952e-16
C1474 VCM_REF VSS 7.517030e-16
C1475 VCM_REF eeg_fd_ota_full2_nc_0/eeg_cmfb_amp_dl2_s2_0/m1_68_166# 1.233540e-16
C1476 VCM_REF eeg_fd_ota_full2_nc_0/stage2_0/VBP2 1.233540e-16
C1477 eeg_fd_ota_full2_nc_0/eeg_cmfb_amp_dl2_s2_0/m1_68_166# VSS 2.522110e-16
C1478 eeg_fd_ota_full2_nc_0/eeg_cmfb_amp_dl2_s2_0/m1_68_166# eeg_fd_ota_full2_nc_0/stage2_0/VBP2 2.845540e-17
C1479 eeg_fd_ota_full2_nc_0/stage2_0/VBP2 VSS 2.522110e-16
C1481 VCM_REF VSS 6.276408e-16
C1482 VCM_REF eeg_fd_ota_full2_nc_0/eeg_bias_gen_0/VBNF 2.510694e-16
C1483 VCM_REF eeg_fd_ota_full2_nc_0/eeg_cmfb_amp_dl2_0/VBP 3.362127e-17
C1486 VCM_REF eeg_fd_ota_full2_nc_0/eeg_cmfb_amp_dl2_0/m1_68_166# 2.427824e-16
C1487 VDD18 VSS 2.501711e-15
C1488 VDD18 eeg_fd_ota_full2_nc_0/eeg_cmfb_amp_dl2_0/VBP 7.544897e-16
C1490 VDD18 eeg_fd_ota_full2_nc_0/eeg_cmfb_amp_dl2_0/m1_370_1493# 2.510033e-16
C1492 VSS eeg_fd_ota_full2_nc_0/eeg_bias_gen_0/VBNF 2.369513e-15
C1493 VSS eeg_fd_ota_full2_nc_0/eeg_cmfb_amp_dl2_0/VBP 3.358056e-17
C1494 VSS eeg_fd_ota_full2_nc_0/eeg_cmfb_amp_dl2_0/VCM_SENSE 2.749285e-16
C1495 VSS eeg_fd_ota_full2_nc_0/eeg_cmfb_amp_dl2_0/m1_370_1493# 5.700428e-17
C1496 VSS eeg_fd_ota_full2_nc_0/eeg_cmfb_amp_dl2_0/m1_68_166# 5.221927e-16
C1497 eeg_fd_ota_full2_nc_0/eeg_bias_gen_0/VBNF VSS 1.604850e-15
C1499 eeg_fd_ota_full2_nc_0/eeg_bias_gen_0/VBNF eeg_fd_ota_full2_nc_0/eeg_cmfb_amp_dl2_0/VCM_SENSE 3.744583e-17
C1501 eeg_fd_ota_full2_nc_0/eeg_bias_gen_0/VBNF eeg_fd_ota_full2_nc_0/eeg_cmfb_amp_dl2_0/m1_68_166# 3.152511e-16
C1502 eeg_fd_ota_full2_nc_0/eeg_cmfb_amp_dl2_0/VBP VSS 2.449490e-15
C1503 eeg_fd_ota_full2_nc_0/eeg_cmfb_amp_dl2_0/VBP eeg_fd_ota_full2_nc_0/eeg_cmfb_amp_dl2_0/m1_370_1493# 4.345090e-17
C1505 eeg_fd_ota_full2_nc_0/eeg_cmfb_amp_dl2_0/VCM_SENSE VSS 3.299460e-16
C1506 eeg_fd_ota_full2_nc_0/eeg_cmfb_amp_dl2_0/VCM_SENSE eeg_fd_ota_full2_nc_0/eeg_cmfb_amp_dl2_0/m1_370_1493# 3.677346e-17
C1507 eeg_fd_ota_full2_nc_0/eeg_cmfb_amp_dl2_0/VCM_SENSE eeg_fd_ota_full2_nc_0/eeg_cmfb_amp_dl2_0/m1_68_166# 3.012335e-16
C1508 eeg_fd_ota_full2_nc_0/eeg_cmfb_amp_dl2_0/m1_370_1493# VSS 9.975700e-16
C1509 eeg_fd_ota_full2_nc_0/eeg_cmfb_amp_dl2_0/m1_370_1493# eeg_fd_ota_full2_nc_0/eeg_cmfb_amp_dl2_0/m1_68_166# 4.867321e-17
C1510 eeg_fd_ota_full2_nc_0/eeg_cmfb_amp_dl2_0/m1_68_166# VSS 1.237070e-15
C1511 VDD18 VSS 6.757137e-15
C1512 VDD18 eeg_fd_ota_full2_nc_0/eeg_cmfb_amp_dl2_0/VBP 1.873828e-15
C1513 eeg_fd_ota_full2_nc_0/eeg_cmfb_amp_dl2_0/VBP VSS 4.451080e-16
C1514 VCM_REF VSS 7.517030e-16
C1515 VCM_REF eeg_fd_ota_full2_nc_0/eeg_cmfb_amp_dl2_0/VBP 1.233540e-16
C1516 VCM_REF eeg_fd_ota_full2_nc_0/eeg_cmfb_amp_dl2_0/m1_68_166# 1.233540e-16
C1517 eeg_fd_ota_full2_nc_0/eeg_cmfb_amp_dl2_0/VBP VSS 2.522110e-16
C1518 eeg_fd_ota_full2_nc_0/eeg_cmfb_amp_dl2_0/VBP eeg_fd_ota_full2_nc_0/eeg_cmfb_amp_dl2_0/m1_68_166# 2.845540e-17
C1519 eeg_fd_ota_full2_nc_0/eeg_cmfb_amp_dl2_0/m1_68_166# VSS 2.522110e-16
C1520 VSS eeg_fd_ota_full2_nc_0/eeg_bias_gen_0/VBNF 9.287020e-16
C1521 VSS eeg_fd_ota_full2_nc_0/eeg_cmfb_amp_dl2_0/m1_68_166# 9.828080e-17
C1522 eeg_fd_ota_full2_nc_0/eeg_bias_gen_0/VBNF VSS 2.698520e-15
C1523 eeg_fd_ota_full2_nc_0/eeg_bias_gen_0/VBNF eeg_fd_ota_full2_nc_0/eeg_cmfb_amp_dl2_0/m1_68_166# 8.339500e-16
C1524 eeg_fd_ota_full2_nc_0/eeg_cmfb_amp_dl2_0/m1_68_166# VSS 2.771420e-17
C1525 VDD18 VSS 3.587888e-15
C1526 VDD18 eeg_fd_ota_full2_nc_0/eeg_cmfb_amp_dl2_0/m1_370_1493# 9.654664e-16
C1527 eeg_fd_ota_full2_nc_0/eeg_cmfb_amp_dl2_0/m1_370_1493# VSS 2.472537e-16
C1528 eeg_fd_ota_full2_nc_0/eeg_cmfb_amp_dl2_0/VCM_SENSE VSS 7.517030e-16
C1529 eeg_fd_ota_full2_nc_0/eeg_cmfb_amp_dl2_0/VCM_SENSE eeg_fd_ota_full2_nc_0/eeg_cmfb_amp_dl2_0/m1_370_1493# 1.233540e-16
C1530 eeg_fd_ota_full2_nc_0/eeg_cmfb_amp_dl2_0/VCM_SENSE eeg_fd_ota_full2_nc_0/eeg_cmfb_amp_dl2_0/m1_68_166# 1.233540e-16
C1531 eeg_fd_ota_full2_nc_0/eeg_cmfb_amp_dl2_0/m1_370_1493# VSS 2.522110e-16
C1532 eeg_fd_ota_full2_nc_0/eeg_cmfb_amp_dl2_0/m1_370_1493# eeg_fd_ota_full2_nc_0/eeg_cmfb_amp_dl2_0/m1_68_166# 2.845540e-17
C1533 eeg_fd_ota_full2_nc_0/eeg_cmfb_amp_dl2_0/m1_68_166# VSS 2.522110e-16
C1534 OINTN OINTP 1.250845e-14
C1535 OINTN VCM_REF 1.570960e-15
C1536 OINTN VDD18 1.668936e-15
C1537 OINTN VSS 1.325307e-13
C1538 OINTN eeg_fd_ota_full2_nc_0/stage2_0/N2N 2.549263e-16
C1540 OINTN eeg_fd_ota_full2_nc_0/stage2_0/VBP2 9.372474e-15
C1541 OINTN eeg_fd_ota_full2_nc_0/stage2_0/VCM2 1.065290e-15
C1542 OINTN eeg_fd_ota_full2_nc_0/stage2_0/m1_12966_n5928# 5.354797e-13
C1544 OINTN eeg_fd_ota_full2_nc_0/stage2_0/m1_42369_n8557# 7.005580e-17
C1549 OINTN eeg_fd_ota_full2_nc_0/stage2_0/m1_47077_n15864# 2.753997e-16
C1550 OINTN eeg_fd_ota_full2_nc_0/stage2_0/m1_47505_n8557# 3.457173e-16
C1551 OINTN eeg_fd_ota_full2_nc_0/stage2_0/m1_47933_n15864# 5.016444e-17
C1553 OINTN eeg_fd_ota_full2_nc_0/stage2_0/m1_48789_n15864# 3.737416e-17
C1555 OINTN eeg_fd_ota_full2_nc_0/stage2_0/m1_49645_n15864# 3.556346e-17
C1556 OINTN eeg_fd_ota_full2_nc_0/stage2_0/m1_50501_n15864# 3.556346e-17
C1557 OINTN eeg_fd_ota_full2_nc_0/stage2_0/m1_51357_n15864# 3.556346e-17
C1558 OINTN eeg_fd_ota_full2_nc_0/stage2_0/m1_52213_n15864# 3.556346e-17
C1559 OINTN eeg_fd_ota_full2_nc_0/stage2_0/m1_53069_n15864# 3.556346e-17
C1560 OINTN eeg_fd_ota_full2_nc_0/stage2_0/m1_53925_n15864# 3.556346e-17
C1561 OINTN eeg_fd_ota_full2_nc_0/stage2_0/m1_54781_n15864# 3.556346e-17
C1562 OINTN eeg_fd_ota_full2_nc_0/stage2_0/m1_55637_n15864# 3.556346e-17
C1563 OINTN eeg_fd_ota_full2_nc_0/stage2_0/m1_56493_n15864# 3.556346e-17
C1564 OINTN eeg_fd_ota_full2_nc_0/stage2_0/m1_57349_n15864# 3.556346e-17
C1565 OINTN eeg_fd_ota_full2_nc_0/stage2_0/m1_58205_n15864# 3.556346e-17
C1566 OINTN eeg_fd_ota_full2_nc_0/stage2_0/m1_59061_n15864# 3.556346e-17
C1567 OINTN eeg_fd_ota_full2_nc_0/stage2_0/m1_59917_n15864# 3.556346e-17
C1568 OINTN eeg_fd_ota_full2_nc_0/stage2_0/m1_60773_n15864# 3.556345e-17
C1569 OINTN eeg_fd_ota_full2_nc_0/stage2_0/m1_61629_n15864# 3.556346e-17
C1570 OINTN eeg_fd_ota_full2_nc_0/stage2_0/m1_62485_n15864# 3.556346e-17
C1571 OINTN eeg_fd_ota_full2_nc_0/stage2_0/m1_63941_n15864# 3.556346e-17
C1572 OINTN eeg_fd_ota_full2_nc_0/stage2_0/m1_64797_n15864# 3.556346e-17
C1573 OINTN eeg_fd_ota_full2_nc_0/stage2_0/m1_65653_n15864# 3.556346e-17
C1574 OINTN eeg_fd_ota_full2_nc_0/stage2_0/m1_66509_n15864# 3.556346e-17
C1575 OINTN eeg_fd_ota_full2_nc_0/stage2_0/m1_67365_n15864# 3.556346e-17
C1576 OINTN eeg_fd_ota_full2_nc_0/stage2_0/m1_68221_n15864# 3.556346e-17
C1577 OINTN eeg_fd_ota_full2_nc_0/stage2_0/m1_69077_n15864# 3.556346e-17
C1579 OINTN eeg_fd_ota_full2_nc_0/stage2_0/m1_74369_n8557# 7.005580e-17
C1581 OINTP VCM_REF 1.032390e-14
C1582 OINTP VDD18 2.580708e-15
C1583 OINTP VSS 1.249100e-13
C1584 OINTP eeg_fd_ota_full2_nc_0/stage2_0/N2N 1.938902e-16
C1585 OINTP eeg_fd_ota_full2_nc_0/stage2_0/N2P 4.630645e-16
C1586 OINTP eeg_fd_ota_full2_nc_0/stage2_0/VBP2 4.258694e-15
C1587 OINTP eeg_fd_ota_full2_nc_0/stage2_0/VCM2 4.979118e-16
C1588 OINTP eeg_fd_ota_full2_nc_0/stage2_0/m1_12966_n5928# 2.275473e-16
C1589 OINTP eeg_fd_ota_full2_nc_0/stage2_0/m1_19941_n15864# 5.564592e-17
C1590 OINTP eeg_fd_ota_full2_nc_0/stage2_0/m1_20369_n8557# 7.195410e-17
C1591 OINTP eeg_fd_ota_full2_nc_0/stage2_0/m1_20797_n15864# 3.732998e-17
C1593 OINTP eeg_fd_ota_full2_nc_0/stage2_0/m1_21653_n15864# 3.556346e-17
C1594 OINTP eeg_fd_ota_full2_nc_0/stage2_0/m1_22509_n15864# 3.556346e-17
C1595 OINTP eeg_fd_ota_full2_nc_0/stage2_0/m1_23365_n15864# 3.556346e-17
C1596 OINTP eeg_fd_ota_full2_nc_0/stage2_0/m1_24221_n15864# 3.556346e-17
C1597 OINTP eeg_fd_ota_full2_nc_0/stage2_0/m1_25077_n15864# 3.556346e-17
C1598 OINTP eeg_fd_ota_full2_nc_0/stage2_0/m1_25933_n15864# 3.556346e-17
C1599 OINTP eeg_fd_ota_full2_nc_0/stage2_0/m1_26789_n15864# 3.556346e-17
C1600 OINTP eeg_fd_ota_full2_nc_0/stage2_0/m1_27645_n15864# 3.556346e-17
C1601 OINTP eeg_fd_ota_full2_nc_0/stage2_0/m1_28501_n15864# 3.556345e-17
C1602 OINTP eeg_fd_ota_full2_nc_0/stage2_0/m1_29357_n15864# 3.556346e-17
C1603 OINTP eeg_fd_ota_full2_nc_0/stage2_0/m1_30213_n15864# 3.556346e-17
C1604 OINTP eeg_fd_ota_full2_nc_0/stage2_0/m1_31069_n15864# 3.556346e-17
C1605 OINTP eeg_fd_ota_full2_nc_0/stage2_0/m1_31925_n15864# 3.556346e-17
C1606 OINTP eeg_fd_ota_full2_nc_0/stage2_0/m1_32781_n15864# 3.556345e-17
C1607 OINTP eeg_fd_ota_full2_nc_0/stage2_0/m1_33637_n15864# 3.556346e-17
C1608 OINTP eeg_fd_ota_full2_nc_0/stage2_0/m1_34493_n15864# 3.556345e-17
C1609 OINTP eeg_fd_ota_full2_nc_0/stage2_0/m1_35349_n15864# 3.556346e-17
C1610 OINTP eeg_fd_ota_full2_nc_0/stage2_0/m1_36205_n15864# 3.556346e-17
C1611 OINTP eeg_fd_ota_full2_nc_0/stage2_0/m1_37061_n15864# 3.556346e-17
C1612 OINTP eeg_fd_ota_full2_nc_0/stage2_0/m1_37917_n15864# 3.556346e-17
C1613 OINTP eeg_fd_ota_full2_nc_0/stage2_0/m1_38773_n15864# 3.556345e-17
C1614 OINTP eeg_fd_ota_full2_nc_0/stage2_0/m1_39629_n15864# 3.556346e-17
C1615 OINTP eeg_fd_ota_full2_nc_0/stage2_0/m1_3966_n5928# 5.354613e-13
C1616 OINTP eeg_fd_ota_full2_nc_0/stage2_0/m1_40485_n15864# 3.556346e-17
C1619 OINTP eeg_fd_ota_full2_nc_0/stage2_0/m1_64369_n8557# 7.005580e-17
C1621 VCM_REF VDD18 7.346787e-16
C1622 VCM_REF VSS 1.681050e-14
C1623 VCM_REF eeg_fd_ota_full2_nc_0/stage2_0/VBP2 1.491687e-16
C1624 VCM_REF eeg_fd_ota_full2_nc_0/stage2_0/VCM2 1.478710e-14
C1626 VCM_REF eeg_fd_ota_full2_nc_0/stage2_0/m1_71217_n8557# 7.005580e-17
C1628 VCM_REF eeg_fd_ota_full2_nc_0/stage2_0/m1_81217_n8557# 7.005580e-17
C1629 VDD18 VSS 2.040385e-14
C1632 VDD18 eeg_fd_ota_full2_nc_0/stage2_0/VBP2 1.186903e-14
C1633 VDD18 eeg_fd_ota_full2_nc_0/stage2_0/VCM2 2.084367e-15
C1634 VSS eeg_fd_ota_full2_nc_0/stage2_0/N2N 8.879202e-15
C1635 VSS eeg_fd_ota_full2_nc_0/stage2_0/N2P 1.289378e-15
C1637 VSS eeg_fd_ota_full2_nc_0/stage2_0/VCM2 1.074530e-16
C1638 eeg_fd_ota_full2_nc_0/stage2_0/N2N VSS 6.410800e-15
C1639 eeg_fd_ota_full2_nc_0/stage2_0/N2N eeg_fd_ota_full2_nc_0/stage2_0/N2P 8.666164e-15
C1640 eeg_fd_ota_full2_nc_0/stage2_0/N2N eeg_fd_ota_full2_nc_0/stage2_0/VBP2 3.636257e-17
C1641 eeg_fd_ota_full2_nc_0/stage2_0/N2N eeg_fd_ota_full2_nc_0/stage2_0/VCM2 9.568950e-17
C1643 eeg_fd_ota_full2_nc_0/stage2_0/N2P VSS 1.406960e-14
C1644 eeg_fd_ota_full2_nc_0/stage2_0/N2P eeg_fd_ota_full2_nc_0/stage2_0/VBP2 3.636256e-17
C1645 eeg_fd_ota_full2_nc_0/stage2_0/N2P eeg_fd_ota_full2_nc_0/stage2_0/VCM2 1.074530e-16
C1647 eeg_fd_ota_full2_nc_0/stage2_0/VBP2 VSS 2.127810e-14
C1648 eeg_fd_ota_full2_nc_0/stage2_0/VBP2 eeg_fd_ota_full2_nc_0/stage2_0/VCM2 4.340982e-15
C1649 eeg_fd_ota_full2_nc_0/stage2_0/VCM2 VSS 2.468510e-14
C1650 eeg_fd_ota_full2_nc_0/stage2_0/VCM2 eeg_fd_ota_full2_nc_0/stage2_0/m1_12966_n5928# 1.228753e-16
C1652 eeg_fd_ota_full2_nc_0/stage2_0/VCM2 eeg_fd_ota_full2_nc_0/stage2_0/m1_40057_n8557# 7.005580e-17
C1655 eeg_fd_ota_full2_nc_0/stage2_0/VCM2 eeg_fd_ota_full2_nc_0/stage2_0/m1_62057_n8557# 7.005580e-17
C1657 eeg_fd_ota_full2_nc_0/stage2_0/m1_12966_n5928# VSS 3.335950e-14
C1658 eeg_fd_ota_full2_nc_0/stage2_0/m1_12966_n5928# eeg_fd_ota_full2_nc_0/stage2_0/m1_20369_n8557# 2.202720e-17
C1659 eeg_fd_ota_full2_nc_0/stage2_0/m1_12966_n5928# eeg_fd_ota_full2_nc_0/stage2_0/m1_21225_n8557# 2.202720e-17
C1660 eeg_fd_ota_full2_nc_0/stage2_0/m1_12966_n5928# eeg_fd_ota_full2_nc_0/stage2_0/m1_22081_n8557# 2.202720e-17
C1661 eeg_fd_ota_full2_nc_0/stage2_0/m1_12966_n5928# eeg_fd_ota_full2_nc_0/stage2_0/m1_22937_n8557# 2.202720e-17
C1662 eeg_fd_ota_full2_nc_0/stage2_0/m1_12966_n5928# eeg_fd_ota_full2_nc_0/stage2_0/m1_23793_n8557# 2.202720e-17
C1663 eeg_fd_ota_full2_nc_0/stage2_0/m1_12966_n5928# eeg_fd_ota_full2_nc_0/stage2_0/m1_24649_n8557# 2.202720e-17
C1664 eeg_fd_ota_full2_nc_0/stage2_0/m1_12966_n5928# eeg_fd_ota_full2_nc_0/stage2_0/m1_25505_n8557# 2.202720e-17
C1665 eeg_fd_ota_full2_nc_0/stage2_0/m1_12966_n5928# eeg_fd_ota_full2_nc_0/stage2_0/m1_26361_n8557# 2.202720e-17
C1666 eeg_fd_ota_full2_nc_0/stage2_0/m1_12966_n5928# eeg_fd_ota_full2_nc_0/stage2_0/m1_27217_n8557# 2.202720e-17
C1667 eeg_fd_ota_full2_nc_0/stage2_0/m1_12966_n5928# eeg_fd_ota_full2_nc_0/stage2_0/m1_28073_n8557# 2.202720e-17
C1668 eeg_fd_ota_full2_nc_0/stage2_0/m1_12966_n5928# eeg_fd_ota_full2_nc_0/stage2_0/m1_28929_n8557# 2.202720e-17
C1669 eeg_fd_ota_full2_nc_0/stage2_0/m1_12966_n5928# eeg_fd_ota_full2_nc_0/stage2_0/m1_29785_n8557# 2.202720e-17
C1670 eeg_fd_ota_full2_nc_0/stage2_0/m1_12966_n5928# eeg_fd_ota_full2_nc_0/stage2_0/m1_30641_n8557# 2.202720e-17
C1671 eeg_fd_ota_full2_nc_0/stage2_0/m1_12966_n5928# eeg_fd_ota_full2_nc_0/stage2_0/m1_31497_n8557# 2.202720e-17
C1672 eeg_fd_ota_full2_nc_0/stage2_0/m1_12966_n5928# eeg_fd_ota_full2_nc_0/stage2_0/m1_32353_n8557# 2.202720e-17
C1673 eeg_fd_ota_full2_nc_0/stage2_0/m1_12966_n5928# eeg_fd_ota_full2_nc_0/stage2_0/m1_33209_n8557# 2.202719e-17
C1674 eeg_fd_ota_full2_nc_0/stage2_0/m1_12966_n5928# eeg_fd_ota_full2_nc_0/stage2_0/m1_34065_n8557# 2.202719e-17
C1675 eeg_fd_ota_full2_nc_0/stage2_0/m1_12966_n5928# eeg_fd_ota_full2_nc_0/stage2_0/m1_34921_n8557# 2.202720e-17
C1676 eeg_fd_ota_full2_nc_0/stage2_0/m1_12966_n5928# eeg_fd_ota_full2_nc_0/stage2_0/m1_35777_n8557# 2.202720e-17
C1677 eeg_fd_ota_full2_nc_0/stage2_0/m1_12966_n5928# eeg_fd_ota_full2_nc_0/stage2_0/m1_36633_n8557# 2.202720e-17
C1678 eeg_fd_ota_full2_nc_0/stage2_0/m1_12966_n5928# eeg_fd_ota_full2_nc_0/stage2_0/m1_37489_n8557# 2.202720e-17
C1679 eeg_fd_ota_full2_nc_0/stage2_0/m1_12966_n5928# eeg_fd_ota_full2_nc_0/stage2_0/m1_38345_n8557# 2.202719e-17
C1680 eeg_fd_ota_full2_nc_0/stage2_0/m1_12966_n5928# eeg_fd_ota_full2_nc_0/stage2_0/m1_39201_n8557# 2.202720e-17
C1681 eeg_fd_ota_full2_nc_0/stage2_0/m1_12966_n5928# eeg_fd_ota_full2_nc_0/stage2_0/m1_3966_n5928# 2.125553e-15
C1682 eeg_fd_ota_full2_nc_0/stage2_0/m1_12966_n5928# eeg_fd_ota_full2_nc_0/stage2_0/m1_40057_n8557# 2.202720e-17
C1683 eeg_fd_ota_full2_nc_0/stage2_0/m1_12966_n5928# eeg_fd_ota_full2_nc_0/stage2_0/m1_42369_n8557# 2.202720e-17
C1684 eeg_fd_ota_full2_nc_0/stage2_0/m1_12966_n5928# eeg_fd_ota_full2_nc_0/stage2_0/m1_43225_n8557# 2.202720e-17
C1685 eeg_fd_ota_full2_nc_0/stage2_0/m1_12966_n5928# eeg_fd_ota_full2_nc_0/stage2_0/m1_44081_n8557# 2.202720e-17
C1686 eeg_fd_ota_full2_nc_0/stage2_0/m1_12966_n5928# eeg_fd_ota_full2_nc_0/stage2_0/m1_44937_n8557# 2.202720e-17
C1687 eeg_fd_ota_full2_nc_0/stage2_0/m1_12966_n5928# eeg_fd_ota_full2_nc_0/stage2_0/m1_45793_n8557# 2.202720e-17
C1688 eeg_fd_ota_full2_nc_0/stage2_0/m1_12966_n5928# eeg_fd_ota_full2_nc_0/stage2_0/m1_46649_n8557# 2.202719e-17
C1691 eeg_fd_ota_full2_nc_0/stage2_0/m1_12966_n5928# eeg_fd_ota_full2_nc_0/stage2_0/m1_48361_n8557# 2.202720e-17
C1692 eeg_fd_ota_full2_nc_0/stage2_0/m1_12966_n5928# eeg_fd_ota_full2_nc_0/stage2_0/m1_48789_n15864# 2.180820e-17
C1693 eeg_fd_ota_full2_nc_0/stage2_0/m1_12966_n5928# eeg_fd_ota_full2_nc_0/stage2_0/m1_49217_n8557# 2.202720e-17
C1694 eeg_fd_ota_full2_nc_0/stage2_0/m1_12966_n5928# eeg_fd_ota_full2_nc_0/stage2_0/m1_49645_n15864# 2.180820e-17
C1695 eeg_fd_ota_full2_nc_0/stage2_0/m1_12966_n5928# eeg_fd_ota_full2_nc_0/stage2_0/m1_50073_n8557# 2.202720e-17
C1696 eeg_fd_ota_full2_nc_0/stage2_0/m1_12966_n5928# eeg_fd_ota_full2_nc_0/stage2_0/m1_50501_n15864# 2.180820e-17
C1697 eeg_fd_ota_full2_nc_0/stage2_0/m1_12966_n5928# eeg_fd_ota_full2_nc_0/stage2_0/m1_50929_n8557# 2.202720e-17
C1698 eeg_fd_ota_full2_nc_0/stage2_0/m1_12966_n5928# eeg_fd_ota_full2_nc_0/stage2_0/m1_51357_n15864# 2.180820e-17
C1699 eeg_fd_ota_full2_nc_0/stage2_0/m1_12966_n5928# eeg_fd_ota_full2_nc_0/stage2_0/m1_51785_n8557# 2.202720e-17
C1700 eeg_fd_ota_full2_nc_0/stage2_0/m1_12966_n5928# eeg_fd_ota_full2_nc_0/stage2_0/m1_52213_n15864# 2.180820e-17
C1701 eeg_fd_ota_full2_nc_0/stage2_0/m1_12966_n5928# eeg_fd_ota_full2_nc_0/stage2_0/m1_52641_n8557# 2.202720e-17
C1702 eeg_fd_ota_full2_nc_0/stage2_0/m1_12966_n5928# eeg_fd_ota_full2_nc_0/stage2_0/m1_53069_n15864# 2.180820e-17
C1703 eeg_fd_ota_full2_nc_0/stage2_0/m1_12966_n5928# eeg_fd_ota_full2_nc_0/stage2_0/m1_53497_n8557# 2.202720e-17
C1704 eeg_fd_ota_full2_nc_0/stage2_0/m1_12966_n5928# eeg_fd_ota_full2_nc_0/stage2_0/m1_53925_n15864# 2.180820e-17
C1705 eeg_fd_ota_full2_nc_0/stage2_0/m1_12966_n5928# eeg_fd_ota_full2_nc_0/stage2_0/m1_54353_n8557# 2.202720e-17
C1706 eeg_fd_ota_full2_nc_0/stage2_0/m1_12966_n5928# eeg_fd_ota_full2_nc_0/stage2_0/m1_54781_n15864# 2.180820e-17
C1707 eeg_fd_ota_full2_nc_0/stage2_0/m1_12966_n5928# eeg_fd_ota_full2_nc_0/stage2_0/m1_55209_n8557# 2.202720e-17
C1708 eeg_fd_ota_full2_nc_0/stage2_0/m1_12966_n5928# eeg_fd_ota_full2_nc_0/stage2_0/m1_55637_n15864# 2.180820e-17
C1709 eeg_fd_ota_full2_nc_0/stage2_0/m1_12966_n5928# eeg_fd_ota_full2_nc_0/stage2_0/m1_56065_n8557# 2.202720e-17
C1710 eeg_fd_ota_full2_nc_0/stage2_0/m1_12966_n5928# eeg_fd_ota_full2_nc_0/stage2_0/m1_56493_n15864# 2.180820e-17
C1711 eeg_fd_ota_full2_nc_0/stage2_0/m1_12966_n5928# eeg_fd_ota_full2_nc_0/stage2_0/m1_56921_n8557# 2.846780e-17
C1712 eeg_fd_ota_full2_nc_0/stage2_0/m1_12966_n5928# eeg_fd_ota_full2_nc_0/stage2_0/m1_57349_n15864# 3.624019e-17
C1713 eeg_fd_ota_full2_nc_0/stage2_0/m1_12966_n5928# eeg_fd_ota_full2_nc_0/stage2_0/m1_57777_n8557# 4.853661e-17
C1714 eeg_fd_ota_full2_nc_0/stage2_0/m1_12966_n5928# eeg_fd_ota_full2_nc_0/stage2_0/m1_58205_n15864# 9.402064e-17
C1715 eeg_fd_ota_full2_nc_0/stage2_0/m1_12966_n5928# eeg_fd_ota_full2_nc_0/stage2_0/m1_58633_n8557# 1.810955e-16
C1716 eeg_fd_ota_full2_nc_0/stage2_0/m1_12966_n5928# eeg_fd_ota_full2_nc_0/stage2_0/m1_59061_n15864# 1.319775e-16
C1717 eeg_fd_ota_full2_nc_0/stage2_0/m1_12966_n5928# eeg_fd_ota_full2_nc_0/stage2_0/m1_59489_n8557# 4.022913e-17
C1718 eeg_fd_ota_full2_nc_0/stage2_0/m1_12966_n5928# eeg_fd_ota_full2_nc_0/stage2_0/m1_59917_n15864# 4.057376e-17
C1720 eeg_fd_ota_full2_nc_0/stage2_0/m1_12966_n5928# eeg_fd_ota_full2_nc_0/stage2_0/m1_60773_n15864# 2.405828e-17
C1721 eeg_fd_ota_full2_nc_0/stage2_0/m1_12966_n5928# eeg_fd_ota_full2_nc_0/stage2_0/m1_61629_n15864# 2.180820e-17
C1722 eeg_fd_ota_full2_nc_0/stage2_0/m1_12966_n5928# eeg_fd_ota_full2_nc_0/stage2_0/m1_62485_n15864# 2.180820e-17
C1723 eeg_fd_ota_full2_nc_0/stage2_0/m1_12966_n5928# eeg_fd_ota_full2_nc_0/stage2_0/m1_63941_n15864# 2.180820e-17
C1724 eeg_fd_ota_full2_nc_0/stage2_0/m1_12966_n5928# eeg_fd_ota_full2_nc_0/stage2_0/m1_64797_n15864# 2.180820e-17
C1725 eeg_fd_ota_full2_nc_0/stage2_0/m1_12966_n5928# eeg_fd_ota_full2_nc_0/stage2_0/m1_65653_n15864# 2.180820e-17
C1726 eeg_fd_ota_full2_nc_0/stage2_0/m1_12966_n5928# eeg_fd_ota_full2_nc_0/stage2_0/m1_66509_n15864# 2.180820e-17
C1727 eeg_fd_ota_full2_nc_0/stage2_0/m1_12966_n5928# eeg_fd_ota_full2_nc_0/stage2_0/m1_67365_n15864# 2.180820e-17
C1728 eeg_fd_ota_full2_nc_0/stage2_0/m1_12966_n5928# eeg_fd_ota_full2_nc_0/stage2_0/m1_68221_n15864# 2.180820e-17
C1729 eeg_fd_ota_full2_nc_0/stage2_0/m1_12966_n5928# eeg_fd_ota_full2_nc_0/stage2_0/m1_69077_n15864# 2.180820e-17
C1731 eeg_fd_ota_full2_nc_0/stage2_0/m1_19941_n15864# VSS 4.917160e-16
C1732 eeg_fd_ota_full2_nc_0/stage2_0/m1_19941_n15864# eeg_fd_ota_full2_nc_0/stage2_0/m1_20797_n15864# 6.207713e-17
C1734 eeg_fd_ota_full2_nc_0/stage2_0/m1_20369_n8557# VSS 4.841780e-16
C1735 eeg_fd_ota_full2_nc_0/stage2_0/m1_20369_n8557# eeg_fd_ota_full2_nc_0/stage2_0/m1_21225_n8557# 6.207720e-17
C1737 eeg_fd_ota_full2_nc_0/stage2_0/m1_20797_n15864# VSS 4.429720e-16
C1738 eeg_fd_ota_full2_nc_0/stage2_0/m1_20797_n15864# eeg_fd_ota_full2_nc_0/stage2_0/m1_21653_n15864# 6.207713e-17
C1739 eeg_fd_ota_full2_nc_0/stage2_0/m1_20797_n15864# eeg_fd_ota_full2_nc_0/stage2_0/m1_3966_n5928# 2.180820e-17
C1740 eeg_fd_ota_full2_nc_0/stage2_0/m1_21225_n8557# VSS 4.429720e-16
C1741 eeg_fd_ota_full2_nc_0/stage2_0/m1_21225_n8557# eeg_fd_ota_full2_nc_0/stage2_0/m1_22081_n8557# 6.207706e-17
C1743 eeg_fd_ota_full2_nc_0/stage2_0/m1_21653_n15864# VSS 4.429720e-16
C1744 eeg_fd_ota_full2_nc_0/stage2_0/m1_21653_n15864# eeg_fd_ota_full2_nc_0/stage2_0/m1_22509_n15864# 6.207713e-17
C1745 eeg_fd_ota_full2_nc_0/stage2_0/m1_21653_n15864# eeg_fd_ota_full2_nc_0/stage2_0/m1_3966_n5928# 2.180820e-17
C1746 eeg_fd_ota_full2_nc_0/stage2_0/m1_22081_n8557# VSS 4.429720e-16
C1747 eeg_fd_ota_full2_nc_0/stage2_0/m1_22081_n8557# eeg_fd_ota_full2_nc_0/stage2_0/m1_22937_n8557# 6.207720e-17
C1749 eeg_fd_ota_full2_nc_0/stage2_0/m1_22509_n15864# VSS 4.429720e-16
C1750 eeg_fd_ota_full2_nc_0/stage2_0/m1_22509_n15864# eeg_fd_ota_full2_nc_0/stage2_0/m1_23365_n15864# 6.207713e-17
C1751 eeg_fd_ota_full2_nc_0/stage2_0/m1_22509_n15864# eeg_fd_ota_full2_nc_0/stage2_0/m1_3966_n5928# 2.180820e-17
C1752 eeg_fd_ota_full2_nc_0/stage2_0/m1_22937_n8557# VSS 4.429720e-16
C1753 eeg_fd_ota_full2_nc_0/stage2_0/m1_22937_n8557# eeg_fd_ota_full2_nc_0/stage2_0/m1_23793_n8557# 6.207720e-17
C1755 eeg_fd_ota_full2_nc_0/stage2_0/m1_23365_n15864# VSS 4.429720e-16
C1756 eeg_fd_ota_full2_nc_0/stage2_0/m1_23365_n15864# eeg_fd_ota_full2_nc_0/stage2_0/m1_24221_n15864# 6.207713e-17
C1757 eeg_fd_ota_full2_nc_0/stage2_0/m1_23365_n15864# eeg_fd_ota_full2_nc_0/stage2_0/m1_3966_n5928# 2.180821e-17
C1758 eeg_fd_ota_full2_nc_0/stage2_0/m1_23793_n8557# VSS 4.429720e-16
C1759 eeg_fd_ota_full2_nc_0/stage2_0/m1_23793_n8557# eeg_fd_ota_full2_nc_0/stage2_0/m1_24649_n8557# 6.207720e-17
C1761 eeg_fd_ota_full2_nc_0/stage2_0/m1_24221_n15864# VSS 4.429720e-16
C1762 eeg_fd_ota_full2_nc_0/stage2_0/m1_24221_n15864# eeg_fd_ota_full2_nc_0/stage2_0/m1_25077_n15864# 6.207713e-17
C1763 eeg_fd_ota_full2_nc_0/stage2_0/m1_24221_n15864# eeg_fd_ota_full2_nc_0/stage2_0/m1_3966_n5928# 2.180820e-17
C1764 eeg_fd_ota_full2_nc_0/stage2_0/m1_24649_n8557# VSS 4.429720e-16
C1765 eeg_fd_ota_full2_nc_0/stage2_0/m1_24649_n8557# eeg_fd_ota_full2_nc_0/stage2_0/m1_25505_n8557# 6.207720e-17
C1767 eeg_fd_ota_full2_nc_0/stage2_0/m1_25077_n15864# VSS 4.429720e-16
C1768 eeg_fd_ota_full2_nc_0/stage2_0/m1_25077_n15864# eeg_fd_ota_full2_nc_0/stage2_0/m1_25933_n15864# 6.207713e-17
C1769 eeg_fd_ota_full2_nc_0/stage2_0/m1_25077_n15864# eeg_fd_ota_full2_nc_0/stage2_0/m1_3966_n5928# 2.180820e-17
C1770 eeg_fd_ota_full2_nc_0/stage2_0/m1_25505_n8557# VSS 4.429720e-16
C1771 eeg_fd_ota_full2_nc_0/stage2_0/m1_25505_n8557# eeg_fd_ota_full2_nc_0/stage2_0/m1_26361_n8557# 6.207706e-17
C1773 eeg_fd_ota_full2_nc_0/stage2_0/m1_25933_n15864# VSS 4.429720e-16
C1774 eeg_fd_ota_full2_nc_0/stage2_0/m1_25933_n15864# eeg_fd_ota_full2_nc_0/stage2_0/m1_26789_n15864# 6.207713e-17
C1775 eeg_fd_ota_full2_nc_0/stage2_0/m1_25933_n15864# eeg_fd_ota_full2_nc_0/stage2_0/m1_3966_n5928# 2.180820e-17
C1776 eeg_fd_ota_full2_nc_0/stage2_0/m1_26361_n8557# VSS 4.429720e-16
C1777 eeg_fd_ota_full2_nc_0/stage2_0/m1_26361_n8557# eeg_fd_ota_full2_nc_0/stage2_0/m1_27217_n8557# 6.207720e-17
C1779 eeg_fd_ota_full2_nc_0/stage2_0/m1_26789_n15864# VSS 4.429720e-16
C1780 eeg_fd_ota_full2_nc_0/stage2_0/m1_26789_n15864# eeg_fd_ota_full2_nc_0/stage2_0/m1_27645_n15864# 6.207713e-17
C1781 eeg_fd_ota_full2_nc_0/stage2_0/m1_26789_n15864# eeg_fd_ota_full2_nc_0/stage2_0/m1_3966_n5928# 2.180820e-17
C1782 eeg_fd_ota_full2_nc_0/stage2_0/m1_27217_n8557# VSS 4.429720e-16
C1783 eeg_fd_ota_full2_nc_0/stage2_0/m1_27217_n8557# eeg_fd_ota_full2_nc_0/stage2_0/m1_28073_n8557# 6.207720e-17
C1785 eeg_fd_ota_full2_nc_0/stage2_0/m1_27645_n15864# VSS 4.429720e-16
C1786 eeg_fd_ota_full2_nc_0/stage2_0/m1_27645_n15864# eeg_fd_ota_full2_nc_0/stage2_0/m1_28501_n15864# 6.207713e-17
C1787 eeg_fd_ota_full2_nc_0/stage2_0/m1_27645_n15864# eeg_fd_ota_full2_nc_0/stage2_0/m1_3966_n5928# 2.180820e-17
C1788 eeg_fd_ota_full2_nc_0/stage2_0/m1_28073_n8557# VSS 4.429720e-16
C1789 eeg_fd_ota_full2_nc_0/stage2_0/m1_28073_n8557# eeg_fd_ota_full2_nc_0/stage2_0/m1_28929_n8557# 6.207720e-17
C1791 eeg_fd_ota_full2_nc_0/stage2_0/m1_28501_n15864# VSS 4.429720e-16
C1792 eeg_fd_ota_full2_nc_0/stage2_0/m1_28501_n15864# eeg_fd_ota_full2_nc_0/stage2_0/m1_29357_n15864# 6.207713e-17
C1793 eeg_fd_ota_full2_nc_0/stage2_0/m1_28501_n15864# eeg_fd_ota_full2_nc_0/stage2_0/m1_3966_n5928# 2.180820e-17
C1794 eeg_fd_ota_full2_nc_0/stage2_0/m1_28929_n8557# VSS 4.429720e-16
C1795 eeg_fd_ota_full2_nc_0/stage2_0/m1_28929_n8557# eeg_fd_ota_full2_nc_0/stage2_0/m1_29785_n8557# 6.207720e-17
C1797 eeg_fd_ota_full2_nc_0/stage2_0/m1_29357_n15864# VSS 4.429720e-16
C1798 eeg_fd_ota_full2_nc_0/stage2_0/m1_29357_n15864# eeg_fd_ota_full2_nc_0/stage2_0/m1_30213_n15864# 6.207713e-17
C1799 eeg_fd_ota_full2_nc_0/stage2_0/m1_29357_n15864# eeg_fd_ota_full2_nc_0/stage2_0/m1_3966_n5928# 3.639779e-17
C1800 eeg_fd_ota_full2_nc_0/stage2_0/m1_29785_n8557# VSS 4.429720e-16
C1801 eeg_fd_ota_full2_nc_0/stage2_0/m1_29785_n8557# eeg_fd_ota_full2_nc_0/stage2_0/m1_30641_n8557# 6.207706e-17
C1802 eeg_fd_ota_full2_nc_0/stage2_0/m1_29785_n8557# eeg_fd_ota_full2_nc_0/stage2_0/m1_3966_n5928# 2.849432e-17
C1803 eeg_fd_ota_full2_nc_0/stage2_0/m1_30213_n15864# VSS 4.429720e-16
C1804 eeg_fd_ota_full2_nc_0/stage2_0/m1_30213_n15864# eeg_fd_ota_full2_nc_0/stage2_0/m1_31069_n15864# 6.207713e-17
C1805 eeg_fd_ota_full2_nc_0/stage2_0/m1_30213_n15864# eeg_fd_ota_full2_nc_0/stage2_0/m1_3966_n5928# 9.583904e-17
C1806 eeg_fd_ota_full2_nc_0/stage2_0/m1_30641_n8557# VSS 4.429720e-16
C1807 eeg_fd_ota_full2_nc_0/stage2_0/m1_30641_n8557# eeg_fd_ota_full2_nc_0/stage2_0/m1_31497_n8557# 6.207720e-17
C1808 eeg_fd_ota_full2_nc_0/stage2_0/m1_30641_n8557# eeg_fd_ota_full2_nc_0/stage2_0/m1_3966_n5928# 1.739250e-16
C1809 eeg_fd_ota_full2_nc_0/stage2_0/m1_31069_n15864# VSS 4.429720e-16
C1810 eeg_fd_ota_full2_nc_0/stage2_0/m1_31069_n15864# eeg_fd_ota_full2_nc_0/stage2_0/m1_31925_n15864# 6.207713e-17
C1811 eeg_fd_ota_full2_nc_0/stage2_0/m1_31069_n15864# eeg_fd_ota_full2_nc_0/stage2_0/m1_3966_n5928# 1.304816e-16
C1812 eeg_fd_ota_full2_nc_0/stage2_0/m1_31497_n8557# VSS 4.429720e-16
C1813 eeg_fd_ota_full2_nc_0/stage2_0/m1_31497_n8557# eeg_fd_ota_full2_nc_0/stage2_0/m1_32353_n8557# 6.207720e-17
C1814 eeg_fd_ota_full2_nc_0/stage2_0/m1_31497_n8557# eeg_fd_ota_full2_nc_0/stage2_0/m1_3966_n5928# 3.952004e-17
C1815 eeg_fd_ota_full2_nc_0/stage2_0/m1_31925_n15864# VSS 4.429720e-16
C1816 eeg_fd_ota_full2_nc_0/stage2_0/m1_31925_n15864# eeg_fd_ota_full2_nc_0/stage2_0/m1_32781_n15864# 6.207713e-17
C1817 eeg_fd_ota_full2_nc_0/stage2_0/m1_31925_n15864# eeg_fd_ota_full2_nc_0/stage2_0/m1_3966_n5928# 4.036033e-17
C1818 eeg_fd_ota_full2_nc_0/stage2_0/m1_32353_n8557# VSS 4.429720e-16
C1819 eeg_fd_ota_full2_nc_0/stage2_0/m1_32353_n8557# eeg_fd_ota_full2_nc_0/stage2_0/m1_33209_n8557# 6.207714e-17
C1821 eeg_fd_ota_full2_nc_0/stage2_0/m1_32781_n15864# VSS 4.429720e-16
C1822 eeg_fd_ota_full2_nc_0/stage2_0/m1_32781_n15864# eeg_fd_ota_full2_nc_0/stage2_0/m1_33637_n15864# 6.207713e-17
C1823 eeg_fd_ota_full2_nc_0/stage2_0/m1_32781_n15864# eeg_fd_ota_full2_nc_0/stage2_0/m1_3966_n5928# 2.393807e-17
C1824 eeg_fd_ota_full2_nc_0/stage2_0/m1_33209_n8557# VSS 4.429720e-16
C1825 eeg_fd_ota_full2_nc_0/stage2_0/m1_33209_n8557# eeg_fd_ota_full2_nc_0/stage2_0/m1_34065_n8557# 6.207720e-17
C1826 eeg_fd_ota_full2_nc_0/stage2_0/m1_33637_n15864# VSS 4.429720e-16
C1827 eeg_fd_ota_full2_nc_0/stage2_0/m1_33637_n15864# eeg_fd_ota_full2_nc_0/stage2_0/m1_34493_n15864# 6.207713e-17
C1828 eeg_fd_ota_full2_nc_0/stage2_0/m1_33637_n15864# eeg_fd_ota_full2_nc_0/stage2_0/m1_3966_n5928# 2.180820e-17
C1829 eeg_fd_ota_full2_nc_0/stage2_0/m1_34065_n8557# VSS 4.429720e-16
C1830 eeg_fd_ota_full2_nc_0/stage2_0/m1_34065_n8557# eeg_fd_ota_full2_nc_0/stage2_0/m1_34921_n8557# 6.207720e-17
C1831 eeg_fd_ota_full2_nc_0/stage2_0/m1_34493_n15864# VSS 4.429720e-16
C1832 eeg_fd_ota_full2_nc_0/stage2_0/m1_34493_n15864# eeg_fd_ota_full2_nc_0/stage2_0/m1_35349_n15864# 6.207713e-17
C1833 eeg_fd_ota_full2_nc_0/stage2_0/m1_34493_n15864# eeg_fd_ota_full2_nc_0/stage2_0/m1_3966_n5928# 2.180820e-17
C1834 eeg_fd_ota_full2_nc_0/stage2_0/m1_34921_n8557# VSS 4.429720e-16
C1835 eeg_fd_ota_full2_nc_0/stage2_0/m1_34921_n8557# eeg_fd_ota_full2_nc_0/stage2_0/m1_35777_n8557# 6.207720e-17
C1836 eeg_fd_ota_full2_nc_0/stage2_0/m1_35349_n15864# VSS 4.429720e-16
C1837 eeg_fd_ota_full2_nc_0/stage2_0/m1_35349_n15864# eeg_fd_ota_full2_nc_0/stage2_0/m1_36205_n15864# 6.207713e-17
C1838 eeg_fd_ota_full2_nc_0/stage2_0/m1_35349_n15864# eeg_fd_ota_full2_nc_0/stage2_0/m1_3966_n5928# 2.180820e-17
C1839 eeg_fd_ota_full2_nc_0/stage2_0/m1_35777_n8557# VSS 4.429720e-16
C1840 eeg_fd_ota_full2_nc_0/stage2_0/m1_35777_n8557# eeg_fd_ota_full2_nc_0/stage2_0/m1_36633_n8557# 6.207720e-17
C1841 eeg_fd_ota_full2_nc_0/stage2_0/m1_36205_n15864# VSS 4.429720e-16
C1842 eeg_fd_ota_full2_nc_0/stage2_0/m1_36205_n15864# eeg_fd_ota_full2_nc_0/stage2_0/m1_37061_n15864# 6.207713e-17
C1843 eeg_fd_ota_full2_nc_0/stage2_0/m1_36205_n15864# eeg_fd_ota_full2_nc_0/stage2_0/m1_3966_n5928# 2.180820e-17
C1844 eeg_fd_ota_full2_nc_0/stage2_0/m1_36633_n8557# VSS 4.429720e-16
C1845 eeg_fd_ota_full2_nc_0/stage2_0/m1_36633_n8557# eeg_fd_ota_full2_nc_0/stage2_0/m1_37489_n8557# 6.207706e-17
C1846 eeg_fd_ota_full2_nc_0/stage2_0/m1_37061_n15864# VSS 4.429720e-16
C1847 eeg_fd_ota_full2_nc_0/stage2_0/m1_37061_n15864# eeg_fd_ota_full2_nc_0/stage2_0/m1_37917_n15864# 6.207713e-17
C1848 eeg_fd_ota_full2_nc_0/stage2_0/m1_37061_n15864# eeg_fd_ota_full2_nc_0/stage2_0/m1_3966_n5928# 2.180820e-17
C1849 eeg_fd_ota_full2_nc_0/stage2_0/m1_37489_n8557# VSS 4.429720e-16
C1850 eeg_fd_ota_full2_nc_0/stage2_0/m1_37489_n8557# eeg_fd_ota_full2_nc_0/stage2_0/m1_38345_n8557# 6.207720e-17
C1851 eeg_fd_ota_full2_nc_0/stage2_0/m1_37917_n15864# VSS 4.429720e-16
C1852 eeg_fd_ota_full2_nc_0/stage2_0/m1_37917_n15864# eeg_fd_ota_full2_nc_0/stage2_0/m1_38773_n15864# 6.207713e-17
C1853 eeg_fd_ota_full2_nc_0/stage2_0/m1_37917_n15864# eeg_fd_ota_full2_nc_0/stage2_0/m1_3966_n5928# 2.180820e-17
C1854 eeg_fd_ota_full2_nc_0/stage2_0/m1_38345_n8557# VSS 4.429720e-16
C1855 eeg_fd_ota_full2_nc_0/stage2_0/m1_38345_n8557# eeg_fd_ota_full2_nc_0/stage2_0/m1_39201_n8557# 6.207720e-17
C1856 eeg_fd_ota_full2_nc_0/stage2_0/m1_38773_n15864# VSS 4.429720e-16
C1857 eeg_fd_ota_full2_nc_0/stage2_0/m1_38773_n15864# eeg_fd_ota_full2_nc_0/stage2_0/m1_39629_n15864# 6.207713e-17
C1858 eeg_fd_ota_full2_nc_0/stage2_0/m1_38773_n15864# eeg_fd_ota_full2_nc_0/stage2_0/m1_3966_n5928# 2.180820e-17
C1859 eeg_fd_ota_full2_nc_0/stage2_0/m1_39201_n8557# VSS 4.429720e-16
C1860 eeg_fd_ota_full2_nc_0/stage2_0/m1_39201_n8557# eeg_fd_ota_full2_nc_0/stage2_0/m1_40057_n8557# 6.207720e-17
C1861 eeg_fd_ota_full2_nc_0/stage2_0/m1_39629_n15864# VSS 4.429720e-16
C1862 eeg_fd_ota_full2_nc_0/stage2_0/m1_39629_n15864# eeg_fd_ota_full2_nc_0/stage2_0/m1_3966_n5928# 2.180820e-17
C1863 eeg_fd_ota_full2_nc_0/stage2_0/m1_39629_n15864# eeg_fd_ota_full2_nc_0/stage2_0/m1_40485_n15864# 6.207713e-17
C1864 eeg_fd_ota_full2_nc_0/stage2_0/m1_3966_n5928# VSS 2.573120e-14
C1865 eeg_fd_ota_full2_nc_0/stage2_0/m1_3966_n5928# eeg_fd_ota_full2_nc_0/stage2_0/m1_40485_n15864# 2.180820e-17
C1867 eeg_fd_ota_full2_nc_0/stage2_0/m1_40057_n8557# VSS 4.841780e-16
C1868 eeg_fd_ota_full2_nc_0/stage2_0/m1_40485_n15864# VSS 4.698080e-16
C1869 eeg_fd_ota_full2_nc_0/stage2_0/m1_40485_n15864# eeg_fd_ota_full2_nc_0/stage2_0/m1_41941_n15864# 2.192795e-17
C1870 eeg_fd_ota_full2_nc_0/stage2_0/m1_41941_n15864# VSS 4.698080e-16
C1871 eeg_fd_ota_full2_nc_0/stage2_0/m1_41941_n15864# eeg_fd_ota_full2_nc_0/stage2_0/m1_42797_n15864# 6.207713e-17
C1872 eeg_fd_ota_full2_nc_0/stage2_0/m1_42369_n8557# VSS 4.841780e-16
C1873 eeg_fd_ota_full2_nc_0/stage2_0/m1_42369_n8557# eeg_fd_ota_full2_nc_0/stage2_0/m1_43225_n8557# 6.207706e-17
C1874 eeg_fd_ota_full2_nc_0/stage2_0/m1_42797_n15864# VSS 4.429720e-16
C1875 eeg_fd_ota_full2_nc_0/stage2_0/m1_42797_n15864# eeg_fd_ota_full2_nc_0/stage2_0/m1_43653_n15864# 6.207713e-17
C1876 eeg_fd_ota_full2_nc_0/stage2_0/m1_43225_n8557# VSS 4.429720e-16
C1877 eeg_fd_ota_full2_nc_0/stage2_0/m1_43225_n8557# eeg_fd_ota_full2_nc_0/stage2_0/m1_44081_n8557# 6.207720e-17
C1878 eeg_fd_ota_full2_nc_0/stage2_0/m1_43653_n15864# VSS 4.429720e-16
C1879 eeg_fd_ota_full2_nc_0/stage2_0/m1_43653_n15864# eeg_fd_ota_full2_nc_0/stage2_0/m1_44509_n15864# 6.207713e-17
C1880 eeg_fd_ota_full2_nc_0/stage2_0/m1_44081_n8557# VSS 4.429720e-16
C1881 eeg_fd_ota_full2_nc_0/stage2_0/m1_44081_n8557# eeg_fd_ota_full2_nc_0/stage2_0/m1_44937_n8557# 6.207720e-17
C1882 eeg_fd_ota_full2_nc_0/stage2_0/m1_44509_n15864# VSS 4.429720e-16
C1883 eeg_fd_ota_full2_nc_0/stage2_0/m1_44509_n15864# eeg_fd_ota_full2_nc_0/stage2_0/m1_45365_n15864# 6.207713e-17
C1884 eeg_fd_ota_full2_nc_0/stage2_0/m1_44937_n8557# VSS 4.429720e-16
C1885 eeg_fd_ota_full2_nc_0/stage2_0/m1_44937_n8557# eeg_fd_ota_full2_nc_0/stage2_0/m1_45793_n8557# 6.207720e-17
C1886 eeg_fd_ota_full2_nc_0/stage2_0/m1_45365_n15864# VSS 4.429720e-16
C1887 eeg_fd_ota_full2_nc_0/stage2_0/m1_45365_n15864# eeg_fd_ota_full2_nc_0/stage2_0/m1_46221_n15864# 6.207713e-17
C1888 eeg_fd_ota_full2_nc_0/stage2_0/m1_45793_n8557# VSS 4.429720e-16
C1889 eeg_fd_ota_full2_nc_0/stage2_0/m1_45793_n8557# eeg_fd_ota_full2_nc_0/stage2_0/m1_46649_n8557# 6.207720e-17
C1890 eeg_fd_ota_full2_nc_0/stage2_0/m1_46221_n15864# VSS 4.429720e-16
C1891 eeg_fd_ota_full2_nc_0/stage2_0/m1_46221_n15864# eeg_fd_ota_full2_nc_0/stage2_0/m1_47077_n15864# 6.207713e-17
C1892 eeg_fd_ota_full2_nc_0/stage2_0/m1_46649_n8557# VSS 4.429720e-16
C1893 eeg_fd_ota_full2_nc_0/stage2_0/m1_46649_n8557# eeg_fd_ota_full2_nc_0/stage2_0/m1_47505_n8557# 6.207714e-17
C1894 eeg_fd_ota_full2_nc_0/stage2_0/m1_47077_n15864# VSS 4.429720e-16
C1895 eeg_fd_ota_full2_nc_0/stage2_0/m1_47077_n15864# eeg_fd_ota_full2_nc_0/stage2_0/m1_47933_n15864# 6.207713e-17
C1896 eeg_fd_ota_full2_nc_0/stage2_0/m1_47505_n8557# VSS 4.429720e-16
C1897 eeg_fd_ota_full2_nc_0/stage2_0/m1_47505_n8557# eeg_fd_ota_full2_nc_0/stage2_0/m1_48361_n8557# 6.207720e-17
C1898 eeg_fd_ota_full2_nc_0/stage2_0/m1_47933_n15864# VSS 4.429720e-16
C1899 eeg_fd_ota_full2_nc_0/stage2_0/m1_47933_n15864# eeg_fd_ota_full2_nc_0/stage2_0/m1_48789_n15864# 6.207713e-17
C1900 eeg_fd_ota_full2_nc_0/stage2_0/m1_48361_n8557# VSS 4.429720e-16
C1901 eeg_fd_ota_full2_nc_0/stage2_0/m1_48361_n8557# eeg_fd_ota_full2_nc_0/stage2_0/m1_49217_n8557# 6.207720e-17
C1902 eeg_fd_ota_full2_nc_0/stage2_0/m1_48789_n15864# VSS 4.429720e-16
C1903 eeg_fd_ota_full2_nc_0/stage2_0/m1_48789_n15864# eeg_fd_ota_full2_nc_0/stage2_0/m1_49645_n15864# 6.207713e-17
C1904 eeg_fd_ota_full2_nc_0/stage2_0/m1_49217_n8557# VSS 4.429720e-16
C1905 eeg_fd_ota_full2_nc_0/stage2_0/m1_49217_n8557# eeg_fd_ota_full2_nc_0/stage2_0/m1_50073_n8557# 6.207706e-17
C1906 eeg_fd_ota_full2_nc_0/stage2_0/m1_49645_n15864# VSS 4.429720e-16
C1907 eeg_fd_ota_full2_nc_0/stage2_0/m1_49645_n15864# eeg_fd_ota_full2_nc_0/stage2_0/m1_50501_n15864# 6.207713e-17
C1908 eeg_fd_ota_full2_nc_0/stage2_0/m1_50073_n8557# VSS 4.429720e-16
C1909 eeg_fd_ota_full2_nc_0/stage2_0/m1_50073_n8557# eeg_fd_ota_full2_nc_0/stage2_0/m1_50929_n8557# 6.207720e-17
C1910 eeg_fd_ota_full2_nc_0/stage2_0/m1_50501_n15864# VSS 4.429720e-16
C1911 eeg_fd_ota_full2_nc_0/stage2_0/m1_50501_n15864# eeg_fd_ota_full2_nc_0/stage2_0/m1_51357_n15864# 6.207713e-17
C1912 eeg_fd_ota_full2_nc_0/stage2_0/m1_50929_n8557# VSS 4.429720e-16
C1913 eeg_fd_ota_full2_nc_0/stage2_0/m1_50929_n8557# eeg_fd_ota_full2_nc_0/stage2_0/m1_51785_n8557# 6.207720e-17
C1914 eeg_fd_ota_full2_nc_0/stage2_0/m1_51357_n15864# VSS 4.429720e-16
C1915 eeg_fd_ota_full2_nc_0/stage2_0/m1_51357_n15864# eeg_fd_ota_full2_nc_0/stage2_0/m1_52213_n15864# 6.207713e-17
C1916 eeg_fd_ota_full2_nc_0/stage2_0/m1_51785_n8557# VSS 4.429720e-16
C1917 eeg_fd_ota_full2_nc_0/stage2_0/m1_51785_n8557# eeg_fd_ota_full2_nc_0/stage2_0/m1_52641_n8557# 6.207720e-17
C1918 eeg_fd_ota_full2_nc_0/stage2_0/m1_52213_n15864# VSS 4.429720e-16
C1919 eeg_fd_ota_full2_nc_0/stage2_0/m1_52213_n15864# eeg_fd_ota_full2_nc_0/stage2_0/m1_53069_n15864# 6.207713e-17
C1920 eeg_fd_ota_full2_nc_0/stage2_0/m1_52641_n8557# VSS 4.429720e-16
C1921 eeg_fd_ota_full2_nc_0/stage2_0/m1_52641_n8557# eeg_fd_ota_full2_nc_0/stage2_0/m1_53497_n8557# 6.207720e-17
C1922 eeg_fd_ota_full2_nc_0/stage2_0/m1_53069_n15864# VSS 4.429720e-16
C1923 eeg_fd_ota_full2_nc_0/stage2_0/m1_53069_n15864# eeg_fd_ota_full2_nc_0/stage2_0/m1_53925_n15864# 6.207713e-17
C1924 eeg_fd_ota_full2_nc_0/stage2_0/m1_53497_n8557# VSS 4.429720e-16
C1925 eeg_fd_ota_full2_nc_0/stage2_0/m1_53497_n8557# eeg_fd_ota_full2_nc_0/stage2_0/m1_54353_n8557# 6.207706e-17
C1926 eeg_fd_ota_full2_nc_0/stage2_0/m1_53925_n15864# VSS 4.429720e-16
C1927 eeg_fd_ota_full2_nc_0/stage2_0/m1_53925_n15864# eeg_fd_ota_full2_nc_0/stage2_0/m1_54781_n15864# 6.207713e-17
C1928 eeg_fd_ota_full2_nc_0/stage2_0/m1_54353_n8557# VSS 4.429720e-16
C1929 eeg_fd_ota_full2_nc_0/stage2_0/m1_54353_n8557# eeg_fd_ota_full2_nc_0/stage2_0/m1_55209_n8557# 6.207720e-17
C1930 eeg_fd_ota_full2_nc_0/stage2_0/m1_54781_n15864# VSS 4.429720e-16
C1931 eeg_fd_ota_full2_nc_0/stage2_0/m1_54781_n15864# eeg_fd_ota_full2_nc_0/stage2_0/m1_55637_n15864# 6.207713e-17
C1932 eeg_fd_ota_full2_nc_0/stage2_0/m1_55209_n8557# VSS 4.429720e-16
C1933 eeg_fd_ota_full2_nc_0/stage2_0/m1_55209_n8557# eeg_fd_ota_full2_nc_0/stage2_0/m1_56065_n8557# 6.207720e-17
C1934 eeg_fd_ota_full2_nc_0/stage2_0/m1_55637_n15864# VSS 4.429720e-16
C1935 eeg_fd_ota_full2_nc_0/stage2_0/m1_55637_n15864# eeg_fd_ota_full2_nc_0/stage2_0/m1_56493_n15864# 6.207713e-17
C1936 eeg_fd_ota_full2_nc_0/stage2_0/m1_56065_n8557# VSS 4.429720e-16
C1937 eeg_fd_ota_full2_nc_0/stage2_0/m1_56065_n8557# eeg_fd_ota_full2_nc_0/stage2_0/m1_56921_n8557# 6.207720e-17
C1938 eeg_fd_ota_full2_nc_0/stage2_0/m1_56493_n15864# VSS 4.429720e-16
C1939 eeg_fd_ota_full2_nc_0/stage2_0/m1_56493_n15864# eeg_fd_ota_full2_nc_0/stage2_0/m1_57349_n15864# 6.207713e-17
C1940 eeg_fd_ota_full2_nc_0/stage2_0/m1_56921_n8557# VSS 4.429720e-16
C1941 eeg_fd_ota_full2_nc_0/stage2_0/m1_56921_n8557# eeg_fd_ota_full2_nc_0/stage2_0/m1_57777_n8557# 6.207720e-17
C1942 eeg_fd_ota_full2_nc_0/stage2_0/m1_57349_n15864# VSS 4.429720e-16
C1943 eeg_fd_ota_full2_nc_0/stage2_0/m1_57349_n15864# eeg_fd_ota_full2_nc_0/stage2_0/m1_58205_n15864# 6.207713e-17
C1944 eeg_fd_ota_full2_nc_0/stage2_0/m1_57777_n8557# VSS 4.429720e-16
C1945 eeg_fd_ota_full2_nc_0/stage2_0/m1_57777_n8557# eeg_fd_ota_full2_nc_0/stage2_0/m1_58633_n8557# 6.207706e-17
C1946 eeg_fd_ota_full2_nc_0/stage2_0/m1_58205_n15864# VSS 4.429720e-16
C1947 eeg_fd_ota_full2_nc_0/stage2_0/m1_58205_n15864# eeg_fd_ota_full2_nc_0/stage2_0/m1_59061_n15864# 6.207713e-17
C1948 eeg_fd_ota_full2_nc_0/stage2_0/m1_58633_n8557# VSS 4.429720e-16
C1949 eeg_fd_ota_full2_nc_0/stage2_0/m1_58633_n8557# eeg_fd_ota_full2_nc_0/stage2_0/m1_59489_n8557# 6.207720e-17
C1950 eeg_fd_ota_full2_nc_0/stage2_0/m1_59061_n15864# VSS 4.429720e-16
C1951 eeg_fd_ota_full2_nc_0/stage2_0/m1_59061_n15864# eeg_fd_ota_full2_nc_0/stage2_0/m1_59917_n15864# 6.207713e-17
C1952 eeg_fd_ota_full2_nc_0/stage2_0/m1_59489_n8557# VSS 4.429720e-16
C1953 eeg_fd_ota_full2_nc_0/stage2_0/m1_59489_n8557# eeg_fd_ota_full2_nc_0/stage2_0/m1_60345_n8557# 6.207720e-17
C1954 eeg_fd_ota_full2_nc_0/stage2_0/m1_59917_n15864# VSS 4.429720e-16
C1955 eeg_fd_ota_full2_nc_0/stage2_0/m1_59917_n15864# eeg_fd_ota_full2_nc_0/stage2_0/m1_60773_n15864# 6.207713e-17
C1956 eeg_fd_ota_full2_nc_0/stage2_0/m1_60345_n8557# VSS 4.429720e-16
C1957 eeg_fd_ota_full2_nc_0/stage2_0/m1_60345_n8557# eeg_fd_ota_full2_nc_0/stage2_0/m1_61201_n8557# 6.207714e-17
C1958 eeg_fd_ota_full2_nc_0/stage2_0/m1_60773_n15864# VSS 4.429720e-16
C1959 eeg_fd_ota_full2_nc_0/stage2_0/m1_60773_n15864# eeg_fd_ota_full2_nc_0/stage2_0/m1_61629_n15864# 6.207713e-17
C1960 eeg_fd_ota_full2_nc_0/stage2_0/m1_61201_n8557# VSS 4.429720e-16
C1961 eeg_fd_ota_full2_nc_0/stage2_0/m1_61201_n8557# eeg_fd_ota_full2_nc_0/stage2_0/m1_62057_n8557# 6.207720e-17
C1962 eeg_fd_ota_full2_nc_0/stage2_0/m1_61629_n15864# VSS 4.429720e-16
C1963 eeg_fd_ota_full2_nc_0/stage2_0/m1_61629_n15864# eeg_fd_ota_full2_nc_0/stage2_0/m1_62485_n15864# 6.207713e-17
C1964 eeg_fd_ota_full2_nc_0/stage2_0/m1_62057_n8557# VSS 4.841780e-16
C1965 eeg_fd_ota_full2_nc_0/stage2_0/m1_62485_n15864# VSS 4.698080e-16
C1966 eeg_fd_ota_full2_nc_0/stage2_0/m1_62485_n15864# eeg_fd_ota_full2_nc_0/stage2_0/m1_63941_n15864# 2.192799e-17
C1967 eeg_fd_ota_full2_nc_0/stage2_0/m1_63941_n15864# VSS 4.698080e-16
C1968 eeg_fd_ota_full2_nc_0/stage2_0/m1_63941_n15864# eeg_fd_ota_full2_nc_0/stage2_0/m1_64797_n15864# 6.207713e-17
C1969 eeg_fd_ota_full2_nc_0/stage2_0/m1_64369_n8557# VSS 4.841780e-16
C1970 eeg_fd_ota_full2_nc_0/stage2_0/m1_64369_n8557# eeg_fd_ota_full2_nc_0/stage2_0/m1_65225_n8557# 6.207720e-17
C1971 eeg_fd_ota_full2_nc_0/stage2_0/m1_64797_n15864# VSS 4.429720e-16
C1972 eeg_fd_ota_full2_nc_0/stage2_0/m1_64797_n15864# eeg_fd_ota_full2_nc_0/stage2_0/m1_65653_n15864# 6.207713e-17
C1973 eeg_fd_ota_full2_nc_0/stage2_0/m1_65225_n8557# VSS 4.429720e-16
C1974 eeg_fd_ota_full2_nc_0/stage2_0/m1_65225_n8557# eeg_fd_ota_full2_nc_0/stage2_0/m1_66081_n8557# 6.207720e-17
C1975 eeg_fd_ota_full2_nc_0/stage2_0/m1_65653_n15864# VSS 4.429720e-16
C1976 eeg_fd_ota_full2_nc_0/stage2_0/m1_65653_n15864# eeg_fd_ota_full2_nc_0/stage2_0/m1_66509_n15864# 6.207713e-17
C1977 eeg_fd_ota_full2_nc_0/stage2_0/m1_66081_n8557# VSS 4.429720e-16
C1978 eeg_fd_ota_full2_nc_0/stage2_0/m1_66081_n8557# eeg_fd_ota_full2_nc_0/stage2_0/m1_66937_n8557# 6.207706e-17
C1979 eeg_fd_ota_full2_nc_0/stage2_0/m1_66509_n15864# VSS 4.429720e-16
C1980 eeg_fd_ota_full2_nc_0/stage2_0/m1_66509_n15864# eeg_fd_ota_full2_nc_0/stage2_0/m1_67365_n15864# 6.207713e-17
C1981 eeg_fd_ota_full2_nc_0/stage2_0/m1_66937_n8557# VSS 4.429720e-16
C1982 eeg_fd_ota_full2_nc_0/stage2_0/m1_66937_n8557# eeg_fd_ota_full2_nc_0/stage2_0/m1_67793_n8557# 6.207720e-17
C1983 eeg_fd_ota_full2_nc_0/stage2_0/m1_67365_n15864# VSS 4.429720e-16
C1984 eeg_fd_ota_full2_nc_0/stage2_0/m1_67365_n15864# eeg_fd_ota_full2_nc_0/stage2_0/m1_68221_n15864# 6.207713e-17
C1985 eeg_fd_ota_full2_nc_0/stage2_0/m1_67793_n8557# VSS 4.429720e-16
C1986 eeg_fd_ota_full2_nc_0/stage2_0/m1_67793_n8557# eeg_fd_ota_full2_nc_0/stage2_0/m1_68649_n8557# 6.207720e-17
C1987 eeg_fd_ota_full2_nc_0/stage2_0/m1_68221_n15864# VSS 4.429720e-16
C1988 eeg_fd_ota_full2_nc_0/stage2_0/m1_68221_n15864# eeg_fd_ota_full2_nc_0/stage2_0/m1_69077_n15864# 6.207713e-17
C1989 eeg_fd_ota_full2_nc_0/stage2_0/m1_68649_n8557# VSS 4.429720e-16
C1990 eeg_fd_ota_full2_nc_0/stage2_0/m1_68649_n8557# eeg_fd_ota_full2_nc_0/stage2_0/m1_69505_n8557# 6.207720e-17
C1991 eeg_fd_ota_full2_nc_0/stage2_0/m1_69077_n15864# VSS 4.429720e-16
C1992 eeg_fd_ota_full2_nc_0/stage2_0/m1_69077_n15864# eeg_fd_ota_full2_nc_0/stage2_0/m1_69933_n15864# 6.207713e-17
C1993 eeg_fd_ota_full2_nc_0/stage2_0/m1_69505_n8557# VSS 4.429720e-16
C1994 eeg_fd_ota_full2_nc_0/stage2_0/m1_69505_n8557# eeg_fd_ota_full2_nc_0/stage2_0/m1_70361_n8557# 6.207720e-17
C1995 eeg_fd_ota_full2_nc_0/stage2_0/m1_69933_n15864# VSS 4.429720e-16
C1996 eeg_fd_ota_full2_nc_0/stage2_0/m1_69933_n15864# eeg_fd_ota_full2_nc_0/stage2_0/m1_70789_n15864# 6.207713e-17
C1997 eeg_fd_ota_full2_nc_0/stage2_0/m1_70361_n8557# VSS 4.429720e-16
C1998 eeg_fd_ota_full2_nc_0/stage2_0/m1_70361_n8557# eeg_fd_ota_full2_nc_0/stage2_0/m1_71217_n8557# 6.207706e-17
C1999 eeg_fd_ota_full2_nc_0/stage2_0/m1_70789_n15864# VSS 4.429720e-16
C2000 eeg_fd_ota_full2_nc_0/stage2_0/m1_70789_n15864# eeg_fd_ota_full2_nc_0/stage2_0/m1_71645_n15864# 6.207713e-17
C2001 eeg_fd_ota_full2_nc_0/stage2_0/m1_71217_n8557# VSS 4.841780e-16
C2002 eeg_fd_ota_full2_nc_0/stage2_0/m1_71645_n15864# VSS 4.917160e-16
C2003 eeg_fd_ota_full2_nc_0/stage2_0/m1_73941_n15864# VSS 4.917160e-16
C2004 eeg_fd_ota_full2_nc_0/stage2_0/m1_73941_n15864# eeg_fd_ota_full2_nc_0/stage2_0/m1_74797_n15864# 6.207713e-17
C2005 eeg_fd_ota_full2_nc_0/stage2_0/m1_74369_n8557# VSS 4.841780e-16
C2006 eeg_fd_ota_full2_nc_0/stage2_0/m1_74369_n8557# eeg_fd_ota_full2_nc_0/stage2_0/m1_75225_n8557# 6.207706e-17
C2007 eeg_fd_ota_full2_nc_0/stage2_0/m1_74797_n15864# VSS 4.429720e-16
C2008 eeg_fd_ota_full2_nc_0/stage2_0/m1_74797_n15864# eeg_fd_ota_full2_nc_0/stage2_0/m1_75653_n15864# 6.207713e-17
C2009 eeg_fd_ota_full2_nc_0/stage2_0/m1_75225_n8557# VSS 4.429720e-16
C2010 eeg_fd_ota_full2_nc_0/stage2_0/m1_75225_n8557# eeg_fd_ota_full2_nc_0/stage2_0/m1_76081_n8557# 6.207720e-17
C2011 eeg_fd_ota_full2_nc_0/stage2_0/m1_75653_n15864# VSS 4.429720e-16
C2012 eeg_fd_ota_full2_nc_0/stage2_0/m1_75653_n15864# eeg_fd_ota_full2_nc_0/stage2_0/m1_76509_n15864# 6.207713e-17
C2013 eeg_fd_ota_full2_nc_0/stage2_0/m1_76081_n8557# VSS 4.429720e-16
C2014 eeg_fd_ota_full2_nc_0/stage2_0/m1_76081_n8557# eeg_fd_ota_full2_nc_0/stage2_0/m1_76937_n8557# 6.207720e-17
C2015 eeg_fd_ota_full2_nc_0/stage2_0/m1_76509_n15864# VSS 4.429720e-16
C2016 eeg_fd_ota_full2_nc_0/stage2_0/m1_76509_n15864# eeg_fd_ota_full2_nc_0/stage2_0/m1_77365_n15864# 6.207713e-17
C2017 eeg_fd_ota_full2_nc_0/stage2_0/m1_76937_n8557# VSS 4.429720e-16
C2018 eeg_fd_ota_full2_nc_0/stage2_0/m1_76937_n8557# eeg_fd_ota_full2_nc_0/stage2_0/m1_77793_n8557# 6.207720e-17
C2019 eeg_fd_ota_full2_nc_0/stage2_0/m1_77365_n15864# VSS 4.429720e-16
C2020 eeg_fd_ota_full2_nc_0/stage2_0/m1_77365_n15864# eeg_fd_ota_full2_nc_0/stage2_0/m1_78221_n15864# 6.207713e-17
C2021 eeg_fd_ota_full2_nc_0/stage2_0/m1_77793_n8557# VSS 4.429720e-16
C2022 eeg_fd_ota_full2_nc_0/stage2_0/m1_77793_n8557# eeg_fd_ota_full2_nc_0/stage2_0/m1_78649_n8557# 6.207720e-17
C2023 eeg_fd_ota_full2_nc_0/stage2_0/m1_78221_n15864# VSS 4.429720e-16
C2024 eeg_fd_ota_full2_nc_0/stage2_0/m1_78221_n15864# eeg_fd_ota_full2_nc_0/stage2_0/m1_79077_n15864# 6.207713e-17
C2025 eeg_fd_ota_full2_nc_0/stage2_0/m1_78649_n8557# VSS 4.429720e-16
C2026 eeg_fd_ota_full2_nc_0/stage2_0/m1_78649_n8557# eeg_fd_ota_full2_nc_0/stage2_0/m1_79505_n8557# 6.207706e-17
C2027 eeg_fd_ota_full2_nc_0/stage2_0/m1_79077_n15864# VSS 4.429720e-16
C2028 eeg_fd_ota_full2_nc_0/stage2_0/m1_79077_n15864# eeg_fd_ota_full2_nc_0/stage2_0/m1_79933_n15864# 6.207713e-17
C2029 eeg_fd_ota_full2_nc_0/stage2_0/m1_79505_n8557# VSS 4.429720e-16
C2030 eeg_fd_ota_full2_nc_0/stage2_0/m1_79505_n8557# eeg_fd_ota_full2_nc_0/stage2_0/m1_80361_n8557# 6.207720e-17
C2031 eeg_fd_ota_full2_nc_0/stage2_0/m1_79933_n15864# VSS 4.429720e-16
C2032 eeg_fd_ota_full2_nc_0/stage2_0/m1_79933_n15864# eeg_fd_ota_full2_nc_0/stage2_0/m1_80789_n15864# 6.207713e-17
C2033 eeg_fd_ota_full2_nc_0/stage2_0/m1_80361_n8557# VSS 4.429720e-16
C2034 eeg_fd_ota_full2_nc_0/stage2_0/m1_80361_n8557# eeg_fd_ota_full2_nc_0/stage2_0/m1_81217_n8557# 6.207720e-17
C2035 eeg_fd_ota_full2_nc_0/stage2_0/m1_80789_n15864# VSS 4.429720e-16
C2036 eeg_fd_ota_full2_nc_0/stage2_0/m1_80789_n15864# eeg_fd_ota_full2_nc_0/stage2_0/m1_81645_n15864# 6.207713e-17
C2037 eeg_fd_ota_full2_nc_0/stage2_0/m1_81217_n8557# VSS 4.841780e-16
C2038 eeg_fd_ota_full2_nc_0/stage2_0/m1_81645_n15864# VSS 4.917160e-16
C2039 eeg_fd_ota_full2_nc_0/stage2_0/m1_59061_n15864# VSS 6.746650e-16
C2040 eeg_fd_ota_full2_nc_0/stage2_0/m1_59489_n8557# VSS 6.746650e-16
C2041 eeg_fd_ota_full2_nc_0/stage2_0/m1_25933_n15864# VSS 6.746650e-16
C2042 eeg_fd_ota_full2_nc_0/stage2_0/m1_26361_n8557# VSS 6.746650e-16
C2043 eeg_fd_ota_full2_nc_0/stage2_0/m1_21225_n8557# VSS 6.746650e-16
C2044 eeg_fd_ota_full2_nc_0/stage2_0/m1_21653_n15864# VSS 6.746650e-16
C2045 eeg_fd_ota_full2_nc_0/stage2_0/m1_37489_n8557# VSS 6.746650e-16
C2046 eeg_fd_ota_full2_nc_0/stage2_0/m1_37917_n15864# VSS 6.746650e-16
C2047 eeg_fd_ota_full2_nc_0/stage2_0/m1_79933_n15864# VSS 6.746650e-16
C2048 eeg_fd_ota_full2_nc_0/stage2_0/m1_80361_n8557# VSS 6.746650e-16
C2049 eeg_fd_ota_full2_nc_0/stage2_0/m1_75225_n8557# VSS 6.746650e-16
C2050 eeg_fd_ota_full2_nc_0/stage2_0/m1_75653_n15864# VSS 6.746650e-16
C2051 eeg_fd_ota_full2_nc_0/stage2_0/m1_69077_n15864# VSS 6.746650e-16
C2052 eeg_fd_ota_full2_nc_0/stage2_0/m1_69505_n8557# VSS 6.746650e-16
C2053 eeg_fd_ota_full2_nc_0/stage2_0/m1_64369_n8557# VSS 6.746650e-16
C2054 eeg_fd_ota_full2_nc_0/stage2_0/m1_64797_n15864# VSS 6.746650e-16
C2055 eeg_fd_ota_full2_nc_0/stage2_0/m1_58633_n8557# VSS 6.746650e-16
C2056 eeg_fd_ota_full2_nc_0/stage2_0/m1_59061_n15864# VSS 6.746650e-16
C2057 eeg_fd_ota_full2_nc_0/stage2_0/m1_30213_n15864# VSS 6.746650e-16
C2058 eeg_fd_ota_full2_nc_0/stage2_0/m1_30641_n8557# VSS 6.746650e-16
C2059 eeg_fd_ota_full2_nc_0/stage2_0/m1_25505_n8557# VSS 6.746650e-16
C2060 eeg_fd_ota_full2_nc_0/stage2_0/m1_25933_n15864# VSS 6.746650e-16
C2061 eeg_fd_ota_full2_nc_0/stage2_0/m1_20797_n15864# VSS 6.746650e-16
C2062 eeg_fd_ota_full2_nc_0/stage2_0/m1_21225_n8557# VSS 6.746650e-16
C2063 eeg_fd_ota_full2_nc_0/stage2_0/m1_37061_n15864# VSS 6.746650e-16
C2064 eeg_fd_ota_full2_nc_0/stage2_0/m1_37489_n8557# VSS 6.746650e-16
C2065 eeg_fd_ota_full2_nc_0/stage2_0/m1_79505_n8557# VSS 6.746650e-16
C2066 eeg_fd_ota_full2_nc_0/stage2_0/m1_79933_n15864# VSS 6.746650e-16
C2067 eeg_fd_ota_full2_nc_0/stage2_0/m1_74797_n15864# VSS 6.746650e-16
C2068 eeg_fd_ota_full2_nc_0/stage2_0/m1_75225_n8557# VSS 6.746650e-16
C2069 eeg_fd_ota_full2_nc_0/stage2_0/m1_68649_n8557# VSS 6.746650e-16
C2070 eeg_fd_ota_full2_nc_0/stage2_0/m1_69077_n15864# VSS 6.746650e-16
C2071 eeg_fd_ota_full2_nc_0/stage2_0/m1_63941_n15864# VSS 6.746650e-16
C2072 eeg_fd_ota_full2_nc_0/stage2_0/m1_64369_n8557# VSS 6.746650e-16
C2073 eeg_fd_ota_full2_nc_0/stage2_0/m1_58205_n15864# VSS 6.746650e-16
C2074 eeg_fd_ota_full2_nc_0/stage2_0/m1_58633_n8557# VSS 6.746650e-16
C2075 eeg_fd_ota_full2_nc_0/stage2_0/m1_29785_n8557# VSS 6.746650e-16
C2076 eeg_fd_ota_full2_nc_0/stage2_0/m1_30213_n15864# VSS 6.746650e-16
C2077 eeg_fd_ota_full2_nc_0/stage2_0/m1_25077_n15864# VSS 6.746650e-16
C2078 eeg_fd_ota_full2_nc_0/stage2_0/m1_25505_n8557# VSS 6.746650e-16
C2079 eeg_fd_ota_full2_nc_0/stage2_0/m1_20369_n8557# VSS 6.746650e-16
C2080 eeg_fd_ota_full2_nc_0/stage2_0/m1_20797_n15864# VSS 6.746650e-16
C2081 eeg_fd_ota_full2_nc_0/stage2_0/m1_36633_n8557# VSS 6.746650e-16
C2082 eeg_fd_ota_full2_nc_0/stage2_0/m1_37061_n15864# VSS 6.746650e-16
C2083 eeg_fd_ota_full2_nc_0/stage2_0/m1_79077_n15864# VSS 6.746650e-16
C2084 eeg_fd_ota_full2_nc_0/stage2_0/m1_79505_n8557# VSS 6.746650e-16
C2085 eeg_fd_ota_full2_nc_0/stage2_0/m1_74369_n8557# VSS 6.746650e-16
C2086 eeg_fd_ota_full2_nc_0/stage2_0/m1_74797_n15864# VSS 6.746650e-16
C2087 eeg_fd_ota_full2_nc_0/stage2_0/m1_68221_n15864# VSS 6.746650e-16
C2088 eeg_fd_ota_full2_nc_0/stage2_0/m1_68649_n8557# VSS 6.746650e-16
C2089 OINTP VSS 6.746650e-16
C2090 eeg_fd_ota_full2_nc_0/stage2_0/m1_63941_n15864# VSS 6.746650e-16
C2091 eeg_fd_ota_full2_nc_0/stage2_0/m1_29357_n15864# VSS 6.746650e-16
C2092 eeg_fd_ota_full2_nc_0/stage2_0/m1_29785_n8557# VSS 6.746650e-16
C2093 eeg_fd_ota_full2_nc_0/stage2_0/m1_24649_n8557# VSS 6.746650e-16
C2094 eeg_fd_ota_full2_nc_0/stage2_0/m1_25077_n15864# VSS 6.746650e-16
C2095 eeg_fd_ota_full2_nc_0/stage2_0/m1_19941_n15864# VSS 6.746650e-16
C2096 eeg_fd_ota_full2_nc_0/stage2_0/m1_20369_n8557# VSS 6.746650e-16
C2097 eeg_fd_ota_full2_nc_0/stage2_0/m1_36205_n15864# VSS 6.746650e-16
C2098 eeg_fd_ota_full2_nc_0/stage2_0/m1_36633_n8557# VSS 6.746650e-16
C2099 eeg_fd_ota_full2_nc_0/stage2_0/m1_78649_n8557# VSS 6.746650e-16
C2100 eeg_fd_ota_full2_nc_0/stage2_0/m1_79077_n15864# VSS 6.746650e-16
C2101 eeg_fd_ota_full2_nc_0/stage2_0/m1_73941_n15864# VSS 6.746650e-16
C2102 eeg_fd_ota_full2_nc_0/stage2_0/m1_74369_n8557# VSS 6.746650e-16
C2103 eeg_fd_ota_full2_nc_0/stage2_0/m1_67793_n8557# VSS 6.746650e-16
C2104 eeg_fd_ota_full2_nc_0/stage2_0/m1_68221_n15864# VSS 6.746650e-16
C2105 eeg_fd_ota_full2_nc_0/stage2_0/VCM2 VSS 6.746650e-16
C2106 eeg_fd_ota_full2_nc_0/stage2_0/m1_62485_n15864# VSS 6.746650e-16
C2107 eeg_fd_ota_full2_nc_0/stage2_0/m1_28929_n8557# VSS 6.746650e-16
C2108 eeg_fd_ota_full2_nc_0/stage2_0/m1_29357_n15864# VSS 6.746650e-16
C2109 eeg_fd_ota_full2_nc_0/stage2_0/m1_24221_n15864# VSS 6.746650e-16
C2110 eeg_fd_ota_full2_nc_0/stage2_0/m1_24649_n8557# VSS 6.746650e-16
C2111 OINTP VSS 6.746650e-16
C2112 eeg_fd_ota_full2_nc_0/stage2_0/m1_19941_n15864# VSS 6.746650e-16
C2113 eeg_fd_ota_full2_nc_0/stage2_0/m1_35777_n8557# VSS 6.746650e-16
C2114 eeg_fd_ota_full2_nc_0/stage2_0/m1_36205_n15864# VSS 6.746650e-16
C2115 eeg_fd_ota_full2_nc_0/stage2_0/m1_78221_n15864# VSS 6.746650e-16
C2116 eeg_fd_ota_full2_nc_0/stage2_0/m1_78649_n8557# VSS 6.746650e-16
C2117 OINTN VSS 6.746650e-16
C2118 eeg_fd_ota_full2_nc_0/stage2_0/m1_73941_n15864# VSS 6.746650e-16
C2119 eeg_fd_ota_full2_nc_0/stage2_0/m1_67365_n15864# VSS 6.746650e-16
C2120 eeg_fd_ota_full2_nc_0/stage2_0/m1_67793_n8557# VSS 6.746650e-16
C2121 eeg_fd_ota_full2_nc_0/stage2_0/m1_28501_n15864# VSS 6.746650e-16
C2122 eeg_fd_ota_full2_nc_0/stage2_0/m1_28929_n8557# VSS 6.746650e-16
C2123 eeg_fd_ota_full2_nc_0/stage2_0/m1_23793_n8557# VSS 6.746650e-16
C2124 eeg_fd_ota_full2_nc_0/stage2_0/m1_24221_n15864# VSS 6.746650e-16
C2125 eeg_fd_ota_full2_nc_0/stage2_0/m1_40057_n8557# VSS 6.746650e-16
C2126 eeg_fd_ota_full2_nc_0/stage2_0/m1_40485_n15864# VSS 6.746650e-16
C2127 eeg_fd_ota_full2_nc_0/stage2_0/m1_35349_n15864# VSS 6.746650e-16
C2128 eeg_fd_ota_full2_nc_0/stage2_0/m1_35777_n8557# VSS 6.746650e-16
C2129 eeg_fd_ota_full2_nc_0/stage2_0/m1_77793_n8557# VSS 6.746650e-16
C2130 eeg_fd_ota_full2_nc_0/stage2_0/m1_78221_n15864# VSS 6.746650e-16
C2131 VCM_REF VSS 6.746650e-16
C2132 eeg_fd_ota_full2_nc_0/stage2_0/m1_71645_n15864# VSS 6.746650e-16
C2133 eeg_fd_ota_full2_nc_0/stage2_0/m1_28073_n8557# VSS 6.746650e-16
C2134 eeg_fd_ota_full2_nc_0/stage2_0/m1_28501_n15864# VSS 6.746650e-16
C2135 eeg_fd_ota_full2_nc_0/stage2_0/m1_23365_n15864# VSS 6.746650e-16
C2136 eeg_fd_ota_full2_nc_0/stage2_0/m1_23793_n8557# VSS 6.746650e-16
C2137 eeg_fd_ota_full2_nc_0/stage2_0/m1_39629_n15864# VSS 6.746650e-16
C2138 eeg_fd_ota_full2_nc_0/stage2_0/m1_40057_n8557# VSS 6.746650e-16
C2139 eeg_fd_ota_full2_nc_0/stage2_0/m1_34921_n8557# VSS 6.746650e-16
C2140 eeg_fd_ota_full2_nc_0/stage2_0/m1_35349_n15864# VSS 6.746650e-16
C2141 eeg_fd_ota_full2_nc_0/stage2_0/m1_77365_n15864# VSS 6.746650e-16
C2142 eeg_fd_ota_full2_nc_0/stage2_0/m1_77793_n8557# VSS 6.746650e-16
C2143 eeg_fd_ota_full2_nc_0/stage2_0/m1_27645_n15864# VSS 6.746650e-16
C2144 eeg_fd_ota_full2_nc_0/stage2_0/m1_28073_n8557# VSS 6.746650e-16
C2145 eeg_fd_ota_full2_nc_0/stage2_0/m1_22937_n8557# VSS 6.746650e-16
C2146 eeg_fd_ota_full2_nc_0/stage2_0/m1_23365_n15864# VSS 6.746650e-16
C2147 eeg_fd_ota_full2_nc_0/stage2_0/m1_39201_n8557# VSS 6.746650e-16
C2148 eeg_fd_ota_full2_nc_0/stage2_0/m1_39629_n15864# VSS 6.746650e-16
C2149 VCM_REF VSS 6.746650e-16
C2150 eeg_fd_ota_full2_nc_0/stage2_0/m1_81645_n15864# VSS 6.746650e-16
C2151 eeg_fd_ota_full2_nc_0/stage2_0/m1_27217_n8557# VSS 6.746650e-16
C2152 eeg_fd_ota_full2_nc_0/stage2_0/m1_27645_n15864# VSS 6.746650e-16
C2153 eeg_fd_ota_full2_nc_0/stage2_0/m1_22509_n15864# VSS 6.746650e-16
C2154 eeg_fd_ota_full2_nc_0/stage2_0/m1_22937_n8557# VSS 6.746650e-16
C2155 eeg_fd_ota_full2_nc_0/stage2_0/m1_38773_n15864# VSS 6.746650e-16
C2156 eeg_fd_ota_full2_nc_0/stage2_0/m1_39201_n8557# VSS 6.746650e-16
C2157 eeg_fd_ota_full2_nc_0/stage2_0/m1_26789_n15864# VSS 6.746650e-16
C2158 eeg_fd_ota_full2_nc_0/stage2_0/m1_27217_n8557# VSS 6.746650e-16
C2159 eeg_fd_ota_full2_nc_0/stage2_0/m1_22081_n8557# VSS 6.746650e-16
C2160 eeg_fd_ota_full2_nc_0/stage2_0/m1_22509_n15864# VSS 6.746650e-16
C2161 eeg_fd_ota_full2_nc_0/stage2_0/m1_26361_n8557# VSS 6.746650e-16
C2162 eeg_fd_ota_full2_nc_0/stage2_0/m1_26789_n15864# VSS 6.746650e-16
C2163 OINTN VDD18 9.216400e-16
C2164 OINTN VSS 4.856640e-16
C2165 OINTN eeg_fd_ota_full2_nc_0/stage2_0/VBP2 3.596600e-15
C2166 VDD18 VSS 1.074004e-13
C2167 VDD18 eeg_fd_ota_full2_nc_0/stage2_0/VBP2 2.903319e-14
C2168 eeg_fd_ota_full2_nc_0/stage2_0/VBP2 VSS 7.027174e-15
C2169 eeg_fd_ota_full2_nc_0/stage2_0/m1_34493_n15864# VSS 6.746650e-16
C2170 eeg_fd_ota_full2_nc_0/stage2_0/m1_34921_n8557# VSS 6.746650e-16
C2171 OINTN VSS 1.639490e-16
C2172 OINTN eeg_fd_ota_full2_nc_0/stage2_0/N2N 8.991500e-16
C2173 VSS eeg_fd_ota_full2_nc_0/stage2_0/N2N 9.971760e-16
C2174 eeg_fd_ota_full2_nc_0/stage2_0/N2N VSS 7.765320e-15
C2175 eeg_fd_ota_full2_nc_0/stage2_0/m1_34065_n8557# VSS 6.746650e-16
C2176 eeg_fd_ota_full2_nc_0/stage2_0/m1_34493_n15864# VSS 6.746650e-16
C2177 eeg_fd_ota_full2_nc_0/stage2_0/m1_33637_n15864# VSS 6.746650e-16
C2178 eeg_fd_ota_full2_nc_0/stage2_0/m1_34065_n8557# VSS 6.746650e-16
C2179 eeg_fd_ota_full2_nc_0/stage2_0/m1_33209_n8557# VSS 6.746650e-16
C2180 eeg_fd_ota_full2_nc_0/stage2_0/m1_33637_n15864# VSS 6.746650e-16
C2181 eeg_fd_ota_full2_nc_0/stage2_0/m1_32781_n15864# VSS 6.746650e-16
C2182 eeg_fd_ota_full2_nc_0/stage2_0/m1_33209_n8557# VSS 6.746650e-16
C2183 eeg_fd_ota_full2_nc_0/stage2_0/m1_32353_n8557# VSS 6.746650e-16
C2184 eeg_fd_ota_full2_nc_0/stage2_0/m1_32781_n15864# VSS 6.746650e-16
C2185 eeg_fd_ota_full2_nc_0/stage2_0/m1_31925_n15864# VSS 6.746650e-16
C2186 eeg_fd_ota_full2_nc_0/stage2_0/m1_32353_n8557# VSS 6.746650e-16
C2187 eeg_fd_ota_full2_nc_0/stage2_0/N2N VSS 6.668820e-16
C2189 eeg_fd_ota_full2_nc_0/stage2_0/m1_12966_n5928# VSS 6.668820e-16
C2190 eeg_fd_ota_full2_nc_0/stage2_0/m1_31497_n8557# VSS 6.746650e-16
C2191 eeg_fd_ota_full2_nc_0/stage2_0/m1_31925_n15864# VSS 6.746650e-16
C2192 eeg_fd_ota_full2_nc_0/stage2_0/m1_44937_n8557# VSS 6.746650e-16
C2193 eeg_fd_ota_full2_nc_0/stage2_0/m1_45365_n15864# VSS 6.746650e-16
C2194 eeg_fd_ota_full2_nc_0/stage2_0/N2P VSS 6.668820e-16
C2196 eeg_fd_ota_full2_nc_0/stage2_0/m1_3966_n5928# VSS 6.668820e-16
C2197 eeg_fd_ota_full2_nc_0/stage2_0/m1_31069_n15864# VSS 6.746650e-16
C2198 eeg_fd_ota_full2_nc_0/stage2_0/m1_31497_n8557# VSS 6.746650e-16
C2199 eeg_fd_ota_full2_nc_0/stage2_0/m1_44509_n15864# VSS 6.746650e-16
C2200 eeg_fd_ota_full2_nc_0/stage2_0/m1_44937_n8557# VSS 6.746650e-16
C2201 eeg_fd_ota_full2_nc_0/stage2_0/m1_49217_n8557# VSS 6.746650e-16
C2202 eeg_fd_ota_full2_nc_0/stage2_0/m1_49645_n15864# VSS 6.746650e-16
C2203 eeg_fd_ota_full2_nc_0/stage2_0/m1_30641_n8557# VSS 6.746650e-16
C2204 eeg_fd_ota_full2_nc_0/stage2_0/m1_31069_n15864# VSS 6.746650e-16
C2205 eeg_fd_ota_full2_nc_0/stage2_0/m1_44081_n8557# VSS 6.746650e-16
C2206 eeg_fd_ota_full2_nc_0/stage2_0/m1_44509_n15864# VSS 6.746650e-16
C2207 eeg_fd_ota_full2_nc_0/stage2_0/m1_48789_n15864# VSS 6.746650e-16
C2208 eeg_fd_ota_full2_nc_0/stage2_0/m1_49217_n8557# VSS 6.746650e-16
C2209 eeg_fd_ota_full2_nc_0/stage2_0/m1_53497_n8557# VSS 6.746650e-16
C2210 eeg_fd_ota_full2_nc_0/stage2_0/m1_53925_n15864# VSS 6.746650e-16
C2211 eeg_fd_ota_full2_nc_0/stage2_0/m1_43653_n15864# VSS 6.746650e-16
C2212 eeg_fd_ota_full2_nc_0/stage2_0/m1_44081_n8557# VSS 6.746650e-16
C2213 eeg_fd_ota_full2_nc_0/stage2_0/m1_48361_n8557# VSS 6.746650e-16
C2214 eeg_fd_ota_full2_nc_0/stage2_0/m1_48789_n15864# VSS 6.746650e-16
C2215 eeg_fd_ota_full2_nc_0/stage2_0/m1_53069_n15864# VSS 6.746650e-16
C2216 eeg_fd_ota_full2_nc_0/stage2_0/m1_53497_n8557# VSS 6.746650e-16
C2217 eeg_fd_ota_full2_nc_0/stage2_0/m1_57777_n8557# VSS 6.746650e-16
C2218 eeg_fd_ota_full2_nc_0/stage2_0/m1_58205_n15864# VSS 6.746650e-16
C2219 eeg_fd_ota_full2_nc_0/stage2_0/m1_43225_n8557# VSS 6.746650e-16
C2220 eeg_fd_ota_full2_nc_0/stage2_0/m1_43653_n15864# VSS 6.746650e-16
C2221 eeg_fd_ota_full2_nc_0/stage2_0/m1_47933_n15864# VSS 6.746650e-16
C2222 eeg_fd_ota_full2_nc_0/stage2_0/m1_48361_n8557# VSS 6.746650e-16
C2223 eeg_fd_ota_full2_nc_0/stage2_0/m1_52641_n8557# VSS 6.746650e-16
C2224 eeg_fd_ota_full2_nc_0/stage2_0/m1_53069_n15864# VSS 6.746650e-16
C2225 eeg_fd_ota_full2_nc_0/stage2_0/m1_57349_n15864# VSS 6.746650e-16
C2226 eeg_fd_ota_full2_nc_0/stage2_0/m1_57777_n8557# VSS 6.746650e-16
C2227 eeg_fd_ota_full2_nc_0/stage2_0/m1_42797_n15864# VSS 6.746650e-16
C2228 eeg_fd_ota_full2_nc_0/stage2_0/m1_43225_n8557# VSS 6.746650e-16
C2229 eeg_fd_ota_full2_nc_0/stage2_0/m1_47505_n8557# VSS 6.746650e-16
C2230 eeg_fd_ota_full2_nc_0/stage2_0/m1_47933_n15864# VSS 6.746650e-16
C2231 eeg_fd_ota_full2_nc_0/stage2_0/m1_52213_n15864# VSS 6.746650e-16
C2232 eeg_fd_ota_full2_nc_0/stage2_0/m1_52641_n8557# VSS 6.746650e-16
C2233 eeg_fd_ota_full2_nc_0/stage2_0/m1_56921_n8557# VSS 6.746650e-16
C2234 eeg_fd_ota_full2_nc_0/stage2_0/m1_57349_n15864# VSS 6.746650e-16
C2235 eeg_fd_ota_full2_nc_0/stage2_0/m1_42369_n8557# VSS 6.746650e-16
C2236 eeg_fd_ota_full2_nc_0/stage2_0/m1_42797_n15864# VSS 6.746650e-16
C2237 eeg_fd_ota_full2_nc_0/stage2_0/m1_47077_n15864# VSS 6.746650e-16
C2238 eeg_fd_ota_full2_nc_0/stage2_0/m1_47505_n8557# VSS 6.746650e-16
C2239 eeg_fd_ota_full2_nc_0/stage2_0/m1_51785_n8557# VSS 6.746650e-16
C2240 eeg_fd_ota_full2_nc_0/stage2_0/m1_52213_n15864# VSS 6.746650e-16
C2241 eeg_fd_ota_full2_nc_0/stage2_0/m1_56493_n15864# VSS 6.746650e-16
C2242 eeg_fd_ota_full2_nc_0/stage2_0/m1_56921_n8557# VSS 6.746650e-16
C2243 eeg_fd_ota_full2_nc_0/stage2_0/m1_62057_n8557# VSS 6.746650e-16
C2244 eeg_fd_ota_full2_nc_0/stage2_0/m1_62485_n15864# VSS 6.746650e-16
C2245 eeg_fd_ota_full2_nc_0/stage2_0/m1_41941_n15864# VSS 6.746650e-16
C2246 eeg_fd_ota_full2_nc_0/stage2_0/m1_42369_n8557# VSS 6.746650e-16
C2247 eeg_fd_ota_full2_nc_0/stage2_0/m1_46649_n8557# VSS 6.746650e-16
C2248 eeg_fd_ota_full2_nc_0/stage2_0/m1_47077_n15864# VSS 6.746650e-16
C2249 eeg_fd_ota_full2_nc_0/stage2_0/m1_51357_n15864# VSS 6.746650e-16
C2250 eeg_fd_ota_full2_nc_0/stage2_0/m1_51785_n8557# VSS 6.746650e-16
C2251 eeg_fd_ota_full2_nc_0/stage2_0/m1_56065_n8557# VSS 6.746650e-16
C2252 eeg_fd_ota_full2_nc_0/stage2_0/m1_56493_n15864# VSS 6.746650e-16
C2253 eeg_fd_ota_full2_nc_0/stage2_0/m1_61629_n15864# VSS 6.746650e-16
C2254 eeg_fd_ota_full2_nc_0/stage2_0/m1_62057_n8557# VSS 6.746650e-16
C2255 eeg_fd_ota_full2_nc_0/stage2_0/m1_66937_n8557# VSS 6.746650e-16
C2256 eeg_fd_ota_full2_nc_0/stage2_0/m1_67365_n15864# VSS 6.746650e-16
C2257 OINTN VSS 6.746650e-16
C2258 eeg_fd_ota_full2_nc_0/stage2_0/m1_41941_n15864# VSS 6.746650e-16
C2259 eeg_fd_ota_full2_nc_0/stage2_0/m1_46221_n15864# VSS 6.746650e-16
C2260 eeg_fd_ota_full2_nc_0/stage2_0/m1_46649_n8557# VSS 6.746650e-16
C2261 eeg_fd_ota_full2_nc_0/stage2_0/m1_50929_n8557# VSS 6.746650e-16
C2262 eeg_fd_ota_full2_nc_0/stage2_0/m1_51357_n15864# VSS 6.746650e-16
C2263 eeg_fd_ota_full2_nc_0/stage2_0/m1_55637_n15864# VSS 6.746650e-16
C2264 eeg_fd_ota_full2_nc_0/stage2_0/m1_56065_n8557# VSS 6.746650e-16
C2265 eeg_fd_ota_full2_nc_0/stage2_0/m1_61201_n8557# VSS 6.746650e-16
C2266 eeg_fd_ota_full2_nc_0/stage2_0/m1_61629_n15864# VSS 6.746650e-16
C2267 eeg_fd_ota_full2_nc_0/stage2_0/m1_71217_n8557# VSS 6.746650e-16
C2268 eeg_fd_ota_full2_nc_0/stage2_0/m1_71645_n15864# VSS 6.746650e-16
C2269 eeg_fd_ota_full2_nc_0/stage2_0/m1_66509_n15864# VSS 6.746650e-16
C2270 eeg_fd_ota_full2_nc_0/stage2_0/m1_66937_n8557# VSS 6.746650e-16
C2271 eeg_fd_ota_full2_nc_0/stage2_0/VCM2 VSS 6.746650e-16
C2272 eeg_fd_ota_full2_nc_0/stage2_0/m1_40485_n15864# VSS 6.746650e-16
C2273 eeg_fd_ota_full2_nc_0/stage2_0/m1_45793_n8557# VSS 6.746650e-16
C2274 eeg_fd_ota_full2_nc_0/stage2_0/m1_46221_n15864# VSS 6.746650e-16
C2275 eeg_fd_ota_full2_nc_0/stage2_0/m1_50501_n15864# VSS 6.746650e-16
C2276 eeg_fd_ota_full2_nc_0/stage2_0/m1_50929_n8557# VSS 6.746650e-16
C2277 eeg_fd_ota_full2_nc_0/stage2_0/m1_55209_n8557# VSS 6.746650e-16
C2278 eeg_fd_ota_full2_nc_0/stage2_0/m1_55637_n15864# VSS 6.746650e-16
C2279 eeg_fd_ota_full2_nc_0/stage2_0/m1_60773_n15864# VSS 6.746650e-16
C2280 eeg_fd_ota_full2_nc_0/stage2_0/m1_61201_n8557# VSS 6.746650e-16
C2281 eeg_fd_ota_full2_nc_0/stage2_0/m1_76937_n8557# VSS 6.746650e-16
C2282 eeg_fd_ota_full2_nc_0/stage2_0/m1_77365_n15864# VSS 6.746650e-16
C2283 eeg_fd_ota_full2_nc_0/stage2_0/m1_70789_n15864# VSS 6.746650e-16
C2284 eeg_fd_ota_full2_nc_0/stage2_0/m1_71217_n8557# VSS 6.746650e-16
C2285 eeg_fd_ota_full2_nc_0/stage2_0/m1_66081_n8557# VSS 6.746650e-16
C2286 eeg_fd_ota_full2_nc_0/stage2_0/m1_66509_n15864# VSS 6.746650e-16
C2287 OINTP VDD18 9.216400e-16
C2288 OINTP VSS 4.856640e-16
C2289 OINTP eeg_fd_ota_full2_nc_0/stage2_0/VBP2 3.596600e-15
C2290 VDD18 VSS 1.074004e-13
C2291 VDD18 eeg_fd_ota_full2_nc_0/stage2_0/VBP2 2.903319e-14
C2292 eeg_fd_ota_full2_nc_0/stage2_0/VBP2 VSS 7.027174e-15
C2293 eeg_fd_ota_full2_nc_0/stage2_0/m1_45365_n15864# VSS 6.746650e-16
C2294 eeg_fd_ota_full2_nc_0/stage2_0/m1_45793_n8557# VSS 6.746650e-16
C2295 eeg_fd_ota_full2_nc_0/stage2_0/m1_50073_n8557# VSS 6.746650e-16
C2296 eeg_fd_ota_full2_nc_0/stage2_0/m1_50501_n15864# VSS 6.746650e-16
C2297 eeg_fd_ota_full2_nc_0/stage2_0/m1_54781_n15864# VSS 6.746650e-16
C2298 eeg_fd_ota_full2_nc_0/stage2_0/m1_55209_n8557# VSS 6.746650e-16
C2299 eeg_fd_ota_full2_nc_0/stage2_0/m1_60345_n8557# VSS 6.746650e-16
C2300 eeg_fd_ota_full2_nc_0/stage2_0/m1_60773_n15864# VSS 6.746650e-16
C2301 eeg_fd_ota_full2_nc_0/stage2_0/m1_81217_n8557# VSS 6.746650e-16
C2302 eeg_fd_ota_full2_nc_0/stage2_0/m1_81645_n15864# VSS 6.746650e-16
C2303 eeg_fd_ota_full2_nc_0/stage2_0/m1_76509_n15864# VSS 6.746650e-16
C2304 eeg_fd_ota_full2_nc_0/stage2_0/m1_76937_n8557# VSS 6.746650e-16
C2305 eeg_fd_ota_full2_nc_0/stage2_0/m1_70361_n8557# VSS 6.746650e-16
C2306 eeg_fd_ota_full2_nc_0/stage2_0/m1_70789_n15864# VSS 6.746650e-16
C2307 eeg_fd_ota_full2_nc_0/stage2_0/m1_65653_n15864# VSS 6.746650e-16
C2308 eeg_fd_ota_full2_nc_0/stage2_0/m1_66081_n8557# VSS 6.746650e-16
C2309 eeg_fd_ota_full2_nc_0/stage2_0/m1_49645_n15864# VSS 6.746650e-16
C2310 eeg_fd_ota_full2_nc_0/stage2_0/m1_50073_n8557# VSS 6.746650e-16
C2311 eeg_fd_ota_full2_nc_0/stage2_0/m1_54353_n8557# VSS 6.746650e-16
C2312 eeg_fd_ota_full2_nc_0/stage2_0/m1_54781_n15864# VSS 6.746650e-16
C2313 eeg_fd_ota_full2_nc_0/stage2_0/m1_59917_n15864# VSS 6.746650e-16
C2314 eeg_fd_ota_full2_nc_0/stage2_0/m1_60345_n8557# VSS 6.746650e-16
C2315 eeg_fd_ota_full2_nc_0/stage2_0/m1_38345_n8557# VSS 6.746650e-16
C2316 eeg_fd_ota_full2_nc_0/stage2_0/m1_38773_n15864# VSS 6.746650e-16
C2317 eeg_fd_ota_full2_nc_0/stage2_0/m1_80789_n15864# VSS 6.746650e-16
C2318 eeg_fd_ota_full2_nc_0/stage2_0/m1_81217_n8557# VSS 6.746650e-16
C2319 eeg_fd_ota_full2_nc_0/stage2_0/m1_76081_n8557# VSS 6.746650e-16
C2320 eeg_fd_ota_full2_nc_0/stage2_0/m1_76509_n15864# VSS 6.746650e-16
C2321 eeg_fd_ota_full2_nc_0/stage2_0/m1_69933_n15864# VSS 6.746650e-16
C2322 eeg_fd_ota_full2_nc_0/stage2_0/m1_70361_n8557# VSS 6.746650e-16
C2323 eeg_fd_ota_full2_nc_0/stage2_0/m1_65225_n8557# VSS 6.746650e-16
C2324 eeg_fd_ota_full2_nc_0/stage2_0/m1_65653_n15864# VSS 6.746650e-16
C2325 eeg_fd_ota_full2_nc_0/stage2_0/m1_53925_n15864# VSS 6.746650e-16
C2326 eeg_fd_ota_full2_nc_0/stage2_0/m1_54353_n8557# VSS 6.746650e-16
C2327 eeg_fd_ota_full2_nc_0/stage2_0/m1_59489_n8557# VSS 6.746650e-16
C2328 eeg_fd_ota_full2_nc_0/stage2_0/m1_59917_n15864# VSS 6.746650e-16
C2329 eeg_fd_ota_full2_nc_0/stage2_0/m1_21653_n15864# VSS 6.746650e-16
C2330 eeg_fd_ota_full2_nc_0/stage2_0/m1_22081_n8557# VSS 6.746650e-16
C2331 eeg_fd_ota_full2_nc_0/stage2_0/m1_37917_n15864# VSS 6.746650e-16
C2332 eeg_fd_ota_full2_nc_0/stage2_0/m1_38345_n8557# VSS 6.746650e-16
C2333 eeg_fd_ota_full2_nc_0/stage2_0/m1_80361_n8557# VSS 6.746650e-16
C2334 eeg_fd_ota_full2_nc_0/stage2_0/m1_80789_n15864# VSS 6.746650e-16
C2335 eeg_fd_ota_full2_nc_0/stage2_0/m1_75653_n15864# VSS 6.746650e-16
C2336 eeg_fd_ota_full2_nc_0/stage2_0/m1_76081_n8557# VSS 6.746650e-16
C2337 eeg_fd_ota_full2_nc_0/stage2_0/m1_69505_n8557# VSS 6.746650e-16
C2338 eeg_fd_ota_full2_nc_0/stage2_0/m1_69933_n15864# VSS 6.746650e-16
C2339 eeg_fd_ota_full2_nc_0/stage2_0/m1_64797_n15864# VSS 6.746650e-16
C2340 eeg_fd_ota_full2_nc_0/stage2_0/m1_65225_n8557# VSS 6.746650e-16
C2341 OINTP VSS 1.639490e-16
C2342 OINTP eeg_fd_ota_full2_nc_0/stage2_0/N2P 8.991500e-16
C2343 VSS eeg_fd_ota_full2_nc_0/stage2_0/N2P 9.971760e-16
C2344 eeg_fd_ota_full2_nc_0/stage2_0/N2P VSS 7.765320e-15
C2345 VCM_REF VDD18 2.703258e-17
C2346 VCM_REF VSS 3.541190e-14
C2348 VCM_REF eeg_fd_ota_full2_nc_0/eeg_cmfb_amp_dl2_0/VCM_SENSE 1.587590e-14
C2349 VCM_REF eeg_fd_ota_full2_nc_0/eeg_fd_ota_core_soft_0/m1_50637_3443# 7.008770e-17
C2351 VCM_REF eeg_fd_ota_full2_nc_0/eeg_fd_ota_core_soft_0/m1_n51183_3443# 7.008770e-17
C2355 VDD18 VSS 1.621650e-14
C2356 VDD18 eeg_fd_ota_full2_nc_0/eeg_cmfb_amp_dl2_0/VBP 3.427693e-15
C2357 VDD18 eeg_fd_ota_full2_nc_0/eeg_cmfb_amp_dl2_0/VCM_SENSE 4.825121e-15
C2358 VDD18 eeg_fd_ota_full2_nc_0/stage2_0/N2N 2.666394e-16
C2359 VDD18 eeg_fd_ota_full2_nc_0/stage2_0/N2P 2.827840e-16
C2360 VDD18 eeg_pseudo_res_0/B 2.563693e-17
C2361 VDD18 eeg_pseudo_res_1/B 2.022347e-16
C2362 VSS eeg_fd_ota_full2_nc_0/eeg_bias_gen_0/VBNF 3.521512e-15
C2363 VSS eeg_fd_ota_full2_nc_0/eeg_fd_ota_core_soft_0/m1_n22658_111# 2.612991e-14
C2364 VSS eeg_fd_ota_full2_nc_0/stage2_0/N2N 1.737419e-15
C2365 VSS eeg_fd_ota_full2_nc_0/stage2_0/N2P 8.481620e-16
C2366 VSS eeg_pseudo_res_0/B 1.319906e-14
C2367 VSS eeg_pseudo_res_1/B 2.891675e-15
C2368 eeg_fd_ota_full2_nc_0/eeg_bias_gen_0/VBNF VSS 6.189670e-15
C2369 eeg_fd_ota_full2_nc_0/eeg_bias_gen_0/VBNF eeg_fd_ota_full2_nc_0/eeg_fd_ota_core_soft_0/m1_n22658_111# 6.839995e-16
C2370 eeg_fd_ota_full2_nc_0/eeg_bias_gen_0/VBNF eeg_pseudo_res_0/B 6.911931e-17
C2371 eeg_fd_ota_full2_nc_0/eeg_bias_gen_0/VBNF eeg_pseudo_res_1/B 6.042561e-17
C2372 eeg_fd_ota_full2_nc_0/eeg_cmfb_amp_dl2_0/VBP VSS 1.400120e-14
C2374 eeg_fd_ota_full2_nc_0/eeg_cmfb_amp_dl2_0/VBP eeg_fd_ota_full2_nc_0/stage2_0/N2N 7.668368e-16
C2375 eeg_fd_ota_full2_nc_0/eeg_cmfb_amp_dl2_0/VBP eeg_fd_ota_full2_nc_0/stage2_0/N2P 7.875883e-16
C2376 eeg_fd_ota_full2_nc_0/eeg_cmfb_amp_dl2_0/VBP eeg_pseudo_res_0/B 6.164535e-17
C2377 eeg_fd_ota_full2_nc_0/eeg_cmfb_amp_dl2_0/VBP eeg_pseudo_res_1/B 6.844558e-16
C2378 eeg_fd_ota_full2_nc_0/eeg_cmfb_amp_dl2_0/VCM_SENSE VSS 2.834820e-14
C2379 eeg_fd_ota_full2_nc_0/eeg_cmfb_amp_dl2_0/VCM_SENSE eeg_fd_ota_full2_nc_0/eeg_fd_ota_core_soft_0/m1_27397_3443# 7.008770e-17
C2381 eeg_fd_ota_full2_nc_0/eeg_cmfb_amp_dl2_0/VCM_SENSE eeg_fd_ota_full2_nc_0/eeg_fd_ota_core_soft_0/m1_n27943_3443# 7.008770e-17
C2385 eeg_fd_ota_full2_nc_0/eeg_fd_ota_core_soft_0/m1_26969_n3864# VSS 4.917160e-16
C2386 eeg_fd_ota_full2_nc_0/eeg_fd_ota_core_soft_0/m1_26969_n3864# eeg_fd_ota_full2_nc_0/eeg_fd_ota_core_soft_0/m1_27825_n3864# 6.207710e-17
C2387 eeg_fd_ota_full2_nc_0/eeg_fd_ota_core_soft_0/m1_27397_3443# VSS 4.840670e-16
C2388 eeg_fd_ota_full2_nc_0/eeg_fd_ota_core_soft_0/m1_27397_3443# eeg_fd_ota_full2_nc_0/eeg_fd_ota_core_soft_0/m1_28253_3443# 6.207710e-17
C2390 eeg_fd_ota_full2_nc_0/eeg_fd_ota_core_soft_0/m1_27825_n3864# VSS 4.429720e-16
C2391 eeg_fd_ota_full2_nc_0/eeg_fd_ota_core_soft_0/m1_27825_n3864# eeg_fd_ota_full2_nc_0/eeg_fd_ota_core_soft_0/m1_28681_n3864# 6.207720e-17
C2392 eeg_fd_ota_full2_nc_0/eeg_fd_ota_core_soft_0/m1_28253_3443# VSS 4.429720e-16
C2393 eeg_fd_ota_full2_nc_0/eeg_fd_ota_core_soft_0/m1_28253_3443# eeg_fd_ota_full2_nc_0/eeg_fd_ota_core_soft_0/m1_29109_3443# 6.207710e-17
C2395 eeg_fd_ota_full2_nc_0/eeg_fd_ota_core_soft_0/m1_28681_n3864# VSS 4.429720e-16
C2396 eeg_fd_ota_full2_nc_0/eeg_fd_ota_core_soft_0/m1_28681_n3864# eeg_fd_ota_full2_nc_0/eeg_fd_ota_core_soft_0/m1_29537_n3864# 6.207710e-17
C2397 eeg_fd_ota_full2_nc_0/eeg_fd_ota_core_soft_0/m1_29109_3443# VSS 4.429720e-16
C2398 eeg_fd_ota_full2_nc_0/eeg_fd_ota_core_soft_0/m1_29109_3443# eeg_fd_ota_full2_nc_0/eeg_fd_ota_core_soft_0/m1_29965_3443# 6.207720e-17
C2400 eeg_fd_ota_full2_nc_0/eeg_fd_ota_core_soft_0/m1_29537_n3864# VSS 4.429720e-16
C2401 eeg_fd_ota_full2_nc_0/eeg_fd_ota_core_soft_0/m1_29537_n3864# eeg_fd_ota_full2_nc_0/eeg_fd_ota_core_soft_0/m1_30393_n3864# 6.207710e-17
C2402 eeg_fd_ota_full2_nc_0/eeg_fd_ota_core_soft_0/m1_29965_3443# VSS 4.429720e-16
C2403 eeg_fd_ota_full2_nc_0/eeg_fd_ota_core_soft_0/m1_29965_3443# eeg_fd_ota_full2_nc_0/eeg_fd_ota_core_soft_0/m1_30821_3443# 6.207710e-17
C2405 eeg_fd_ota_full2_nc_0/eeg_fd_ota_core_soft_0/m1_30393_n3864# VSS 4.429720e-16
C2406 eeg_fd_ota_full2_nc_0/eeg_fd_ota_core_soft_0/m1_30393_n3864# eeg_fd_ota_full2_nc_0/eeg_fd_ota_core_soft_0/m1_31249_n3864# 6.207710e-17
C2407 eeg_fd_ota_full2_nc_0/eeg_fd_ota_core_soft_0/m1_30821_3443# VSS 4.429720e-16
C2408 eeg_fd_ota_full2_nc_0/eeg_fd_ota_core_soft_0/m1_30821_3443# eeg_fd_ota_full2_nc_0/eeg_fd_ota_core_soft_0/m1_31677_3443# 6.207710e-17
C2410 eeg_fd_ota_full2_nc_0/eeg_fd_ota_core_soft_0/m1_31249_n3864# VSS 4.429720e-16
C2411 eeg_fd_ota_full2_nc_0/eeg_fd_ota_core_soft_0/m1_31249_n3864# eeg_fd_ota_full2_nc_0/eeg_fd_ota_core_soft_0/m1_32105_n3864# 6.207710e-17
C2412 eeg_fd_ota_full2_nc_0/eeg_fd_ota_core_soft_0/m1_31677_3443# VSS 4.429720e-16
C2413 eeg_fd_ota_full2_nc_0/eeg_fd_ota_core_soft_0/m1_31677_3443# eeg_fd_ota_full2_nc_0/eeg_fd_ota_core_soft_0/m1_32533_3443# 6.207710e-17
C2415 eeg_fd_ota_full2_nc_0/eeg_fd_ota_core_soft_0/m1_32105_n3864# VSS 4.429720e-16
C2416 eeg_fd_ota_full2_nc_0/eeg_fd_ota_core_soft_0/m1_32105_n3864# eeg_fd_ota_full2_nc_0/eeg_fd_ota_core_soft_0/m1_32961_n3864# 6.207720e-17
C2417 eeg_fd_ota_full2_nc_0/eeg_fd_ota_core_soft_0/m1_32533_3443# VSS 4.429720e-16
C2418 eeg_fd_ota_full2_nc_0/eeg_fd_ota_core_soft_0/m1_32533_3443# eeg_fd_ota_full2_nc_0/eeg_fd_ota_core_soft_0/m1_33389_3443# 6.207710e-17
C2420 eeg_fd_ota_full2_nc_0/eeg_fd_ota_core_soft_0/m1_32961_n3864# VSS 4.429720e-16
C2421 eeg_fd_ota_full2_nc_0/eeg_fd_ota_core_soft_0/m1_32961_n3864# eeg_fd_ota_full2_nc_0/eeg_fd_ota_core_soft_0/m1_33817_n3864# 6.207710e-17
C2422 eeg_fd_ota_full2_nc_0/eeg_fd_ota_core_soft_0/m1_33389_3443# VSS 4.429720e-16
C2423 eeg_fd_ota_full2_nc_0/eeg_fd_ota_core_soft_0/m1_33389_3443# eeg_fd_ota_full2_nc_0/eeg_fd_ota_core_soft_0/m1_34245_3443# 6.207720e-17
C2425 eeg_fd_ota_full2_nc_0/eeg_fd_ota_core_soft_0/m1_33817_n3864# VSS 4.429720e-16
C2426 eeg_fd_ota_full2_nc_0/eeg_fd_ota_core_soft_0/m1_33817_n3864# eeg_fd_ota_full2_nc_0/eeg_fd_ota_core_soft_0/m1_34673_n3864# 6.207710e-17
C2427 eeg_fd_ota_full2_nc_0/eeg_fd_ota_core_soft_0/m1_34245_3443# VSS 4.429720e-16
C2428 eeg_fd_ota_full2_nc_0/eeg_fd_ota_core_soft_0/m1_34245_3443# eeg_fd_ota_full2_nc_0/eeg_fd_ota_core_soft_0/m1_35101_3443# 6.207710e-17
C2430 eeg_fd_ota_full2_nc_0/eeg_fd_ota_core_soft_0/m1_34673_n3864# VSS 4.429720e-16
C2431 eeg_fd_ota_full2_nc_0/eeg_fd_ota_core_soft_0/m1_34673_n3864# eeg_fd_ota_full2_nc_0/eeg_fd_ota_core_soft_0/m1_35529_n3864# 6.207720e-17
C2432 eeg_fd_ota_full2_nc_0/eeg_fd_ota_core_soft_0/m1_35101_3443# VSS 4.429720e-16
C2433 eeg_fd_ota_full2_nc_0/eeg_fd_ota_core_soft_0/m1_35101_3443# eeg_fd_ota_full2_nc_0/eeg_fd_ota_core_soft_0/m1_35957_3443# 6.207710e-17
C2435 eeg_fd_ota_full2_nc_0/eeg_fd_ota_core_soft_0/m1_35529_n3864# VSS 4.429720e-16
C2436 eeg_fd_ota_full2_nc_0/eeg_fd_ota_core_soft_0/m1_35529_n3864# eeg_fd_ota_full2_nc_0/eeg_fd_ota_core_soft_0/m1_36385_n3864# 6.207710e-17
C2437 eeg_fd_ota_full2_nc_0/eeg_fd_ota_core_soft_0/m1_35957_3443# VSS 4.429720e-16
C2438 eeg_fd_ota_full2_nc_0/eeg_fd_ota_core_soft_0/m1_35957_3443# eeg_fd_ota_full2_nc_0/eeg_fd_ota_core_soft_0/m1_36813_3443# 6.207710e-17
C2440 eeg_fd_ota_full2_nc_0/eeg_fd_ota_core_soft_0/m1_36385_n3864# VSS 4.429720e-16
C2441 eeg_fd_ota_full2_nc_0/eeg_fd_ota_core_soft_0/m1_36385_n3864# eeg_fd_ota_full2_nc_0/eeg_fd_ota_core_soft_0/m1_37241_n3864# 6.207710e-17
C2442 eeg_fd_ota_full2_nc_0/eeg_fd_ota_core_soft_0/m1_36813_3443# VSS 4.429720e-16
C2443 eeg_fd_ota_full2_nc_0/eeg_fd_ota_core_soft_0/m1_36813_3443# eeg_fd_ota_full2_nc_0/eeg_fd_ota_core_soft_0/m1_37669_3443# 6.207710e-17
C2445 eeg_fd_ota_full2_nc_0/eeg_fd_ota_core_soft_0/m1_37241_n3864# VSS 4.429720e-16
C2446 eeg_fd_ota_full2_nc_0/eeg_fd_ota_core_soft_0/m1_37241_n3864# eeg_fd_ota_full2_nc_0/eeg_fd_ota_core_soft_0/m1_38097_n3864# 6.207710e-17
C2447 eeg_fd_ota_full2_nc_0/eeg_fd_ota_core_soft_0/m1_37669_3443# VSS 4.429720e-16
C2448 eeg_fd_ota_full2_nc_0/eeg_fd_ota_core_soft_0/m1_37669_3443# eeg_fd_ota_full2_nc_0/eeg_fd_ota_core_soft_0/m1_38525_3443# 6.207720e-17
C2450 eeg_fd_ota_full2_nc_0/eeg_fd_ota_core_soft_0/m1_38097_n3864# VSS 4.429720e-16
C2451 eeg_fd_ota_full2_nc_0/eeg_fd_ota_core_soft_0/m1_38097_n3864# eeg_fd_ota_full2_nc_0/eeg_fd_ota_core_soft_0/m1_38953_n3864# 6.207710e-17
C2452 eeg_fd_ota_full2_nc_0/eeg_fd_ota_core_soft_0/m1_38525_3443# VSS 4.429720e-16
C2453 eeg_fd_ota_full2_nc_0/eeg_fd_ota_core_soft_0/m1_38525_3443# eeg_fd_ota_full2_nc_0/eeg_fd_ota_core_soft_0/m1_39381_3443# 6.207710e-17
C2455 eeg_fd_ota_full2_nc_0/eeg_fd_ota_core_soft_0/m1_38953_n3864# VSS 4.429720e-16
C2456 eeg_fd_ota_full2_nc_0/eeg_fd_ota_core_soft_0/m1_38953_n3864# eeg_fd_ota_full2_nc_0/eeg_fd_ota_core_soft_0/m1_39809_n3864# 6.207720e-17
C2457 eeg_fd_ota_full2_nc_0/eeg_fd_ota_core_soft_0/m1_39381_3443# VSS 4.429720e-16
C2458 eeg_fd_ota_full2_nc_0/eeg_fd_ota_core_soft_0/m1_39381_3443# eeg_fd_ota_full2_nc_0/eeg_fd_ota_core_soft_0/m1_40237_3443# 6.207710e-17
C2460 eeg_fd_ota_full2_nc_0/eeg_fd_ota_core_soft_0/m1_39809_n3864# VSS 4.429720e-16
C2461 eeg_fd_ota_full2_nc_0/eeg_fd_ota_core_soft_0/m1_39809_n3864# eeg_fd_ota_full2_nc_0/eeg_fd_ota_core_soft_0/m1_40665_n3864# 6.207710e-17
C2462 eeg_fd_ota_full2_nc_0/eeg_fd_ota_core_soft_0/m1_40237_3443# VSS 4.429720e-16
C2463 eeg_fd_ota_full2_nc_0/eeg_fd_ota_core_soft_0/m1_40237_3443# eeg_fd_ota_full2_nc_0/eeg_fd_ota_core_soft_0/m1_41093_3443# 6.207710e-17
C2465 eeg_fd_ota_full2_nc_0/eeg_fd_ota_core_soft_0/m1_40665_n3864# VSS 4.429720e-16
C2466 eeg_fd_ota_full2_nc_0/eeg_fd_ota_core_soft_0/m1_40665_n3864# eeg_fd_ota_full2_nc_0/eeg_fd_ota_core_soft_0/m1_41521_n3864# 6.207710e-17
C2467 eeg_fd_ota_full2_nc_0/eeg_fd_ota_core_soft_0/m1_41093_3443# VSS 4.429720e-16
C2468 eeg_fd_ota_full2_nc_0/eeg_fd_ota_core_soft_0/m1_41093_3443# eeg_fd_ota_full2_nc_0/eeg_fd_ota_core_soft_0/m1_41949_3443# 6.207710e-17
C2470 eeg_fd_ota_full2_nc_0/eeg_fd_ota_core_soft_0/m1_41521_n3864# VSS 4.429720e-16
C2471 eeg_fd_ota_full2_nc_0/eeg_fd_ota_core_soft_0/m1_41521_n3864# eeg_fd_ota_full2_nc_0/eeg_fd_ota_core_soft_0/m1_42377_n3864# 6.207710e-17
C2472 eeg_fd_ota_full2_nc_0/eeg_fd_ota_core_soft_0/m1_41949_3443# VSS 4.429720e-16
C2473 eeg_fd_ota_full2_nc_0/eeg_fd_ota_core_soft_0/m1_41949_3443# eeg_fd_ota_full2_nc_0/eeg_fd_ota_core_soft_0/m1_42805_3443# 6.207720e-17
C2475 eeg_fd_ota_full2_nc_0/eeg_fd_ota_core_soft_0/m1_42377_n3864# VSS 4.429720e-16
C2476 eeg_fd_ota_full2_nc_0/eeg_fd_ota_core_soft_0/m1_42377_n3864# eeg_fd_ota_full2_nc_0/eeg_fd_ota_core_soft_0/m1_43233_n3864# 6.207710e-17
C2477 eeg_fd_ota_full2_nc_0/eeg_fd_ota_core_soft_0/m1_42805_3443# VSS 4.429720e-16
C2478 eeg_fd_ota_full2_nc_0/eeg_fd_ota_core_soft_0/m1_42805_3443# eeg_fd_ota_full2_nc_0/eeg_fd_ota_core_soft_0/m1_43661_3443# 6.207710e-17
C2480 eeg_fd_ota_full2_nc_0/eeg_fd_ota_core_soft_0/m1_43233_n3864# VSS 4.429720e-16
C2481 eeg_fd_ota_full2_nc_0/eeg_fd_ota_core_soft_0/m1_43233_n3864# eeg_fd_ota_full2_nc_0/eeg_fd_ota_core_soft_0/m1_44089_n3864# 6.207720e-17
C2482 eeg_fd_ota_full2_nc_0/eeg_fd_ota_core_soft_0/m1_43661_3443# VSS 4.429720e-16
C2483 eeg_fd_ota_full2_nc_0/eeg_fd_ota_core_soft_0/m1_43661_3443# eeg_fd_ota_full2_nc_0/eeg_fd_ota_core_soft_0/m1_44517_3443# 6.207710e-17
C2485 eeg_fd_ota_full2_nc_0/eeg_fd_ota_core_soft_0/m1_44089_n3864# VSS 4.429720e-16
C2486 eeg_fd_ota_full2_nc_0/eeg_fd_ota_core_soft_0/m1_44089_n3864# eeg_fd_ota_full2_nc_0/eeg_fd_ota_core_soft_0/m1_44945_n3864# 6.207710e-17
C2487 eeg_fd_ota_full2_nc_0/eeg_fd_ota_core_soft_0/m1_44517_3443# VSS 4.429720e-16
C2488 eeg_fd_ota_full2_nc_0/eeg_fd_ota_core_soft_0/m1_44517_3443# eeg_fd_ota_full2_nc_0/eeg_fd_ota_core_soft_0/m1_45373_3443# 6.207720e-17
C2490 eeg_fd_ota_full2_nc_0/eeg_fd_ota_core_soft_0/m1_44945_n3864# VSS 4.429720e-16
C2491 eeg_fd_ota_full2_nc_0/eeg_fd_ota_core_soft_0/m1_44945_n3864# eeg_fd_ota_full2_nc_0/eeg_fd_ota_core_soft_0/m1_45801_n3864# 6.207710e-17
C2492 eeg_fd_ota_full2_nc_0/eeg_fd_ota_core_soft_0/m1_45373_3443# VSS 4.429720e-16
C2493 eeg_fd_ota_full2_nc_0/eeg_fd_ota_core_soft_0/m1_45373_3443# eeg_fd_ota_full2_nc_0/eeg_fd_ota_core_soft_0/m1_46229_3443# 6.207710e-17
C2495 eeg_fd_ota_full2_nc_0/eeg_fd_ota_core_soft_0/m1_45801_n3864# VSS 4.429720e-16
C2496 eeg_fd_ota_full2_nc_0/eeg_fd_ota_core_soft_0/m1_45801_n3864# eeg_fd_ota_full2_nc_0/eeg_fd_ota_core_soft_0/m1_46657_n3864# 6.207710e-17
C2497 eeg_fd_ota_full2_nc_0/eeg_fd_ota_core_soft_0/m1_46229_3443# VSS 4.429720e-16
C2498 eeg_fd_ota_full2_nc_0/eeg_fd_ota_core_soft_0/m1_46229_3443# eeg_fd_ota_full2_nc_0/eeg_fd_ota_core_soft_0/m1_47085_3443# 6.207710e-17
C2500 eeg_fd_ota_full2_nc_0/eeg_fd_ota_core_soft_0/m1_46657_n3864# VSS 4.429720e-16
C2501 eeg_fd_ota_full2_nc_0/eeg_fd_ota_core_soft_0/m1_46657_n3864# eeg_fd_ota_full2_nc_0/eeg_fd_ota_core_soft_0/m1_47513_n3864# 6.207710e-17
C2502 eeg_fd_ota_full2_nc_0/eeg_fd_ota_core_soft_0/m1_47085_3443# VSS 4.826260e-16
C2503 eeg_fd_ota_full2_nc_0/eeg_fd_ota_core_soft_0/m1_47085_3443# eeg_fd_ota_full2_nc_0/stage2_0/N2N 9.251920e-17
C2504 eeg_fd_ota_full2_nc_0/eeg_fd_ota_core_soft_0/m1_47513_n3864# VSS 4.917160e-16
C2505 eeg_fd_ota_full2_nc_0/eeg_fd_ota_core_soft_0/m1_50209_n3864# VSS 4.917160e-16
C2506 eeg_fd_ota_full2_nc_0/eeg_fd_ota_core_soft_0/m1_50209_n3864# eeg_fd_ota_full2_nc_0/eeg_fd_ota_core_soft_0/m1_51065_n3864# 6.207720e-17
C2507 eeg_fd_ota_full2_nc_0/eeg_fd_ota_core_soft_0/m1_50637_3443# VSS 4.840670e-16
C2508 eeg_fd_ota_full2_nc_0/eeg_fd_ota_core_soft_0/m1_50637_3443# eeg_fd_ota_full2_nc_0/eeg_fd_ota_core_soft_0/m1_51493_3443# 6.207710e-17
C2510 eeg_fd_ota_full2_nc_0/eeg_fd_ota_core_soft_0/m1_51065_n3864# VSS 4.429720e-16
C2511 eeg_fd_ota_full2_nc_0/eeg_fd_ota_core_soft_0/m1_51065_n3864# eeg_fd_ota_full2_nc_0/eeg_fd_ota_core_soft_0/m1_51921_n3864# 6.207710e-17
C2512 eeg_fd_ota_full2_nc_0/eeg_fd_ota_core_soft_0/m1_51493_3443# VSS 4.429720e-16
C2513 eeg_fd_ota_full2_nc_0/eeg_fd_ota_core_soft_0/m1_51493_3443# eeg_fd_ota_full2_nc_0/eeg_fd_ota_core_soft_0/m1_52349_3443# 6.207720e-17
C2515 eeg_fd_ota_full2_nc_0/eeg_fd_ota_core_soft_0/m1_51921_n3864# VSS 4.429720e-16
C2516 eeg_fd_ota_full2_nc_0/eeg_fd_ota_core_soft_0/m1_51921_n3864# eeg_fd_ota_full2_nc_0/eeg_fd_ota_core_soft_0/m1_52777_n3864# 6.207710e-17
C2517 eeg_fd_ota_full2_nc_0/eeg_fd_ota_core_soft_0/m1_52349_3443# VSS 4.429720e-16
C2518 eeg_fd_ota_full2_nc_0/eeg_fd_ota_core_soft_0/m1_52349_3443# eeg_fd_ota_full2_nc_0/eeg_fd_ota_core_soft_0/m1_53205_3443# 6.207710e-17
C2520 eeg_fd_ota_full2_nc_0/eeg_fd_ota_core_soft_0/m1_52777_n3864# VSS 4.429720e-16
C2521 eeg_fd_ota_full2_nc_0/eeg_fd_ota_core_soft_0/m1_52777_n3864# eeg_fd_ota_full2_nc_0/eeg_fd_ota_core_soft_0/m1_53633_n3864# 6.207710e-17
C2522 eeg_fd_ota_full2_nc_0/eeg_fd_ota_core_soft_0/m1_53205_3443# VSS 4.429720e-16
C2523 eeg_fd_ota_full2_nc_0/eeg_fd_ota_core_soft_0/m1_53205_3443# eeg_fd_ota_full2_nc_0/eeg_fd_ota_core_soft_0/m1_54061_3443# 6.207710e-17
C2525 eeg_fd_ota_full2_nc_0/eeg_fd_ota_core_soft_0/m1_53633_n3864# VSS 4.429720e-16
C2526 eeg_fd_ota_full2_nc_0/eeg_fd_ota_core_soft_0/m1_53633_n3864# eeg_fd_ota_full2_nc_0/eeg_fd_ota_core_soft_0/m1_54489_n3864# 6.207710e-17
C2527 eeg_fd_ota_full2_nc_0/eeg_fd_ota_core_soft_0/m1_54061_3443# VSS 4.429720e-16
C2528 eeg_fd_ota_full2_nc_0/eeg_fd_ota_core_soft_0/m1_54061_3443# eeg_fd_ota_full2_nc_0/eeg_fd_ota_core_soft_0/m1_54917_3443# 6.207710e-17
C2530 eeg_fd_ota_full2_nc_0/eeg_fd_ota_core_soft_0/m1_54489_n3864# VSS 4.429720e-16
C2531 eeg_fd_ota_full2_nc_0/eeg_fd_ota_core_soft_0/m1_54489_n3864# eeg_fd_ota_full2_nc_0/eeg_fd_ota_core_soft_0/m1_55345_n3864# 6.207720e-17
C2532 eeg_fd_ota_full2_nc_0/eeg_fd_ota_core_soft_0/m1_54917_3443# VSS 4.429720e-16
C2533 eeg_fd_ota_full2_nc_0/eeg_fd_ota_core_soft_0/m1_54917_3443# eeg_fd_ota_full2_nc_0/eeg_fd_ota_core_soft_0/m1_55773_3443# 6.207710e-17
C2535 eeg_fd_ota_full2_nc_0/eeg_fd_ota_core_soft_0/m1_55345_n3864# VSS 4.429720e-16
C2536 eeg_fd_ota_full2_nc_0/eeg_fd_ota_core_soft_0/m1_55345_n3864# eeg_fd_ota_full2_nc_0/eeg_fd_ota_core_soft_0/m1_56201_n3864# 6.207710e-17
C2537 eeg_fd_ota_full2_nc_0/eeg_fd_ota_core_soft_0/m1_55773_3443# VSS 4.429720e-16
C2538 eeg_fd_ota_full2_nc_0/eeg_fd_ota_core_soft_0/m1_55773_3443# eeg_fd_ota_full2_nc_0/eeg_fd_ota_core_soft_0/m1_56629_3443# 6.207720e-17
C2540 eeg_fd_ota_full2_nc_0/eeg_fd_ota_core_soft_0/m1_56201_n3864# VSS 4.429720e-16
C2541 eeg_fd_ota_full2_nc_0/eeg_fd_ota_core_soft_0/m1_56201_n3864# eeg_fd_ota_full2_nc_0/eeg_fd_ota_core_soft_0/m1_57057_n3864# 6.207710e-17
C2542 eeg_fd_ota_full2_nc_0/eeg_fd_ota_core_soft_0/m1_56629_3443# VSS 4.429720e-16
C2543 eeg_fd_ota_full2_nc_0/eeg_fd_ota_core_soft_0/m1_56629_3443# eeg_fd_ota_full2_nc_0/eeg_fd_ota_core_soft_0/m1_57485_3443# 6.207710e-17
C2545 eeg_fd_ota_full2_nc_0/eeg_fd_ota_core_soft_0/m1_57057_n3864# VSS 4.429720e-16
C2546 eeg_fd_ota_full2_nc_0/eeg_fd_ota_core_soft_0/m1_57057_n3864# eeg_fd_ota_full2_nc_0/eeg_fd_ota_core_soft_0/m1_57913_n3864# 6.207714e-17
C2547 eeg_fd_ota_full2_nc_0/eeg_fd_ota_core_soft_0/m1_57485_3443# VSS 4.826260e-16
C2548 eeg_fd_ota_full2_nc_0/eeg_fd_ota_core_soft_0/m1_57485_3443# eeg_fd_ota_full2_nc_0/stage2_0/N2N 9.251921e-17
C2549 eeg_fd_ota_full2_nc_0/eeg_fd_ota_core_soft_0/m1_57913_n3864# VSS 4.917160e-16
C2550 eeg_fd_ota_full2_nc_0/eeg_fd_ota_core_soft_0/m1_n22658_111# VSS 1.794040e-14
C2551 eeg_fd_ota_full2_nc_0/eeg_fd_ota_core_soft_0/m1_n22658_111# eeg_fd_ota_full2_nc_0/stage2_0/N2N 3.475590e-16
C2552 eeg_fd_ota_full2_nc_0/eeg_fd_ota_core_soft_0/m1_n22658_111# eeg_fd_ota_full2_nc_0/stage2_0/N2P 5.910065e-17
C2553 eeg_fd_ota_full2_nc_0/eeg_fd_ota_core_soft_0/m1_n22658_111# eeg_pseudo_res_0/B 4.063561e-15
C2554 eeg_fd_ota_full2_nc_0/eeg_fd_ota_core_soft_0/m1_n22658_111# eeg_pseudo_res_1/B 4.388117e-15
C2555 eeg_fd_ota_full2_nc_0/eeg_fd_ota_core_soft_0/m1_n27515_n3864# VSS 4.917160e-16
C2556 eeg_fd_ota_full2_nc_0/eeg_fd_ota_core_soft_0/m1_n27515_n3864# eeg_fd_ota_full2_nc_0/eeg_fd_ota_core_soft_0/m1_n28371_n3864# 6.207710e-17
C2557 eeg_fd_ota_full2_nc_0/eeg_fd_ota_core_soft_0/m1_n27943_3443# VSS 4.840670e-16
C2558 eeg_fd_ota_full2_nc_0/eeg_fd_ota_core_soft_0/m1_n27943_3443# eeg_fd_ota_full2_nc_0/eeg_fd_ota_core_soft_0/m1_n28799_3443# 6.207710e-17
C2560 eeg_fd_ota_full2_nc_0/eeg_fd_ota_core_soft_0/m1_n28371_n3864# VSS 4.429720e-16
C2561 eeg_fd_ota_full2_nc_0/eeg_fd_ota_core_soft_0/m1_n28371_n3864# eeg_fd_ota_full2_nc_0/eeg_fd_ota_core_soft_0/m1_n29227_n3864# 6.207710e-17
C2562 eeg_fd_ota_full2_nc_0/eeg_fd_ota_core_soft_0/m1_n28799_3443# VSS 4.429720e-16
C2563 eeg_fd_ota_full2_nc_0/eeg_fd_ota_core_soft_0/m1_n28799_3443# eeg_fd_ota_full2_nc_0/eeg_fd_ota_core_soft_0/m1_n29655_3443# 6.207720e-17
C2565 eeg_fd_ota_full2_nc_0/eeg_fd_ota_core_soft_0/m1_n29227_n3864# VSS 4.429720e-16
C2566 eeg_fd_ota_full2_nc_0/eeg_fd_ota_core_soft_0/m1_n29227_n3864# eeg_fd_ota_full2_nc_0/eeg_fd_ota_core_soft_0/m1_n30083_n3864# 6.207710e-17
C2567 eeg_fd_ota_full2_nc_0/eeg_fd_ota_core_soft_0/m1_n29655_3443# VSS 4.429720e-16
C2568 eeg_fd_ota_full2_nc_0/eeg_fd_ota_core_soft_0/m1_n29655_3443# eeg_fd_ota_full2_nc_0/eeg_fd_ota_core_soft_0/m1_n30511_3443# 6.207710e-17
C2570 eeg_fd_ota_full2_nc_0/eeg_fd_ota_core_soft_0/m1_n30083_n3864# VSS 4.429720e-16
C2571 eeg_fd_ota_full2_nc_0/eeg_fd_ota_core_soft_0/m1_n30083_n3864# eeg_fd_ota_full2_nc_0/eeg_fd_ota_core_soft_0/m1_n30939_n3864# 6.207720e-17
C2572 eeg_fd_ota_full2_nc_0/eeg_fd_ota_core_soft_0/m1_n30511_3443# VSS 4.429720e-16
C2573 eeg_fd_ota_full2_nc_0/eeg_fd_ota_core_soft_0/m1_n30511_3443# eeg_fd_ota_full2_nc_0/eeg_fd_ota_core_soft_0/m1_n31367_3443# 6.207710e-17
C2575 eeg_fd_ota_full2_nc_0/eeg_fd_ota_core_soft_0/m1_n30939_n3864# VSS 4.429720e-16
C2576 eeg_fd_ota_full2_nc_0/eeg_fd_ota_core_soft_0/m1_n30939_n3864# eeg_fd_ota_full2_nc_0/eeg_fd_ota_core_soft_0/m1_n31795_n3864# 6.207710e-17
C2577 eeg_fd_ota_full2_nc_0/eeg_fd_ota_core_soft_0/m1_n31367_3443# VSS 4.429720e-16
C2578 eeg_fd_ota_full2_nc_0/eeg_fd_ota_core_soft_0/m1_n31367_3443# eeg_fd_ota_full2_nc_0/eeg_fd_ota_core_soft_0/m1_n32223_3443# 6.207710e-17
C2580 eeg_fd_ota_full2_nc_0/eeg_fd_ota_core_soft_0/m1_n31795_n3864# VSS 4.429720e-16
C2581 eeg_fd_ota_full2_nc_0/eeg_fd_ota_core_soft_0/m1_n31795_n3864# eeg_fd_ota_full2_nc_0/eeg_fd_ota_core_soft_0/m1_n32651_n3864# 6.207710e-17
C2582 eeg_fd_ota_full2_nc_0/eeg_fd_ota_core_soft_0/m1_n32223_3443# VSS 4.429720e-16
C2583 eeg_fd_ota_full2_nc_0/eeg_fd_ota_core_soft_0/m1_n32223_3443# eeg_fd_ota_full2_nc_0/eeg_fd_ota_core_soft_0/m1_n33079_3443# 6.207710e-17
C2585 eeg_fd_ota_full2_nc_0/eeg_fd_ota_core_soft_0/m1_n32651_n3864# VSS 4.429720e-16
C2586 eeg_fd_ota_full2_nc_0/eeg_fd_ota_core_soft_0/m1_n32651_n3864# eeg_fd_ota_full2_nc_0/eeg_fd_ota_core_soft_0/m1_n33507_n3864# 6.207710e-17
C2587 eeg_fd_ota_full2_nc_0/eeg_fd_ota_core_soft_0/m1_n33079_3443# VSS 4.429720e-16
C2588 eeg_fd_ota_full2_nc_0/eeg_fd_ota_core_soft_0/m1_n33079_3443# eeg_fd_ota_full2_nc_0/eeg_fd_ota_core_soft_0/m1_n33935_3443# 6.207720e-17
C2590 eeg_fd_ota_full2_nc_0/eeg_fd_ota_core_soft_0/m1_n33507_n3864# VSS 4.429720e-16
C2591 eeg_fd_ota_full2_nc_0/eeg_fd_ota_core_soft_0/m1_n33507_n3864# eeg_fd_ota_full2_nc_0/eeg_fd_ota_core_soft_0/m1_n34363_n3864# 6.207710e-17
C2592 eeg_fd_ota_full2_nc_0/eeg_fd_ota_core_soft_0/m1_n33935_3443# VSS 4.429720e-16
C2593 eeg_fd_ota_full2_nc_0/eeg_fd_ota_core_soft_0/m1_n33935_3443# eeg_fd_ota_full2_nc_0/eeg_fd_ota_core_soft_0/m1_n34791_3443# 6.207710e-17
C2595 eeg_fd_ota_full2_nc_0/eeg_fd_ota_core_soft_0/m1_n34363_n3864# VSS 4.429720e-16
C2596 eeg_fd_ota_full2_nc_0/eeg_fd_ota_core_soft_0/m1_n34363_n3864# eeg_fd_ota_full2_nc_0/eeg_fd_ota_core_soft_0/m1_n35219_n3864# 6.207720e-17
C2597 eeg_fd_ota_full2_nc_0/eeg_fd_ota_core_soft_0/m1_n34791_3443# VSS 4.429720e-16
C2598 eeg_fd_ota_full2_nc_0/eeg_fd_ota_core_soft_0/m1_n34791_3443# eeg_fd_ota_full2_nc_0/eeg_fd_ota_core_soft_0/m1_n35647_3443# 6.207710e-17
C2600 eeg_fd_ota_full2_nc_0/eeg_fd_ota_core_soft_0/m1_n35219_n3864# VSS 4.429720e-16
C2601 eeg_fd_ota_full2_nc_0/eeg_fd_ota_core_soft_0/m1_n35219_n3864# eeg_fd_ota_full2_nc_0/eeg_fd_ota_core_soft_0/m1_n36075_n3864# 6.207710e-17
C2602 eeg_fd_ota_full2_nc_0/eeg_fd_ota_core_soft_0/m1_n35647_3443# VSS 4.429720e-16
C2603 eeg_fd_ota_full2_nc_0/eeg_fd_ota_core_soft_0/m1_n35647_3443# eeg_fd_ota_full2_nc_0/eeg_fd_ota_core_soft_0/m1_n36503_3443# 6.207720e-17
C2605 eeg_fd_ota_full2_nc_0/eeg_fd_ota_core_soft_0/m1_n36075_n3864# VSS 4.429720e-16
C2606 eeg_fd_ota_full2_nc_0/eeg_fd_ota_core_soft_0/m1_n36075_n3864# eeg_fd_ota_full2_nc_0/eeg_fd_ota_core_soft_0/m1_n36931_n3864# 6.207710e-17
C2607 eeg_fd_ota_full2_nc_0/eeg_fd_ota_core_soft_0/m1_n36503_3443# VSS 4.429720e-16
C2608 eeg_fd_ota_full2_nc_0/eeg_fd_ota_core_soft_0/m1_n36503_3443# eeg_fd_ota_full2_nc_0/eeg_fd_ota_core_soft_0/m1_n37359_3443# 6.207710e-17
C2610 eeg_fd_ota_full2_nc_0/eeg_fd_ota_core_soft_0/m1_n36931_n3864# VSS 4.429720e-16
C2611 eeg_fd_ota_full2_nc_0/eeg_fd_ota_core_soft_0/m1_n36931_n3864# eeg_fd_ota_full2_nc_0/eeg_fd_ota_core_soft_0/m1_n37787_n3864# 6.207710e-17
C2612 eeg_fd_ota_full2_nc_0/eeg_fd_ota_core_soft_0/m1_n37359_3443# VSS 4.429720e-16
C2613 eeg_fd_ota_full2_nc_0/eeg_fd_ota_core_soft_0/m1_n37359_3443# eeg_fd_ota_full2_nc_0/eeg_fd_ota_core_soft_0/m1_n38215_3443# 6.207710e-17
C2615 eeg_fd_ota_full2_nc_0/eeg_fd_ota_core_soft_0/m1_n37787_n3864# VSS 4.429720e-16
C2616 eeg_fd_ota_full2_nc_0/eeg_fd_ota_core_soft_0/m1_n37787_n3864# eeg_fd_ota_full2_nc_0/eeg_fd_ota_core_soft_0/m1_n38643_n3864# 6.207710e-17
C2617 eeg_fd_ota_full2_nc_0/eeg_fd_ota_core_soft_0/m1_n38215_3443# VSS 4.429720e-16
C2618 eeg_fd_ota_full2_nc_0/eeg_fd_ota_core_soft_0/m1_n38215_3443# eeg_fd_ota_full2_nc_0/eeg_fd_ota_core_soft_0/m1_n39071_3443# 6.207710e-17
C2620 eeg_fd_ota_full2_nc_0/eeg_fd_ota_core_soft_0/m1_n38643_n3864# VSS 4.429720e-16
C2621 eeg_fd_ota_full2_nc_0/eeg_fd_ota_core_soft_0/m1_n38643_n3864# eeg_fd_ota_full2_nc_0/eeg_fd_ota_core_soft_0/m1_n39499_n3864# 6.207720e-17
C2622 eeg_fd_ota_full2_nc_0/eeg_fd_ota_core_soft_0/m1_n39071_3443# VSS 4.429720e-16
C2623 eeg_fd_ota_full2_nc_0/eeg_fd_ota_core_soft_0/m1_n39071_3443# eeg_fd_ota_full2_nc_0/eeg_fd_ota_core_soft_0/m1_n39927_3443# 6.207710e-17
C2625 eeg_fd_ota_full2_nc_0/eeg_fd_ota_core_soft_0/m1_n39499_n3864# VSS 4.429720e-16
C2626 eeg_fd_ota_full2_nc_0/eeg_fd_ota_core_soft_0/m1_n39499_n3864# eeg_fd_ota_full2_nc_0/eeg_fd_ota_core_soft_0/m1_n40355_n3864# 6.207710e-17
C2627 eeg_fd_ota_full2_nc_0/eeg_fd_ota_core_soft_0/m1_n39927_3443# VSS 4.429720e-16
C2628 eeg_fd_ota_full2_nc_0/eeg_fd_ota_core_soft_0/m1_n39927_3443# eeg_fd_ota_full2_nc_0/eeg_fd_ota_core_soft_0/m1_n40783_3443# 6.207720e-17
C2630 eeg_fd_ota_full2_nc_0/eeg_fd_ota_core_soft_0/m1_n40355_n3864# VSS 4.429720e-16
C2631 eeg_fd_ota_full2_nc_0/eeg_fd_ota_core_soft_0/m1_n40355_n3864# eeg_fd_ota_full2_nc_0/eeg_fd_ota_core_soft_0/m1_n41211_n3864# 6.207710e-17
C2632 eeg_fd_ota_full2_nc_0/eeg_fd_ota_core_soft_0/m1_n40783_3443# VSS 4.429720e-16
C2633 eeg_fd_ota_full2_nc_0/eeg_fd_ota_core_soft_0/m1_n40783_3443# eeg_fd_ota_full2_nc_0/eeg_fd_ota_core_soft_0/m1_n41639_3443# 6.207710e-17
C2635 eeg_fd_ota_full2_nc_0/eeg_fd_ota_core_soft_0/m1_n41211_n3864# VSS 4.429720e-16
C2636 eeg_fd_ota_full2_nc_0/eeg_fd_ota_core_soft_0/m1_n41211_n3864# eeg_fd_ota_full2_nc_0/eeg_fd_ota_core_soft_0/m1_n42067_n3864# 6.207720e-17
C2637 eeg_fd_ota_full2_nc_0/eeg_fd_ota_core_soft_0/m1_n41639_3443# VSS 4.429720e-16
C2638 eeg_fd_ota_full2_nc_0/eeg_fd_ota_core_soft_0/m1_n41639_3443# eeg_fd_ota_full2_nc_0/eeg_fd_ota_core_soft_0/m1_n42495_3443# 6.207710e-17
C2640 eeg_fd_ota_full2_nc_0/eeg_fd_ota_core_soft_0/m1_n42067_n3864# VSS 4.429720e-16
C2641 eeg_fd_ota_full2_nc_0/eeg_fd_ota_core_soft_0/m1_n42067_n3864# eeg_fd_ota_full2_nc_0/eeg_fd_ota_core_soft_0/m1_n42923_n3864# 6.207710e-17
C2642 eeg_fd_ota_full2_nc_0/eeg_fd_ota_core_soft_0/m1_n42495_3443# VSS 4.429720e-16
C2643 eeg_fd_ota_full2_nc_0/eeg_fd_ota_core_soft_0/m1_n42495_3443# eeg_fd_ota_full2_nc_0/eeg_fd_ota_core_soft_0/m1_n43351_3443# 6.207710e-17
C2645 eeg_fd_ota_full2_nc_0/eeg_fd_ota_core_soft_0/m1_n42923_n3864# VSS 4.429720e-16
C2646 eeg_fd_ota_full2_nc_0/eeg_fd_ota_core_soft_0/m1_n42923_n3864# eeg_fd_ota_full2_nc_0/eeg_fd_ota_core_soft_0/m1_n43779_n3864# 6.207710e-17
C2647 eeg_fd_ota_full2_nc_0/eeg_fd_ota_core_soft_0/m1_n43351_3443# VSS 4.429720e-16
C2648 eeg_fd_ota_full2_nc_0/eeg_fd_ota_core_soft_0/m1_n43351_3443# eeg_fd_ota_full2_nc_0/eeg_fd_ota_core_soft_0/m1_n44207_3443# 6.207710e-17
C2650 eeg_fd_ota_full2_nc_0/eeg_fd_ota_core_soft_0/m1_n43779_n3864# VSS 4.429720e-16
C2651 eeg_fd_ota_full2_nc_0/eeg_fd_ota_core_soft_0/m1_n43779_n3864# eeg_fd_ota_full2_nc_0/eeg_fd_ota_core_soft_0/m1_n44635_n3864# 6.207710e-17
C2652 eeg_fd_ota_full2_nc_0/eeg_fd_ota_core_soft_0/m1_n44207_3443# VSS 4.429720e-16
C2653 eeg_fd_ota_full2_nc_0/eeg_fd_ota_core_soft_0/m1_n44207_3443# eeg_fd_ota_full2_nc_0/eeg_fd_ota_core_soft_0/m1_n45063_3443# 6.207720e-17
C2655 eeg_fd_ota_full2_nc_0/eeg_fd_ota_core_soft_0/m1_n44635_n3864# VSS 4.429720e-16
C2656 eeg_fd_ota_full2_nc_0/eeg_fd_ota_core_soft_0/m1_n44635_n3864# eeg_fd_ota_full2_nc_0/eeg_fd_ota_core_soft_0/m1_n45491_n3864# 6.207710e-17
C2657 eeg_fd_ota_full2_nc_0/eeg_fd_ota_core_soft_0/m1_n45063_3443# VSS 4.429720e-16
C2658 eeg_fd_ota_full2_nc_0/eeg_fd_ota_core_soft_0/m1_n45063_3443# eeg_fd_ota_full2_nc_0/eeg_fd_ota_core_soft_0/m1_n45919_3443# 6.207710e-17
C2660 eeg_fd_ota_full2_nc_0/eeg_fd_ota_core_soft_0/m1_n45491_n3864# VSS 4.429720e-16
C2661 eeg_fd_ota_full2_nc_0/eeg_fd_ota_core_soft_0/m1_n45491_n3864# eeg_fd_ota_full2_nc_0/eeg_fd_ota_core_soft_0/m1_n46347_n3864# 6.207720e-17
C2662 eeg_fd_ota_full2_nc_0/eeg_fd_ota_core_soft_0/m1_n45919_3443# VSS 4.429720e-16
C2663 eeg_fd_ota_full2_nc_0/eeg_fd_ota_core_soft_0/m1_n45919_3443# eeg_fd_ota_full2_nc_0/eeg_fd_ota_core_soft_0/m1_n46775_3443# 6.207710e-17
C2665 eeg_fd_ota_full2_nc_0/eeg_fd_ota_core_soft_0/m1_n46347_n3864# VSS 4.429720e-16
C2666 eeg_fd_ota_full2_nc_0/eeg_fd_ota_core_soft_0/m1_n46347_n3864# eeg_fd_ota_full2_nc_0/eeg_fd_ota_core_soft_0/m1_n47203_n3864# 6.207710e-17
C2667 eeg_fd_ota_full2_nc_0/eeg_fd_ota_core_soft_0/m1_n46775_3443# VSS 4.429720e-16
C2668 eeg_fd_ota_full2_nc_0/eeg_fd_ota_core_soft_0/m1_n46775_3443# eeg_fd_ota_full2_nc_0/eeg_fd_ota_core_soft_0/m1_n47631_3443# 6.207710e-17
C2670 eeg_fd_ota_full2_nc_0/eeg_fd_ota_core_soft_0/m1_n47203_n3864# VSS 4.429720e-16
C2671 eeg_fd_ota_full2_nc_0/eeg_fd_ota_core_soft_0/m1_n47203_n3864# eeg_fd_ota_full2_nc_0/eeg_fd_ota_core_soft_0/m1_n48059_n3864# 6.207710e-17
C2672 eeg_fd_ota_full2_nc_0/eeg_fd_ota_core_soft_0/m1_n47631_3443# VSS 4.826260e-16
C2673 eeg_fd_ota_full2_nc_0/eeg_fd_ota_core_soft_0/m1_n47631_3443# eeg_fd_ota_full2_nc_0/stage2_0/N2P 9.885553e-17
C2674 eeg_fd_ota_full2_nc_0/eeg_fd_ota_core_soft_0/m1_n48059_n3864# VSS 4.917160e-16
C2675 eeg_fd_ota_full2_nc_0/eeg_fd_ota_core_soft_0/m1_n50755_n3864# VSS 4.917160e-16
C2676 eeg_fd_ota_full2_nc_0/eeg_fd_ota_core_soft_0/m1_n50755_n3864# eeg_fd_ota_full2_nc_0/eeg_fd_ota_core_soft_0/m1_n51611_n3864# 6.207710e-17
C2677 eeg_fd_ota_full2_nc_0/eeg_fd_ota_core_soft_0/m1_n51183_3443# VSS 4.840670e-16
C2678 eeg_fd_ota_full2_nc_0/eeg_fd_ota_core_soft_0/m1_n51183_3443# eeg_fd_ota_full2_nc_0/eeg_fd_ota_core_soft_0/m1_n52039_3443# 6.207720e-17
C2680 eeg_fd_ota_full2_nc_0/eeg_fd_ota_core_soft_0/m1_n51611_n3864# VSS 4.429720e-16
C2681 eeg_fd_ota_full2_nc_0/eeg_fd_ota_core_soft_0/m1_n51611_n3864# eeg_fd_ota_full2_nc_0/eeg_fd_ota_core_soft_0/m1_n52467_n3864# 6.207710e-17
C2682 eeg_fd_ota_full2_nc_0/eeg_fd_ota_core_soft_0/m1_n52039_3443# VSS 4.429720e-16
C2683 eeg_fd_ota_full2_nc_0/eeg_fd_ota_core_soft_0/m1_n52039_3443# eeg_fd_ota_full2_nc_0/eeg_fd_ota_core_soft_0/m1_n52895_3443# 6.207710e-17
C2685 eeg_fd_ota_full2_nc_0/eeg_fd_ota_core_soft_0/m1_n52467_n3864# VSS 4.429720e-16
C2686 eeg_fd_ota_full2_nc_0/eeg_fd_ota_core_soft_0/m1_n52467_n3864# eeg_fd_ota_full2_nc_0/eeg_fd_ota_core_soft_0/m1_n53323_n3864# 6.207720e-17
C2687 eeg_fd_ota_full2_nc_0/eeg_fd_ota_core_soft_0/m1_n52895_3443# VSS 4.429720e-16
C2688 eeg_fd_ota_full2_nc_0/eeg_fd_ota_core_soft_0/m1_n52895_3443# eeg_fd_ota_full2_nc_0/eeg_fd_ota_core_soft_0/m1_n53751_3443# 6.207710e-17
C2690 eeg_fd_ota_full2_nc_0/eeg_fd_ota_core_soft_0/m1_n53323_n3864# VSS 4.429720e-16
C2691 eeg_fd_ota_full2_nc_0/eeg_fd_ota_core_soft_0/m1_n53323_n3864# eeg_fd_ota_full2_nc_0/eeg_fd_ota_core_soft_0/m1_n54179_n3864# 6.207710e-17
C2692 eeg_fd_ota_full2_nc_0/eeg_fd_ota_core_soft_0/m1_n53751_3443# VSS 4.429720e-16
C2693 eeg_fd_ota_full2_nc_0/eeg_fd_ota_core_soft_0/m1_n53751_3443# eeg_fd_ota_full2_nc_0/eeg_fd_ota_core_soft_0/m1_n54607_3443# 6.207710e-17
C2695 eeg_fd_ota_full2_nc_0/eeg_fd_ota_core_soft_0/m1_n54179_n3864# VSS 4.429720e-16
C2696 eeg_fd_ota_full2_nc_0/eeg_fd_ota_core_soft_0/m1_n54179_n3864# eeg_fd_ota_full2_nc_0/eeg_fd_ota_core_soft_0/m1_n55035_n3864# 6.207710e-17
C2697 eeg_fd_ota_full2_nc_0/eeg_fd_ota_core_soft_0/m1_n54607_3443# VSS 4.429720e-16
C2698 eeg_fd_ota_full2_nc_0/eeg_fd_ota_core_soft_0/m1_n54607_3443# eeg_fd_ota_full2_nc_0/eeg_fd_ota_core_soft_0/m1_n55463_3443# 6.207710e-17
C2700 eeg_fd_ota_full2_nc_0/eeg_fd_ota_core_soft_0/m1_n55035_n3864# VSS 4.429720e-16
C2701 eeg_fd_ota_full2_nc_0/eeg_fd_ota_core_soft_0/m1_n55035_n3864# eeg_fd_ota_full2_nc_0/eeg_fd_ota_core_soft_0/m1_n55891_n3864# 6.207710e-17
C2702 eeg_fd_ota_full2_nc_0/eeg_fd_ota_core_soft_0/m1_n55463_3443# VSS 4.429720e-16
C2703 eeg_fd_ota_full2_nc_0/eeg_fd_ota_core_soft_0/m1_n55463_3443# eeg_fd_ota_full2_nc_0/eeg_fd_ota_core_soft_0/m1_n56319_3443# 6.207720e-17
C2705 eeg_fd_ota_full2_nc_0/eeg_fd_ota_core_soft_0/m1_n55891_n3864# VSS 4.429720e-16
C2706 eeg_fd_ota_full2_nc_0/eeg_fd_ota_core_soft_0/m1_n55891_n3864# eeg_fd_ota_full2_nc_0/eeg_fd_ota_core_soft_0/m1_n56747_n3864# 6.207710e-17
C2707 eeg_fd_ota_full2_nc_0/eeg_fd_ota_core_soft_0/m1_n56319_3443# VSS 4.429720e-16
C2708 eeg_fd_ota_full2_nc_0/eeg_fd_ota_core_soft_0/m1_n56319_3443# eeg_fd_ota_full2_nc_0/eeg_fd_ota_core_soft_0/m1_n57175_3443# 6.207710e-17
C2710 eeg_fd_ota_full2_nc_0/eeg_fd_ota_core_soft_0/m1_n56747_n3864# VSS 4.429720e-16
C2711 eeg_fd_ota_full2_nc_0/eeg_fd_ota_core_soft_0/m1_n56747_n3864# eeg_fd_ota_full2_nc_0/eeg_fd_ota_core_soft_0/m1_n57603_n3864# 6.207720e-17
C2712 eeg_fd_ota_full2_nc_0/eeg_fd_ota_core_soft_0/m1_n57175_3443# VSS 4.429720e-16
C2713 eeg_fd_ota_full2_nc_0/eeg_fd_ota_core_soft_0/m1_n57175_3443# eeg_fd_ota_full2_nc_0/eeg_fd_ota_core_soft_0/m1_n58031_3443# 6.207710e-17
C2715 eeg_fd_ota_full2_nc_0/eeg_fd_ota_core_soft_0/m1_n57603_n3864# VSS 4.429720e-16
C2716 eeg_fd_ota_full2_nc_0/eeg_fd_ota_core_soft_0/m1_n57603_n3864# eeg_fd_ota_full2_nc_0/eeg_fd_ota_core_soft_0/m1_n58459_n3864# 6.207710e-17
C2717 eeg_fd_ota_full2_nc_0/eeg_fd_ota_core_soft_0/m1_n58031_3443# VSS 4.826260e-16
C2718 eeg_fd_ota_full2_nc_0/eeg_fd_ota_core_soft_0/m1_n58031_3443# eeg_fd_ota_full2_nc_0/stage2_0/N2P 9.885557e-17
C2719 eeg_fd_ota_full2_nc_0/eeg_fd_ota_core_soft_0/m1_n58459_n3864# VSS 4.917160e-16
C2720 eeg_fd_ota_full2_nc_0/stage2_0/N2N VSS 3.540680e-14
C2721 eeg_fd_ota_full2_nc_0/stage2_0/N2N eeg_fd_ota_full2_nc_0/stage2_0/N2P 9.928293e-15
C2722 eeg_fd_ota_full2_nc_0/stage2_0/N2N eeg_pseudo_res_0/B 7.379468e-15
C2723 eeg_fd_ota_full2_nc_0/stage2_0/N2N eeg_pseudo_res_1/B 6.641364e-15
C2724 eeg_fd_ota_full2_nc_0/stage2_0/N2P VSS 2.760890e-14
C2725 eeg_fd_ota_full2_nc_0/stage2_0/N2P eeg_pseudo_res_0/B 1.018187e-14
C2726 eeg_fd_ota_full2_nc_0/stage2_0/N2P eeg_pseudo_res_1/B 3.395166e-15
C2727 eeg_pseudo_res_0/B VSS 1.448180e-14
C2728 eeg_pseudo_res_0/B eeg_pseudo_res_1/B 2.623505e-14
C2729 eeg_pseudo_res_1/B VSS 3.261730e-14
C2730 eeg_fd_ota_full2_nc_0/eeg_fd_ota_core_soft_0/m1_n50755_n3864# VSS 6.746650e-16
C2731 eeg_fd_ota_full2_nc_0/eeg_fd_ota_core_soft_0/m1_n51183_3443# VSS 6.746650e-16
C2732 eeg_fd_ota_full2_nc_0/eeg_fd_ota_core_soft_0/m1_n51183_3443# VSS 6.746650e-16
C2733 eeg_fd_ota_full2_nc_0/eeg_fd_ota_core_soft_0/m1_n51611_n3864# VSS 6.746650e-16
C2734 eeg_fd_ota_full2_nc_0/eeg_fd_ota_core_soft_0/m1_n51611_n3864# VSS 6.746650e-16
C2735 eeg_fd_ota_full2_nc_0/eeg_fd_ota_core_soft_0/m1_n52039_3443# VSS 6.746650e-16
C2736 eeg_fd_ota_full2_nc_0/eeg_fd_ota_core_soft_0/m1_n52039_3443# VSS 6.746650e-16
C2737 eeg_fd_ota_full2_nc_0/eeg_fd_ota_core_soft_0/m1_n52467_n3864# VSS 6.746650e-16
C2738 eeg_fd_ota_full2_nc_0/eeg_fd_ota_core_soft_0/m1_n52467_n3864# VSS 6.746650e-16
C2739 eeg_fd_ota_full2_nc_0/eeg_fd_ota_core_soft_0/m1_n52895_3443# VSS 6.746650e-16
C2740 VSS eeg_fd_ota_full2_nc_0/eeg_bias_gen_0/VBNF 6.766352e-15
C2741 VSS eeg_fd_ota_full2_nc_0/eeg_fd_ota_core_soft_0/m1_n22658_111# 7.972532e-16
C2742 eeg_fd_ota_full2_nc_0/eeg_bias_gen_0/VBNF VSS 2.104804e-14
C2743 eeg_fd_ota_full2_nc_0/eeg_bias_gen_0/VBNF eeg_fd_ota_full2_nc_0/eeg_fd_ota_core_soft_0/m1_n22658_111# 6.671600e-15
C2744 eeg_fd_ota_full2_nc_0/eeg_fd_ota_core_soft_0/m1_n22658_111# VSS 2.222918e-16
C2745 eeg_fd_ota_full2_nc_0/eeg_fd_ota_core_soft_0/m1_n52895_3443# VSS 6.746650e-16
C2746 eeg_fd_ota_full2_nc_0/eeg_fd_ota_core_soft_0/m1_n53323_n3864# VSS 6.746650e-16
C2747 eeg_fd_ota_full2_nc_0/eeg_fd_ota_core_soft_0/m1_30393_n3864# VSS 6.746650e-16
C2748 eeg_fd_ota_full2_nc_0/eeg_fd_ota_core_soft_0/m1_30821_3443# VSS 6.746650e-16
C2749 eeg_fd_ota_full2_nc_0/eeg_fd_ota_core_soft_0/m1_n53323_n3864# VSS 6.746650e-16
C2750 eeg_fd_ota_full2_nc_0/eeg_fd_ota_core_soft_0/m1_n53751_3443# VSS 6.746650e-16
C2751 eeg_fd_ota_full2_nc_0/eeg_fd_ota_core_soft_0/m1_29965_3443# VSS 6.746650e-16
C2752 eeg_fd_ota_full2_nc_0/eeg_fd_ota_core_soft_0/m1_30393_n3864# VSS 6.746650e-16
C2753 eeg_fd_ota_full2_nc_0/eeg_fd_ota_core_soft_0/m1_34673_n3864# VSS 6.746650e-16
C2754 eeg_fd_ota_full2_nc_0/eeg_fd_ota_core_soft_0/m1_35101_3443# VSS 6.746650e-16
C2755 eeg_fd_ota_full2_nc_0/eeg_fd_ota_core_soft_0/m1_n53751_3443# VSS 6.746650e-16
C2756 eeg_fd_ota_full2_nc_0/eeg_fd_ota_core_soft_0/m1_n54179_n3864# VSS 6.746650e-16
C2757 eeg_fd_ota_full2_nc_0/eeg_fd_ota_core_soft_0/m1_38953_n3864# VSS 6.746650e-16
C2758 eeg_fd_ota_full2_nc_0/eeg_fd_ota_core_soft_0/m1_39381_3443# VSS 6.746650e-16
C2759 eeg_fd_ota_full2_nc_0/eeg_fd_ota_core_soft_0/m1_29537_n3864# VSS 6.746650e-16
C2760 eeg_fd_ota_full2_nc_0/eeg_fd_ota_core_soft_0/m1_29965_3443# VSS 6.746650e-16
C2761 eeg_fd_ota_full2_nc_0/eeg_fd_ota_core_soft_0/m1_34245_3443# VSS 6.746650e-16
C2762 eeg_fd_ota_full2_nc_0/eeg_fd_ota_core_soft_0/m1_34673_n3864# VSS 6.746650e-16
C2763 eeg_fd_ota_full2_nc_0/eeg_fd_ota_core_soft_0/m1_n54179_n3864# VSS 6.746650e-16
C2764 eeg_fd_ota_full2_nc_0/eeg_fd_ota_core_soft_0/m1_n54607_3443# VSS 6.746650e-16
C2765 eeg_fd_ota_full2_nc_0/eeg_fd_ota_core_soft_0/m1_43233_n3864# VSS 6.746650e-16
C2766 eeg_fd_ota_full2_nc_0/eeg_fd_ota_core_soft_0/m1_43661_3443# VSS 6.746650e-16
C2767 eeg_fd_ota_full2_nc_0/eeg_fd_ota_core_soft_0/m1_38525_3443# VSS 6.746650e-16
C2768 eeg_fd_ota_full2_nc_0/eeg_fd_ota_core_soft_0/m1_38953_n3864# VSS 6.746650e-16
C2769 eeg_fd_ota_full2_nc_0/eeg_fd_ota_core_soft_0/m1_29109_3443# VSS 6.746650e-16
C2770 eeg_fd_ota_full2_nc_0/eeg_fd_ota_core_soft_0/m1_29537_n3864# VSS 6.746650e-16
C2771 eeg_fd_ota_full2_nc_0/eeg_fd_ota_core_soft_0/m1_33817_n3864# VSS 6.746650e-16
C2772 eeg_fd_ota_full2_nc_0/eeg_fd_ota_core_soft_0/m1_34245_3443# VSS 6.746650e-16
C2773 eeg_fd_ota_full2_nc_0/eeg_fd_ota_core_soft_0/m1_n54607_3443# VSS 6.746650e-16
C2774 eeg_fd_ota_full2_nc_0/eeg_fd_ota_core_soft_0/m1_n55035_n3864# VSS 6.746650e-16
C2775 eeg_fd_ota_full2_nc_0/eeg_fd_ota_core_soft_0/m1_42805_3443# VSS 6.746650e-16
C2776 eeg_fd_ota_full2_nc_0/eeg_fd_ota_core_soft_0/m1_43233_n3864# VSS 6.746650e-16
C2777 eeg_fd_ota_full2_nc_0/eeg_fd_ota_core_soft_0/m1_38097_n3864# VSS 6.746650e-16
C2778 eeg_fd_ota_full2_nc_0/eeg_fd_ota_core_soft_0/m1_38525_3443# VSS 6.746650e-16
C2779 eeg_fd_ota_full2_nc_0/eeg_fd_ota_core_soft_0/m1_28681_n3864# VSS 6.746650e-16
C2780 eeg_fd_ota_full2_nc_0/eeg_fd_ota_core_soft_0/m1_29109_3443# VSS 6.746650e-16
C2781 eeg_fd_ota_full2_nc_0/eeg_fd_ota_core_soft_0/m1_33389_3443# VSS 6.746650e-16
C2782 eeg_fd_ota_full2_nc_0/eeg_fd_ota_core_soft_0/m1_33817_n3864# VSS 6.746650e-16
C2783 eeg_fd_ota_full2_nc_0/eeg_fd_ota_core_soft_0/m1_42377_n3864# VSS 6.746650e-16
C2784 eeg_fd_ota_full2_nc_0/eeg_fd_ota_core_soft_0/m1_42805_3443# VSS 6.746650e-16
C2785 eeg_fd_ota_full2_nc_0/eeg_fd_ota_core_soft_0/m1_37669_3443# VSS 6.746650e-16
C2786 eeg_fd_ota_full2_nc_0/eeg_fd_ota_core_soft_0/m1_38097_n3864# VSS 6.746650e-16
C2787 eeg_fd_ota_full2_nc_0/eeg_fd_ota_core_soft_0/m1_28253_3443# VSS 6.746650e-16
C2788 eeg_fd_ota_full2_nc_0/eeg_fd_ota_core_soft_0/m1_28681_n3864# VSS 6.746650e-16
C2789 eeg_fd_ota_full2_nc_0/eeg_fd_ota_core_soft_0/m1_32961_n3864# VSS 6.746650e-16
C2790 eeg_fd_ota_full2_nc_0/eeg_fd_ota_core_soft_0/m1_33389_3443# VSS 6.746650e-16
C2791 VSS eeg_fd_ota_full2_nc_0/eeg_fd_ota_core_soft_0/m1_n22658_111# 1.572616e-15
C2792 VSS eeg_fd_ota_full2_nc_0/stage2_0/N2P 1.412244e-15
C2795 eeg_fd_ota_full2_nc_0/eeg_fd_ota_core_soft_0/m1_n22658_111# VSS 2.094330e-15
C2796 eeg_fd_ota_full2_nc_0/eeg_fd_ota_core_soft_0/m1_n22658_111# eeg_fd_ota_full2_nc_0/stage2_0/N2N 2.029956e-15
C2797 eeg_fd_ota_full2_nc_0/eeg_fd_ota_core_soft_0/m1_n22658_111# eeg_fd_ota_full2_nc_0/stage2_0/N2P 2.196456e-15
C2798 eeg_fd_ota_full2_nc_0/eeg_fd_ota_core_soft_0/m1_n22658_111# eeg_pseudo_res_0/B 1.694693e-14
C2799 eeg_fd_ota_full2_nc_0/eeg_fd_ota_core_soft_0/m1_n22658_111# eeg_pseudo_res_1/B 1.694693e-14
C2800 eeg_fd_ota_full2_nc_0/stage2_0/N2N VSS 1.622652e-16
C2801 eeg_fd_ota_full2_nc_0/stage2_0/N2N eeg_pseudo_res_0/B 1.694693e-14
C2802 eeg_fd_ota_full2_nc_0/stage2_0/N2P VSS 1.754879e-16
C2803 eeg_fd_ota_full2_nc_0/stage2_0/N2P eeg_pseudo_res_1/B 1.694693e-14
C2804 eeg_pseudo_res_0/B VSS 3.113808e-14
C2805 eeg_pseudo_res_0/B eeg_pseudo_res_1/B 2.420658e-16
C2806 eeg_pseudo_res_1/B VSS 3.114656e-14
C2807 eeg_fd_ota_full2_nc_0/eeg_fd_ota_core_soft_0/m1_41949_3443# VSS 6.746650e-16
C2808 eeg_fd_ota_full2_nc_0/eeg_fd_ota_core_soft_0/m1_42377_n3864# VSS 6.746650e-16
C2809 eeg_fd_ota_full2_nc_0/eeg_fd_ota_core_soft_0/m1_37241_n3864# VSS 6.746650e-16
C2810 eeg_fd_ota_full2_nc_0/eeg_fd_ota_core_soft_0/m1_37669_3443# VSS 6.746650e-16
C2811 eeg_fd_ota_full2_nc_0/eeg_fd_ota_core_soft_0/m1_27825_n3864# VSS 6.746650e-16
C2812 eeg_fd_ota_full2_nc_0/eeg_fd_ota_core_soft_0/m1_28253_3443# VSS 6.746650e-16
C2813 eeg_fd_ota_full2_nc_0/eeg_fd_ota_core_soft_0/m1_32533_3443# VSS 6.746650e-16
C2814 eeg_fd_ota_full2_nc_0/eeg_fd_ota_core_soft_0/m1_32961_n3864# VSS 6.746650e-16
C2815 eeg_fd_ota_full2_nc_0/eeg_fd_ota_core_soft_0/m1_41521_n3864# VSS 6.746650e-16
C2816 eeg_fd_ota_full2_nc_0/eeg_fd_ota_core_soft_0/m1_41949_3443# VSS 6.746650e-16
C2817 eeg_fd_ota_full2_nc_0/eeg_fd_ota_core_soft_0/m1_36813_3443# VSS 6.746650e-16
C2818 eeg_fd_ota_full2_nc_0/eeg_fd_ota_core_soft_0/m1_37241_n3864# VSS 6.746650e-16
C2819 eeg_fd_ota_full2_nc_0/eeg_fd_ota_core_soft_0/m1_27397_3443# VSS 6.746650e-16
C2820 eeg_fd_ota_full2_nc_0/eeg_fd_ota_core_soft_0/m1_27825_n3864# VSS 6.746650e-16
C2821 eeg_fd_ota_full2_nc_0/eeg_fd_ota_core_soft_0/m1_32105_n3864# VSS 6.746650e-16
C2822 eeg_fd_ota_full2_nc_0/eeg_fd_ota_core_soft_0/m1_32533_3443# VSS 6.746650e-16
C2823 eeg_fd_ota_full2_nc_0/eeg_fd_ota_core_soft_0/m1_41093_3443# VSS 6.746650e-16
C2824 eeg_fd_ota_full2_nc_0/eeg_fd_ota_core_soft_0/m1_41521_n3864# VSS 6.746650e-16
C2825 eeg_fd_ota_full2_nc_0/eeg_fd_ota_core_soft_0/m1_36385_n3864# VSS 6.746650e-16
C2826 eeg_fd_ota_full2_nc_0/eeg_fd_ota_core_soft_0/m1_36813_3443# VSS 6.746650e-16
C2827 eeg_fd_ota_full2_nc_0/eeg_fd_ota_core_soft_0/m1_26969_n3864# VSS 6.746650e-16
C2828 eeg_fd_ota_full2_nc_0/eeg_fd_ota_core_soft_0/m1_27397_3443# VSS 6.746650e-16
C2829 eeg_fd_ota_full2_nc_0/eeg_fd_ota_core_soft_0/m1_31677_3443# VSS 6.746650e-16
C2830 eeg_fd_ota_full2_nc_0/eeg_fd_ota_core_soft_0/m1_32105_n3864# VSS 6.746650e-16
C2831 eeg_fd_ota_full2_nc_0/eeg_fd_ota_core_soft_0/m1_47513_n3864# VSS 6.746650e-16
C2832 eeg_fd_ota_full2_nc_0/stage2_0/N2N VSS 6.746650e-16
C2833 eeg_fd_ota_full2_nc_0/eeg_fd_ota_core_soft_0/m1_40665_n3864# VSS 6.746650e-16
C2834 eeg_fd_ota_full2_nc_0/eeg_fd_ota_core_soft_0/m1_41093_3443# VSS 6.746650e-16
C2835 eeg_fd_ota_full2_nc_0/eeg_cmfb_amp_dl2_0/VCM_SENSE VSS 6.746650e-16
C2836 eeg_fd_ota_full2_nc_0/eeg_fd_ota_core_soft_0/m1_26969_n3864# VSS 6.746650e-16
C2837 eeg_fd_ota_full2_nc_0/eeg_fd_ota_core_soft_0/m1_31249_n3864# VSS 6.746650e-16
C2838 eeg_fd_ota_full2_nc_0/eeg_fd_ota_core_soft_0/m1_31677_3443# VSS 6.746650e-16
C2839 eeg_fd_ota_full2_nc_0/eeg_fd_ota_core_soft_0/m1_35957_3443# VSS 6.746650e-16
C2840 eeg_fd_ota_full2_nc_0/eeg_fd_ota_core_soft_0/m1_36385_n3864# VSS 6.746650e-16
C2841 eeg_fd_ota_full2_nc_0/eeg_fd_ota_core_soft_0/m1_53633_n3864# VSS 6.746650e-16
C2842 eeg_fd_ota_full2_nc_0/eeg_fd_ota_core_soft_0/m1_54061_3443# VSS 6.746650e-16
C2843 eeg_fd_ota_full2_nc_0/eeg_fd_ota_core_soft_0/m1_47085_3443# VSS 6.746650e-16
C2844 eeg_fd_ota_full2_nc_0/eeg_fd_ota_core_soft_0/m1_47513_n3864# VSS 6.746650e-16
C2845 eeg_fd_ota_full2_nc_0/eeg_fd_ota_core_soft_0/m1_40237_3443# VSS 6.746650e-16
C2846 eeg_fd_ota_full2_nc_0/eeg_fd_ota_core_soft_0/m1_40665_n3864# VSS 6.746650e-16
C2847 eeg_fd_ota_full2_nc_0/eeg_fd_ota_core_soft_0/m1_35529_n3864# VSS 6.746650e-16
C2848 eeg_fd_ota_full2_nc_0/eeg_fd_ota_core_soft_0/m1_35957_3443# VSS 6.746650e-16
C2849 eeg_fd_ota_full2_nc_0/eeg_fd_ota_core_soft_0/m1_30821_3443# VSS 6.746650e-16
C2850 eeg_fd_ota_full2_nc_0/eeg_fd_ota_core_soft_0/m1_31249_n3864# VSS 6.746650e-16
C2851 eeg_fd_ota_full2_nc_0/eeg_fd_ota_core_soft_0/m1_57913_n3864# VSS 6.746650e-16
C2852 eeg_fd_ota_full2_nc_0/stage2_0/N2N VSS 6.746650e-16
C2853 eeg_fd_ota_full2_nc_0/eeg_fd_ota_core_soft_0/m1_53205_3443# VSS 6.746650e-16
C2854 eeg_fd_ota_full2_nc_0/eeg_fd_ota_core_soft_0/m1_53633_n3864# VSS 6.746650e-16
C2855 eeg_fd_ota_full2_nc_0/eeg_fd_ota_core_soft_0/m1_46657_n3864# VSS 6.746650e-16
C2856 eeg_fd_ota_full2_nc_0/eeg_fd_ota_core_soft_0/m1_47085_3443# VSS 6.746650e-16
C2857 eeg_fd_ota_full2_nc_0/eeg_fd_ota_core_soft_0/m1_39809_n3864# VSS 6.746650e-16
C2858 eeg_fd_ota_full2_nc_0/eeg_fd_ota_core_soft_0/m1_40237_3443# VSS 6.746650e-16
C2859 eeg_fd_ota_full2_nc_0/eeg_fd_ota_core_soft_0/m1_35101_3443# VSS 6.746650e-16
C2860 eeg_fd_ota_full2_nc_0/eeg_fd_ota_core_soft_0/m1_35529_n3864# VSS 6.746650e-16
C2861 eeg_fd_ota_full2_nc_0/eeg_fd_ota_core_soft_0/m1_57485_3443# VSS 6.746650e-16
C2862 eeg_fd_ota_full2_nc_0/eeg_fd_ota_core_soft_0/m1_57913_n3864# VSS 6.746650e-16
C2863 eeg_fd_ota_full2_nc_0/eeg_fd_ota_core_soft_0/m1_52777_n3864# VSS 6.746650e-16
C2864 eeg_fd_ota_full2_nc_0/eeg_fd_ota_core_soft_0/m1_53205_3443# VSS 6.746650e-16
C2865 eeg_fd_ota_full2_nc_0/eeg_fd_ota_core_soft_0/m1_46229_3443# VSS 6.746650e-16
C2866 eeg_fd_ota_full2_nc_0/eeg_fd_ota_core_soft_0/m1_46657_n3864# VSS 6.746650e-16
C2867 eeg_fd_ota_full2_nc_0/eeg_fd_ota_core_soft_0/m1_n44635_n3864# VSS 6.746650e-16
C2868 eeg_fd_ota_full2_nc_0/eeg_fd_ota_core_soft_0/m1_n45063_3443# VSS 6.746650e-16
C2869 eeg_fd_ota_full2_nc_0/eeg_fd_ota_core_soft_0/m1_39381_3443# VSS 6.746650e-16
C2870 eeg_fd_ota_full2_nc_0/eeg_fd_ota_core_soft_0/m1_39809_n3864# VSS 6.746650e-16
C2871 eeg_fd_ota_full2_nc_0/eeg_fd_ota_core_soft_0/m1_57057_n3864# VSS 6.746650e-16
C2872 eeg_fd_ota_full2_nc_0/eeg_fd_ota_core_soft_0/m1_57485_3443# VSS 6.746650e-16
C2873 eeg_fd_ota_full2_nc_0/eeg_fd_ota_core_soft_0/m1_52349_3443# VSS 6.746650e-16
C2874 eeg_fd_ota_full2_nc_0/eeg_fd_ota_core_soft_0/m1_52777_n3864# VSS 6.746650e-16
C2875 eeg_fd_ota_full2_nc_0/eeg_fd_ota_core_soft_0/m1_45801_n3864# VSS 6.746650e-16
C2876 eeg_fd_ota_full2_nc_0/eeg_fd_ota_core_soft_0/m1_46229_3443# VSS 6.746650e-16
C2877 eeg_fd_ota_full2_nc_0/eeg_fd_ota_core_soft_0/m1_n45063_3443# VSS 6.746650e-16
C2878 eeg_fd_ota_full2_nc_0/eeg_fd_ota_core_soft_0/m1_n45491_n3864# VSS 6.746650e-16
C2879 eeg_fd_ota_full2_nc_0/eeg_fd_ota_core_soft_0/m1_n40355_n3864# VSS 6.746650e-16
C2880 eeg_fd_ota_full2_nc_0/eeg_fd_ota_core_soft_0/m1_n40783_3443# VSS 6.746650e-16
C2881 eeg_fd_ota_full2_nc_0/eeg_fd_ota_core_soft_0/m1_56629_3443# VSS 6.746650e-16
C2882 eeg_fd_ota_full2_nc_0/eeg_fd_ota_core_soft_0/m1_57057_n3864# VSS 6.746650e-16
C2883 eeg_fd_ota_full2_nc_0/eeg_fd_ota_core_soft_0/m1_51921_n3864# VSS 6.746650e-16
C2884 eeg_fd_ota_full2_nc_0/eeg_fd_ota_core_soft_0/m1_52349_3443# VSS 6.746650e-16
C2885 eeg_fd_ota_full2_nc_0/eeg_fd_ota_core_soft_0/m1_45373_3443# VSS 6.746650e-16
C2886 eeg_fd_ota_full2_nc_0/eeg_fd_ota_core_soft_0/m1_45801_n3864# VSS 6.746650e-16
C2887 eeg_fd_ota_full2_nc_0/eeg_fd_ota_core_soft_0/m1_n45491_n3864# VSS 6.746650e-16
C2888 eeg_fd_ota_full2_nc_0/eeg_fd_ota_core_soft_0/m1_n45919_3443# VSS 6.746650e-16
C2889 eeg_fd_ota_full2_nc_0/eeg_fd_ota_core_soft_0/m1_n40783_3443# VSS 6.746650e-16
C2890 eeg_fd_ota_full2_nc_0/eeg_fd_ota_core_soft_0/m1_n41211_n3864# VSS 6.746650e-16
C2891 eeg_fd_ota_full2_nc_0/eeg_fd_ota_core_soft_0/m1_n36075_n3864# VSS 6.746650e-16
C2892 eeg_fd_ota_full2_nc_0/eeg_fd_ota_core_soft_0/m1_n36503_3443# VSS 6.746650e-16
C2893 eeg_fd_ota_full2_nc_0/eeg_fd_ota_core_soft_0/m1_56201_n3864# VSS 6.746650e-16
C2894 eeg_fd_ota_full2_nc_0/eeg_fd_ota_core_soft_0/m1_56629_3443# VSS 6.746650e-16
C2895 eeg_fd_ota_full2_nc_0/eeg_fd_ota_core_soft_0/m1_51493_3443# VSS 6.746650e-16
C2896 eeg_fd_ota_full2_nc_0/eeg_fd_ota_core_soft_0/m1_51921_n3864# VSS 6.746650e-16
C2897 eeg_fd_ota_full2_nc_0/eeg_fd_ota_core_soft_0/m1_44945_n3864# VSS 6.746650e-16
C2898 eeg_fd_ota_full2_nc_0/eeg_fd_ota_core_soft_0/m1_45373_3443# VSS 6.746650e-16
C2899 eeg_fd_ota_full2_nc_0/eeg_fd_ota_core_soft_0/m1_n45919_3443# VSS 6.746650e-16
C2900 eeg_fd_ota_full2_nc_0/eeg_fd_ota_core_soft_0/m1_n46347_n3864# VSS 6.746650e-16
C2901 eeg_fd_ota_full2_nc_0/eeg_fd_ota_core_soft_0/m1_n41211_n3864# VSS 6.746650e-16
C2902 eeg_fd_ota_full2_nc_0/eeg_fd_ota_core_soft_0/m1_n41639_3443# VSS 6.746650e-16
C2903 eeg_fd_ota_full2_nc_0/eeg_fd_ota_core_soft_0/m1_n36503_3443# VSS 6.746650e-16
C2904 eeg_fd_ota_full2_nc_0/eeg_fd_ota_core_soft_0/m1_n36931_n3864# VSS 6.746650e-16
C2905 eeg_fd_ota_full2_nc_0/eeg_fd_ota_core_soft_0/m1_n31795_n3864# VSS 6.746650e-16
C2906 eeg_fd_ota_full2_nc_0/eeg_fd_ota_core_soft_0/m1_n32223_3443# VSS 6.746650e-16
C2907 eeg_fd_ota_full2_nc_0/eeg_fd_ota_core_soft_0/m1_55773_3443# VSS 6.746650e-16
C2908 eeg_fd_ota_full2_nc_0/eeg_fd_ota_core_soft_0/m1_56201_n3864# VSS 6.746650e-16
C2909 eeg_fd_ota_full2_nc_0/eeg_fd_ota_core_soft_0/m1_51065_n3864# VSS 6.746650e-16
C2910 eeg_fd_ota_full2_nc_0/eeg_fd_ota_core_soft_0/m1_51493_3443# VSS 6.746650e-16
C2911 eeg_fd_ota_full2_nc_0/eeg_fd_ota_core_soft_0/m1_44517_3443# VSS 6.746650e-16
C2912 eeg_fd_ota_full2_nc_0/eeg_fd_ota_core_soft_0/m1_44945_n3864# VSS 6.746650e-16
C2913 eeg_fd_ota_full2_nc_0/eeg_fd_ota_core_soft_0/m1_n46347_n3864# VSS 6.746650e-16
C2914 eeg_fd_ota_full2_nc_0/eeg_fd_ota_core_soft_0/m1_n46775_3443# VSS 6.746650e-16
C2915 eeg_fd_ota_full2_nc_0/eeg_fd_ota_core_soft_0/m1_n41639_3443# VSS 6.746650e-16
C2916 eeg_fd_ota_full2_nc_0/eeg_fd_ota_core_soft_0/m1_n42067_n3864# VSS 6.746650e-16
C2917 eeg_fd_ota_full2_nc_0/eeg_fd_ota_core_soft_0/m1_n36931_n3864# VSS 6.746650e-16
C2918 eeg_fd_ota_full2_nc_0/eeg_fd_ota_core_soft_0/m1_n37359_3443# VSS 6.746650e-16
C2919 eeg_fd_ota_full2_nc_0/eeg_fd_ota_core_soft_0/m1_n32223_3443# VSS 6.746650e-16
C2920 eeg_fd_ota_full2_nc_0/eeg_fd_ota_core_soft_0/m1_n32651_n3864# VSS 6.746650e-16
C2921 eeg_fd_ota_full2_nc_0/eeg_fd_ota_core_soft_0/m1_n27515_n3864# VSS 6.746650e-16
C2922 eeg_fd_ota_full2_nc_0/eeg_fd_ota_core_soft_0/m1_n27943_3443# VSS 6.746650e-16
C2923 VDD18 VSS 4.124974e-14
C2924 VDD18 eeg_fd_ota_full2_nc_0/eeg_cmfb_amp_dl2_0/VBP 1.216293e-14
C2925 VDD18 eeg_fd_ota_full2_nc_0/stage2_0/N2P 1.242512e-15
C2926 eeg_fd_ota_full2_nc_0/eeg_cmfb_amp_dl2_0/VBP VSS 2.342324e-15
C2927 eeg_fd_ota_full2_nc_0/eeg_cmfb_amp_dl2_0/VBP eeg_fd_ota_full2_nc_0/stage2_0/N2P 3.335800e-15
C2928 eeg_fd_ota_full2_nc_0/eeg_fd_ota_core_soft_0/m1_55345_n3864# VSS 6.746650e-16
C2929 eeg_fd_ota_full2_nc_0/eeg_fd_ota_core_soft_0/m1_55773_3443# VSS 6.746650e-16
C2930 eeg_fd_ota_full2_nc_0/eeg_fd_ota_core_soft_0/m1_50637_3443# VSS 6.746650e-16
C2931 eeg_fd_ota_full2_nc_0/eeg_fd_ota_core_soft_0/m1_51065_n3864# VSS 6.746650e-16
C2932 eeg_fd_ota_full2_nc_0/eeg_fd_ota_core_soft_0/m1_44089_n3864# VSS 6.746650e-16
C2933 eeg_fd_ota_full2_nc_0/eeg_fd_ota_core_soft_0/m1_44517_3443# VSS 6.746650e-16
C2934 eeg_fd_ota_full2_nc_0/eeg_fd_ota_core_soft_0/m1_n55035_n3864# VSS 6.746650e-16
C2935 eeg_fd_ota_full2_nc_0/eeg_fd_ota_core_soft_0/m1_n55463_3443# VSS 6.746650e-16
C2936 eeg_fd_ota_full2_nc_0/eeg_fd_ota_core_soft_0/m1_n46775_3443# VSS 6.746650e-16
C2937 eeg_fd_ota_full2_nc_0/eeg_fd_ota_core_soft_0/m1_n47203_n3864# VSS 6.746650e-16
C2938 eeg_fd_ota_full2_nc_0/eeg_fd_ota_core_soft_0/m1_n42067_n3864# VSS 6.746650e-16
C2939 eeg_fd_ota_full2_nc_0/eeg_fd_ota_core_soft_0/m1_n42495_3443# VSS 6.746650e-16
C2940 eeg_fd_ota_full2_nc_0/eeg_fd_ota_core_soft_0/m1_n37359_3443# VSS 6.746650e-16
C2941 eeg_fd_ota_full2_nc_0/eeg_fd_ota_core_soft_0/m1_n37787_n3864# VSS 6.746650e-16
C2942 eeg_fd_ota_full2_nc_0/eeg_fd_ota_core_soft_0/m1_n32651_n3864# VSS 6.746650e-16
C2943 eeg_fd_ota_full2_nc_0/eeg_fd_ota_core_soft_0/m1_n33079_3443# VSS 6.746650e-16
C2944 eeg_fd_ota_full2_nc_0/eeg_fd_ota_core_soft_0/m1_n27943_3443# VSS 6.746650e-16
C2945 eeg_fd_ota_full2_nc_0/eeg_fd_ota_core_soft_0/m1_n28371_n3864# VSS 6.746650e-16
C2946 eeg_fd_ota_full2_nc_0/eeg_fd_ota_core_soft_0/m1_54917_3443# VSS 6.746650e-16
C2947 eeg_fd_ota_full2_nc_0/eeg_fd_ota_core_soft_0/m1_55345_n3864# VSS 6.746650e-16
C2948 eeg_fd_ota_full2_nc_0/eeg_fd_ota_core_soft_0/m1_50209_n3864# VSS 6.746650e-16
C2949 eeg_fd_ota_full2_nc_0/eeg_fd_ota_core_soft_0/m1_50637_3443# VSS 6.746650e-16
C2950 eeg_fd_ota_full2_nc_0/eeg_fd_ota_core_soft_0/m1_43661_3443# VSS 6.746650e-16
C2951 eeg_fd_ota_full2_nc_0/eeg_fd_ota_core_soft_0/m1_44089_n3864# VSS 6.746650e-16
C2952 eeg_fd_ota_full2_nc_0/eeg_fd_ota_core_soft_0/m1_n55463_3443# VSS 6.746650e-16
C2953 eeg_fd_ota_full2_nc_0/eeg_fd_ota_core_soft_0/m1_n55891_n3864# VSS 6.746650e-16
C2954 eeg_fd_ota_full2_nc_0/eeg_fd_ota_core_soft_0/m1_n47203_n3864# VSS 6.746650e-16
C2955 eeg_fd_ota_full2_nc_0/eeg_fd_ota_core_soft_0/m1_n47631_3443# VSS 6.746650e-16
C2956 eeg_fd_ota_full2_nc_0/eeg_fd_ota_core_soft_0/m1_n42495_3443# VSS 6.746650e-16
C2957 eeg_fd_ota_full2_nc_0/eeg_fd_ota_core_soft_0/m1_n42923_n3864# VSS 6.746650e-16
C2958 eeg_fd_ota_full2_nc_0/eeg_fd_ota_core_soft_0/m1_n37787_n3864# VSS 6.746650e-16
C2959 eeg_fd_ota_full2_nc_0/eeg_fd_ota_core_soft_0/m1_n38215_3443# VSS 6.746650e-16
C2960 eeg_fd_ota_full2_nc_0/eeg_fd_ota_core_soft_0/m1_n33079_3443# VSS 6.746650e-16
C2961 eeg_fd_ota_full2_nc_0/eeg_fd_ota_core_soft_0/m1_n33507_n3864# VSS 6.746650e-16
C2962 eeg_fd_ota_full2_nc_0/eeg_fd_ota_core_soft_0/m1_n28371_n3864# VSS 6.746650e-16
C2963 eeg_fd_ota_full2_nc_0/eeg_fd_ota_core_soft_0/m1_n28799_3443# VSS 6.746650e-16
C2964 eeg_fd_ota_full2_nc_0/eeg_fd_ota_core_soft_0/m1_54489_n3864# VSS 6.746650e-16
C2965 eeg_fd_ota_full2_nc_0/eeg_fd_ota_core_soft_0/m1_54917_3443# VSS 6.746650e-16
C2966 VCM_REF VSS 6.746650e-16
C2967 eeg_fd_ota_full2_nc_0/eeg_fd_ota_core_soft_0/m1_50209_n3864# VSS 6.746650e-16
C2968 eeg_fd_ota_full2_nc_0/eeg_fd_ota_core_soft_0/m1_n55891_n3864# VSS 6.746650e-16
C2969 eeg_fd_ota_full2_nc_0/eeg_fd_ota_core_soft_0/m1_n56319_3443# VSS 6.746650e-16
C2970 eeg_fd_ota_full2_nc_0/eeg_fd_ota_core_soft_0/m1_n47631_3443# VSS 6.746650e-16
C2971 eeg_fd_ota_full2_nc_0/eeg_fd_ota_core_soft_0/m1_n48059_n3864# VSS 6.746650e-16
C2972 eeg_fd_ota_full2_nc_0/eeg_fd_ota_core_soft_0/m1_n42923_n3864# VSS 6.746650e-16
C2973 eeg_fd_ota_full2_nc_0/eeg_fd_ota_core_soft_0/m1_n43351_3443# VSS 6.746650e-16
C2974 eeg_fd_ota_full2_nc_0/eeg_fd_ota_core_soft_0/m1_n38215_3443# VSS 6.746650e-16
C2975 eeg_fd_ota_full2_nc_0/eeg_fd_ota_core_soft_0/m1_n38643_n3864# VSS 6.746650e-16
C2976 eeg_fd_ota_full2_nc_0/eeg_fd_ota_core_soft_0/m1_n33507_n3864# VSS 6.746650e-16
C2977 eeg_fd_ota_full2_nc_0/eeg_fd_ota_core_soft_0/m1_n33935_3443# VSS 6.746650e-16
C2978 eeg_fd_ota_full2_nc_0/eeg_fd_ota_core_soft_0/m1_n28799_3443# VSS 6.746650e-16
C2979 eeg_fd_ota_full2_nc_0/eeg_fd_ota_core_soft_0/m1_n29227_n3864# VSS 6.746650e-16
C2980 eeg_fd_ota_full2_nc_0/eeg_fd_ota_core_soft_0/m1_54061_3443# VSS 6.746650e-16
C2981 eeg_fd_ota_full2_nc_0/eeg_fd_ota_core_soft_0/m1_54489_n3864# VSS 6.746650e-16
C2982 eeg_fd_ota_full2_nc_0/eeg_fd_ota_core_soft_0/m1_n56319_3443# VSS 6.746650e-16
C2983 eeg_fd_ota_full2_nc_0/eeg_fd_ota_core_soft_0/m1_n56747_n3864# VSS 6.746650e-16
C2984 eeg_fd_ota_full2_nc_0/eeg_fd_ota_core_soft_0/m1_n48059_n3864# VSS 6.746650e-16
C2985 eeg_fd_ota_full2_nc_0/stage2_0/N2P VSS 6.746650e-16
C2986 eeg_fd_ota_full2_nc_0/eeg_fd_ota_core_soft_0/m1_n43351_3443# VSS 6.746650e-16
C2987 eeg_fd_ota_full2_nc_0/eeg_fd_ota_core_soft_0/m1_n43779_n3864# VSS 6.746650e-16
C2988 eeg_fd_ota_full2_nc_0/eeg_fd_ota_core_soft_0/m1_n38643_n3864# VSS 6.746650e-16
C2989 eeg_fd_ota_full2_nc_0/eeg_fd_ota_core_soft_0/m1_n39071_3443# VSS 6.746650e-16
C2990 eeg_fd_ota_full2_nc_0/eeg_fd_ota_core_soft_0/m1_n33935_3443# VSS 6.746650e-16
C2991 eeg_fd_ota_full2_nc_0/eeg_fd_ota_core_soft_0/m1_n34363_n3864# VSS 6.746650e-16
C2992 eeg_fd_ota_full2_nc_0/eeg_fd_ota_core_soft_0/m1_n29227_n3864# VSS 6.746650e-16
C2993 eeg_fd_ota_full2_nc_0/eeg_fd_ota_core_soft_0/m1_n29655_3443# VSS 6.746650e-16
C2994 eeg_fd_ota_full2_nc_0/eeg_fd_ota_core_soft_0/m1_n56747_n3864# VSS 6.746650e-16
C2995 eeg_fd_ota_full2_nc_0/eeg_fd_ota_core_soft_0/m1_n57175_3443# VSS 6.746650e-16
C2996 VCM_REF VSS 6.746650e-16
C2997 eeg_fd_ota_full2_nc_0/eeg_fd_ota_core_soft_0/m1_n50755_n3864# VSS 6.746650e-16
C2998 eeg_fd_ota_full2_nc_0/eeg_fd_ota_core_soft_0/m1_n43779_n3864# VSS 6.746650e-16
C2999 eeg_fd_ota_full2_nc_0/eeg_fd_ota_core_soft_0/m1_n44207_3443# VSS 6.746650e-16
C3000 eeg_fd_ota_full2_nc_0/eeg_fd_ota_core_soft_0/m1_n39071_3443# VSS 6.746650e-16
C3001 eeg_fd_ota_full2_nc_0/eeg_fd_ota_core_soft_0/m1_n39499_n3864# VSS 6.746650e-16
C3002 eeg_fd_ota_full2_nc_0/eeg_fd_ota_core_soft_0/m1_n34363_n3864# VSS 6.746650e-16
C3003 eeg_fd_ota_full2_nc_0/eeg_fd_ota_core_soft_0/m1_n34791_3443# VSS 6.746650e-16
C3004 eeg_fd_ota_full2_nc_0/eeg_fd_ota_core_soft_0/m1_n29655_3443# VSS 6.746650e-16
C3005 eeg_fd_ota_full2_nc_0/eeg_fd_ota_core_soft_0/m1_n30083_n3864# VSS 6.746650e-16
C3006 eeg_fd_ota_full2_nc_0/eeg_fd_ota_core_soft_0/m1_n57175_3443# VSS 6.746650e-16
C3007 eeg_fd_ota_full2_nc_0/eeg_fd_ota_core_soft_0/m1_n57603_n3864# VSS 6.746650e-16
C3008 eeg_fd_ota_full2_nc_0/eeg_fd_ota_core_soft_0/m1_n44207_3443# VSS 6.746650e-16
C3009 eeg_fd_ota_full2_nc_0/eeg_fd_ota_core_soft_0/m1_n44635_n3864# VSS 6.746650e-16
C3010 eeg_fd_ota_full2_nc_0/eeg_fd_ota_core_soft_0/m1_n39499_n3864# VSS 6.746650e-16
C3011 eeg_fd_ota_full2_nc_0/eeg_fd_ota_core_soft_0/m1_n39927_3443# VSS 6.746650e-16
C3012 eeg_fd_ota_full2_nc_0/eeg_fd_ota_core_soft_0/m1_n34791_3443# VSS 6.746650e-16
C3013 eeg_fd_ota_full2_nc_0/eeg_fd_ota_core_soft_0/m1_n35219_n3864# VSS 6.746650e-16
C3014 eeg_fd_ota_full2_nc_0/eeg_fd_ota_core_soft_0/m1_n30083_n3864# VSS 6.746650e-16
C3015 eeg_fd_ota_full2_nc_0/eeg_fd_ota_core_soft_0/m1_n30511_3443# VSS 6.746650e-16
C3016 VDD18 VSS 4.124974e-14
C3017 VDD18 eeg_fd_ota_full2_nc_0/eeg_cmfb_amp_dl2_0/VBP 1.216293e-14
C3018 VDD18 eeg_fd_ota_full2_nc_0/stage2_0/N2N 1.242512e-15
C3019 eeg_fd_ota_full2_nc_0/eeg_cmfb_amp_dl2_0/VBP VSS 2.342324e-15
C3020 eeg_fd_ota_full2_nc_0/eeg_cmfb_amp_dl2_0/VBP eeg_fd_ota_full2_nc_0/stage2_0/N2N 3.335800e-15
C3021 eeg_fd_ota_full2_nc_0/eeg_fd_ota_core_soft_0/m1_n57603_n3864# VSS 6.746650e-16
C3022 eeg_fd_ota_full2_nc_0/eeg_fd_ota_core_soft_0/m1_n58031_3443# VSS 6.746650e-16
C3023 eeg_fd_ota_full2_nc_0/eeg_fd_ota_core_soft_0/m1_n39927_3443# VSS 6.746650e-16
C3024 eeg_fd_ota_full2_nc_0/eeg_fd_ota_core_soft_0/m1_n40355_n3864# VSS 6.746650e-16
C3025 eeg_fd_ota_full2_nc_0/eeg_fd_ota_core_soft_0/m1_n35219_n3864# VSS 6.746650e-16
C3026 eeg_fd_ota_full2_nc_0/eeg_fd_ota_core_soft_0/m1_n35647_3443# VSS 6.746650e-16
C3027 eeg_fd_ota_full2_nc_0/eeg_fd_ota_core_soft_0/m1_n30511_3443# VSS 6.746650e-16
C3028 eeg_fd_ota_full2_nc_0/eeg_fd_ota_core_soft_0/m1_n30939_n3864# VSS 6.746650e-16
C3029 eeg_fd_ota_full2_nc_0/eeg_fd_ota_core_soft_0/m1_n58031_3443# VSS 6.746650e-16
C3030 eeg_fd_ota_full2_nc_0/eeg_fd_ota_core_soft_0/m1_n58459_n3864# VSS 6.746650e-16
C3031 eeg_fd_ota_full2_nc_0/eeg_fd_ota_core_soft_0/m1_n35647_3443# VSS 6.746650e-16
C3032 eeg_fd_ota_full2_nc_0/eeg_fd_ota_core_soft_0/m1_n36075_n3864# VSS 6.746650e-16
C3033 eeg_fd_ota_full2_nc_0/eeg_fd_ota_core_soft_0/m1_n30939_n3864# VSS 6.746650e-16
C3034 eeg_fd_ota_full2_nc_0/eeg_fd_ota_core_soft_0/m1_n31367_3443# VSS 6.746650e-16
C3035 eeg_fd_ota_full2_nc_0/eeg_fd_ota_core_soft_0/m1_n58459_n3864# VSS 6.746650e-16
C3036 eeg_fd_ota_full2_nc_0/stage2_0/N2P VSS 6.746650e-16
C3037 eeg_fd_ota_full2_nc_0/eeg_fd_ota_core_soft_0/m1_n31367_3443# VSS 6.746650e-16
C3038 eeg_fd_ota_full2_nc_0/eeg_fd_ota_core_soft_0/m1_n31795_n3864# VSS 6.746650e-16
C3039 eeg_fd_ota_full2_nc_0/eeg_cmfb_amp_dl2_0/VCM_SENSE VSS 6.746650e-16
C3040 eeg_fd_ota_full2_nc_0/eeg_fd_ota_core_soft_0/m1_n27515_n3864# VSS 6.746650e-16
C3041 BIT VDD18 1.658314e-16
C3042 BIT VSS 1.620786e-15
C3043 BIT eeg_inv_0/Y 1.823050e-16
C3044 VDD18 VSS 1.332013e-15
C3045 VDD18 eeg_inv_0/Y 7.937490e-16
C3046 VSS eeg_inv_0/Y 7.176584e-17
C3047 eeg_inv_0/Y VSS 9.197480e-16
C3048 BIT VDD18 1.883250e-16
C3049 BIT VSS 4.355510e-17
C3050 BIT eeg_inv_0/Y 2.887600e-17
C3051 VDD18 VSS 2.592707e-15
C3052 VDD18 eeg_inv_0/Y 3.212380e-16
C3053 eeg_inv_0/Y VSS 8.691660e-17
C3054 BIT VSS 2.152613e-16
C3056 VSS eeg_inv_0/Y 5.623600e-17
C3057 eeg_inv_0/Y VSS 1.770690e-16
C3058 CLK OINTN 7.955695e-17
C3059 CLK OINTP 1.039127e-16
C3060 CLK VDD18 2.732596e-15
C3061 CLK VSS 7.825184e-15
C3062 CLK eeg_nand2_0/A 3.851780e-16
C3063 CLK eeg_nand2_1/A 3.626436e-16
C3064 CLK eeg_strongarm_0/m1_250_166# 1.349240e-16
C3065 CLK eeg_strongarm_0/m1_2620_1559# 6.501157e-17
C3066 CLK eeg_strongarm_0/m1_n4_2402# 3.193121e-16
C3067 OINTN OINTP 9.933296e-16
C3068 OINTN VDD18 2.087887e-17
C3069 OINTN VSS 1.309612e-15
C3072 OINTN eeg_strongarm_0/m1_250_166# 1.556074e-15
C3073 OINTN eeg_strongarm_0/m1_2620_1559# 1.143658e-16
C3076 OINTP VSS 2.013781e-15
C3079 OINTP eeg_strongarm_0/m1_250_166# 7.312386e-16
C3081 OINTP eeg_strongarm_0/m1_n4_2402# 1.088728e-16
C3082 VDD18 VSS 5.795918e-15
C3083 VDD18 eeg_nand2_0/A 9.359910e-16
C3084 VDD18 eeg_nand2_1/A 1.094066e-15
C3086 VDD18 eeg_strongarm_0/m1_2620_1559# 1.931588e-16
C3087 VDD18 eeg_strongarm_0/m1_n4_2402# 1.894291e-16
C3088 VSS eeg_nand2_0/A 1.601089e-15
C3089 VSS eeg_nand2_1/A 8.262288e-16
C3090 VSS eeg_strongarm_0/m1_250_166# 7.737294e-16
C3091 VSS eeg_strongarm_0/m1_2620_1559# 2.038501e-16
C3092 VSS eeg_strongarm_0/m1_n4_2402# 2.727656e-16
C3093 eeg_nand2_0/A VSS 1.455580e-15
C3094 eeg_nand2_0/A eeg_nand2_1/A 1.819334e-15
C3096 eeg_nand2_0/A eeg_strongarm_0/m1_2620_1559# 2.765148e-16
C3097 eeg_nand2_0/A eeg_strongarm_0/m1_n4_2402# 6.193080e-17
C3098 eeg_nand2_1/A VSS 1.549860e-15
C3100 eeg_nand2_1/A eeg_strongarm_0/m1_2620_1559# 1.746873e-16
C3101 eeg_nand2_1/A eeg_strongarm_0/m1_n4_2402# 3.587802e-16
C3102 eeg_strongarm_0/m1_250_166# VSS 1.845520e-15
C3103 eeg_strongarm_0/m1_250_166# eeg_strongarm_0/m1_2620_1559# 1.905126e-16
C3104 eeg_strongarm_0/m1_250_166# eeg_strongarm_0/m1_n4_2402# 2.354135e-16
C3105 eeg_strongarm_0/m1_2620_1559# VSS 1.083600e-15
C3106 eeg_strongarm_0/m1_2620_1559# eeg_strongarm_0/m1_n4_2402# 3.747850e-17
C3107 eeg_strongarm_0/m1_n4_2402# VSS 1.209190e-15
C3108 CLK VSS 7.062382e-16
C3109 CLK eeg_strongarm_0/m1_250_166# 1.003644e-16
C3110 VSS eeg_strongarm_0/m1_250_166# 4.978080e-16
C3111 eeg_strongarm_0/m1_250_166# VSS 7.028120e-17
C3112 CLK VDD18 1.735233e-16
C3113 CLK VSS 4.470230e-17
C3115 VDD18 VSS 2.014100e-15
C3116 VDD18 eeg_strongarm_0/m1_2620_1559# 1.740840e-16
C3117 eeg_strongarm_0/m1_2620_1559# VSS 6.164950e-17
C3118 CLK VDD18 1.735233e-16
C3119 CLK VSS 4.470230e-17
C3121 VDD18 VSS 2.014100e-15
C3122 VDD18 eeg_strongarm_0/m1_n4_2402# 1.740840e-16
C3123 eeg_strongarm_0/m1_n4_2402# VSS 6.164950e-17
C3124 CLK VDD18 3.021706e-16
C3125 CLK VSS 7.012160e-17
C3126 CLK eeg_nand2_0/A 2.221660e-17
C3127 VDD18 VSS 2.359843e-15
C3128 VDD18 eeg_nand2_0/A 1.288370e-16
C3130 CLK VDD18 3.021706e-16
C3131 CLK VSS 7.012160e-17
C3132 CLK eeg_nand2_1/A 2.221660e-17
C3133 VDD18 VSS 2.359843e-15
C3134 VDD18 eeg_nand2_1/A 1.288370e-16
C3136 VDD18 VSS 1.409425e-15
C3137 VDD18 eeg_nand2_0/A 7.598330e-17
C3138 VDD18 eeg_nand2_1/A 2.905230e-16
C3141 eeg_nand2_1/A VSS 8.104460e-17
C3142 VDD18 VSS 1.409425e-15
C3143 VDD18 eeg_nand2_0/A 2.905230e-16
C3144 VDD18 eeg_nand2_1/A 7.598330e-17
C3145 eeg_nand2_0/A VSS 8.104460e-17
C3148 eeg_nand2_0/A VSS 3.899740e-17
C3150 eeg_nand2_0/A eeg_strongarm_0/m1_n4_2402# 4.872180e-17
C3151 eeg_nand2_1/A VSS 3.467880e-16
C3152 eeg_nand2_1/A eeg_strongarm_0/m1_n4_2402# 2.048900e-17
C3153 eeg_strongarm_0/m1_n4_2402# VSS 1.091040e-16
C3154 eeg_nand2_0/A VSS 3.467880e-16
C3156 eeg_nand2_0/A eeg_strongarm_0/m1_2620_1559# 2.048900e-17
C3157 eeg_nand2_1/A VSS 3.899740e-17
C3158 eeg_nand2_1/A eeg_strongarm_0/m1_2620_1559# 4.872180e-17
C3159 eeg_strongarm_0/m1_2620_1559# VSS 1.091040e-16
C3160 OINTN VSS 8.818740e-16
C3161 OINTN eeg_strongarm_0/m1_250_166# 9.019660e-17
C3162 OINTN eeg_strongarm_0/m1_2620_1559# 8.496640e-17
C3163 eeg_strongarm_0/m1_250_166# VSS 3.922686e-16
C3164 eeg_strongarm_0/m1_250_166# eeg_strongarm_0/m1_2620_1559# 1.231068e-16
C3165 eeg_strongarm_0/m1_2620_1559# VSS 7.014680e-17
C3166 OINTP VSS 8.818740e-16
C3167 OINTP eeg_strongarm_0/m1_250_166# 9.019660e-17
C3168 OINTP eeg_strongarm_0/m1_n4_2402# 8.496640e-17
C3169 eeg_strongarm_0/m1_250_166# VSS 3.922686e-16
C3170 eeg_strongarm_0/m1_250_166# eeg_strongarm_0/m1_n4_2402# 1.231068e-16
C3171 eeg_strongarm_0/m1_n4_2402# VSS 7.014680e-17
C3172 eeg_tg_lowq_1/A VSS 6.746650e-16
C3173 m1_57225_71443# VSS 6.746650e-16
C3174 m1_56797_64136# VSS 6.746650e-16
C3175 m1_57225_71443# VSS 6.746650e-16
C3176 m1_56369_71443# VSS 6.746650e-16
C3177 m1_56797_64136# VSS 6.746650e-16
C3178 m1_55941_64136# VSS 6.746650e-16
C3179 m1_56369_71443# VSS 6.746650e-16
.ends
