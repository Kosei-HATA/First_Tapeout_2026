* PEX verification bench: full-macro AFE gain at 8 Hz (post-layout).
* Same stimulus as tb_f1k_8.spice but instancing the flat PEX netlist of
* eeg_afe_top (PGA outputs exposed as the PGA_OUTP/PGA_OUTN alias pins).
* x32 gain (S32), 1 kHz chopper, 16 kHz SDM clock (SDM runs and loads the
* PGA, as integrated).  tran 1.536 s, save-limited vectors (memory!).
.lib /Users/noah/.volare/volare/sky130/versions/0fe599b2afb6708d281543108caf8310912f54af/sky130A/libs.tech/ngspice/sky130.lib.spice tt
* PEX note: .lib tt alone covers all magic-ext2spice device names
* (nfet/pfet_01v8, res_xhigh_po_0p69, cap_mim_m3_1) — extra includes
* REDEFINE the subckts and break param passing.  Merged FETs carry
* nf=<fingers> so per-finger w stays inside the PDK model bins.
.temp 27
.include eeg_afe_top_pex.spice
.param VDD=1.80 VCM={1.80/2} VCMA=0.927 TCHOP=1m TCLK=62.5u
VDD_SRC VDD18 0 {VDD}
VREF VCM_REF 0 {VCM}
* SDM DAC references centered on the analog CM
VVP VP 0 {VCMA+25m}
VVN VN 0 {VCMA-25m}
* 1 kHz chopper clocks (both chopper stages driven together)
VPHI PHI 0 PULSE(0 {VDD} 50n 20n 20n 499.85u {TCHOP})
VPHIB PHIB 0 PULSE(0 {VDD} 500.05u 20n 20n 499.85u {TCHOP})
BNPHI NPHI 0 V={VDD}-v(PHI)
BNPHIB NPHIB 0 V={VDD}-v(PHIB)
* 16 kHz SDM clock
VCLK CLK16 0 PULSE(0 {VDD} 0 100n 100n 31.15u {TCLK})
BNCLK NCLK16 0 V={VDD}-v(CLK16)
* 100 uV 8 Hz differential EEG at the electrodes
VSIGP ELP 0 SIN({VCM} 100u 8)
VSIGN ELN 0 SIN({VCM} 100u 8 0 0 180)
* x32 gain select
VS8 S8 0 0
VS16 S16 0 0
VS32 S32 0 {VDD}
VS64 S64 0 0
XTOP ELP ELN VCM_REF VP VN PHI NPHI PHIB NPHIB PHI NPHI PHIB NPHIB CLK16 NCLK16 BIT NBIT S8 S16 S32 S64 VDD18 0 PGA_OUTP PGA_OUTN eeg_afe_top
* settled-state guides (from the pre-layout macro bench)
.nodeset v(PGA_OUTP)=0.93 v(PGA_OUTN)=0.93 v(BIT)=1.8
* speed: PEX-verified settle by ~0.3 s (pre-layout CSV); 3 clean 8 Hz
* cycles after 0.5 s suffice for the LS fit.  reltol/trtol relaxed ~3x
* (checked to shift the fitted amplitude by <1%).
.options reltol=3e-3 trtol=3 gmin=1e-13
.control
set noaskquit
set num_threads=4
* limit saved vectors: full-batch save needs >10 GB RAM per run
save time v(PGA_OUTP) v(PGA_OUTN) i(VDD_SRC)
tran 500n 0.875s
wrdata ../results/tb_afe_f1k8_pex.csv time v(PGA_OUTP) v(PGA_OUTN)
let idd=-i(VDD_SRC)
meas tran idd_avg avg idd from=0.7s to=0.875s
let vcmout=(v(PGA_OUTP)+v(PGA_OUTN))/2
meas tran vcm_avg avg vcmout from=0.7s to=0.875s
quit
.endc
.end
