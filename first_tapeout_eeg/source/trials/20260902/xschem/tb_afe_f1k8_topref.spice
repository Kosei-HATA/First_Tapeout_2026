* Pre-layout reference for the PEX gain check: same stimulus as
* tb_afe_f1k8_pex.spice but instancing the schematic eeg_afe_top
* ( PGA outputs read hierarchically as v(XTOP.PGA_OUTP) ).
.lib /Users/noah/.volare/volare/sky130/versions/0fe599b2afb6708d281543108caf8310912f54af/sky130A/libs.tech/ngspice/sky130.lib.spice tt
.temp 27
.include eeg_tg_lowq.spice
.include eeg_fd_ota_core_soft.spice
.include eeg_bias_gen.spice
.include eeg_fd_ota_chopped_full2.spice
.include eeg_pseudo_res.spice
.include eeg_afe_pga.spice
.include eeg_fd_ota_full2_nc.spice
.include eeg_strongarm.spice
.include eeg_sdm2.spice
.include eeg_sdm1ct.spice
.include eeg_afe_top.spice
.param VDD=1.80 VCM={1.80/2} VCMA=0.927 TCHOP=1m TCLK=62.5u
VDD_SRC VDD18 0 {VDD}
VREF VCM_REF 0 {VCM}
VVP VP 0 {VCMA+25m}
VVN VN 0 {VCMA-25m}
VPHI PHI 0 PULSE(0 {VDD} 50n 20n 20n 499.85u {TCHOP})
VPHIB PHIB 0 PULSE(0 {VDD} 500.05u 20n 20n 499.85u {TCHOP})
BNPHI NPHI 0 V={VDD}-v(PHI)
BNPHIB NPHIB 0 V={VDD}-v(PHIB)
VCLK CLK16 0 PULSE(0 {VDD} 0 100n 100n 31.15u {TCLK})
BNCLK NCLK16 0 V={VDD}-v(CLK16)
VSIGP ELP 0 SIN({VCM} 100u 8)
VSIGN ELN 0 SIN({VCM} 100u 8 0 0 180)
VS8 S8 0 0
VS16 S16 0 0
VS32 S32 0 {VDD}
VS64 S64 0 0
XTOP ELP ELN VCM_REF VP VN PHI NPHI PHIB NPHIB PHI NPHI PHIB NPHIB CLK16 NCLK16 BIT NBIT S8 S16 S32 S64 VDD18 0 eeg_afe_top
.nodeset v(XTOP.PGA_OUTP)=0.93 v(XTOP.PGA_OUTN)=0.93 v(BIT)=1.8
.control
set noaskquit
save time v(XTOP.PGA_OUTP) v(XTOP.PGA_OUTN) i(VDD_SRC)
tran 100n 1.536s
wrdata ../results/tb_afe_f1k8_topref.csv time v(XTOP.PGA_OUTP) v(XTOP.PGA_OUTN)
let idd=-i(VDD_SRC)
meas tran idd_avg avg idd from=1.4s to=1.536s
let vcmout=(v(XTOP.PGA_OUTP)+v(XTOP.PGA_OUTN))/2
meas tran vcm_avg avg vcmout from=1.4s to=1.536s
quit
.endc
.end
