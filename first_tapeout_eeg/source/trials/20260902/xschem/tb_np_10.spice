* Noise evaluation: chopped_full2 PGA x32, choppers frozen straight.
* .noise gives electrode-referred input noise. Chopped in-band noise is
* estimated from the noise density at fchop=8 kHz (1/f removed by modulation).
* sed tokens: 0 clean0
.lib /Users/noah/.volare/volare/sky130/versions/0fe599b2afb6708d281543108caf8310912f54af/sky130A/libs.tech/ngspice/sky130.lib.spice tt
.include eeg_tg_lowq.spice
.include eeg_fd_ota_core_soft.spice
.include eeg_bias_gen.spice
.include eeg_fd_ota_chopped_full2nodsl.spice
.param VDD=1.80 VCM=0.9 RSRC=0
VDD_SRC VDD18 0 {VDD}
VREF VCM_REF 0 {VCM}
VPHI PHI 0 {VDD}
VPHIB PHIB 0 0
BNPHI NPHI 0 V={VDD}-v(PHI)
BNPHIB NPHIB 0 V={VDD}-v(PHIB)
* electrode source resistance in series with each input
VSIGP SRCP 0 DC {VCM} AC 0.5 0
VSIGN SRCN 0 DC {VCM} AC 0.5 180
RSP SRCP SIGP {RSRC}
RSN SRCN SIGN {RSRC}
CINP SIGP INP 32p
CINN SIGN INN 32p
CFP OUTN INP 1p
CFN OUTP INN 1p
RBIASP INP VCM_REF 1T
RBIASN INN VCM_REF 1T
XAFE INP INN VCM_REF OUTP OUTN PHI NPHI PHIB NPHIB PHI NPHI PHIB NPHIB VDD18 0 eeg_fd_ota_chopped_full2
CLOADP OUTP 0 5p
CLOADN OUTN 0 5p
.print noise inoise_spectrum onoise_spectrum
.control
set noaskquit
noise v(OUTP,OUTN) VSIGP dec 1 10 10 1
setplot noise1
print inoise_spectrum
print onoise.m.xafe.xstg1.xm1.msky130_fd_pr__nfet_01v8
print onoise.m.xafe.xstg1.xm2.msky130_fd_pr__nfet_01v8
print onoise.m.xafe.xstg1.xm3.msky130_fd_pr__pfet_01v8
print onoise.m.xafe.xstg1.xm4.msky130_fd_pr__pfet_01v8
print onoise.m.xafe.xstg1.xm5.msky130_fd_pr__nfet_01v8
print onoise.m.xafe.xm21.msky130_fd_pr__nfet_01v8
print onoise.m.xafe.xm22.msky130_fd_pr__nfet_01v8
print onoise.m.xafe.xm23.msky130_fd_pr__pfet_01v8
print onoise.m.xafe.xm24.msky130_fd_pr__pfet_01v8
print onoise.m.xafe.xcm1.xm6.msky130_fd_pr__nfet_01v8
print onoise.m.xafe.xcm2.xm6.msky130_fd_pr__nfet_01v8
print onoise.m.xafe.xbg.xmn1.msky130_fd_pr__nfet_01v8
quit
.endc
.end
