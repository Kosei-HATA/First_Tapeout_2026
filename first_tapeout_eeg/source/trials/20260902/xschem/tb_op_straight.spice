* Standard verification bench: internal-chopper PGA x32, pseudo-R bias, RST.
* Lessons baked in: RST clears the t=0 op garbage; pseudo-R settles it in
* ~0.3-1 s; measure with LS-fit (scripts/lsfit_gain.py), not windowed FFT.
* sed tokens: tt 1.80 27 fix1  (TT: tt 1.80 27)
.lib /Users/noah/.volare/volare/sky130/versions/0fe599b2afb6708d281543108caf8310912f54af/sky130A/libs.tech/ngspice/sky130.lib.spice tt
.temp 27
.include eeg_tg_lowq.spice
.include eeg_fd_ota_core_soft.spice
.include eeg_bias_gen.spice
.include eeg_fd_ota_chopped_full2.spice
.include eeg_pseudo_res.spice
.param VDD=1.80 VCM={1.80/2} TCHOP=125u
VDD_SRC VDD18 0 {VDD}
VREF VCM_REF 0 {VCM}
VPHI PHI 0 {VDD}
VPHIB PHIB 0 0
BNPHI NPHI 0 V={VDD}-v(PHI)
BNPHIB NPHIB 0 V={VDD}-v(PHIB)
VSIGP SIGP 0 0.95
VSIGN SIGN 0 0.85
CINP SIGP INP 32p
CINN SIGN INN 32p
CFP OUTN INP 1p
CFN OUTP INN 1p
XPRP INP VCM_REF eeg_pseudo_res
XPRN INN VCM_REF eeg_pseudo_res
VRST RST 0 0
BRSTN NRST 0 V={VDD}-v(RST)
XRSTP INP VCM_REF RST NRST VDD18 0 eeg_tg_lowq
XRSTN INN VCM_REF RST NRST VDD18 0 eeg_tg_lowq
XAFE INP INN VCM_REF OUTP OUTN PHI NPHI PHIB NPHIB PHI NPHI PHIB NPHIB VDD18 0 eeg_fd_ota_chopped_full2
CLOADP OUTP 0 5p
CLOADN OUTN 0 5p
* settled-state guide (from the 3 s settle run, TT)
.nodeset v(INP)=0.9 v(INN)=0.9 v(XAFE.INP_M)=0.9 v(XAFE.INN_M)=0.9 v(XAFE.N1P)=0.932 v(XAFE.N1N)=0.932 v(XAFE.N2P)=0.932 v(XAFE.N2N)=0.932 v(XAFE.VBP1)=0.6155 v(XAFE.VBP2)=0.3848 v(OUTP)=0.9267 v(OUTN)=0.9267
.control
set noaskquit
op
print v(INP) v(INN) v(XAFE.INP_M) v(XAFE.INN_M) v(OUTP) v(OUTN)
quit
.endc
.end
