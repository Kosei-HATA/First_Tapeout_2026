* PEX fallback bench: PGA-only (eeg_afe_pga) gain at 8 Hz, post-layout.
* Same drive as tb_afe_f1k8_pex.spice but without the SDM (5 pF load, as in
* the historical tb_f1k_8 OTA bench).  Pins follow the magic-extracted
* eeg_afe_pga subckt order.
.lib /Users/noah/.volare/volare/sky130/versions/0fe599b2afb6708d281543108caf8310912f54af/sky130A/libs.tech/ngspice/sky130.lib.spice tt
* PEX note: .lib tt alone covers all magic-ext2spice device names
* (nfet/pfet_01v8, res_xhigh_po_0p69, cap_mim_m3_1) — extra includes
* REDEFINE the subckts and break param passing.  Merged FETs carry
* nf=<fingers> so per-finger w stays inside the PDK model bins.
.temp 27
.include eeg_afe_pga_pex.spice
.param VDD=1.80 VCM={1.80/2} TCHOP=1m
VDD_SRC VDD18 0 {VDD}
VREF VCM_REF 0 {VCM}
VPHI PHI 0 PULSE(0 {VDD} 50n 20n 20n 499.85u {TCHOP})
VPHIB PHIB 0 PULSE(0 {VDD} 500.05u 20n 20n 499.85u {TCHOP})
BNPHI NPHI 0 V={VDD}-v(PHI)
BNPHIB NPHIB 0 V={VDD}-v(PHIB)
BNPHIBM NPHIBM 0 V={VDD}-v(PHIB)
BPHII PHII 0 V=v(PHI)
BNPHII NPHII 0 V={VDD}-v(PHI)
BPHIBM PHIBM 0 V=v(PHIB)
BNPHIBI NPHIBI 0 V={VDD}-v(PHIB)
VSIGP ELP 0 SIN({VCM} 100u 8)
VSIGN ELN 0 SIN({VCM} 100u 8 0 0 180)
VRST RST 0 0
VS8 S8 0 0
VS16 S16 0 0
VS32 S32 0 {VDD}
VS64 S64 0 0
CLOADP OUTP 0 5p
CLOADN OUTN 0 5p
XPGA S16 NPHIBM OUTP OUTN NPHII S32 S64 PHI NPHI PHIB ELP ELN VDD18 RST 0 S8 PHII PHIBM VCM_REF NPHIBI eeg_afe_pga
.nodeset v(OUTP)=0.93 v(OUTN)=0.93
* speed: AFE settles by ~0.3 s; 3 clean 8 Hz cycles after 0.45 s suffice
.options reltol=3e-3 trtol=3 gmin=1e-13
.control
set noaskquit
set num_threads=4
save time v(OUTP) v(OUTN) i(VDD_SRC)
tran 500n 0.75s
wrdata ../results/tb_pga_f1k8_pex.csv time v(OUTP) v(OUTN)
let idd=-i(VDD_SRC)
meas tran idd_avg avg idd from=0.6s to=0.75s
let vcmout=(v(OUTP)+v(OUTN))/2
meas tran vcm_avg avg vcmout from=0.6s to=0.75s
quit
.endc
.end
