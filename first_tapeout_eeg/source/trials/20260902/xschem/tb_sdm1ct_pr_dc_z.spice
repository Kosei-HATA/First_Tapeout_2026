* CT 1st-order SDM test, pseudo-resistor RF variant: 32 Hz 0.6 FS input, fs=16 kHz.
* Memory-safe: save-limited vectors; individual voltages written, diffs in Python.
.lib /Users/noah/.volare/volare/sky130/versions/0fe599b2afb6708d281543108caf8310912f54af/sky130A/libs.tech/ngspice/sky130.lib.spice tt
.include eeg_tg_lowq.spice
.include eeg_fd_ota_core_soft.spice
.include eeg_bias_gen.spice
.include eeg_fd_ota_chopped_full2.spice
.include eeg_fd_ota_full2_nc.spice
.include eeg_strongarm.spice
.include eeg_sdm2.spice
.include eeg_pseudo_res.spice
.include eeg_sdm1ct_pr.spice
.param VDD=1.80 VCM=0.9 TCLK=62.5u
VDD_SRC VDD18 0 {VDD}
VREF VCM_REF 0 {VCM}
VVP VP 0 {VCM+25m}
VVN VN 0 {VCM-25m}
VCLK CLK 0 PULSE(0 {VDD} 0 100n 100n 31.15u {TCLK})
BNCLK NCLK 0 V={VDD}-v(CLK)
VINP VINP 0 {VCM}
VINN VINN 0 {VCM}
XSDM VINP VINN VCM_REF VP VN BIT NBIT OINTP OINTN CLK NCLK VDD18 0 eeg_sdm1ct_pr
.nodeset v(OINTP)=0.93 v(OINTN)=0.93 v(BIT)=1.8 v(NBIT)=0 v(XSDM.INP)=0.9 v(XSDM.INN)=0.9 v(XSDM.XRFP.M)=0.9 v(XSDM.XRFN.M)=0.9
.control
set noaskquit
* limit saved vectors (memory safety); diffs computed in Python
save time v(VINP) v(VINN) v(OINTP) v(OINTN) v(BIT)
tran 100n 130m
wrdata ../results/sdm1ct_pr_dc_z.csv time v(VINP) v(VINN) v(OINTP) v(OINTN) v(BIT)
quit
.endc
.end
