* Sanity: measure a KNOWN passive network with the same injection method.
* DUT: two 32pF caps in series with a 1G bleed to mimic the bench.
VCM VCMR 0 0.9
C1 SIGP MID 32p
C2 MID SIGN 32p
RB1 SIGP VCMR 1G
RB2 SIGN VCMR 1G
RB3 MID VCMR 1G
IINJ SIGP SIGN DC 0 AC 1
.control
set noaskquit
ac dec 10 1 1e6
let zmag = mag(v(SIGP)-v(SIGN))
let zph = ph(v(SIGP)-v(SIGN))
wrdata ../results/zin_sanity.csv zmag zph
quit
.endc
.end
